* Physical AI - Experiment 13 architecture A: current-gain multi-range (Experiment 11 baseline)
* CCCS alpha on every bank, including unity
* Frozen Experiment 9 network F. Weights were not edited.
* Behavioral circuit analysis. Not transistor-level or PCB power.
* scale_error=0 Ileak=0 rail=5 linear=True relu=none
* shape: 16 -> 32 -> 16

Vin1 in1 0 DC 0
Vin2 in2 0 DC 0
Vin3 in3 0 DC 0
Vin4 in4 0 DC 0
Vin5 in5 0 DC 0
Vin6 in6 0 DC 0
Vin7 in7 0 DC 0
Vin8 in8 0 DC 0
Vin9 in9 0 DC 0
Vin10 in10 0 DC 0
Vin11 in11 0 DC 0
Vin12 in12 0 DC 0
Vin13 in13 0 DC 0
Vin14 in14 0 DC 0
Vin15 in15 0 DC 0
Vin16 in16 0 DC 0
Vref vref 0 DC 1

* h1 input 1 w=-0.0168555731920106 w-  bank=m alpha=0.01 R=19775.8527423636 G_phys=5.05667195760317e-05 G_eff=5.05667195760317e-07
Rh1n1m1 in1 h1nm 19775.8527423636
* h1 input 2 w=+0.167421682129858 w+  bank=n alpha=1 R=199098.067283059 G_phys=5.02265046389574e-06 G_eff=5.02265046389574e-06
Rh1p2n1 in2 h1pn 199098.067283059
* h1 input 3 w=-0.175338604042315 w-  bank=n alpha=1 R=190108.353579049 G_phys=5.26015812126946e-06 G_eff=5.26015812126946e-06
Rh1n3n1 in3 h1nn 190108.353579049
* h1 input 4 w=-0.3026243730549 w-  bank=n alpha=1 R=110147.55023478 G_phys=9.078731191647e-06 G_eff=9.078731191647e-06
Rh1n4n1 in4 h1nn 110147.55023478
* h1 input 5 w=-0.0731653551060092 w-  bank=n alpha=1 R=455589.032336913 G_phys=2.19496065318027e-06 G_eff=2.19496065318027e-06
Rh1n5n1 in5 h1nn 455589.032336913
* h1 input 6 w=+0.135452999280782 w+  bank=n alpha=1 R=246087.820205711 G_phys=4.06358997842346e-06 G_eff=4.06358997842346e-06
Rh1p6n1 in6 h1pn 246087.820205711
* h1 input 7 w=+0.21541693193391 w+  bank=n alpha=1 R=154738.687595643 G_phys=6.46250795801731e-06 G_eff=6.46250795801731e-06
Rh1p7n1 in7 h1pn 154738.687595643
* h1 input 8 w=-0.0225117532106789 w-  bank=m alpha=0.01 R=14807.0801156087 G_phys=6.75352596320366e-05 G_eff=6.75352596320366e-07
Rh1n8m1 in8 h1nm 14807.0801156087
* h1 input 9 w=-0.120865686071453 w-  bank=n alpha=1 R=275788.227550601 G_phys=3.62597058214359e-06 G_eff=3.62597058214359e-06
Rh1n9n1 in9 h1nn 275788.227550601
* h1 input 10 w=+0.732018397911567 w+  bank=n alpha=1 R=45536.19612353 G_phys=2.1960551937347e-05 G_eff=2.1960551937347e-05
Rh1p10n1 in10 h1pn 45536.19612353
* h1 input 11 w=+0.435334885703784 w+  bank=n alpha=1 R=76569.405365814 G_phys=1.30600465711135e-05 G_eff=1.30600465711135e-05
Rh1p11n1 in11 h1pn 76569.405365814
* h1 input 12 w=+0.385479984810207 w+  bank=n alpha=1 R=86472.2803954274 G_phys=1.15643995443062e-05 G_eff=1.15643995443062e-05
Rh1p12n1 in12 h1pn 86472.2803954274
* h1 input 13 w=-0.42800728852471 w-  bank=n alpha=1 R=77880.2936936643 G_phys=1.28402186557413e-05 G_eff=1.28402186557413e-05
Rh1n13n1 in13 h1nn 77880.2936936643
* h1 input 14 w=+0.104452911276431 w+  bank=n alpha=1 R=319123.066327159 G_phys=3.13358733829293e-06 G_eff=3.13358733829293e-06
Rh1p14n1 in14 h1pn 319123.066327159
* h1 input 15 w=-0.361295245628978 w-  bank=n alpha=1 R=92260.6475911506 G_phys=1.08388573688693e-05 G_eff=1.08388573688693e-05
Rh1n15n1 in15 h1nn 92260.6475911506
* h1 input 16 w=+0.0759383856082483 w+  bank=n alpha=1 R=438952.356786904 G_phys=2.27815156824745e-06 G_eff=2.27815156824745e-06
Rh1p16n1 in16 h1pn 438952.356786904
* h1 bias=-0.0910888061470142 b-  bank=n alpha=1 R=365943.245315286 G_phys=2.73266418441043e-06 G_eff=2.73266418441043e-06
Rh1bnn1 vref h1nn 365943.245315286
Vh1nm h1nm 0 DC 0
Fh1nm h1d 0 Vh1nm 0.01
Vh1nn h1nn 0 DC 0
Fh1nn h1d 0 Vh1nn 1
Vh1pn h1pn 0 DC 0
Fh1pn 0 h1d Vh1pn 1
Vh1d h1d 0 DC 0
Hh1 h1lin 0 Vh1d 33333.3333333333
Eh1 h1buf 0 h1lin 0 1

* h2 input 1 w=+0.0248542194622879 w+  bank=m alpha=0.01 R=13411.5389879417 G_phys=7.45626583868636e-05 G_eff=7.45626583868636e-07
Rh2p1m1 in1 h2pm 13411.5389879417
* h2 input 2 w=+0.400223191665755 w+  bank=n alpha=1 R=83286.8610002279 G_phys=1.20066957499727e-05 G_eff=1.20066957499727e-05
Rh2p2n1 in2 h2pn 83286.8610002279
* h2 input 3 w=+0.358260577298724 w+  bank=n alpha=1 R=93042.1471004872 G_phys=1.07478173189617e-05 G_eff=1.07478173189617e-05
Rh2p3n1 in3 h2pn 93042.1471004872
* h2 input 4 w=+0.348073132477087 w+  bank=n alpha=1 R=95765.315455733 G_phys=1.04421939743126e-05 G_eff=1.04421939743126e-05
Rh2p4n1 in4 h2pn 95765.315455733
* h2 input 5 w=-0.489776715185261 w-  bank=n alpha=1 R=68058.2238800895 G_phys=1.46933014555578e-05 G_eff=1.46933014555578e-05
Rh2n5n1 in5 h2nn 68058.2238800895
* h2 input 6 w=-0.262585224656684 w-  bank=n alpha=1 R=126942.913017726 G_phys=7.87755673970051e-06 G_eff=7.87755673970051e-06
Rh2n6n1 in6 h2nn 126942.913017726
* h2 input 7 w=+0.634452480443638 w+  bank=n alpha=1 R=52538.7390873232 G_phys=1.90335744133091e-05 G_eff=1.90335744133091e-05
Rh2p7n1 in7 h2pn 52538.7390873232
* h2 input 8 w=-0.0150494358056585 w-  bank=m alpha=0.01 R=22149.2245714621 G_phys=4.51483074169756e-05 G_eff=4.51483074169756e-07
Rh2n8m1 in8 h2nm 22149.2245714621
* h2 input 9 w=+0.317089980091076 w+  bank=n alpha=1 R=105122.632142962 G_phys=9.51269940273229e-06 G_eff=9.51269940273229e-06
Rh2p9n1 in9 h2pn 105122.632142962
* h2 input 10 w=-0.171694565495531 w-  bank=n alpha=1 R=194143.2056229 G_phys=5.15083696486594e-06 G_eff=5.15083696486594e-06
Rh2n10n1 in10 h2nn 194143.2056229
* h2 input 11 w=+0.113535277026032 w+  bank=n alpha=1 R=293594.503897589 G_phys=3.40605831078097e-06 G_eff=3.40605831078097e-06
Rh2p11n1 in11 h2pn 293594.503897589
* h2 input 12 w=+0.342235951147447 w+  bank=n alpha=1 R=97398.6900603912 G_phys=1.02670785344234e-05 G_eff=1.02670785344234e-05
Rh2p12n1 in12 h2pn 97398.6900603912
* h2 input 13 w=-0.268945400148547 w-  bank=n alpha=1 R=123940.89400645 G_phys=8.0683620044564e-06 G_eff=8.0683620044564e-06
Rh2n13n1 in13 h2nn 123940.89400645
* h2 input 14 w=+0.239258603190851 w+  bank=n alpha=1 R=139319.267473714 G_phys=7.17775809572554e-06 G_eff=7.17775809572554e-06
Rh2p14n1 in14 h2pn 139319.267473714
* h2 input 15 w=+0.347826837541335 w+  bank=n alpha=1 R=95833.1265320264 G_phys=1.043480512624e-05 G_eff=1.043480512624e-05
Rh2p15n1 in15 h2pn 95833.1265320264
* h2 input 16 w=+0.00438097035906581 w+  bank=m alpha=0.01 R=76086.6442849918 G_phys=1.31429110771974e-05 G_eff=1.31429110771974e-07
Rh2p16m1 in16 h2pm 76086.6442849918
* h2 bias=-0.0501304580317642 b-  bank=n alpha=1 R=664931.752911819 G_phys=1.50391374095293e-06 G_eff=1.50391374095293e-06
Rh2bnn1 vref h2nn 664931.752911819
Vh2nm h2nm 0 DC 0
Fh2nm h2d 0 Vh2nm 0.01
Vh2nn h2nn 0 DC 0
Fh2nn h2d 0 Vh2nn 1
Vh2pm h2pm 0 DC 0
Fh2pm 0 h2d Vh2pm 0.01
Vh2pn h2pn 0 DC 0
Fh2pn 0 h2d Vh2pn 1
Vh2d h2d 0 DC 0
Hh2 h2lin 0 Vh2d 33333.3333333333
Eh2 h2buf 0 h2lin 0 1

* h3 input 1 w=-0.916033562434709 w-  bank=n alpha=1 R=36388.7686000689 G_phys=2.74810068730413e-05 G_eff=2.74810068730413e-05
Rh3n1n1 in1 h3nn 36388.7686000689
* h3 input 2 w=+0.507521982744407 w+  bank=n alpha=1 R=65678.6000738028 G_phys=1.52256594823322e-05 G_eff=1.52256594823322e-05
Rh3p2n1 in2 h3pn 65678.6000738028
* h3 input 3 w=+0.0871477019742823 w+  bank=n alpha=1 R=382492.395991924 G_phys=2.61443105922847e-06 G_eff=2.61443105922847e-06
Rh3p3n1 in3 h3pn 382492.395991924
* h3 input 4 w=-0.0658557100969535 w-  bank=n alpha=1 R=506157.071030889 G_phys=1.97567130290861e-06 G_eff=1.97567130290861e-06
Rh3n4n1 in4 h3nn 506157.071030889
* h3 input 5 w=-0.179053685151098 w-  bank=n alpha=1 R=186163.905563878 G_phys=5.37161055453294e-06 G_eff=5.37161055453294e-06
Rh3n5n1 in5 h3nn 186163.905563878
* h3 input 6 w=+0.315007728496672 w+  bank=n alpha=1 R=105817.509597024 G_phys=9.45023185490017e-06 G_eff=9.45023185490017e-06
Rh3p6n1 in6 h3pn 105817.509597024
* h3 input 7 w=+0.677608935484657 w+  bank=n alpha=1 R=49192.5823107569 G_phys=2.03282680645397e-05 G_eff=2.03282680645397e-05
Rh3p7n1 in7 h3pn 49192.5823107569
* h3 input 8 w=+0.295351776524173 w+  bank=n alpha=1 R=112859.769206789 G_phys=8.8605532957252e-06 G_eff=8.8605532957252e-06
Rh3p8n1 in8 h3pn 112859.769206789
* h3 input 9 w=+0.00172302579693755 w+  bank=m alpha=0.01 R=193458.121129578 G_phys=5.16907739081266e-06 G_eff=5.16907739081266e-08
Rh3p9m1 in9 h3pm 193458.121129578
* h3 input 10 w=+0.317835264102281 w+  bank=n alpha=1 R=104876.132695604 G_phys=9.53505792306844e-06 G_eff=9.53505792306844e-06
Rh3p10n1 in10 h3pn 104876.132695604
* h3 input 11 w=-0.530129158700576 w-  bank=n alpha=1 R=62877.7587240027 G_phys=1.59038747610173e-05 G_eff=1.59038747610173e-05
Rh3n11n1 in11 h3nn 62877.7587240027
* h3 input 12 w=-0.291249394999097 w-  bank=n alpha=1 R=114449.450902505 G_phys=8.7374818499729e-06 G_eff=8.7374818499729e-06
Rh3n12n1 in12 h3nn 114449.450902505
* h3 input 13 w=-0.395820894073244 w-  bank=n alpha=1 R=84213.1727567804 G_phys=1.18746268221973e-05 G_eff=1.18746268221973e-05
Rh3n13n1 in13 h3nn 84213.1727567804
* h3 input 14 w=-0.0451489915790311 w-  bank=n alpha=1 R=738296.297825057 G_phys=1.35446974737093e-06 G_eff=1.35446974737093e-06
Rh3n14n1 in14 h3nn 738296.297825057
* h3 input 15 w=+0.0633187763010491 w+  bank=n alpha=1 R=526436.789852823 G_phys=1.89956328903147e-06 G_eff=1.89956328903147e-06
Rh3p15n1 in15 h3pn 526436.789852823
* h3 input 16 w=-0.149745176344707 w-  bank=n alpha=1 R=222600.381174225 G_phys=4.49235529034122e-06 G_eff=4.49235529034122e-06
Rh3n16n1 in16 h3nn 222600.381174225
* h3 bias=-0.0553554658432052 b-  bank=n alpha=1 R=602168.780003591 G_phys=1.66066397529616e-06 G_eff=1.66066397529616e-06
Rh3bnn1 vref h3nn 602168.780003591
Vh3nn h3nn 0 DC 0
Fh3nn h3d 0 Vh3nn 1
Vh3pm h3pm 0 DC 0
Fh3pm 0 h3d Vh3pm 0.01
Vh3pn h3pn 0 DC 0
Fh3pn 0 h3d Vh3pn 1
Vh3d h3d 0 DC 0
Hh3 h3lin 0 Vh3d 33333.3333333333
Eh3 h3buf 0 h3lin 0 1

* h4 input 1 w=+0.0673940677866904 w+  bank=n alpha=1 R=494603.374273786 G_phys=2.02182203360071e-06 G_eff=2.02182203360071e-06
Rh4p1n1 in1 h4pn 494603.374273786
* h4 input 2 w=-0.087995350925692 w-  bank=n alpha=1 R=378807.891356463 G_phys=2.63986052777076e-06 G_eff=2.63986052777076e-06
Rh4n2n1 in2 h4nn 378807.891356463
* h4 input 3 w=-0.354237391786533 w-  bank=n alpha=1 R=94098.8560389478 G_phys=1.0627121753596e-05 G_eff=1.0627121753596e-05
Rh4n3n1 in3 h4nn 94098.8560389478
* h4 input 4 w=-0.0201421700797575 w-  bank=m alpha=0.01 R=16549.0278362969 G_phys=6.04265102392725e-05 G_eff=6.04265102392725e-07
Rh4n4m1 in4 h4nm 16549.0278362969
* h4 input 5 w=-0.808084436849872 w-  bank=n alpha=1 R=41249.814763511 G_phys=2.42425331054962e-05 G_eff=2.42425331054962e-05
Rh4n5n1 in5 h4nn 41249.814763511
* h4 input 6 w=-0.290030636557288 w-  bank=n alpha=1 R=114930.387110153 G_phys=8.70091909671864e-06 G_eff=8.70091909671864e-06
Rh4n6n1 in6 h4nn 114930.387110153
* h4 input 7 w=+0.344262354214072 w+  bank=n alpha=1 R=96825.3801942158 G_phys=1.03278706264222e-05 G_eff=1.03278706264222e-05
Rh4p7n1 in7 h4pn 96825.3801942158
* h4 input 8 w=-0.872472737770673 w-  bank=n alpha=1 R=38205.5872811637 G_phys=2.61741821331202e-05 G_eff=2.61741821331202e-05
Rh4n8n1 in8 h4nn 38205.5872811637
* h4 input 9 w=+0.163024654235771 w+  bank=n alpha=1 R=204468.051103029 G_phys=4.89073962707314e-06 G_eff=4.89073962707314e-06
Rh4p9n1 in9 h4pn 204468.051103029
* h4 input 10 w=-0.143734302026109 w-  bank=n alpha=1 R=231909.383240185 G_phys=4.31202906078326e-06 G_eff=4.31202906078326e-06
Rh4n10n1 in10 h4nn 231909.383240185
* h4 input 11 w=-0.110414936368951 w-  bank=n alpha=1 R=301891.523280421 G_phys=3.31244809106853e-06 G_eff=3.31244809106853e-06
Rh4n11n1 in11 h4nn 301891.523280421
* h4 input 12 w=+0.321561566587255 w+  bank=n alpha=1 R=103660.812724298 G_phys=9.64684699761765e-06 G_eff=9.64684699761765e-06
Rh4p12n1 in12 h4pn 103660.812724298
* h4 input 13 w=-0.501486514423905 w-  bank=n alpha=1 R=66469.0522568205 G_phys=1.50445954327172e-05 G_eff=1.50445954327172e-05
Rh4n13n1 in13 h4nn 66469.0522568205
* h4 input 14 w=-0.0233644803539605 w-  bank=m alpha=0.01 R=14266.6701028012 G_phys=7.00934410618815e-05 G_eff=7.00934410618815e-07
Rh4n14m1 in14 h4nm 14266.6701028012
* h4 input 15 w=-0.211065663454959 w-  bank=n alpha=1 R=157928.735483053 G_phys=6.33196990364878e-06 G_eff=6.33196990364878e-06
Rh4n15n1 in15 h4nn 157928.735483053
* h4 input 16 w=+0.18002446765288 w+  bank=n alpha=1 R=185160.016124064 G_phys=5.40073402958641e-06 G_eff=5.40073402958641e-06
Rh4p16n1 in16 h4pn 185160.016124064
* h4 bias=+0.0472838049870426 b+  bank=n alpha=1 R=704963.006730694 G_phys=1.41851414961128e-06 G_eff=1.41851414961128e-06
Rh4bpn1 vref h4pn 704963.006730694
Vh4nm h4nm 0 DC 0
Fh4nm h4d 0 Vh4nm 0.01
Vh4nn h4nn 0 DC 0
Fh4nn h4d 0 Vh4nn 1
Vh4pn h4pn 0 DC 0
Fh4pn 0 h4d Vh4pn 1
Vh4d h4d 0 DC 0
Hh4 h4lin 0 Vh4d 33333.3333333333
Eh4 h4buf 0 h4lin 0 1

* h5 input 1 w=-0.122756848133934 w-  bank=n alpha=1 R=271539.501380525 G_phys=3.68270544401802e-06 G_eff=3.68270544401802e-06
Rh5n1n1 in1 h5nn 271539.501380525
* h5 input 2 w=+0.794704720471975 w+  bank=n alpha=1 R=41944.300159104 G_phys=2.38411416141592e-05 G_eff=2.38411416141592e-05
Rh5p2n1 in2 h5pn 41944.300159104
* h5 input 3 w=-0.26372184795707 w-  bank=n alpha=1 R=126395.797661631 G_phys=7.91165543871211e-06 G_eff=7.91165543871211e-06
Rh5n3n1 in3 h5nn 126395.797661631
* h5 input 4 w=+0.65217090039031 w+  bank=n alpha=1 R=51111.3472149464 G_phys=1.95651270117093e-05 G_eff=1.95651270117093e-05
Rh5p4n1 in4 h5pn 51111.3472149464
* h5 input 5 w=-0.272670344884174 w-  bank=n alpha=1 R=122247.739656077 G_phys=8.18011034652521e-06 G_eff=8.18011034652521e-06
Rh5n5n1 in5 h5nn 122247.739656077
* h5 input 6 w=+0.0607101548077554 w+  bank=n alpha=1 R=549056.964833751 G_phys=1.82130464423266e-06 G_eff=1.82130464423266e-06
Rh5p6n1 in6 h5pn 549056.964833751
* h5 input 7 w=+0.629980287413506 w+  bank=n alpha=1 R=52911.7085078791 G_phys=1.88994086224052e-05 G_eff=1.88994086224052e-05
Rh5p7n1 in7 h5pn 52911.7085078791
* h5 input 8 w=-0.369402487956774 w-  bank=n alpha=1 R=90235.8116690157 G_phys=1.10820746387032e-05 G_eff=1.10820746387032e-05
Rh5n8n1 in8 h5nn 90235.8116690157
* h5 input 9 w=-0.0924511829208223 w-  bank=n alpha=1 R=360550.641757401 G_phys=2.77353548762467e-06 G_eff=2.77353548762467e-06
Rh5n9n1 in9 h5nn 360550.641757401
* h5 input 10 w=-0.00426485730080124 w-  bank=m alpha=0.01 R=78158.1445340996 G_phys=1.27945719024037e-05 G_eff=1.27945719024037e-07
Rh5n10m1 in10 h5nm 78158.1445340996
* h5 input 11 w=+0.540478898079688 w+  bank=n alpha=1 R=61673.6998461292 G_phys=1.62143669423906e-05 G_eff=1.62143669423906e-05
Rh5p11n1 in11 h5pn 61673.6998461292
* h5 input 12 w=+0.161688921548601 w+  bank=n alpha=1 R=206157.187604928 G_phys=4.85066764645802e-06 G_eff=4.85066764645802e-06
Rh5p12n1 in12 h5pn 206157.187604928
* h5 input 13 w=+0.0259557799028364 w+  bank=m alpha=0.01 R=12842.3547503154 G_phys=7.78673397085092e-05 G_eff=7.78673397085092e-07
Rh5p13m1 in13 h5pm 12842.3547503154
* h5 input 14 w=+0.470073429319239 w+  bank=n alpha=1 R=70910.907220616 G_phys=1.41022028795772e-05 G_eff=1.41022028795772e-05
Rh5p14n1 in14 h5pn 70910.907220616
* h5 input 15 w=+0.188749264833093 w+  bank=n alpha=1 R=176601.129349083 G_phys=5.66247794499279e-06 G_eff=5.66247794499279e-06
Rh5p15n1 in15 h5pn 176601.129349083
* h5 input 16 w=+0.031866913791992 w+  bank=m alpha=0.01 R=10460.1699276288 G_phys=9.56007413759761e-05 G_eff=9.56007413759761e-07
Rh5p16m1 in16 h5pm 10460.1699276288
* h5 bias=+0.0181393489298792 b+  bank=m alpha=0.01 R=18376.2567566174 G_phys=5.44180467896375e-05 G_eff=5.44180467896375e-07
Rh5bpm1 vref h5pm 18376.2567566174
Vh5nm h5nm 0 DC 0
Fh5nm h5d 0 Vh5nm 0.01
Vh5nn h5nn 0 DC 0
Fh5nn h5d 0 Vh5nn 1
Vh5pm h5pm 0 DC 0
Fh5pm 0 h5d Vh5pm 0.01
Vh5pn h5pn 0 DC 0
Fh5pn 0 h5d Vh5pn 1
Vh5d h5d 0 DC 0
Hh5 h5lin 0 Vh5d 33333.3333333333
Eh5 h5buf 0 h5lin 0 1

* h6 input 1 w=-0.340583473625464 w-  bank=n alpha=1 R=97871.2589266431 G_phys=1.02175042087639e-05 G_eff=1.02175042087639e-05
Rh6n1n1 in1 h6nn 97871.2589266431
* h6 input 2 w=-0.593797589144587 w-  bank=n alpha=1 R=56135.8515809279 G_phys=1.78139276743376e-05 G_eff=1.78139276743376e-05
Rh6n2n1 in2 h6nn 56135.8515809279
* h6 input 3 w=-0.388639564922933 w-  bank=n alpha=1 R=85769.2740057059 G_phys=1.1659186947688e-05 G_eff=1.1659186947688e-05
Rh6n3n1 in3 h6nn 85769.2740057059
* h6 input 4 w=+0.284617429170421 w+  bank=n alpha=1 R=117116.275803947 G_phys=8.53852287511263e-06 G_eff=8.53852287511263e-06
Rh6p4n1 in4 h6pn 117116.275803947
* h6 input 5 w=-0.270576674342045 w-  bank=n alpha=1 R=123193.669278364 G_phys=8.11730023026134e-06 G_eff=8.11730023026134e-06
Rh6n5n1 in5 h6nn 123193.669278364
* h6 input 6 w=+0.0593082278184784 w+  bank=n alpha=1 R=562035.565037534 G_phys=1.77924683455435e-06 G_eff=1.77924683455435e-06
Rh6p6n1 in6 h6pn 562035.565037534
* h6 input 7 w=+0.460681196235491 w+  bank=n alpha=1 R=72356.6179946576 G_phys=1.38204358870647e-05 G_eff=1.38204358870647e-05
Rh6p7n1 in7 h6pn 72356.6179946576
* h6 input 8 w=+0.530418434730864 w+  bank=n alpha=1 R=62843.46687582 G_phys=1.59125530419259e-05 G_eff=1.59125530419259e-05
Rh6p8n1 in8 h6pn 62843.46687582
* h6 input 9 w=+0.069052799324409 w+  bank=n alpha=1 R=482722.40458687 G_phys=2.07158397973227e-06 G_eff=2.07158397973227e-06
Rh6p9n1 in9 h6pn 482722.40458687
* h6 input 10 w=+0.150678240315211 w+  bank=n alpha=1 R=221221.944612585 G_phys=4.52034720945633e-06 G_eff=4.52034720945633e-06
Rh6p10n1 in10 h6pn 221221.944612585
* h6 input 11 w=+0.0896190095447204 w+  bank=n alpha=1 R=371944.897658123 G_phys=2.68857028634161e-06 G_eff=2.68857028634161e-06
Rh6p11n1 in11 h6pn 371944.897658123
* h6 input 12 w=-0.177342454994274 w-  bank=n alpha=1 R=187960.256524077 G_phys=5.32027364982823e-06 G_eff=5.32027364982823e-06
Rh6n12n1 in12 h6nn 187960.256524077
* h6 input 13 w=+0.643544080066549 w+  bank=n alpha=1 R=51796.5037140678 G_phys=1.93063224019965e-05 G_eff=1.93063224019965e-05
Rh6p13n1 in13 h6pn 51796.5037140678
* h6 input 14 w=+0.0993069474158396 w+  bank=n alpha=1 R=335659.63108052 G_phys=2.97920842247519e-06 G_eff=2.97920842247519e-06
Rh6p14n1 in14 h6pn 335659.63108052
* h6 input 15 w=-0.324176483950696 w-  bank=n alpha=1 R=102824.649484455 G_phys=9.72529451852089e-06 G_eff=9.72529451852089e-06
Rh6n15n1 in15 h6nn 102824.649484455
* h6 input 16 w=+0.0932186969347454 w+  bank=n alpha=1 R=357582.056276406 G_phys=2.79656090804236e-06 G_eff=2.79656090804236e-06
Rh6p16n1 in16 h6pn 357582.056276406
* h6 bias=-0.0198556852101353 b-  bank=m alpha=0.01 R=16787.8030803583 G_phys=5.95670556304058e-05 G_eff=5.95670556304058e-07
Rh6bnm1 vref h6nm 16787.8030803583
Vh6nm h6nm 0 DC 0
Fh6nm h6d 0 Vh6nm 0.01
Vh6nn h6nn 0 DC 0
Fh6nn h6d 0 Vh6nn 1
Vh6pn h6pn 0 DC 0
Fh6pn 0 h6d Vh6pn 1
Vh6d h6d 0 DC 0
Hh6 h6lin 0 Vh6d 33333.3333333333
Eh6 h6buf 0 h6lin 0 1

* h7 input 1 w=+0.32217720874051 w+  bank=n alpha=1 R=103462.729296227 G_phys=9.6653162622153e-06 G_eff=9.6653162622153e-06
Rh7p1n1 in1 h7pn 103462.729296227
* h7 input 2 w=-0.146738476402048 w-  bank=n alpha=1 R=227161.50631143 G_phys=4.40215429206143e-06 G_eff=4.40215429206143e-06
Rh7n2n1 in2 h7nn 227161.50631143
* h7 input 3 w=+0.524171111363509 w+  bank=n alpha=1 R=63592.4655340589 G_phys=1.57251333409053e-05 G_eff=1.57251333409053e-05
Rh7p3n1 in3 h7pn 63592.4655340589
* h7 input 4 w=-0.439531494343149 w-  bank=n alpha=1 R=75838.3273151968 G_phys=1.31859448302945e-05 G_eff=1.31859448302945e-05
Rh7n4n1 in4 h7nn 75838.3273151968
* h7 input 5 w=+0.367500929015048 w+  bank=n alpha=1 R=90702.718555491 G_phys=1.10250278704514e-05 G_eff=1.10250278704514e-05
Rh7p5n1 in5 h7pn 90702.718555491
* h7 input 6 w=-1.05409273633464 w-  bank=n alpha=1 R=31622.7711133294 G_phys=3.16227820900391e-05 G_eff=3.16227820900391e-05
Rh7n6n1 in6 h7nn 31622.7711133294
* h7 input 7 w=-0.045065971974084 w-  bank=n alpha=1 R=739656.372051673 G_phys=1.35197915922252e-06 G_eff=1.35197915922252e-06
Rh7n7n1 in7 h7nn 739656.372051673
* h7 input 8 w=-0.167915862386558 w-  bank=n alpha=1 R=198512.117077998 G_phys=5.03747587159673e-06 G_eff=5.03747587159673e-06
Rh7n8n1 in8 h7nn 198512.117077998
* h7 input 9 w=+0.0197430594045346 w+  bank=m alpha=0.01 R=16883.5703982521 G_phys=5.92291782136037e-05 G_eff=5.92291782136037e-07
Rh7p9m1 in9 h7pm 16883.5703982521
* h7 input 10 w=-0.287534460104587 w-  bank=n alpha=1 R=115928.133696423 G_phys=8.6260338031376e-06 G_eff=8.6260338031376e-06
Rh7n10n1 in10 h7nn 115928.133696423
* h7 input 11 w=-0.517871662481308 w-  bank=n alpha=1 R=64366.0114044885 G_phys=1.55361498744393e-05 G_eff=1.55361498744393e-05
Rh7n11n1 in11 h7nn 64366.0114044885
* h7 input 12 w=+0.348150035983652 w+  bank=n alpha=1 R=95744.1616777503 G_phys=1.04445010795096e-05 G_eff=1.04445010795096e-05
Rh7p12n1 in12 h7pn 95744.1616777503
* h7 input 13 w=-0.408247593362815 w-  bank=n alpha=1 R=81649.7975132203 G_phys=1.22474278008844e-05 G_eff=1.22474278008844e-05
Rh7n13n1 in13 h7nn 81649.7975132203
* h7 input 14 w=-0.41711419269885 w-  bank=n alpha=1 R=79914.1671916195 G_phys=1.25134257809655e-05 G_eff=1.25134257809655e-05
Rh7n14n1 in14 h7nn 79914.1671916195
* h7 input 15 w=-0.341449872918214 w-  bank=n alpha=1 R=97622.9191372918 G_phys=1.02434961875464e-05 G_eff=1.02434961875464e-05
Rh7n15n1 in15 h7nn 97622.9191372918
* h7 input 16 w=-0.0335582003371702 w-  bank=n alpha=1 R=993299.193592697 G_phys=1.00674601011511e-06 G_eff=1.00674601011511e-06
Rh7n16n1 in16 h7nn 993299.193592697
* h7 bias=-0.0212324287895191 b-  bank=m alpha=0.01 R=15699.2559182808 G_phys=6.36972863685573e-05 G_eff=6.36972863685573e-07
Rh7bnm1 vref h7nm 15699.2559182808
Vh7nm h7nm 0 DC 0
Fh7nm h7d 0 Vh7nm 0.01
Vh7nn h7nn 0 DC 0
Fh7nn h7d 0 Vh7nn 1
Vh7pm h7pm 0 DC 0
Fh7pm 0 h7d Vh7pm 0.01
Vh7pn h7pn 0 DC 0
Fh7pn 0 h7d Vh7pn 1
Vh7d h7d 0 DC 0
Hh7 h7lin 0 Vh7d 33333.3333333333
Eh7 h7buf 0 h7lin 0 1

* h8 input 1 w=+0.185544590700454 w+  bank=n alpha=1 R=179651.334525549 G_phys=5.56633772101363e-06 G_eff=5.56633772101363e-06
Rh8p1n1 in1 h8pn 179651.334525549
* h8 input 2 w=-0.385658106289114 w-  bank=n alpha=1 R=86432.3419882805 G_phys=1.15697431886734e-05 G_eff=1.15697431886734e-05
Rh8n2n1 in2 h8nn 86432.3419882805
* h8 input 3 w=+0.230915543832556 w+  bank=n alpha=1 R=144352.92133259 G_phys=6.92746631497669e-06 G_eff=6.92746631497669e-06
Rh8p3n1 in3 h8pn 144352.92133259
* h8 input 4 w=+0.205353187615931 w+  bank=n alpha=1 R=162321.966950307 G_phys=6.16059562847793e-06 G_eff=6.16059562847793e-06
Rh8p4n1 in4 h8pn 162321.966950307
* h8 input 5 w=+0.00415238713767869 w+  bank=m alpha=0.01 R=80275.1097817138 G_phys=1.24571614130361e-05 G_eff=1.24571614130361e-07
Rh8p5m1 in5 h8pm 80275.1097817138
* h8 input 6 w=-0.514726379917983 w-  bank=n alpha=1 R=64759.3257968335 G_phys=1.54417913975395e-05 G_eff=1.54417913975395e-05
Rh8n6n1 in6 h8nn 64759.3257968335
* h8 input 7 w=+0.210716479044664 w+  bank=n alpha=1 R=158190.443787113 G_phys=6.32149437133992e-06 G_eff=6.32149437133992e-06
Rh8p7n1 in7 h8pn 158190.443787113
* h8 input 8 w=+0.375574589425665 w+  bank=n alpha=1 R=88752.8982839526 G_phys=1.126723768277e-05 G_eff=1.126723768277e-05
Rh8p8n1 in8 h8pn 88752.8982839526
* h8 input 9 w=+0.00572491873576676 w+  bank=m alpha=0.01 R=58224.9895096002 G_phys=1.71747562073003e-05 G_eff=1.71747562073003e-07
Rh8p9m1 in9 h8pm 58224.9895096002
* h8 input 10 w=-0.367556769900021 w-  bank=n alpha=1 R=90688.9385887256 G_phys=1.10267030970006e-05 G_eff=1.10267030970006e-05
Rh8n10n1 in10 h8nn 90688.9385887256
* h8 input 11 w=+0.41225604099869 w+  bank=n alpha=1 R=80855.9002618455 G_phys=1.23676812299607e-05 G_eff=1.23676812299607e-05
Rh8p11n1 in11 h8pn 80855.9002618455
* h8 input 12 w=+0.21126612483399 w+  bank=n alpha=1 R=157778.883668767 G_phys=6.33798374501969e-06 G_eff=6.33798374501969e-06
Rh8p12n1 in12 h8pn 157778.883668767
* h8 input 13 w=+0.318427374873886 w+  bank=n alpha=1 R=104681.117151235 G_phys=9.55282124621658e-06 G_eff=9.55282124621658e-06
Rh8p13n1 in13 h8pn 104681.117151235
* h8 input 14 w=-0.262828471961964 w-  bank=n alpha=1 R=126825.427566909 G_phys=7.88485415885892e-06 G_eff=7.88485415885892e-06
Rh8n14n1 in14 h8nn 126825.427566909
* h8 input 15 w=+0.319620775512722 w+  bank=n alpha=1 R=104290.258603689 G_phys=9.58862326538165e-06 G_eff=9.58862326538165e-06
Rh8p15n1 in15 h8pn 104290.258603689
* h8 input 16 w=+0.15331491024055 w+  bank=n alpha=1 R=217417.427183263 G_phys=4.59944730721651e-06 G_eff=4.59944730721651e-06
Rh8p16n1 in16 h8pn 217417.427183263
* h8 bias=-0.030517345445392 b-  bank=m alpha=0.01 R=10922.7499465772 G_phys=9.1552036336176e-05 G_eff=9.1552036336176e-07
Rh8bnm1 vref h8nm 10922.7499465772
Vh8nm h8nm 0 DC 0
Fh8nm h8d 0 Vh8nm 0.01
Vh8nn h8nn 0 DC 0
Fh8nn h8d 0 Vh8nn 1
Vh8pm h8pm 0 DC 0
Fh8pm 0 h8d Vh8pm 0.01
Vh8pn h8pn 0 DC 0
Fh8pn 0 h8d Vh8pn 1
Vh8d h8d 0 DC 0
Hh8 h8lin 0 Vh8d 33333.3333333333
Eh8 h8buf 0 h8lin 0 1

* h9 input 1 w=-0.192368051906404 w-  bank=n alpha=1 R=173278.946285486 G_phys=5.77104155719211e-06 G_eff=5.77104155719211e-06
Rh9n1n1 in1 h9nn 173278.946285486
* h9 input 2 w=-0.0188071151742732 w-  bank=m alpha=0.01 R=17723.7885898263 G_phys=5.64213455228198e-05 G_eff=5.64213455228198e-07
Rh9n2m1 in2 h9nm 17723.7885898263
* h9 input 3 w=+0.675590388456855 w+  bank=n alpha=1 R=49339.5612235861 G_phys=2.02677116537057e-05 G_eff=2.02677116537057e-05
Rh9p3n1 in3 h9pn 49339.5612235861
* h9 input 4 w=-0.777819910920126 w-  bank=n alpha=1 R=42854.8213607717 G_phys=2.33345973276038e-05 G_eff=2.33345973276038e-05
Rh9n4n1 in4 h9nn 42854.8213607717
* h9 input 5 w=-0.0591658911038067 w-  bank=n alpha=1 R=563387.666634648 G_phys=1.7749767331142e-06 G_eff=1.7749767331142e-06
Rh9n5n1 in5 h9nn 563387.666634648
* h9 input 6 w=-0.373077376819092 w-  bank=n alpha=1 R=89346.9703725748 G_phys=1.11923213045728e-05 G_eff=1.11923213045728e-05
Rh9n6n1 in6 h9nn 89346.9703725748
* h9 input 7 w=+0.173600484730372 w+  bank=n alpha=1 R=192011.752646342 G_phys=5.20801454191117e-06 G_eff=5.20801454191117e-06
Rh9p7n1 in7 h9pn 192011.752646342
* h9 input 8 w=+0.21285190098274 w+  bank=n alpha=1 R=156603.409128286 G_phys=6.38555702948219e-06 G_eff=6.38555702948219e-06
Rh9p8n1 in8 h9pn 156603.409128286
* h9 input 9 w=+0.47939396555815 w+  bank=n alpha=1 R=69532.2338789223 G_phys=1.43818189667445e-05 G_eff=1.43818189667445e-05
Rh9p9n1 in9 h9pn 69532.2338789223
* h9 input 10 w=-0.695860852133009 w-  bank=n alpha=1 R=47902.2971778874 G_phys=2.08758255639903e-05 G_eff=2.08758255639903e-05
Rh9n10n1 in10 h9nn 47902.2971778874
* h9 input 11 w=+0.426719797848979 w+  bank=n alpha=1 R=78115.2726012736 G_phys=1.28015939354694e-05 G_eff=1.28015939354694e-05
Rh9p11n1 in11 h9pn 78115.2726012736
* h9 input 12 w=+0.190883817865507 w+  bank=n alpha=1 R=174626.292087365 G_phys=5.7265145359652e-06 G_eff=5.7265145359652e-06
Rh9p12n1 in12 h9pn 174626.292087365
* h9 input 13 w=-0.203891646942192 w-  bank=n alpha=1 R=163485.526912165 G_phys=6.11674940826577e-06 G_eff=6.11674940826577e-06
Rh9n13n1 in13 h9nn 163485.526912165
* h9 input 14 w=-0.0564974778722501 w-  bank=n alpha=1 R=589996.838597032 G_phys=1.6949243361675e-06 G_eff=1.6949243361675e-06
Rh9n14n1 in14 h9nn 589996.838597032
* h9 input 15 w=-0.251891815788561 w-  bank=n alpha=1 R=132331.942699216 G_phys=7.55675447365683e-06 G_eff=7.55675447365683e-06
Rh9n15n1 in15 h9nn 132331.942699216
* h9 input 16 w=-0.340248378281639 w-  bank=n alpha=1 R=97967.6479331866 G_phys=1.02074513484492e-05 G_eff=1.02074513484492e-05
Rh9n16n1 in16 h9nn 97967.6479331866
* h9 bias=-0.0264599072666679 b-  bank=m alpha=0.01 R=12597.6757958347 G_phys=7.93797218000037e-05 G_eff=7.93797218000037e-07
Rh9bnm1 vref h9nm 12597.6757958347
Vh9nm h9nm 0 DC 0
Fh9nm h9d 0 Vh9nm 0.01
Vh9nn h9nn 0 DC 0
Fh9nn h9d 0 Vh9nn 1
Vh9pn h9pn 0 DC 0
Fh9pn 0 h9d Vh9pn 1
Vh9d h9d 0 DC 0
Hh9 h9lin 0 Vh9d 33333.3333333333
Eh9 h9buf 0 h9lin 0 1

* h10 input 1 w=+0.0856004623316453 w+  bank=n alpha=1 R=389405.996479186 G_phys=2.56801386994936e-06 G_eff=2.56801386994936e-06
Rh10p1n1 in1 h10pn 389405.996479186
* h10 input 2 w=+0.717707405140542 w+  bank=n alpha=1 R=46444.1819808254 G_phys=2.15312221542163e-05 G_eff=2.15312221542163e-05
Rh10p2n1 in2 h10pn 46444.1819808254
* h10 input 3 w=+0.367326370670395 w+  bank=n alpha=1 R=90745.8216857607 G_phys=1.10197911201119e-05 G_eff=1.10197911201119e-05
Rh10p3n1 in3 h10pn 90745.8216857607
* h10 input 4 w=+0.5220921972442 w+  bank=n alpha=1 R=63845.6837878046 G_phys=1.5662765917326e-05 G_eff=1.5662765917326e-05
Rh10p4n1 in4 h10pn 63845.6837878046
* h10 input 5 w=+0.0909071116243784 w+  bank=n alpha=1 R=366674.649955487 G_phys=2.72721334873135e-06 G_eff=2.72721334873135e-06
Rh10p5n1 in5 h10pn 366674.649955487
* h10 input 6 w=-0.0568053629833511 w-  bank=n alpha=1 R=586799.055277631 G_phys=1.70416088950053e-06 G_eff=1.70416088950053e-06
Rh10n6n1 in6 h10nn 586799.055277631
* h10 input 7 w=+0.372078007523385 w+  bank=n alpha=1 R=89586.9485950155 G_phys=1.11623402257016e-05 G_eff=1.11623402257016e-05
Rh10p7n1 in7 h10pn 89586.9485950155
* h10 input 8 w=+0.384900055079612 w+  bank=n alpha=1 R=86602.568363984 G_phys=1.15470016523884e-05 G_eff=1.15470016523884e-05
Rh10p8n1 in8 h10pn 86602.568363984
* h10 input 9 w=+0.617655459577812 w+  bank=n alpha=1 R=53967.5199440765 G_phys=1.85296637873344e-05 G_eff=1.85296637873344e-05
Rh10p9n1 in9 h10pn 53967.5199440765
* h10 input 10 w=+0.306521845436409 w+  bank=n alpha=1 R=108747.007202293 G_phys=9.19565536309227e-06 G_eff=9.19565536309227e-06
Rh10p10n1 in10 h10pn 108747.007202293
* h10 input 11 w=-0.0307901580575706 w-  bank=m alpha=0.01 R=10825.970191841 G_phys=9.23704741727117e-05 G_eff=9.23704741727117e-07
Rh10n11m1 in11 h10nm 10825.970191841
* h10 input 12 w=+0.163538031424557 w+  bank=n alpha=1 R=203826.186746724 G_phys=4.9061409427367e-06 G_eff=4.9061409427367e-06
Rh10p12n1 in12 h10pn 203826.186746724
* h10 input 13 w=-0.0170713095619708 w-  bank=m alpha=0.01 R=19525.9380730749 G_phys=5.12139286859123e-05 G_eff=5.12139286859123e-07
Rh10n13m1 in13 h10nm 19525.9380730749
* h10 input 14 w=-0.123347220224403 w-  bank=n alpha=1 R=270239.842233093 G_phys=3.7004166067321e-06 G_eff=3.7004166067321e-06
Rh10n14n1 in14 h10nn 270239.842233093
* h10 input 15 w=-0.136765368652097 w-  bank=n alpha=1 R=243726.417453869 G_phys=4.10296105956291e-06 G_eff=4.10296105956291e-06
Rh10n15n1 in15 h10nn 243726.417453869
* h10 input 16 w=+0.269183781267177 w+  bank=n alpha=1 R=123831.1356517 G_phys=8.07551343801532e-06 G_eff=8.07551343801532e-06
Rh10p16n1 in16 h10pn 123831.1356517
* h10 bias=-0.0641449868406755 b-  bank=n alpha=1 R=519656.094343386 G_phys=1.92434960522027e-06 G_eff=1.92434960522027e-06
Rh10bnn1 vref h10nn 519656.094343386
Vh10nm h10nm 0 DC 0
Fh10nm h10d 0 Vh10nm 0.01
Vh10nn h10nn 0 DC 0
Fh10nn h10d 0 Vh10nn 1
Vh10pn h10pn 0 DC 0
Fh10pn 0 h10d Vh10pn 1
Vh10d h10d 0 DC 0
Hh10 h10lin 0 Vh10d 33333.3333333333
Eh10 h10buf 0 h10lin 0 1

* h11 input 1 w=+0.100174494534941 w+  bank=n alpha=1 R=332752.69806035 G_phys=3.00523483604823e-06 G_eff=3.00523483604823e-06
Rh11p1n1 in1 h11pn 332752.69806035
* h11 input 2 w=-0.350357054027393 w-  bank=n alpha=1 R=95141.0366943178 G_phys=1.05107116208218e-05 G_eff=1.05107116208218e-05
Rh11n2n1 in2 h11nn 95141.0366943178
* h11 input 3 w=-0.364058373495884 w-  bank=n alpha=1 R=91560.4083302596 G_phys=1.09217512048765e-05 G_eff=1.09217512048765e-05
Rh11n3n1 in3 h11nn 91560.4083302596
* h11 input 4 w=+0.201551043415431 w+  bank=n alpha=1 R=165384.077246515 G_phys=6.04653130246294e-06 G_eff=6.04653130246294e-06
Rh11p4n1 in4 h11pn 165384.077246515
* h11 input 5 w=+0.30370864041576 w+  bank=n alpha=1 R=109754.313501591 G_phys=9.1112592124728e-06 G_eff=9.1112592124728e-06
Rh11p5n1 in5 h11pn 109754.313501591
* h11 input 6 w=+0.221531530750713 w+  bank=n alpha=1 R=150467.670314809 G_phys=6.64594592252139e-06 G_eff=6.64594592252139e-06
Rh11p6n1 in6 h11pn 150467.670314809
* h11 input 7 w=-0.554388667333083 w-  bank=n alpha=1 R=60126.2891856812 G_phys=1.66316600199925e-05 G_eff=1.66316600199925e-05
Rh11n7n1 in7 h11nn 60126.2891856812
* h11 input 8 w=+0.382929077760783 w+  bank=n alpha=1 R=87048.3211362621 G_phys=1.14878723328235e-05 G_eff=1.14878723328235e-05
Rh11p8n1 in8 h11pn 87048.3211362621
* h11 input 9 w=-0.415059943002996 w-  bank=n alpha=1 R=80309.6851316552 G_phys=1.24517982900899e-05 G_eff=1.24517982900899e-05
Rh11n9n1 in9 h11nn 80309.6851316552
* h11 input 10 w=-0.579957638432045 w-  bank=n alpha=1 R=57475.4622138477 G_phys=1.73987291529614e-05 G_eff=1.73987291529614e-05
Rh11n10n1 in10 h11nn 57475.4622138477
* h11 input 11 w=+0.208304459025755 w+  bank=n alpha=1 R=160022.178542092 G_phys=6.24913377077265e-06 G_eff=6.24913377077265e-06
Rh11p11n1 in11 h11pn 160022.178542092
* h11 input 12 w=+0.150185585205542 w+  bank=n alpha=1 R=221947.620923232 G_phys=4.50556755616625e-06 G_eff=4.50556755616625e-06
Rh11p12n1 in12 h11pn 221947.620923232
* h11 input 13 w=-0.130595100347527 w-  bank=n alpha=1 R=255241.837133476 G_phys=3.9178530104258e-06 G_eff=3.9178530104258e-06
Rh11n13n1 in13 h11nn 255241.837133476
* h11 input 14 w=+0.223944918125423 w+  bank=n alpha=1 R=148846.125254178 G_phys=6.71834754376269e-06 G_eff=6.71834754376269e-06
Rh11p14n1 in14 h11pn 148846.125254178
* h11 input 15 w=+0.219816736012751 w+  bank=n alpha=1 R=151641.471609331 G_phys=6.59450208038254e-06 G_eff=6.59450208038254e-06
Rh11p15n1 in15 h11pn 151641.471609331
* h11 input 16 w=-0.0825561420887272 w-  bank=n alpha=1 R=403765.637419301 G_phys=2.47668426266182e-06 G_eff=2.47668426266182e-06
Rh11n16n1 in16 h11nn 403765.637419301
* h11 bias=-0.0111908465565794 b-  bank=m alpha=0.01 R=29786.2482206369 G_phys=3.35725396697381e-05 G_eff=3.35725396697381e-07
Rh11bnm1 vref h11nm 29786.2482206369
Vh11nm h11nm 0 DC 0
Fh11nm h11d 0 Vh11nm 0.01
Vh11nn h11nn 0 DC 0
Fh11nn h11d 0 Vh11nn 1
Vh11pn h11pn 0 DC 0
Fh11pn 0 h11d Vh11pn 1
Vh11d h11d 0 DC 0
Hh11 h11lin 0 Vh11d 33333.3333333333
Eh11 h11buf 0 h11lin 0 1

* h12 input 1 w=-0.0647804813106503 w-  bank=n alpha=1 R=514558.284516066 G_phys=1.94341443931951e-06 G_eff=1.94341443931951e-06
Rh12n1n1 in1 h12nn 514558.284516066
* h12 input 2 w=-0.668825239918342 w-  bank=n alpha=1 R=49838.6295011879 G_phys=2.00647571975503e-05 G_eff=2.00647571975503e-05
Rh12n2n1 in2 h12nn 49838.6295011879
* h12 input 3 w=+0.43152134817872 w+  bank=n alpha=1 R=77246.0817385283 G_phys=1.29456404453616e-05 G_eff=1.29456404453616e-05
Rh12p3n1 in3 h12pn 77246.0817385283
* h12 input 4 w=+0.0766102486579458 w+  bank=n alpha=1 R=435102.795216892 G_phys=2.29830745973837e-06 G_eff=2.29830745973837e-06
Rh12p4n1 in4 h12pn 435102.795216892
* h12 input 5 w=+0.112143595115044 w+  bank=n alpha=1 R=297237.959057206 G_phys=3.36430785345132e-06 G_eff=3.36430785345132e-06
Rh12p5n1 in5 h12pn 297237.959057206
* h12 input 6 w=-0.214387519256146 w-  bank=n alpha=1 R=155481.687781961 G_phys=6.43162557768439e-06 G_eff=6.43162557768439e-06
Rh12n6n1 in6 h12nn 155481.687781961
* h12 input 7 w=+0.0362945018752433 w+  bank=n alpha=1 R=918412.751548746 G_phys=1.0888350562573e-06 G_eff=1.0888350562573e-06
Rh12p7n1 in7 h12pn 918412.751548746
* h12 input 8 w=-0.654320698371061 w-  bank=n alpha=1 R=50943.4187491196 G_phys=1.96296209511318e-05 G_eff=1.96296209511318e-05
Rh12n8n1 in8 h12nn 50943.4187491196
* h12 input 9 w=-0.424313635659581 w-  bank=n alpha=1 R=78558.2421397273 G_phys=1.27294090697874e-05 G_eff=1.27294090697874e-05
Rh12n9n1 in9 h12nn 78558.2421397273
* h12 input 10 w=-0.147731830075345 w-  bank=n alpha=1 R=225634.064888609 G_phys=4.43195490226035e-06 G_eff=4.43195490226035e-06
Rh12n10n1 in10 h12nn 225634.064888609
* h12 input 11 w=+0.422841356490785 w+  bank=n alpha=1 R=78831.7718256581 G_phys=1.26852406947236e-05 G_eff=1.26852406947236e-05
Rh12p11n1 in11 h12pn 78831.7718256581
* h12 input 12 w=+0.250573650346706 w+  bank=n alpha=1 R=133028.086900644 G_phys=7.51720951040119e-06 G_eff=7.51720951040119e-06
Rh12p12n1 in12 h12pn 133028.086900644
* h12 input 13 w=+0.0601122436783251 w+  bank=n alpha=1 R=554518.202842467 G_phys=1.80336731034975e-06 G_eff=1.80336731034975e-06
Rh12p13n1 in13 h12pn 554518.202842467
* h12 input 14 w=-0.651755086554606 w-  bank=n alpha=1 R=51143.9557910386 G_phys=1.95526525966382e-05 G_eff=1.95526525966382e-05
Rh12n14n1 in14 h12nn 51143.9557910386
* h12 input 15 w=+0.130109285988943 w+  bank=n alpha=1 R=256194.88324735 G_phys=3.90327857966829e-06 G_eff=3.90327857966829e-06
Rh12p15n1 in15 h12pn 256194.88324735
* h12 input 16 w=-0.0778767908450736 w-  bank=n alpha=1 R=428026.54002071 G_phys=2.33630372535221e-06 G_eff=2.33630372535221e-06
Rh12n16n1 in16 h12nn 428026.54002071
* h12 bias=+0.0176157808963936 b+  bank=m alpha=0.01 R=18922.4272993526 G_phys=5.28473426891809e-05 G_eff=5.28473426891809e-07
Rh12bpm1 vref h12pm 18922.4272993526
Vh12nn h12nn 0 DC 0
Fh12nn h12d 0 Vh12nn 1
Vh12pm h12pm 0 DC 0
Fh12pm 0 h12d Vh12pm 0.01
Vh12pn h12pn 0 DC 0
Fh12pn 0 h12d Vh12pn 1
Vh12d h12d 0 DC 0
Hh12 h12lin 0 Vh12d 33333.3333333333
Eh12 h12buf 0 h12lin 0 1

* h13 input 1 w=+0.034343742118514 w+  bank=n alpha=1 R=970579.537264929 G_phys=1.03031226355542e-06 G_eff=1.03031226355542e-06
Rh13p1n1 in1 h13pn 970579.537264929
* h13 input 2 w=-0.102232912320493 w-  bank=n alpha=1 R=326052.858876169 G_phys=3.06698736961478e-06 G_eff=3.06698736961478e-06
Rh13n2n1 in2 h13nn 326052.858876169
* h13 input 3 w=+1.31993068300228 w+  bank=n alpha=1 R=25253.8514049194 G_phys=3.95979204900683e-05 G_eff=3.95979204900683e-05
Rh13p3n1 in3 h13pn 25253.8514049194
* h13 input 4 w=-0.233319639483811 w-  bank=n alpha=1 R=142865.527338714 G_phys=6.99958918451433e-06 G_eff=6.99958918451433e-06
Rh13n4n1 in4 h13nn 142865.527338714
* h13 input 5 w=-0.375430599339701 w-  bank=n alpha=1 R=88786.9379639253 G_phys=1.1262917980191e-05 G_eff=1.1262917980191e-05
Rh13n5n1 in5 h13nn 88786.9379639253
* h13 input 6 w=+0.442115486842334 w+  bank=n alpha=1 R=75395.0818855177 G_phys=1.326346460527e-05 G_eff=1.326346460527e-05
Rh13p6n1 in6 h13pn 75395.0818855177
* h13 input 7 w=-0.102130412545238 w-  bank=n alpha=1 R=326380.090930979 G_phys=3.06391237635715e-06 G_eff=3.06391237635715e-06
Rh13n7n1 in7 h13nn 326380.090930979
* h13 input 8 w=-0.136235661297007 w-  bank=n alpha=1 R=244674.067098066 G_phys=4.08706983891021e-06 G_eff=4.08706983891021e-06
Rh13n8n1 in8 h13nn 244674.067098066
* h13 input 9 w=+0.0915800560074952 w+  bank=n alpha=1 R=363980.268046628 G_phys=2.74740168022485e-06 G_eff=2.74740168022485e-06
Rh13p9n1 in9 h13pn 363980.268046628
* h13 input 10 w=-0.194905587913072 w-  bank=n alpha=1 R=171022.974201232 G_phys=5.84716763739217e-06 G_eff=5.84716763739217e-06
Rh13n10n1 in10 h13nn 171022.974201232
* h13 input 11 w=-0.611958537828416 w-  bank=n alpha=1 R=54469.9212002489 G_phys=1.83587561348525e-05 G_eff=1.83587561348525e-05
Rh13n11n1 in11 h13nn 54469.9212002489
* h13 input 12 w=+0.19411196838682 w+  bank=n alpha=1 R=171722.195237894 G_phys=5.8233590516046e-06 G_eff=5.8233590516046e-06
Rh13p12n1 in12 h13pn 171722.195237894
* h13 input 13 w=+0.146421986160596 w+  bank=n alpha=1 R=227652.514539539 G_phys=4.39265958481789e-06 G_eff=4.39265958481789e-06
Rh13p13n1 in13 h13pn 227652.514539539
* h13 input 14 w=+0.246088955287688 w+  bank=n alpha=1 R=135452.374505655 G_phys=7.38266865863065e-06 G_eff=7.38266865863065e-06
Rh13p14n1 in14 h13pn 135452.374505655
* h13 input 15 w=-0.101801651380703 w-  bank=n alpha=1 R=327434.112131228 G_phys=3.05404954142109e-06 G_eff=3.05404954142109e-06
Rh13n15n1 in15 h13nn 327434.112131228
* h13 input 16 w=-0.212672591801914 w-  bank=n alpha=1 R=156735.445084435 G_phys=6.38017775405741e-06 G_eff=6.38017775405741e-06
Rh13n16n1 in16 h13nn 156735.445084435
* h13 bias=+0.0212362032828689 b+  bank=m alpha=0.01 R=15696.4655542844 G_phys=6.37086098486067e-05 G_eff=6.37086098486067e-07
Rh13bpm1 vref h13pm 15696.4655542844
Vh13nn h13nn 0 DC 0
Fh13nn h13d 0 Vh13nn 1
Vh13pm h13pm 0 DC 0
Fh13pm 0 h13d Vh13pm 0.01
Vh13pn h13pn 0 DC 0
Fh13pn 0 h13d Vh13pn 1
Vh13d h13d 0 DC 0
Hh13 h13lin 0 Vh13d 33333.3333333333
Eh13 h13buf 0 h13lin 0 1

* h14 input 1 w=-0.089975491938664 w-  bank=n alpha=1 R=370471.254061679 G_phys=2.69926475815992e-06 G_eff=2.69926475815992e-06
Rh14n1n1 in1 h14nn 370471.254061679
* h14 input 2 w=-0.0792638889786837 w-  bank=n alpha=1 R=420536.183157725 G_phys=2.37791666936051e-06 G_eff=2.37791666936051e-06
Rh14n2n1 in2 h14nn 420536.183157725
* h14 input 3 w=-0.392380373690676 w-  bank=n alpha=1 R=84951.5815987547 G_phys=1.17714112107203e-05 G_eff=1.17714112107203e-05
Rh14n3n1 in3 h14nn 84951.5815987547
* h14 input 4 w=+0.471386854681532 w+  bank=n alpha=1 R=70713.3281343902 G_phys=1.4141605640446e-05 G_eff=1.4141605640446e-05
Rh14p4n1 in4 h14pn 70713.3281343902
* h14 input 5 w=-0.118903138220599 w-  bank=n alpha=1 R=280340.231823744 G_phys=3.56709414661796e-06 G_eff=3.56709414661796e-06
Rh14n5n1 in5 h14nn 280340.231823744
* h14 input 6 w=+0.618408634475196 w+  bank=n alpha=1 R=53901.7915906385 G_phys=1.85522590342559e-05 G_eff=1.85522590342559e-05
Rh14p6n1 in6 h14pn 53901.7915906385
* h14 input 7 w=-0.0462466843022721 w-  bank=n alpha=1 R=720772.393442608 G_phys=1.38740052906816e-06 G_eff=1.38740052906816e-06
Rh14n7n1 in7 h14nn 720772.393442608
* h14 input 8 w=-0.0297824475583231 w-  bank=m alpha=0.01 R=11192.2746671698 G_phys=8.93473426749692e-05 G_eff=8.93473426749692e-07
Rh14n8m1 in8 h14nm 11192.2746671698
* h14 input 9 w=+0.0766531636417715 w+  bank=n alpha=1 R=434859.198885937 G_phys=2.29959490925314e-06 G_eff=2.29959490925314e-06
Rh14p9n1 in9 h14pn 434859.198885937
* h14 input 10 w=-0.0192124865162136 w-  bank=m alpha=0.01 R=17349.8278347277 G_phys=5.76374595486407e-05 G_eff=5.76374595486407e-07
Rh14n10m1 in10 h14nm 17349.8278347277
* h14 input 11 w=-0.118584174544602 w-  bank=n alpha=1 R=281094.281436313 G_phys=3.55752523633807e-06 G_eff=3.55752523633807e-06
Rh14n11n1 in11 h14nn 281094.281436313
* h14 input 12 w=+0.498792575097448 w+  bank=n alpha=1 R=66828.0463613979 G_phys=1.49637772529234e-05 G_eff=1.49637772529234e-05
Rh14p12n1 in12 h14pn 66828.0463613979
* h14 input 13 w=+0.131240430694277 w+  bank=n alpha=1 R=253986.771888785 G_phys=3.93721292082832e-06 G_eff=3.93721292082832e-06
Rh14p13n1 in13 h14pn 253986.771888785
* h14 input 14 w=-0.699789872634837 w-  bank=n alpha=1 R=47633.346289833 G_phys=2.09936961790451e-05 G_eff=2.09936961790451e-05
Rh14n14n1 in14 h14nn 47633.346289833
* h14 input 15 w=+0.0882030102342884 w+  bank=n alpha=1 R=377916.051218569 G_phys=2.64609030702865e-06 G_eff=2.64609030702865e-06
Rh14p15n1 in15 h14pn 377916.051218569
* h14 input 16 w=-0.409062788225599 w-  bank=n alpha=1 R=81487.082894839 G_phys=1.2271883646768e-05 G_eff=1.2271883646768e-05
Rh14n16n1 in16 h14nn 81487.082894839
* h14 bias=+0.0824693880781811 b+  bank=n alpha=1 R=404190.380335226 G_phys=2.47408164234543e-06 G_eff=2.47408164234543e-06
Rh14bpn1 vref h14pn 404190.380335226
Vh14nm h14nm 0 DC 0
Fh14nm h14d 0 Vh14nm 0.01
Vh14nn h14nn 0 DC 0
Fh14nn h14d 0 Vh14nn 1
Vh14pn h14pn 0 DC 0
Fh14pn 0 h14d Vh14pn 1
Vh14d h14d 0 DC 0
Hh14 h14lin 0 Vh14d 33333.3333333333
Eh14 h14buf 0 h14lin 0 1

* h15 input 1 w=-0.104362920527351 w-  bank=n alpha=1 R=319398.241874589 G_phys=3.13088761582053e-06 G_eff=3.13088761582053e-06
Rh15n1n1 in1 h15nn 319398.241874589
* h15 input 2 w=+0.0920701784982539 w+  bank=n alpha=1 R=362042.670895501 G_phys=2.76210535494762e-06 G_eff=2.76210535494762e-06
Rh15p2n1 in2 h15pn 362042.670895501
* h15 input 3 w=+0.710914651543076 w+  bank=n alpha=1 R=46887.9537944276 G_phys=2.13274395462923e-05 G_eff=2.13274395462923e-05
Rh15p3n1 in3 h15pn 46887.9537944276
* h15 input 4 w=+0.0431405504557543 w+  bank=n alpha=1 R=772668.243246468 G_phys=1.29421651367263e-06 G_eff=1.29421651367263e-06
Rh15p4n1 in4 h15pn 772668.243246468
* h15 input 5 w=-0.544653793286569 w-  bank=n alpha=1 R=61200.9569091444 G_phys=1.63396137985971e-05 G_eff=1.63396137985971e-05
Rh15n5n1 in5 h15nn 61200.9569091444
* h15 input 6 w=+0.236607896967987 w+  bank=n alpha=1 R=140880.054133795 G_phys=7.0982369090396e-06 G_eff=7.0982369090396e-06
Rh15p6n1 in6 h15pn 140880.054133795
* h15 input 7 w=+0.205722108048513 w+  bank=n alpha=1 R=162030.875774774 G_phys=6.17166324145539e-06 G_eff=6.17166324145539e-06
Rh15p7n1 in7 h15pn 162030.875774774
* h15 input 8 w=+0.119910326826568 w+  bank=n alpha=1 R=277985.509801377 G_phys=3.59730980479705e-06 G_eff=3.59730980479705e-06
Rh15p8n1 in8 h15pn 277985.509801377
* h15 input 9 w=-0.0351999996705356 w-  bank=n alpha=1 R=946969.705833129 G_phys=1.05599999011607e-06 G_eff=1.05599999011607e-06
Rh15n9n1 in9 h15nn 946969.705833129
* h15 input 10 w=-0.0279846802936883 w-  bank=m alpha=0.01 R=11911.2789510236 G_phys=8.39540408810648e-05 G_eff=8.39540408810648e-07
Rh15n10m1 in10 h15nm 11911.2789510236
* h15 input 11 w=-0.155672537202176 w-  bank=n alpha=1 R=214124.68719542 G_phys=4.67017611606528e-06 G_eff=4.67017611606528e-06
Rh15n11n1 in11 h15nn 214124.68719542
* h15 input 12 w=-0.248740189524738 w-  bank=n alpha=1 R=134008.635263254 G_phys=7.46220568574215e-06 G_eff=7.46220568574215e-06
Rh15n12n1 in12 h15nn 134008.635263254
* h15 input 13 w=+0.142944744841187 w+  bank=n alpha=1 R=233190.337779587 G_phys=4.28834234523561e-06 G_eff=4.28834234523561e-06
Rh15p13n1 in13 h15pn 233190.337779587
* h15 input 14 w=-0.364164748984914 w-  bank=n alpha=1 R=91533.6627892949 G_phys=1.09249424695474e-05 G_eff=1.09249424695474e-05
Rh15n14n1 in14 h15nn 91533.6627892949
* h15 input 15 w=-0.240848341925517 w-  bank=n alpha=1 R=138399.679511357 G_phys=7.22545025776552e-06 G_eff=7.22545025776552e-06
Rh15n15n1 in15 h15nn 138399.679511357
* h15 input 16 w=-0.736896288827917 w-  bank=n alpha=1 R=45234.7689066968 G_phys=2.21068886648375e-05 G_eff=2.21068886648375e-05
Rh15n16n1 in16 h15nn 45234.7689066968
* h15 bias=+0.00140769830063221 b+  bank=m alpha=0.01 R=236793.163125671 G_phys=4.22309490189663e-06 G_eff=4.22309490189663e-08
Rh15bpm1 vref h15pm 236793.163125671
Vh15nm h15nm 0 DC 0
Fh15nm h15d 0 Vh15nm 0.01
Vh15nn h15nn 0 DC 0
Fh15nn h15d 0 Vh15nn 1
Vh15pm h15pm 0 DC 0
Fh15pm 0 h15d Vh15pm 0.01
Vh15pn h15pn 0 DC 0
Fh15pn 0 h15d Vh15pn 1
Vh15d h15d 0 DC 0
Hh15 h15lin 0 Vh15d 33333.3333333333
Eh15 h15buf 0 h15lin 0 1

* h16 input 1 w=-0.211528252190937 w-  bank=n alpha=1 R=157583.362922343 G_phys=6.3458475657281e-06 G_eff=6.3458475657281e-06
Rh16n1n1 in1 h16nn 157583.362922343
* h16 input 2 w=-0.194947045242045 w-  bank=n alpha=1 R=170986.604551748 G_phys=5.84841135726135e-06 G_eff=5.84841135726135e-06
Rh16n2n1 in2 h16nn 170986.604551748
* h16 input 3 w=-0.281660896127353 w-  bank=n alpha=1 R=118345.619827403 G_phys=8.44982688382059e-06 G_eff=8.44982688382059e-06
Rh16n3n1 in3 h16nn 118345.619827403
* h16 input 4 w=-0.246854224570453 w-  bank=n alpha=1 R=135032.460519305 G_phys=7.4056267371136e-06 G_eff=7.4056267371136e-06
Rh16n4n1 in4 h16nn 135032.460519305
* h16 input 5 w=+0.785179968580328 w+  bank=n alpha=1 R=42453.112238208 G_phys=2.35553990574098e-05 G_eff=2.35553990574098e-05
Rh16p5n1 in5 h16pn 42453.112238208
* h16 input 6 w=-0.342055263707418 w-  bank=n alpha=1 R=97450.1399921314 G_phys=1.02616579112226e-05 G_eff=1.02616579112226e-05
Rh16n6n1 in6 h16nn 97450.1399921314
* h16 input 7 w=-0.213390213186068 w-  bank=n alpha=1 R=156208.351056231 G_phys=6.40170639558203e-06 G_eff=6.40170639558203e-06
Rh16n7n1 in7 h16nn 156208.351056231
* h16 input 8 w=-0.06183287092446 w-  bank=n alpha=1 R=539087.589415927 G_phys=1.8549861277338e-06 G_eff=1.8549861277338e-06
Rh16n8n1 in8 h16nn 539087.589415927
* h16 input 9 w=+0.114369297885863 w+  bank=n alpha=1 R=291453.510247121 G_phys=3.43107893657588e-06 G_eff=3.43107893657588e-06
Rh16p9n1 in9 h16pn 291453.510247121
* h16 input 10 w=+0.418702574206734 w+  bank=n alpha=1 R=79611.0064440994 G_phys=1.2561077226202e-05 G_eff=1.2561077226202e-05
Rh16p10n1 in10 h16pn 79611.0064440994
* h16 input 11 w=-0.38263995973155 w-  bank=n alpha=1 R=87114.0937729534 G_phys=1.14791987919465e-05 G_eff=1.14791987919465e-05
Rh16n11n1 in11 h16nn 87114.0937729534
* h16 input 12 w=-0.447982918675276 w-  bank=n alpha=1 R=74407.5989144918 G_phys=1.34394875602583e-05 G_eff=1.34394875602583e-05
Rh16n12n1 in12 h16nn 74407.5989144918
* h16 input 13 w=-0.354860709093241 w-  bank=n alpha=1 R=93933.5702126856 G_phys=1.06458212727972e-05 G_eff=1.06458212727972e-05
Rh16n13n1 in13 h16nn 93933.5702126856
* h16 input 14 w=-0.245379266072843 w-  bank=n alpha=1 R=135844.131685674 G_phys=7.36137798218528e-06 G_eff=7.36137798218528e-06
Rh16n14n1 in14 h16nn 135844.131685674
* h16 input 15 w=-0.0999148922371372 w-  bank=n alpha=1 R=333617.267526249 G_phys=2.99744676711412e-06 G_eff=2.99744676711412e-06
Rh16n15n1 in15 h16nn 333617.267526249
* h16 input 16 w=-0.428765175056332 w-  bank=n alpha=1 R=77742.632267077 G_phys=1.286295525169e-05 G_eff=1.286295525169e-05
Rh16n16n1 in16 h16nn 77742.632267077
* h16 bias=+0.0857431075924666 b+  bank=n alpha=1 R=388758.166916054 G_phys=2.572293227774e-06 G_eff=2.572293227774e-06
Rh16bpn1 vref h16pn 388758.166916054
Vh16nn h16nn 0 DC 0
Fh16nn h16d 0 Vh16nn 1
Vh16pn h16pn 0 DC 0
Fh16pn 0 h16d Vh16pn 1
Vh16d h16d 0 DC 0
Hh16 h16lin 0 Vh16d 33333.3333333333
Eh16 h16buf 0 h16lin 0 1

* h17 input 1 w=+0.690050155404084 w+  bank=n alpha=1 R=48305.667453714 G_phys=2.07015046621225e-05 G_eff=2.07015046621225e-05
Rh17p1n1 in1 h17pn 48305.667453714
* h17 input 2 w=-0.128803090681736 w-  bank=n alpha=1 R=258792.961852894 G_phys=3.86409272045207e-06 G_eff=3.86409272045207e-06
Rh17n2n1 in2 h17nn 258792.961852894
* h17 input 3 w=-0.49836012605351 w-  bank=n alpha=1 R=66886.036002315 G_phys=1.49508037816053e-05 G_eff=1.49508037816053e-05
Rh17n3n1 in3 h17nn 66886.036002315
* h17 input 4 w=-0.0597081457071854 w-  bank=n alpha=1 R=558271.119267432 G_phys=1.79124437121556e-06 G_eff=1.79124437121556e-06
Rh17n4n1 in4 h17nn 558271.119267432
* h17 input 5 w=+0.0531710366485299 w+  bank=n alpha=1 R=626907.71958562 G_phys=1.5951310994559e-06 G_eff=1.5951310994559e-06
Rh17p5n1 in5 h17pn 626907.71958562
* h17 input 6 w=+0.325686197829899 w+  bank=n alpha=1 R=102348.007239603 G_phys=9.77058593489698e-06 G_eff=9.77058593489698e-06
Rh17p6n1 in6 h17pn 102348.007239603
* h17 input 7 w=-0.138446110206034 w-  bank=n alpha=1 R=240767.568577601 G_phys=4.15338330618101e-06 G_eff=4.15338330618101e-06
Rh17n7n1 in7 h17nn 240767.568577601
* h17 input 8 w=-0.354640771144099 w-  bank=n alpha=1 R=93991.8250961316 G_phys=1.0639223134323e-05 G_eff=1.0639223134323e-05
Rh17n8n1 in8 h17nn 93991.8250961316
* h17 input 9 w=+0.283153126675736 w+  bank=n alpha=1 R=117721.932738911 G_phys=8.49459380027208e-06 G_eff=8.49459380027208e-06
Rh17p9n1 in9 h17pn 117721.932738911
* h17 input 10 w=+0.187509087652136 w+  bank=n alpha=1 R=177769.161754831 G_phys=5.62527262956408e-06 G_eff=5.62527262956408e-06
Rh17p10n1 in10 h17pn 177769.161754831
* h17 input 11 w=+0.286891884918939 w+  bank=n alpha=1 R=116187.78740553 G_phys=8.60675654756817e-06 G_eff=8.60675654756817e-06
Rh17p11n1 in11 h17pn 116187.78740553
* h17 input 12 w=-0.663420236101193 w-  bank=n alpha=1 R=50244.6737670041 G_phys=1.99026070830358e-05 G_eff=1.99026070830358e-05
Rh17n12n1 in12 h17nn 50244.6737670041
* h17 input 13 w=-0.00672050178940724 w-  bank=m alpha=0.01 R=49599.4709589586 G_phys=2.01615053682217e-05 G_eff=2.01615053682217e-07
Rh17n13m1 in13 h17nm 49599.4709589586
* h17 input 14 w=+0.213870810385993 w+  bank=n alpha=1 R=155857.32935305 G_phys=6.41612431157979e-06 G_eff=6.41612431157979e-06
Rh17p14n1 in14 h17pn 155857.32935305
* h17 input 15 w=+0.856655380645102 w+  bank=n alpha=1 R=38911.0184637278 G_phys=2.56996614193531e-05 G_eff=2.56996614193531e-05
Rh17p15n1 in15 h17pn 38911.0184637278
* h17 input 16 w=-0.153994690926048 w-  bank=n alpha=1 R=216457.6787218 G_phys=4.61984072778143e-06 G_eff=4.61984072778143e-06
Rh17n16n1 in16 h17nn 216457.6787218
* h17 bias=+0.0931053836114148 b+  bank=n alpha=1 R=358017.249275869 G_phys=2.79316150834244e-06 G_eff=2.79316150834244e-06
Rh17bpn1 vref h17pn 358017.249275869
Vh17nm h17nm 0 DC 0
Fh17nm h17d 0 Vh17nm 0.01
Vh17nn h17nn 0 DC 0
Fh17nn h17d 0 Vh17nn 1
Vh17pn h17pn 0 DC 0
Fh17pn 0 h17d Vh17pn 1
Vh17d h17d 0 DC 0
Hh17 h17lin 0 Vh17d 33333.3333333333
Eh17 h17buf 0 h17lin 0 1

* h18 input 1 w=+0.00309692999044255 w+  bank=m alpha=0.01 R=107633.473911917 G_phys=9.29078997132766e-06 G_eff=9.29078997132766e-08
Rh18p1m1 in1 h18pm 107633.473911917
* h18 input 2 w=-0.290006429631547 w-  bank=n alpha=1 R=114939.98038486 G_phys=8.70019288894641e-06 G_eff=8.70019288894641e-06
Rh18n2n1 in2 h18nn 114939.98038486
* h18 input 3 w=+0.161902441115013 w+  bank=n alpha=1 R=205885.304160755 G_phys=4.8570732334504e-06 G_eff=4.8570732334504e-06
Rh18p3n1 in3 h18pn 205885.304160755
* h18 input 4 w=-0.201165440039706 w-  bank=n alpha=1 R=165701.093223339 G_phys=6.03496320119118e-06 G_eff=6.03496320119118e-06
Rh18n4n1 in4 h18nn 165701.093223339
* h18 input 5 w=+0.167521926893116 w+  bank=n alpha=1 R=198978.927424831 G_phys=5.02565780679349e-06 G_eff=5.02565780679349e-06
Rh18p5n1 in5 h18pn 198978.927424831
* h18 input 6 w=+0.306365656745506 w+  bank=n alpha=1 R=108802.447661498 G_phys=9.19096970236517e-06 G_eff=9.19096970236517e-06
Rh18p6n1 in6 h18pn 108802.447661498
* h18 input 7 w=+0.567135277617062 w+  bank=n alpha=1 R=58774.9248704654 G_phys=1.70140583285119e-05 G_eff=1.70140583285119e-05
Rh18p7n1 in7 h18pn 58774.9248704654
* h18 input 8 w=+0.27754647202065 w+  bank=n alpha=1 R=120100.007363283 G_phys=8.3263941606195e-06 G_eff=8.3263941606195e-06
Rh18p8n1 in8 h18pn 120100.007363283
* h18 input 9 w=-0.295299170614896 w-  bank=n alpha=1 R=112879.874548662 G_phys=8.85897511844687e-06 G_eff=8.85897511844687e-06
Rh18n9n1 in9 h18nn 112879.874548662
* h18 input 10 w=+0.627786354607437 w+  bank=n alpha=1 R=53096.6197157584 G_phys=1.88335906382231e-05 G_eff=1.88335906382231e-05
Rh18p10n1 in10 h18pn 53096.6197157584
* h18 input 11 w=+0.158870042328046 w+  bank=n alpha=1 R=209815.09694889 G_phys=4.76610126984139e-06 G_eff=4.76610126984139e-06
Rh18p11n1 in11 h18pn 209815.09694889
* h18 input 12 w=+0.503831351799562 w+  bank=n alpha=1 R=66159.704461175 G_phys=1.51149405539869e-05 G_eff=1.51149405539869e-05
Rh18p12n1 in12 h18pn 66159.704461175
* h18 input 13 w=+0.0259448474340262 w+  bank=m alpha=0.01 R=12847.7661771166 G_phys=7.78345423020786e-05 G_eff=7.78345423020786e-07
Rh18p13m1 in13 h18pm 12847.7661771166
* h18 input 14 w=-0.0445667146819355 w-  bank=n alpha=1 R=747942.350501428 G_phys=1.33700144045806e-06 G_eff=1.33700144045806e-06
Rh18n14n1 in14 h18nn 747942.350501428
* h18 input 15 w=-0.425048584977393 w-  bank=n alpha=1 R=78422.4074880905 G_phys=1.27514575493218e-05 G_eff=1.27514575493218e-05
Rh18n15n1 in15 h18nn 78422.4074880905
* h18 input 16 w=-0.290071708244206 w-  bank=n alpha=1 R=114914.113944786 G_phys=8.70215124732617e-06 G_eff=8.70215124732617e-06
Rh18n16n1 in16 h18nn 114914.113944786
* h18 bias=+0.103219643590821 b+  bank=n alpha=1 R=322935.946819115 G_phys=3.09658930772463e-06 G_eff=3.09658930772463e-06
Rh18bpn1 vref h18pn 322935.946819115
Vh18nn h18nn 0 DC 0
Fh18nn h18d 0 Vh18nn 1
Vh18pm h18pm 0 DC 0
Fh18pm 0 h18d Vh18pm 0.01
Vh18pn h18pn 0 DC 0
Fh18pn 0 h18d Vh18pn 1
Vh18d h18d 0 DC 0
Hh18 h18lin 0 Vh18d 33333.3333333333
Eh18 h18buf 0 h18lin 0 1

* h19 input 1 w=+0.361917529899694 w+  bank=n alpha=1 R=92102.0138001377 G_phys=1.08575258969908e-05 G_eff=1.08575258969908e-05
Rh19p1n1 in1 h19pn 92102.0138001377
* h19 input 2 w=+0.460196491117441 w+  bank=n alpha=1 R=72432.8281000013 G_phys=1.38058947335232e-05 G_eff=1.38058947335232e-05
Rh19p2n1 in2 h19pn 72432.8281000013
* h19 input 3 w=+0.284766719035728 w+  bank=n alpha=1 R=117054.877220927 G_phys=8.54300157107185e-06 G_eff=8.54300157107185e-06
Rh19p3n1 in3 h19pn 117054.877220927
* h19 input 4 w=-0.664899666016021 w-  bank=n alpha=1 R=50132.8772400529 G_phys=1.99469899804806e-05 G_eff=1.99469899804806e-05
Rh19n4n1 in4 h19nn 50132.8772400529
* h19 input 5 w=+0.507213486118456 w+  bank=n alpha=1 R=65718.5470134534 G_phys=1.52164045835537e-05 G_eff=1.52164045835537e-05
Rh19p5n1 in5 h19pn 65718.5470134534
* h19 input 6 w=+0.130688397719858 w+  bank=n alpha=1 R=255059.622085094 G_phys=3.92065193159573e-06 G_eff=3.92065193159573e-06
Rh19p6n1 in6 h19pn 255059.622085094
* h19 input 7 w=+0.0897047942241856 w+  bank=n alpha=1 R=371589.206815729 G_phys=2.69114382672557e-06 G_eff=2.69114382672557e-06
Rh19p7n1 in7 h19pn 371589.206815729
* h19 input 8 w=+0.0897866911799249 w+  bank=n alpha=1 R=371250.269892853 G_phys=2.69360073539775e-06 G_eff=2.69360073539775e-06
Rh19p8n1 in8 h19pn 371250.269892853
* h19 input 9 w=-0.272382660879323 w-  bank=n alpha=1 R=122376.854773812 G_phys=8.17147982637969e-06 G_eff=8.17147982637969e-06
Rh19n9n1 in9 h19nn 122376.854773812
* h19 input 10 w=+0.0908546616405757 w+  bank=n alpha=1 R=366886.329566679 G_phys=2.72563984921727e-06 G_eff=2.72563984921727e-06
Rh19p10n1 in10 h19pn 366886.329566679
* h19 input 11 w=-0.0411180740799587 w-  bank=n alpha=1 R=810673.507434053 G_phys=1.23354222239876e-06 G_eff=1.23354222239876e-06
Rh19n11n1 in11 h19nn 810673.507434053
* h19 input 12 w=-0.14910928160707 w-  bank=n alpha=1 R=223549.687679219 G_phys=4.47327844821211e-06 G_eff=4.47327844821211e-06
Rh19n12n1 in12 h19nn 223549.687679219
* h19 input 13 w=-0.0351824330179761 w-  bank=n alpha=1 R=947442.529523243 G_phys=1.05547299053928e-06 G_eff=1.05547299053928e-06
Rh19n13n1 in13 h19nn 947442.529523243
* h19 input 14 w=+0.491588757414346 w+  bank=n alpha=1 R=67807.3548887889 G_phys=1.47476627224304e-05 G_eff=1.47476627224304e-05
Rh19p14n1 in14 h19pn 67807.3548887889
* h19 input 15 w=-0.0385925197286318 w-  bank=n alpha=1 R=863725.239184197 G_phys=1.15777559185895e-06 G_eff=1.15777559185895e-06
Rh19n15n1 in15 h19nn 863725.239184197
* h19 input 16 w=-0.690622583753164 w-  bank=n alpha=1 R=48265.628894127 G_phys=2.07186775125949e-05 G_eff=2.07186775125949e-05
Rh19n16n1 in16 h19nn 48265.628894127
* h19 bias=+0.0200863362195416 b+  bank=m alpha=0.01 R=16595.0290630424 G_phys=6.02590086586248e-05 G_eff=6.02590086586248e-07
Rh19bpm1 vref h19pm 16595.0290630424
Vh19nn h19nn 0 DC 0
Fh19nn h19d 0 Vh19nn 1
Vh19pm h19pm 0 DC 0
Fh19pm 0 h19d Vh19pm 0.01
Vh19pn h19pn 0 DC 0
Fh19pn 0 h19d Vh19pn 1
Vh19d h19d 0 DC 0
Hh19 h19lin 0 Vh19d 33333.3333333333
Eh19 h19buf 0 h19lin 0 1

* h20 input 1 w=-0.0810043123301717 w-  bank=n alpha=1 R=411500.72600416 G_phys=2.43012936990515e-06 G_eff=2.43012936990515e-06
Rh20n1n1 in1 h20nn 411500.72600416
* h20 input 2 w=+0.646296718361532 w+  bank=n alpha=1 R=51575.8975503369 G_phys=1.9388901550846e-05 G_eff=1.9388901550846e-05
Rh20p2n1 in2 h20pn 51575.8975503369
* h20 input 3 w=-0.000929252010170944 w-  bank=m alpha=0.01 R=358711.447147705 G_phys=2.78775603051283e-06 G_eff=2.78775603051283e-08
Rh20n3m1 in3 h20nm 358711.447147705
* h20 input 4 w=+0.269987692172837 w+  bank=n alpha=1 R=123462.418101617 G_phys=8.09963076518511e-06 G_eff=8.09963076518511e-06
Rh20p4n1 in4 h20pn 123462.418101617
* h20 input 5 w=+0.140155013181344 w+  bank=n alpha=1 R=237831.901811489 G_phys=4.20465039544031e-06 G_eff=4.20465039544031e-06
Rh20p5n1 in5 h20pn 237831.901811489
* h20 input 6 w=+0.15481044132605 w+  bank=n alpha=1 R=215317.087451028 G_phys=4.6443132397815e-06 G_eff=4.6443132397815e-06
Rh20p6n1 in6 h20pn 215317.087451028
* h20 input 7 w=-0.803119096824844 w-  bank=n alpha=1 R=41504.8446302892 G_phys=2.40935729047453e-05 G_eff=2.40935729047453e-05
Rh20n7n1 in7 h20nn 41504.8446302892
* h20 input 8 w=+0.12095822380885 w+  bank=n alpha=1 R=275577.238849092 G_phys=3.62874671426549e-06 G_eff=3.62874671426549e-06
Rh20p8n1 in8 h20pn 275577.238849092
* h20 input 9 w=+0.307944073046154 w+  bank=n alpha=1 R=108244.763419549 G_phys=9.23832219138461e-06 G_eff=9.23832219138461e-06
Rh20p9n1 in9 h20pn 108244.763419549
* h20 input 10 w=+0.100067069291622 w+  bank=n alpha=1 R=333109.918870425 G_phys=3.00201207874865e-06 G_eff=3.00201207874865e-06
Rh20p10n1 in10 h20pn 333109.918870425
* h20 input 11 w=+0.376050768766317 w+  bank=n alpha=1 R=88640.513733525 G_phys=1.12815230629895e-05 G_eff=1.12815230629895e-05
Rh20p11n1 in11 h20pn 88640.513733525
* h20 input 12 w=-0.859853426992325 w-  bank=n alpha=1 R=38766.2970070722 G_phys=2.57956028097698e-05 G_eff=2.57956028097698e-05
Rh20n12n1 in12 h20nn 38766.2970070722
* h20 input 13 w=+0.0677970111280841 w+  bank=n alpha=1 R=491663.758898737 G_phys=2.03391033384252e-06 G_eff=2.03391033384252e-06
Rh20p13n1 in13 h20pn 491663.758898737
* h20 input 14 w=-0.43012675419833 w-  bank=n alpha=1 R=77496.5356327578 G_phys=1.29038026259499e-05 G_eff=1.29038026259499e-05
Rh20n14n1 in14 h20nn 77496.5356327578
* h20 input 15 w=-0.0800571778528839 w-  bank=n alpha=1 R=416369.078043045 G_phys=2.40171533558652e-06 G_eff=2.40171533558652e-06
Rh20n15n1 in15 h20nn 416369.078043045
* h20 input 16 w=-0.127529601563162 w-  bank=n alpha=1 R=261377.224775726 G_phys=3.82588804689485e-06 G_eff=3.82588804689485e-06
Rh20n16n1 in16 h20nn 261377.224775726
* h20 bias=+0.0269672795638665 b+  bank=m alpha=0.01 R=12360.6584989005 G_phys=8.09018386915995e-05 G_eff=8.09018386915995e-07
Rh20bpm1 vref h20pm 12360.6584989005
Vh20nm h20nm 0 DC 0
Fh20nm h20d 0 Vh20nm 0.01
Vh20nn h20nn 0 DC 0
Fh20nn h20d 0 Vh20nn 1
Vh20pm h20pm 0 DC 0
Fh20pm 0 h20d Vh20pm 0.01
Vh20pn h20pn 0 DC 0
Fh20pn 0 h20d Vh20pn 1
Vh20d h20d 0 DC 0
Hh20 h20lin 0 Vh20d 33333.3333333333
Eh20 h20buf 0 h20lin 0 1

* h21 input 1 w=-0.00681344895090886 w-  bank=m alpha=0.01 R=48922.8488736045 G_phys=2.04403468527266e-05 G_eff=2.04403468527266e-07
Rh21n1m1 in1 h21nm 48922.8488736045
* h21 input 2 w=+0.17215275761211 w+  bank=n alpha=1 R=193626.484964238 G_phys=5.1645827283633e-06 G_eff=5.1645827283633e-06
Rh21p2n1 in2 h21pn 193626.484964238
* h21 input 3 w=-0.241244992284912 w-  bank=n alpha=1 R=138172.12542993 G_phys=7.23734976854735e-06 G_eff=7.23734976854735e-06
Rh21n3n1 in3 h21nn 138172.12542993
* h21 input 4 w=-0.253516997925259 w-  bank=n alpha=1 R=131483.622818698 G_phys=7.60550993775776e-06 G_eff=7.60550993775776e-06
Rh21n4n1 in4 h21nn 131483.622818698
* h21 input 5 w=+0.732528033504134 w+  bank=n alpha=1 R=45504.515607245 G_phys=2.1975841005124e-05 G_eff=2.1975841005124e-05
Rh21p5n1 in5 h21pn 45504.515607245
* h21 input 6 w=-0.335745026911547 w-  bank=n alpha=1 R=99281.6889648676 G_phys=1.00723508073464e-05 G_eff=1.00723508073464e-05
Rh21n6n1 in6 h21nn 99281.6889648676
* h21 input 7 w=-0.133397447206163 w-  bank=n alpha=1 R=249879.844265815 G_phys=4.00192341618489e-06 G_eff=4.00192341618489e-06
Rh21n7n1 in7 h21nn 249879.844265815
* h21 input 8 w=-0.602502751086194 w-  bank=n alpha=1 R=55324.7819586548 G_phys=1.80750825325858e-05 G_eff=1.80750825325858e-05
Rh21n8n1 in8 h21nn 55324.7819586548
* h21 input 9 w=-0.464313715662176 w-  bank=n alpha=1 R=71790.5420601142 G_phys=1.39294114698653e-05 G_eff=1.39294114698653e-05
Rh21n9n1 in9 h21nn 71790.5420601142
* h21 input 10 w=+0.0220606443883595 w+  bank=m alpha=0.01 R=15109.8638582479 G_phys=6.61819331650786e-05 G_eff=6.61819331650786e-07
Rh21p10m1 in10 h21pm 15109.8638582479
* h21 input 11 w=+0.293613135845564 w+  bank=n alpha=1 R=113528.072364127 G_phys=8.80839407536691e-06 G_eff=8.80839407536691e-06
Rh21p11n1 in11 h21pn 113528.072364127
* h21 input 12 w=+0.585788543436 w+  bank=n alpha=1 R=56903.3548143728 G_phys=1.757365630308e-05 G_eff=1.757365630308e-05
Rh21p12n1 in12 h21pn 56903.3548143728
* h21 input 13 w=-0.255400978522459 w-  bank=n alpha=1 R=130513.726009089 G_phys=7.66202935567376e-06 G_eff=7.66202935567376e-06
Rh21n13n1 in13 h21nn 130513.726009089
* h21 input 14 w=+0.15251581562556 w+  bank=n alpha=1 R=218556.568685111 G_phys=4.57547446876679e-06 G_eff=4.57547446876679e-06
Rh21p14n1 in14 h21pn 218556.568685111
* h21 input 15 w=-0.610279514665944 w-  bank=n alpha=1 R=54619.7808254787 G_phys=1.83083854399783e-05 G_eff=1.83083854399783e-05
Rh21n15n1 in15 h21nn 54619.7808254787
* h21 input 16 w=+0.0580238118020399 w+  bank=n alpha=1 R=574476.793200985 G_phys=1.7407143540612e-06 G_eff=1.7407143540612e-06
Rh21p16n1 in16 h21pn 574476.793200985
* h21 bias=-0.00602264402556266 b-  bank=m alpha=0.01 R=55346.6769609038 G_phys=1.8067932076688e-05 G_eff=1.8067932076688e-07
Rh21bnm1 vref h21nm 55346.6769609038
Vh21nm h21nm 0 DC 0
Fh21nm h21d 0 Vh21nm 0.01
Vh21nn h21nn 0 DC 0
Fh21nn h21d 0 Vh21nn 1
Vh21pm h21pm 0 DC 0
Fh21pm 0 h21d Vh21pm 0.01
Vh21pn h21pn 0 DC 0
Fh21pn 0 h21d Vh21pn 1
Vh21d h21d 0 DC 0
Hh21 h21lin 0 Vh21d 33333.3333333333
Eh21 h21buf 0 h21lin 0 1

* h22 input 1 w=+0.733134048211177 w+  bank=n alpha=1 R=45466.901195853 G_phys=2.19940214463353e-05 G_eff=2.19940214463353e-05
Rh22p1n1 in1 h22pn 45466.901195853
* h22 input 2 w=-0.468945077984231 w-  bank=n alpha=1 R=71081.5293693183 G_phys=1.40683523395269e-05 G_eff=1.40683523395269e-05
Rh22n2n1 in2 h22nn 71081.5293693183
* h22 input 3 w=+0.0425168801269381 w+  bank=n alpha=1 R=784002.335867861 G_phys=1.27550640380814e-06 G_eff=1.27550640380814e-06
Rh22p3n1 in3 h22pn 784002.335867861
* h22 input 4 w=-0.440513463519883 w-  bank=n alpha=1 R=75669.2725506874 G_phys=1.32154039055965e-05 G_eff=1.32154039055965e-05
Rh22n4n1 in4 h22nn 75669.2725506874
* h22 input 5 w=+0.139436850403416 w+  bank=n alpha=1 R=239056.843559604 G_phys=4.18310551210248e-06 G_eff=4.18310551210248e-06
Rh22p5n1 in5 h22pn 239056.843559604
* h22 input 6 w=-0.216633688080034 w-  bank=n alpha=1 R=153869.574158838 G_phys=6.49901064240101e-06 G_eff=6.49901064240101e-06
Rh22n6n1 in6 h22nn 153869.574158838
* h22 input 7 w=+0.3413541130964 w+  bank=n alpha=1 R=97650.305224006 G_phys=1.0240623392892e-05 G_eff=1.0240623392892e-05
Rh22p7n1 in7 h22pn 97650.305224006
* h22 input 8 w=+0.375494249585175 w+  bank=n alpha=1 R=88771.88763918 G_phys=1.12648274875552e-05 G_eff=1.12648274875552e-05
Rh22p8n1 in8 h22pn 88771.88763918
* h22 input 9 w=-0.0598723775607 w-  bank=n alpha=1 R=556739.763667131 G_phys=1.796171326821e-06 G_eff=1.796171326821e-06
Rh22n9n1 in9 h22nn 556739.763667131
* h22 input 10 w=-0.886177024526985 w-  bank=n alpha=1 R=37614.7568835083 G_phys=2.65853107358095e-05 G_eff=2.65853107358095e-05
Rh22n10n1 in10 h22nn 37614.7568835083
* h22 input 11 w=-0.158397755226926 w-  bank=n alpha=1 R=210440.692707917 G_phys=4.75193265680777e-06 G_eff=4.75193265680777e-06
Rh22n11n1 in11 h22nn 210440.692707917
* h22 input 12 w=+0.00642379373490928 w+  bank=m alpha=0.01 R=51890.4166430307 G_phys=1.92713812047279e-05 G_eff=1.92713812047279e-07
Rh22p12m1 in12 h22pm 51890.4166430307
* h22 input 13 w=+0.483338726494796 w+  bank=n alpha=1 R=68964.7477144421 G_phys=1.45001617948439e-05 G_eff=1.45001617948439e-05
Rh22p13n1 in13 h22pn 68964.7477144421
* h22 input 14 w=+0.995892890290009 w+  bank=n alpha=1 R=33470.8015875347 G_phys=2.98767867087003e-05 G_eff=2.98767867087003e-05
Rh22p14n1 in14 h22pn 33470.8015875347
* h22 input 15 w=-0.0635579626600016 w-  bank=n alpha=1 R=524455.661230796 G_phys=1.90673887980005e-06 G_eff=1.90673887980005e-06
Rh22n15n1 in15 h22nn 524455.661230796
* h22 input 16 w=+0.143429643183018 w+  bank=n alpha=1 R=232401.981860887 G_phys=4.30288929549054e-06 G_eff=4.30288929549054e-06
Rh22p16n1 in16 h22pn 232401.981860887
* h22 bias=+0.00381018335041017 b+  bank=m alpha=0.01 R=87484.8537925215 G_phys=1.14305500512305e-05 G_eff=1.14305500512305e-07
Rh22bpm1 vref h22pm 87484.8537925215
Vh22nn h22nn 0 DC 0
Fh22nn h22d 0 Vh22nn 1
Vh22pm h22pm 0 DC 0
Fh22pm 0 h22d Vh22pm 0.01
Vh22pn h22pn 0 DC 0
Fh22pn 0 h22d Vh22pn 1
Vh22d h22d 0 DC 0
Hh22 h22lin 0 Vh22d 33333.3333333333
Eh22 h22buf 0 h22lin 0 1

* h23 input 1 w=-0.311855168471888 w-  bank=n alpha=1 R=106887.224273592 G_phys=9.35565505415663e-06 G_eff=9.35565505415663e-06
Rh23n1n1 in1 h23nn 106887.224273592
* h23 input 2 w=-0.519305850985266 w-  bank=n alpha=1 R=64188.2491215741 G_phys=1.5579175529558e-05 G_eff=1.5579175529558e-05
Rh23n2n1 in2 h23nn 64188.2491215741
* h23 input 3 w=+0.0590711076347425 w+  bank=n alpha=1 R=564291.659121157 G_phys=1.77213322904228e-06 G_eff=1.77213322904228e-06
Rh23p3n1 in3 h23pn 564291.659121157
* h23 input 4 w=-0.153433475387477 w-  bank=n alpha=1 R=217249.418675776 G_phys=4.60300426162431e-06 G_eff=4.60300426162431e-06
Rh23n4n1 in4 h23nn 217249.418675776
* h23 input 5 w=+0.565735693190981 w+  bank=n alpha=1 R=58920.3292889647 G_phys=1.69720707957294e-05 G_eff=1.69720707957294e-05
Rh23p5n1 in5 h23pn 58920.3292889647
* h23 input 6 w=-0.371646754353268 w-  bank=n alpha=1 R=89690.90391046 G_phys=1.1149402630598e-05 G_eff=1.1149402630598e-05
Rh23n6n1 in6 h23nn 89690.90391046
* h23 input 7 w=-0.111660278324499 w-  bank=n alpha=1 R=298524.540987283 G_phys=3.34980834973497e-06 G_eff=3.34980834973497e-06
Rh23n7n1 in7 h23nn 298524.540987283
* h23 input 8 w=+0.496809212320021 w+  bank=n alpha=1 R=67094.8374279775 G_phys=1.49042763696006e-05 G_eff=1.49042763696006e-05
Rh23p8n1 in8 h23pn 67094.8374279775
* h23 input 9 w=-0.177241184436762 w-  bank=n alpha=1 R=188067.65165365 G_phys=5.31723553310286e-06 G_eff=5.31723553310286e-06
Rh23n9n1 in9 h23nn 188067.65165365
* h23 input 10 w=-0.405292848695184 w-  bank=n alpha=1 R=82245.0567303322 G_phys=1.21587854608555e-05 G_eff=1.21587854608555e-05
Rh23n10n1 in10 h23nn 82245.0567303322
* h23 input 11 w=-0.16052467280172 w-  bank=n alpha=1 R=207652.398547522 G_phys=4.81574018405159e-06 G_eff=4.81574018405159e-06
Rh23n11n1 in11 h23nn 207652.398547522
* h23 input 12 w=+0.846508036935069 w+  bank=n alpha=1 R=39377.4564196963 G_phys=2.53952411080521e-05 G_eff=2.53952411080521e-05
Rh23p12n1 in12 h23pn 39377.4564196963
* h23 input 13 w=-0.0538311215013525 w-  bank=n alpha=1 R=619220.488142641 G_phys=1.61493364504058e-06 G_eff=1.61493364504058e-06
Rh23n13n1 in13 h23nn 619220.488142641
* h23 input 14 w=+0.31071243911676 w+  bank=n alpha=1 R=107280.331061375 G_phys=9.3213731735028e-06 G_eff=9.3213731735028e-06
Rh23p14n1 in14 h23pn 107280.331061375
* h23 input 15 w=+0.331311012578656 w+  bank=n alpha=1 R=100610.399497118 G_phys=9.93933037735967e-06 G_eff=9.93933037735967e-06
Rh23p15n1 in15 h23pn 100610.399497118
* h23 input 16 w=-0.486368816876819 w-  bank=n alpha=1 R=68535.0955420638 G_phys=1.45910645063046e-05 G_eff=1.45910645063046e-05
Rh23n16n1 in16 h23nn 68535.0955420638
* h23 bias=-0.0518579015055903 b-  bank=n alpha=1 R=642782.148246781 G_phys=1.55573704516771e-06 G_eff=1.55573704516771e-06
Rh23bnn1 vref h23nn 642782.148246781
Vh23nn h23nn 0 DC 0
Fh23nn h23d 0 Vh23nn 1
Vh23pn h23pn 0 DC 0
Fh23pn 0 h23d Vh23pn 1
Vh23d h23d 0 DC 0
Hh23 h23lin 0 Vh23d 33333.3333333333
Eh23 h23buf 0 h23lin 0 1

* h24 input 1 w=+0.61389120350986 w+  bank=n alpha=1 R=54298.4378058415 G_phys=1.84167361052958e-05 G_eff=1.84167361052958e-05
Rh24p1n1 in1 h24pn 54298.4378058415
* h24 input 2 w=-0.0429199313830527 w-  bank=n alpha=1 R=776639.949300928 G_phys=1.28759794149158e-06 G_eff=1.28759794149158e-06
Rh24n2n1 in2 h24nn 776639.949300928
* h24 input 3 w=-0.014915873427812 w-  bank=m alpha=0.01 R=22347.5571140073 G_phys=4.47476202834361e-05 G_eff=4.47476202834361e-07
Rh24n3m1 in3 h24nm 22347.5571140073
* h24 input 4 w=-0.169036355792668 w-  bank=n alpha=1 R=197196.237324345 G_phys=5.07109067378003e-06 G_eff=5.07109067378003e-06
Rh24n4n1 in4 h24nn 197196.237324345
* h24 input 5 w=-0.510336523880732 w-  bank=n alpha=1 R=65316.378063357 G_phys=1.5310095716422e-05 G_eff=1.5310095716422e-05
Rh24n5n1 in5 h24nn 65316.378063357
* h24 input 6 w=-0.303361656916169 w-  bank=n alpha=1 R=109879.849919678 G_phys=9.10084970748506e-06 G_eff=9.10084970748506e-06
Rh24n6n1 in6 h24nn 109879.849919678
* h24 input 7 w=-0.0292327970624363 w-  bank=m alpha=0.01 R=11402.7177290422 G_phys=8.76983911873088e-05 G_eff=8.76983911873088e-07
Rh24n7m1 in7 h24nm 11402.7177290422
* h24 input 8 w=-0.329334996951297 w-  bank=n alpha=1 R=101214.063618823 G_phys=9.88004990853891e-06 G_eff=9.88004990853891e-06
Rh24n8n1 in8 h24nn 101214.063618823
* h24 input 9 w=+0.0109599477370603 w+  bank=m alpha=0.01 R=30413.7703326988 G_phys=3.28798432111809e-05 G_eff=3.28798432111809e-07
Rh24p9m1 in9 h24pm 30413.7703326988
* h24 input 10 w=+0.0571459019805778 w+  bank=n alpha=1 R=583302.252271078 G_phys=1.71437705941734e-06 G_eff=1.71437705941734e-06
Rh24p10n1 in10 h24pn 583302.252271078
* h24 input 11 w=+0.243568584743939 w+  bank=n alpha=1 R=136853.992760915 G_phys=7.30705754231816e-06 G_eff=7.30705754231816e-06
Rh24p11n1 in11 h24pn 136853.992760915
* h24 input 12 w=-0.323004255102081 w-  bank=n alpha=1 R=103197.814910515 G_phys=9.69012765306243e-06 G_eff=9.69012765306243e-06
Rh24n12n1 in12 h24nn 103197.814910515
* h24 input 13 w=+0.243938800887145 w+  bank=n alpha=1 R=136646.294939994 G_phys=7.31816402661434e-06 G_eff=7.31816402661434e-06
Rh24p13n1 in13 h24pn 136646.294939994
* h24 input 14 w=+0.0840399613598874 w+  bank=n alpha=1 R=396636.704657547 G_phys=2.52119884079662e-06 G_eff=2.52119884079662e-06
Rh24p14n1 in14 h24pn 396636.704657547
* h24 input 15 w=-0.352451854106752 w-  bank=n alpha=1 R=94575.5652720646 G_phys=1.05735556232026e-05 G_eff=1.05735556232026e-05
Rh24n15n1 in15 h24nn 94575.5652720646
* h24 input 16 w=+0.406056698737055 w+  bank=n alpha=1 R=82090.3421542089 G_phys=1.21817009621116e-05 G_eff=1.21817009621116e-05
Rh24p16n1 in16 h24pn 82090.3421542089
* h24 bias=+0.0185909259510049 b+  bank=m alpha=0.01 R=17929.894089827 G_phys=5.57727778530147e-05 G_eff=5.57727778530147e-07
Rh24bpm1 vref h24pm 17929.894089827
Vh24nm h24nm 0 DC 0
Fh24nm h24d 0 Vh24nm 0.01
Vh24nn h24nn 0 DC 0
Fh24nn h24d 0 Vh24nn 1
Vh24pm h24pm 0 DC 0
Fh24pm 0 h24d Vh24pm 0.01
Vh24pn h24pn 0 DC 0
Fh24pn 0 h24d Vh24pn 1
Vh24d h24d 0 DC 0
Hh24 h24lin 0 Vh24d 33333.3333333333
Eh24 h24buf 0 h24lin 0 1

* h25 input 1 w=-0.507226781565224 w-  bank=n alpha=1 R=65716.824396519 G_phys=1.52168034469567e-05 G_eff=1.52168034469567e-05
Rh25n1n1 in1 h25nn 65716.824396519
* h25 input 2 w=-0.323616844242374 w-  bank=n alpha=1 R=103002.467042068 G_phys=9.70850532727122e-06 G_eff=9.70850532727122e-06
Rh25n2n1 in2 h25nn 103002.467042068
* h25 input 3 w=+0.251581142719107 w+  bank=n alpha=1 R=132495.35705683 G_phys=7.5474342815732e-06 G_eff=7.5474342815732e-06
Rh25p3n1 in3 h25pn 132495.35705683
* h25 input 4 w=+0.0279414599016099 w+  bank=m alpha=0.01 R=11929.7035483149 G_phys=8.38243797048297e-05 G_eff=8.38243797048297e-07
Rh25p4m1 in4 h25pm 11929.7035483149
* h25 input 5 w=+0.310516223746861 w+  bank=n alpha=1 R=107348.121560654 G_phys=9.31548671240582e-06 G_eff=9.31548671240582e-06
Rh25p5n1 in5 h25pn 107348.121560654
* h25 input 6 w=-0.583310440311788 w-  bank=n alpha=1 R=57145.0998125736 G_phys=1.74993132093536e-05 G_eff=1.74993132093536e-05
Rh25n6n1 in6 h25nn 57145.0998125736
* h25 input 7 w=-0.128366308561082 w-  bank=n alpha=1 R=259673.536670037 G_phys=3.85098925683245e-06 G_eff=3.85098925683245e-06
Rh25n7n1 in7 h25nn 259673.536670037
* h25 input 8 w=-0.237966635841971 w-  bank=n alpha=1 R=140075.658990571 G_phys=7.13899907525912e-06 G_eff=7.13899907525912e-06
Rh25n8n1 in8 h25nn 140075.658990571
* h25 input 9 w=+0.869293927250567 w+  bank=n alpha=1 R=38345.2964393311 G_phys=2.6078817817517e-05 G_eff=2.6078817817517e-05
Rh25p9n1 in9 h25pn 38345.2964393311
* h25 input 10 w=-0.700407093798758 w-  bank=n alpha=1 R=47591.3702594662 G_phys=2.10122128139627e-05 G_eff=2.10122128139627e-05
Rh25n10n1 in10 h25nn 47591.3702594662
* h25 input 11 w=+0.176416664646434 w+  bank=n alpha=1 R=188946.624742841 G_phys=5.29249993939301e-06 G_eff=5.29249993939301e-06
Rh25p11n1 in11 h25pn 188946.624742841
* h25 input 12 w=+0.165054591787149 w+  bank=n alpha=1 R=201953.383861743 G_phys=4.95163775361447e-06 G_eff=4.95163775361447e-06
Rh25p12n1 in12 h25pn 201953.383861743
* h25 input 13 w=+0.414882742059982 w+  bank=n alpha=1 R=80343.9862738715 G_phys=1.24464822617995e-05 G_eff=1.24464822617995e-05
Rh25p13n1 in13 h25pn 80343.9862738715
* h25 input 14 w=-0.441614461314228 w-  bank=n alpha=1 R=75480.619982721 G_phys=1.32484338394269e-05 G_eff=1.32484338394269e-05
Rh25n14n1 in14 h25nn 75480.619982721
* h25 input 15 w=+0.152726206779301 w+  bank=n alpha=1 R=218255.491550983 G_phys=4.58178620337902e-06 G_eff=4.58178620337902e-06
Rh25p15n1 in15 h25pn 218255.491550983
* h25 input 16 w=-0.0538945970745783 w-  bank=n alpha=1 R=618491.187292992 G_phys=1.61683791223735e-06 G_eff=1.61683791223735e-06
Rh25n16n1 in16 h25nn 618491.187292992
* h25 bias=+0.0841612656537764 b+  bank=n alpha=1 R=396065.019631007 G_phys=2.52483796961329e-06 G_eff=2.52483796961329e-06
Rh25bpn1 vref h25pn 396065.019631007
Vh25nn h25nn 0 DC 0
Fh25nn h25d 0 Vh25nn 1
Vh25pm h25pm 0 DC 0
Fh25pm 0 h25d Vh25pm 0.01
Vh25pn h25pn 0 DC 0
Fh25pn 0 h25d Vh25pn 1
Vh25d h25d 0 DC 0
Hh25 h25lin 0 Vh25d 33333.3333333333
Eh25 h25buf 0 h25lin 0 1

* h26 input 1 w=-0.733410608571861 w-  bank=n alpha=1 R=45449.7561717056 G_phys=2.20023182571558e-05 G_eff=2.20023182571558e-05
Rh26n1n1 in1 h26nn 45449.7561717056
* h26 input 2 w=+0.207000343516658 w+  bank=n alpha=1 R=161030.328583251 G_phys=6.21001030549975e-06 G_eff=6.21001030549975e-06
Rh26p2n1 in2 h26pn 161030.328583251
* h26 input 3 w=-0.0671817515718929 w-  bank=n alpha=1 R=496166.482019488 G_phys=2.01545254715679e-06 G_eff=2.01545254715679e-06
Rh26n3n1 in3 h26nn 496166.482019488
* h26 input 4 w=+0.312724326896377 w+  bank=n alpha=1 R=106590.151345592 G_phys=9.38172980689131e-06 G_eff=9.38172980689131e-06
Rh26p4n1 in4 h26pn 106590.151345592
* h26 input 5 w=+0.0982363551813243 w+  bank=n alpha=1 R=339317.692231219 G_phys=2.94709065543973e-06 G_eff=2.94709065543973e-06
Rh26p5n1 in5 h26pn 339317.692231219
* h26 input 6 w=+0.0433697195878843 w+  bank=n alpha=1 R=768585.401291025 G_phys=1.30109158763653e-06 G_eff=1.30109158763653e-06
Rh26p6n1 in6 h26pn 768585.401291025
* h26 input 7 w=-0.253243820471769 w-  bank=n alpha=1 R=131625.45593901 G_phys=7.59731461415306e-06 G_eff=7.59731461415306e-06
Rh26n7n1 in7 h26nn 131625.45593901
* h26 input 8 w=+0.388367135047654 w+  bank=n alpha=1 R=85829.4390158508 G_phys=1.16510140514296e-05 G_eff=1.16510140514296e-05
Rh26p8n1 in8 h26pn 85829.4390158508
* h26 input 9 w=+0.190562655499984 w+  bank=n alpha=1 R=174920.596304013 G_phys=5.71687966499952e-06 G_eff=5.71687966499952e-06
Rh26p9n1 in9 h26pn 174920.596304013
* h26 input 10 w=-0.282938574156096 w-  bank=n alpha=1 R=117811.201363245 G_phys=8.48815722468287e-06 G_eff=8.48815722468287e-06
Rh26n10n1 in10 h26nn 117811.201363245
* h26 input 11 w=+0.123317846030254 w+  bank=n alpha=1 R=270304.21310761 G_phys=3.69953538090763e-06 G_eff=3.69953538090763e-06
Rh26p11n1 in11 h26pn 270304.21310761
* h26 input 12 w=-0.494646699470857 w-  bank=n alpha=1 R=67388.1648639146 G_phys=1.48394009841257e-05 G_eff=1.48394009841257e-05
Rh26n12n1 in12 h26nn 67388.1648639146
* h26 input 13 w=-0.136127092468903 w-  bank=n alpha=1 R=244869.208096457 G_phys=4.08381277406708e-06 G_eff=4.08381277406708e-06
Rh26n13n1 in13 h26nn 244869.208096457
* h26 input 14 w=+0.481522107274068 w+  bank=n alpha=1 R=69224.928263493 G_phys=1.4445663218222e-05 G_eff=1.4445663218222e-05
Rh26p14n1 in14 h26pn 69224.928263493
* h26 input 15 w=+0.0644124429905188 w+  bank=n alpha=1 R=517498.355686336 G_phys=1.93237328971556e-06 G_eff=1.93237328971556e-06
Rh26p15n1 in15 h26pn 517498.355686336
* h26 input 16 w=+0.0297993400818282 w+  bank=m alpha=0.01 R=11185.930037981 G_phys=8.93980202454845e-05 G_eff=8.93980202454845e-07
Rh26p16m1 in16 h26pm 11185.930037981
* h26 bias=-0.0154994859917217 b-  bank=m alpha=0.01 R=21506.0895252505 G_phys=4.64984579751652e-05 G_eff=4.64984579751652e-07
Rh26bnm1 vref h26nm 21506.0895252505
Vh26nm h26nm 0 DC 0
Fh26nm h26d 0 Vh26nm 0.01
Vh26nn h26nn 0 DC 0
Fh26nn h26d 0 Vh26nn 1
Vh26pm h26pm 0 DC 0
Fh26pm 0 h26d Vh26pm 0.01
Vh26pn h26pn 0 DC 0
Fh26pn 0 h26d Vh26pn 1
Vh26d h26d 0 DC 0
Hh26 h26lin 0 Vh26d 33333.3333333333
Eh26 h26buf 0 h26lin 0 1

* h27 input 1 w=-0.473232380174693 w-  bank=n alpha=1 R=70437.5582267393 G_phys=1.41969714052408e-05 G_eff=1.41969714052408e-05
Rh27n1n1 in1 h27nn 70437.5582267393
* h27 input 2 w=+0.0192680774504759 w+  bank=m alpha=0.01 R=17299.7713025645 G_phys=5.78042323514278e-05 G_eff=5.78042323514278e-07
Rh27p2m1 in2 h27pm 17299.7713025645
* h27 input 3 w=-0.33925202928177 w-  bank=n alpha=1 R=98255.3690361212 G_phys=1.01775608784531e-05 G_eff=1.01775608784531e-05
Rh27n3n1 in3 h27nn 98255.3690361212
* h27 input 4 w=+0.300608725256371 w+  bank=n alpha=1 R=110886.113850838 G_phys=9.01826175769113e-06 G_eff=9.01826175769113e-06
Rh27p4n1 in4 h27pn 110886.113850838
* h27 input 5 w=-0.265937781386581 w-  bank=n alpha=1 R=125342.60141427 G_phys=7.97813344159742e-06 G_eff=7.97813344159742e-06
Rh27n5n1 in5 h27nn 125342.60141427
* h27 input 6 w=-0.0714924370091341 w-  bank=n alpha=1 R=466249.784282421 G_phys=2.14477311027402e-06 G_eff=2.14477311027402e-06
Rh27n6n1 in6 h27nn 466249.784282421
* h27 input 7 w=+0.32365049129675 w+  bank=n alpha=1 R=102991.758794429 G_phys=9.7095147389025e-06 G_eff=9.7095147389025e-06
Rh27p7n1 in7 h27pn 102991.758794429
* h27 input 8 w=+0.264468500812474 w+  bank=n alpha=1 R=126038.954472574 G_phys=7.93405502437422e-06 G_eff=7.93405502437422e-06
Rh27p8n1 in8 h27pn 126038.954472574
* h27 input 9 w=-0.251852607935664 w-  bank=n alpha=1 R=132352.543841231 G_phys=7.55557823806993e-06 G_eff=7.55557823806993e-06
Rh27n9n1 in9 h27nn 132352.543841231
* h27 input 10 w=-0.0922567674902895 w-  bank=n alpha=1 R=361310.440850226 G_phys=2.76770302470868e-06 G_eff=2.76770302470868e-06
Rh27n10n1 in10 h27nn 361310.440850226
* h27 input 11 w=-0.519972660308657 w-  bank=n alpha=1 R=64105.9345573026 G_phys=1.55991798092597e-05 G_eff=1.55991798092597e-05
Rh27n11n1 in11 h27nn 64105.9345573026
* h27 input 12 w=+0.109096005067641 w+  bank=n alpha=1 R=305541.282768935 G_phys=3.27288015202924e-06 G_eff=3.27288015202924e-06
Rh27p12n1 in12 h27pn 305541.282768935
* h27 input 13 w=+0.0733868764952063 w+  bank=n alpha=1 R=454213.817582367 G_phys=2.20160629485619e-06 G_eff=2.20160629485619e-06
Rh27p13n1 in13 h27pn 454213.817582367
* h27 input 14 w=-0.779894486957924 w-  bank=n alpha=1 R=42740.8244201779 G_phys=2.33968346087377e-05 G_eff=2.33968346087377e-05
Rh27n14n1 in14 h27nn 42740.8244201779
* h27 input 15 w=+0.520337169546291 w+  bank=n alpha=1 R=64061.0267423301 G_phys=1.56101150863887e-05 G_eff=1.56101150863887e-05
Rh27p15n1 in15 h27pn 64061.0267423301
* h27 input 16 w=+0.00922691889455085 w+  bank=m alpha=0.01 R=36126.1800545565 G_phys=2.76807566836526e-05 G_eff=2.76807566836526e-07
Rh27p16m1 in16 h27pm 36126.1800545565
* h27 bias=+0.0122793649099004 b+  bank=m alpha=0.01 R=27145.8121636714 G_phys=3.68380947297011e-05 G_eff=3.68380947297011e-07
Rh27bpm1 vref h27pm 27145.8121636714
Vh27nn h27nn 0 DC 0
Fh27nn h27d 0 Vh27nn 1
Vh27pm h27pm 0 DC 0
Fh27pm 0 h27d Vh27pm 0.01
Vh27pn h27pn 0 DC 0
Fh27pn 0 h27d Vh27pn 1
Vh27d h27d 0 DC 0
Hh27 h27lin 0 Vh27d 33333.3333333333
Eh27 h27buf 0 h27lin 0 1

* h28 input 1 w=+0.0928477001370985 w+  bank=n alpha=1 R=359010.86708786 G_phys=2.78543100411296e-06 G_eff=2.78543100411296e-06
Rh28p1n1 in1 h28pn 359010.86708786
* h28 input 2 w=+0.628866123797832 w+  bank=n alpha=1 R=53005.4523083984 G_phys=1.8865983713935e-05 G_eff=1.8865983713935e-05
Rh28p2n1 in2 h28pn 53005.4523083984
* h28 input 3 w=-0.429442295580587 w-  bank=n alpha=1 R=77620.0520451022 G_phys=1.28832688674176e-05 G_eff=1.28832688674176e-05
Rh28n3n1 in3 h28nn 77620.0520451022
* h28 input 4 w=+0.0390774584408687 w+  bank=n alpha=1 R=853006.686291349 G_phys=1.17232375322606e-06 G_eff=1.17232375322606e-06
Rh28p4n1 in4 h28pn 853006.686291349
* h28 input 5 w=-0.500231352741198 w-  bank=n alpha=1 R=66635.8339009967 G_phys=1.50069405822359e-05 G_eff=1.50069405822359e-05
Rh28n5n1 in5 h28nn 66635.8339009967
* h28 input 6 w=-0.374880121408735 w-  bank=n alpha=1 R=88917.3136416848 G_phys=1.1246403642262e-05 G_eff=1.1246403642262e-05
Rh28n6n1 in6 h28nn 88917.3136416848
* h28 input 7 w=-0.575469641796179 w-  bank=n alpha=1 R=57923.7042449224 G_phys=1.72640892538854e-05 G_eff=1.72640892538854e-05
Rh28n7n1 in7 h28nn 57923.7042449224
* h28 input 8 w=+0.475130253886277 w+  bank=n alpha=1 R=70156.2004538479 G_phys=1.42539076165883e-05 G_eff=1.42539076165883e-05
Rh28p8n1 in8 h28pn 70156.2004538479
* h28 input 9 w=-0.381841652824232 w-  bank=n alpha=1 R=87296.221056002 G_phys=1.1455249584727e-05 G_eff=1.1455249584727e-05
Rh28n9n1 in9 h28nn 87296.221056002
* h28 input 10 w=+0.758567082707225 w+  bank=n alpha=1 R=43942.4990791469 G_phys=2.27570124812167e-05 G_eff=2.27570124812167e-05
Rh28p10n1 in10 h28pn 43942.4990791469
* h28 input 11 w=-0.0530277840915393 w-  bank=n alpha=1 R=628601.287125096 G_phys=1.59083352274618e-06 G_eff=1.59083352274618e-06
Rh28n11n1 in11 h28nn 628601.287125096
* h28 input 12 w=+0.0401492881024246 w+  bank=n alpha=1 R=830234.729151284 G_phys=1.20447864307274e-06 G_eff=1.20447864307274e-06
Rh28p12n1 in12 h28pn 830234.729151284
* h28 input 13 w=-0.344979802042177 w-  bank=n alpha=1 R=96624.0143220269 G_phys=1.03493940612653e-05 G_eff=1.03493940612653e-05
Rh28n13n1 in13 h28nn 96624.0143220269
* h28 input 14 w=+0.139059200435423 w+  bank=n alpha=1 R=239706.062086937 G_phys=4.1717760130627e-06 G_eff=4.1717760130627e-06
Rh28p14n1 in14 h28pn 239706.062086937
* h28 input 15 w=-0.317012120275182 w-  bank=n alpha=1 R=105148.450804967 G_phys=9.51036360825546e-06 G_eff=9.51036360825546e-06
Rh28n15n1 in15 h28nn 105148.450804967
* h28 input 16 w=-0.398313118116402 w-  bank=n alpha=1 R=83686.2554037001 G_phys=1.1949393543492e-05 G_eff=1.1949393543492e-05
Rh28n16n1 in16 h28nn 83686.2554037001
* h28 bias=-0.0847668662328426 b-  bank=n alpha=1 R=393235.409243175 G_phys=2.54300598698528e-06 G_eff=2.54300598698528e-06
Rh28bnn1 vref h28nn 393235.409243175
Vh28nn h28nn 0 DC 0
Fh28nn h28d 0 Vh28nn 1
Vh28pn h28pn 0 DC 0
Fh28pn 0 h28d Vh28pn 1
Vh28d h28d 0 DC 0
Hh28 h28lin 0 Vh28d 33333.3333333333
Eh28 h28buf 0 h28lin 0 1

* h29 input 1 w=+0.125932002984804 w+  bank=n alpha=1 R=264693.108529018 G_phys=3.77796008954411e-06 G_eff=3.77796008954411e-06
Rh29p1n1 in1 h29pn 264693.108529018
* h29 input 2 w=-0.650061827874195 w-  bank=n alpha=1 R=51277.1738072033 G_phys=1.95018548362258e-05 G_eff=1.95018548362258e-05
Rh29n2n1 in2 h29nn 51277.1738072033
* h29 input 3 w=-0.0394473233812264 w-  bank=n alpha=1 R=845008.747772155 G_phys=1.18341970143679e-06 G_eff=1.18341970143679e-06
Rh29n3n1 in3 h29nn 845008.747772155
* h29 input 4 w=-0.231823015010513 w-  bank=n alpha=1 R=143787.85183094 G_phys=6.9546904503154e-06 G_eff=6.9546904503154e-06
Rh29n4n1 in4 h29nn 143787.85183094
* h29 input 5 w=+0.19053303604273 w+  bank=n alpha=1 R=174947.788717637 G_phys=5.71599108128189e-06 G_eff=5.71599108128189e-06
Rh29p5n1 in5 h29pn 174947.788717637
* h29 input 6 w=+0.447719174196915 w+  bank=n alpha=1 R=74451.4312864178 G_phys=1.34315752259074e-05 G_eff=1.34315752259074e-05
Rh29p6n1 in6 h29pn 74451.4312864178
* h29 input 7 w=+0.0126486175371352 w+  bank=m alpha=0.01 R=26353.3411738237 G_phys=3.79458526114055e-05 G_eff=3.79458526114055e-07
Rh29p7m1 in7 h29pm 26353.3411738237
* h29 input 8 w=+0.108364236263017 w+  bank=n alpha=1 R=307604.561088107 G_phys=3.25092708789052e-06 G_eff=3.25092708789052e-06
Rh29p8n1 in8 h29pn 307604.561088107
* h29 input 9 w=+0.430118110319429 w+  bank=n alpha=1 R=77498.0930437414 G_phys=1.29035433095829e-05 G_eff=1.29035433095829e-05
Rh29p9n1 in9 h29pn 77498.0930437414
* h29 input 10 w=+0.849664650654267 w+  bank=n alpha=1 R=39231.1640924048 G_phys=2.5489939519628e-05 G_eff=2.5489939519628e-05
Rh29p10n1 in10 h29pn 39231.1640924048
* h29 input 11 w=+0.430581993177771 w+  bank=n alpha=1 R=77414.6013104902 G_phys=1.29174597953331e-05 G_eff=1.29174597953331e-05
Rh29p11n1 in11 h29pn 77414.6013104902
* h29 input 12 w=-0.974573192285427 w-  bank=n alpha=1 R=34203.006605553 G_phys=2.92371957685628e-05 G_eff=2.92371957685628e-05
Rh29n12n1 in12 h29nn 34203.006605553
* h29 input 13 w=+0.16029064712382 w+  bank=n alpha=1 R=207955.572776396 G_phys=4.80871941371461e-06 G_eff=4.80871941371461e-06
Rh29p13n1 in13 h29pn 207955.572776396
* h29 input 14 w=+0.466636118473806 w+  bank=n alpha=1 R=71433.2474784727 G_phys=1.39990835542142e-05 G_eff=1.39990835542142e-05
Rh29p14n1 in14 h29pn 71433.2474784727
* h29 input 15 w=-0.0331745755104183 w-  bank=m alpha=0.01 R=10047.8552688233 G_phys=9.95237265312548e-05 G_eff=9.95237265312548e-07
Rh29n15m1 in15 h29nm 10047.8552688233
* h29 input 16 w=-0.589046477086867 w-  bank=n alpha=1 R=56588.6303202822 G_phys=1.7671394312606e-05 G_eff=1.7671394312606e-05
Rh29n16n1 in16 h29nn 56588.6303202822
* h29 bias=-0.0665836653392507 b-  bank=n alpha=1 R=500623.285959049 G_phys=1.99750996017752e-06 G_eff=1.99750996017752e-06
Rh29bnn1 vref h29nn 500623.285959049
Vh29nm h29nm 0 DC 0
Fh29nm h29d 0 Vh29nm 0.01
Vh29nn h29nn 0 DC 0
Fh29nn h29d 0 Vh29nn 1
Vh29pm h29pm 0 DC 0
Fh29pm 0 h29d Vh29pm 0.01
Vh29pn h29pn 0 DC 0
Fh29pn 0 h29d Vh29pn 1
Vh29d h29d 0 DC 0
Hh29 h29lin 0 Vh29d 33333.3333333333
Eh29 h29buf 0 h29lin 0 1

* h30 input 1 w=-0.507901838841989 w-  bank=n alpha=1 R=65629.4795256756 G_phys=1.52370551652597e-05 G_eff=1.52370551652597e-05
Rh30n1n1 in1 h30nn 65629.4795256756
* h30 input 2 w=-0.0392944483392576 w-  bank=n alpha=1 R=848296.254105474 G_phys=1.17883345017773e-06 G_eff=1.17883345017773e-06
Rh30n2n1 in2 h30nn 848296.254105474
* h30 input 3 w=+0.205776196534446 w+  bank=n alpha=1 R=161988.285791615 G_phys=6.17328589603337e-06 G_eff=6.17328589603337e-06
Rh30p3n1 in3 h30pn 161988.285791615
* h30 input 4 w=+0.172383143604269 w+  bank=n alpha=1 R=193367.707749053 G_phys=5.17149430812806e-06 G_eff=5.17149430812806e-06
Rh30p4n1 in4 h30pn 193367.707749053
* h30 input 5 w=-0.0737740397875715 w-  bank=n alpha=1 R=451830.121128177 G_phys=2.21322119362714e-06 G_eff=2.21322119362714e-06
Rh30n5n1 in5 h30nn 451830.121128177
* h30 input 6 w=-0.113337981854853 w-  bank=n alpha=1 R=294105.583916448 G_phys=3.40013945564559e-06 G_eff=3.40013945564559e-06
Rh30n6n1 in6 h30nn 294105.583916448
* h30 input 7 w=-0.199472534274412 w-  bank=n alpha=1 R=167107.383753781 G_phys=5.98417602823235e-06 G_eff=5.98417602823235e-06
Rh30n7n1 in7 h30nn 167107.383753781
* h30 input 8 w=+0.667476408484971 w+  bank=n alpha=1 R=49939.3430383448 G_phys=2.00242922545491e-05 G_eff=2.00242922545491e-05
Rh30p8n1 in8 h30pn 49939.3430383448
* h30 input 9 w=+0.0327305955718174 w+  bank=m alpha=0.01 R=10184.1511744549 G_phys=9.81917867154523e-05 G_eff=9.81917867154523e-07
Rh30p9m1 in9 h30pm 10184.1511744549
* h30 input 10 w=-0.112124407230259 w-  bank=n alpha=1 R=297288.825481859 G_phys=3.36373221690776e-06 G_eff=3.36373221690776e-06
Rh30n10n1 in10 h30nn 297288.825481859
* h30 input 11 w=+0.283868618501327 w+  bank=n alpha=1 R=117425.214204076 G_phys=8.51605855503981e-06 G_eff=8.51605855503981e-06
Rh30p11n1 in11 h30pn 117425.214204076
* h30 input 12 w=-0.058671072800694 w-  bank=n alpha=1 R=568139.148342606 G_phys=1.76013218402082e-06 G_eff=1.76013218402082e-06
Rh30n12n1 in12 h30nn 568139.148342606
* h30 input 13 w=-0.679698898194489 w-  bank=n alpha=1 R=49041.323182777 G_phys=2.03909669458347e-05 G_eff=2.03909669458347e-05
Rh30n13n1 in13 h30nn 49041.323182777
* h30 input 14 w=+0.213421552049108 w+  bank=n alpha=1 R=156185.413390975 G_phys=6.40264656147323e-06 G_eff=6.40264656147323e-06
Rh30p14n1 in14 h30pn 156185.413390975
* h30 input 15 w=+0.353043376484901 w+  bank=n alpha=1 R=94417.1043944198 G_phys=1.0591301294547e-05 G_eff=1.0591301294547e-05
Rh30p15n1 in15 h30pn 94417.1043944198
* h30 input 16 w=-0.0402310971621178 w-  bank=n alpha=1 R=828546.464915216 G_phys=1.20693291486354e-06 G_eff=1.20693291486354e-06
Rh30n16n1 in16 h30nn 828546.464915216
* h30 bias=+0.0283807691184238 b+  bank=m alpha=0.01 R=11745.0422834716 G_phys=8.51423073552714e-05 G_eff=8.51423073552714e-07
Rh30bpm1 vref h30pm 11745.0422834716
Vh30nn h30nn 0 DC 0
Fh30nn h30d 0 Vh30nn 1
Vh30pm h30pm 0 DC 0
Fh30pm 0 h30d Vh30pm 0.01
Vh30pn h30pn 0 DC 0
Fh30pn 0 h30d Vh30pn 1
Vh30d h30d 0 DC 0
Hh30 h30lin 0 Vh30d 33333.3333333333
Eh30 h30buf 0 h30lin 0 1

* h31 input 1 w=+0.786523739677983 w+  bank=n alpha=1 R=42380.5813502598 G_phys=2.35957121903395e-05 G_eff=2.35957121903395e-05
Rh31p1n1 in1 h31pn 42380.5813502598
* h31 input 2 w=+0.575951127580127 w+  bank=n alpha=1 R=57875.2809693839 G_phys=1.72785338274038e-05 G_eff=1.72785338274038e-05
Rh31p2n1 in2 h31pn 57875.2809693839
* h31 input 3 w=+0.131568206508636 w+  bank=n alpha=1 R=253354.014756941 G_phys=3.94704619525908e-06 G_eff=3.94704619525908e-06
Rh31p3n1 in3 h31pn 253354.014756941
* h31 input 4 w=+0.217046331869883 w+  bank=n alpha=1 R=153577.040653773 G_phys=6.51138995609649e-06 G_eff=6.51138995609649e-06
Rh31p4n1 in4 h31pn 153577.040653773
* h31 input 5 w=+0.0670548023806797 w+  bank=n alpha=1 R=497105.832093803 G_phys=2.01164407142039e-06 G_eff=2.01164407142039e-06
Rh31p5n1 in5 h31pn 497105.832093803
* h31 input 6 w=-0.0924541633789126 w-  bank=n alpha=1 R=360539.018634786 G_phys=2.77362490136738e-06 G_eff=2.77362490136738e-06
Rh31n6n1 in6 h31nn 360539.018634786
* h31 input 7 w=+0.532768880755568 w+  bank=n alpha=1 R=62566.2168669842 G_phys=1.59830664226671e-05 G_eff=1.59830664226671e-05
Rh31p7n1 in7 h31pn 62566.2168669842
* h31 input 8 w=-0.213038536483163 w-  bank=n alpha=1 R=156466.214439883 G_phys=6.39115609449489e-06 G_eff=6.39115609449489e-06
Rh31n8n1 in8 h31nn 156466.214439883
* h31 input 9 w=+0.217996086164886 w+  bank=n alpha=1 R=152907.943989971 G_phys=6.53988258494657e-06 G_eff=6.53988258494657e-06
Rh31p9n1 in9 h31pn 152907.943989971
* h31 input 10 w=-0.173189336412784 w-  bank=n alpha=1 R=192467.58503587 G_phys=5.19568009238351e-06 G_eff=5.19568009238351e-06
Rh31n10n1 in10 h31nn 192467.58503587
* h31 input 11 w=+0.227561810267943 w+  bank=n alpha=1 R=146480.348763639 G_phys=6.8268543080383e-06 G_eff=6.8268543080383e-06
Rh31p11n1 in11 h31pn 146480.348763639
* h31 input 12 w=+0.400647928830177 w+  bank=n alpha=1 R=83198.5664587384 G_phys=1.20194378649053e-05 G_eff=1.20194378649053e-05
Rh31p12n1 in12 h31pn 83198.5664587384
* h31 input 13 w=+0.0924404555732517 w+  bank=n alpha=1 R=360592.482226781 G_phys=2.77321366719755e-06 G_eff=2.77321366719755e-06
Rh31p13n1 in13 h31pn 360592.482226781
* h31 input 14 w=+0.340918137300815 w+  bank=n alpha=1 R=97775.1832074605 G_phys=1.02275441190244e-05 G_eff=1.02275441190244e-05
Rh31p14n1 in14 h31pn 97775.1832074605
* h31 input 15 w=+0.631456773568415 w+  bank=n alpha=1 R=52787.9891840638 G_phys=1.89437032070525e-05 G_eff=1.89437032070525e-05
Rh31p15n1 in15 h31pn 52787.9891840638
* h31 input 16 w=+0.19173700817347 w+  bank=n alpha=1 R=173849.240951834 G_phys=5.75211024520409e-06 G_eff=5.75211024520409e-06
Rh31p16n1 in16 h31pn 173849.240951834
* h31 bias=-0.0537174074345555 b-  bank=n alpha=1 R=620531.31238591 G_phys=1.61152222303666e-06 G_eff=1.61152222303666e-06
Rh31bnn1 vref h31nn 620531.31238591
Vh31nn h31nn 0 DC 0
Fh31nn h31d 0 Vh31nn 1
Vh31pn h31pn 0 DC 0
Fh31pn 0 h31d Vh31pn 1
Vh31d h31d 0 DC 0
Hh31 h31lin 0 Vh31d 33333.3333333333
Eh31 h31buf 0 h31lin 0 1

* h32 input 1 w=+0.018363806586789 w+  bank=m alpha=0.01 R=18151.6469234181 G_phys=5.50914197603669e-05 G_eff=5.50914197603669e-07
Rh32p1m1 in1 h32pm 18151.6469234181
* h32 input 2 w=+0.274234487929714 w+  bank=n alpha=1 R=121550.478880237 G_phys=8.22703463789143e-06 G_eff=8.22703463789143e-06
Rh32p2n1 in2 h32pn 121550.478880237
* h32 input 3 w=+0.286642259390481 w+  bank=n alpha=1 R=116288.970803585 G_phys=8.59926778171444e-06 G_eff=8.59926778171444e-06
Rh32p3n1 in3 h32pn 116288.970803585
* h32 input 4 w=-0.106012181190002 w-  bank=n alpha=1 R=314429.275571559 G_phys=3.18036543570007e-06 G_eff=3.18036543570007e-06
Rh32n4n1 in4 h32nn 314429.275571559
* h32 input 5 w=-0.539184466126997 w-  bank=n alpha=1 R=61821.7612476287 G_phys=1.61755339838099e-05 G_eff=1.61755339838099e-05
Rh32n5n1 in5 h32nn 61821.7612476287
* h32 input 6 w=-0.141969883388357 w-  bank=n alpha=1 R=234791.580705539 G_phys=4.25909650165071e-06 G_eff=4.25909650165071e-06
Rh32n6n1 in6 h32nn 234791.580705539
* h32 input 7 w=-0.343812430494534 w-  bank=n alpha=1 R=96952.0889206571 G_phys=1.0314372914836e-05 G_eff=1.0314372914836e-05
Rh32n7n1 in7 h32nn 96952.0889206571
* h32 input 8 w=-0.197072814561277 w-  bank=n alpha=1 R=169142.219882229 G_phys=5.91218443683832e-06 G_eff=5.91218443683832e-06
Rh32n8n1 in8 h32nn 169142.219882229
* h32 input 9 w=-0.180430465047897 w-  bank=n alpha=1 R=184743.376482927 G_phys=5.41291395143692e-06 G_eff=5.41291395143692e-06
Rh32n9n1 in9 h32nn 184743.376482927
* h32 input 10 w=+0.113268490856906 w+  bank=n alpha=1 R=294286.019714378 G_phys=3.39805472570718e-06 G_eff=3.39805472570718e-06
Rh32p10n1 in10 h32pn 294286.019714378
* h32 input 11 w=+0.0737822862098911 w+  bank=n alpha=1 R=451779.621446112 G_phys=2.21346858629673e-06 G_eff=2.21346858629673e-06
Rh32p11n1 in11 h32pn 451779.621446112
* h32 input 12 w=+0.131260687318804 w+  bank=n alpha=1 R=253947.575730529 G_phys=3.93782061956414e-06 G_eff=3.93782061956414e-06
Rh32p12n1 in12 h32pn 253947.575730529
* h32 input 13 w=-0.105796213840622 w-  bank=n alpha=1 R=315071.136511074 G_phys=3.17388641521865e-06 G_eff=3.17388641521865e-06
Rh32n13n1 in13 h32nn 315071.136511074
* h32 input 14 w=-0.365435123738796 w-  bank=n alpha=1 R=91215.4611529876 G_phys=1.09630537121639e-05 G_eff=1.09630537121639e-05
Rh32n14n1 in14 h32nn 91215.4611529876
* h32 input 15 w=-0.0205558893905 w-  bank=m alpha=0.01 R=16215.9528591055 G_phys=6.16676681714999e-05 G_eff=6.16676681714999e-07
Rh32n15m1 in15 h32nm 16215.9528591055
* h32 input 16 w=-0.212152037098157 w-  bank=n alpha=1 R=157120.024814614 G_phys=6.36456111294471e-06 G_eff=6.36456111294471e-06
Rh32n16n1 in16 h32nn 157120.024814614
* h32 bias=+0.00806132622522946 b+  bank=m alpha=0.01 R=41349.6891231251 G_phys=2.41839786756884e-05 G_eff=2.41839786756884e-07
Rh32bpm1 vref h32pm 41349.6891231251
Vh32nm h32nm 0 DC 0
Fh32nm h32d 0 Vh32nm 0.01
Vh32nn h32nn 0 DC 0
Fh32nn h32d 0 Vh32nn 1
Vh32pm h32pm 0 DC 0
Fh32pm 0 h32d Vh32pm 0.01
Vh32pn h32pn 0 DC 0
Fh32pn 0 h32d Vh32pn 1
Vh32d h32d 0 DC 0
Hh32 h32lin 0 Vh32d 33333.3333333333
Eh32 h32buf 0 h32lin 0 1

* o1 input 1 w=+0.115109951768787 w+  bank=n alpha=1 R=289578.206064126 G_phys=3.4532985530636e-06 G_eff=3.4532985530636e-06
Ro1p1n1 h1buf o1pn 289578.206064126
* o1 input 2 w=+0.416557305918275 w+  bank=n alpha=1 R=80021.0027762017 G_phys=1.24967191775482e-05 G_eff=1.24967191775482e-05
Ro1p2n1 h2buf o1pn 80021.0027762017
* o1 input 3 w=+0.460762298204741 w+  bank=n alpha=1 R=72343.8820042555 G_phys=1.38228689461422e-05 G_eff=1.38228689461422e-05
Ro1p3n1 h3buf o1pn 72343.8820042555
* o1 input 4 w=+0.128235529120638 w+  bank=n alpha=1 R=259938.361559493 G_phys=3.84706587361914e-06 G_eff=3.84706587361914e-06
Ro1p4n1 h4buf o1pn 259938.361559493
* o1 input 5 w=+0.25946188501651 w+  bank=n alpha=1 R=128471.021210735 G_phys=7.78385655049531e-06 G_eff=7.78385655049531e-06
Ro1p5n1 h5buf o1pn 128471.021210735
* o1 input 6 w=+0.0121141451968155 w+  bank=m alpha=0.01 R=27516.0424378073 G_phys=3.63424355904464e-05 G_eff=3.63424355904464e-07
Ro1p6m1 h6buf o1pm 27516.0424378073
* o1 input 7 w=-0.240253536162518 w-  bank=n alpha=1 R=138742.321406604 G_phys=7.20760608487554e-06 G_eff=7.20760608487554e-06
Ro1n7n1 h7buf o1nn 138742.321406604
* o1 input 8 w=+0.187475674056081 w+  bank=n alpha=1 R=177800.845369208 G_phys=5.62427022168244e-06 G_eff=5.62427022168244e-06
Ro1p8n1 h8buf o1pn 177800.845369208
* o1 input 9 w=-0.249792136720497 w-  bank=n alpha=1 R=133444.28600101 G_phys=7.4937641016149e-06 G_eff=7.4937641016149e-06
Ro1n9n1 h9buf o1nn 133444.28600101
* o1 input 10 w=-0.0478130377197742 w-  bank=n alpha=1 R=697159.915433434 G_phys=1.43439113159322e-06 G_eff=1.43439113159322e-06
Ro1n10n1 h10buf o1nn 697159.915433434
* o1 input 11 w=+0.103135444855694 w+  bank=n alpha=1 R=323199.588463238 G_phys=3.09406334567083e-06 G_eff=3.09406334567083e-06
Ro1p11n1 h11buf o1pn 323199.588463238
* o1 input 12 w=-0.0209153710838255 w-  bank=m alpha=0.01 R=15937.2421362923 G_phys=6.27461132514765e-05 G_eff=6.27461132514765e-07
Ro1n12m1 h12buf o1nm 15937.2421362923
* o1 input 13 w=-0.0177641479719743 w-  bank=m alpha=0.01 R=18764.3862153827 G_phys=5.32924439159229e-05 G_eff=5.32924439159229e-07
Ro1n13m1 h13buf o1nm 18764.3862153827
* o1 input 14 w=-0.162077236015947 w-  bank=n alpha=1 R=205663.263717389 G_phys=4.86231708047842e-06 G_eff=4.86231708047842e-06
Ro1n14n1 h14buf o1nn 205663.263717389
* o1 input 15 w=+0.156787201998635 w+  bank=n alpha=1 R=212602.386600556 G_phys=4.70361605995906e-06 G_eff=4.70361605995906e-06
Ro1p15n1 h15buf o1pn 212602.386600556
* o1 input 16 w=-0.00694237968883333 w-  bank=m alpha=0.01 R=48014.2758353441 G_phys=2.08271390665e-05 G_eff=2.08271390665e-07
Ro1n16m1 h16buf o1nm 48014.2758353441
* o1 input 17 w=+0.263424706628807 w+  bank=n alpha=1 R=126538.37128612 G_phys=7.90274119886422e-06 G_eff=7.90274119886422e-06
Ro1p17n1 h17buf o1pn 126538.37128612
* o1 input 18 w=+0.403807796552332 w+  bank=n alpha=1 R=82547.5229005725 G_phys=1.211423389657e-05 G_eff=1.211423389657e-05
Ro1p18n1 h18buf o1pn 82547.5229005725
* o1 input 19 w=+0.415931315874452 w+  bank=n alpha=1 R=80141.4369659891 G_phys=1.24779394762336e-05 G_eff=1.24779394762336e-05
Ro1p19n1 h19buf o1pn 80141.4369659891
* o1 input 20 w=+0.0719298844689274 w+  bank=n alpha=1 R=463414.248186827 G_phys=2.15789653406782e-06 G_eff=2.15789653406782e-06
Ro1p20n1 h20buf o1pn 463414.248186827
* o1 input 21 w=-0.387164693396724 w-  bank=n alpha=1 R=86096.0048833198 G_phys=1.16149408019017e-05 G_eff=1.16149408019017e-05
Ro1n21n1 h21buf o1nn 86096.0048833198
* o1 input 22 w=+0.13881898843949 w+  bank=n alpha=1 R=240120.848797735 G_phys=4.1645696531847e-06 G_eff=4.1645696531847e-06
Ro1p22n1 h22buf o1pn 240120.848797735
* o1 input 23 w=-0.118143194098524 w-  bank=n alpha=1 R=282143.491952108 G_phys=3.54429582295573e-06 G_eff=3.54429582295573e-06
Ro1n23n1 h23buf o1nn 282143.491952108
* o1 input 24 w=-0.494956544406075 w-  bank=n alpha=1 R=67345.9795815646 G_phys=1.48486963321823e-05 G_eff=1.48486963321823e-05
Ro1n24n1 h24buf o1nn 67345.9795815646
* o1 input 25 w=-0.0137314432186455 w-  bank=m alpha=0.01 R=24275.1856469617 G_phys=4.11943296559366e-05 G_eff=4.11943296559366e-07
Ro1n25m1 h25buf o1nm 24275.1856469617
* o1 input 26 w=+0.00762307525297978 w+  bank=m alpha=0.01 R=43726.8847901032 G_phys=2.28692257589393e-05 G_eff=2.28692257589393e-07
Ro1p26m1 h26buf o1pm 43726.8847901032
* o1 input 27 w=+0.187160704798257 w+  bank=n alpha=1 R=178100.063094247 G_phys=5.6148211439477e-06 G_eff=5.6148211439477e-06
Ro1p27n1 h27buf o1pn 178100.063094247
* o1 input 28 w=+0.0939442280900053 w+  bank=n alpha=1 R=354820.450505992 G_phys=2.81832684270016e-06 G_eff=2.81832684270016e-06
Ro1p28n1 h28buf o1pn 354820.450505992
* o1 input 29 w=+0.0315398664392492 w+  bank=m alpha=0.01 R=10568.6349045069 G_phys=9.46195993177476e-05 G_eff=9.46195993177476e-07
Ro1p29m1 h29buf o1pm 10568.6349045069
* o1 input 30 w=+0.183835448783735 w+  bank=n alpha=1 R=181321.576191471 G_phys=5.51506346351205e-06 G_eff=5.51506346351205e-06
Ro1p30n1 h30buf o1pn 181321.576191471
* o1 input 31 w=-0.236627512253244 w-  bank=n alpha=1 R=140868.375853351 G_phys=7.09882536759733e-06 G_eff=7.09882536759733e-06
Ro1n31n1 h31buf o1nn 140868.375853351
* o1 input 32 w=-0.230869865069063 w-  bank=n alpha=1 R=144381.482283805 G_phys=6.92609595207188e-06 G_eff=6.92609595207188e-06
Ro1n32n1 h32buf o1nn 144381.482283805
* o1 bias=-0.0809652357124875 b-  bank=n alpha=1 R=411699.330459582 G_phys=2.42895707137462e-06 G_eff=2.42895707137462e-06
Ro1bnn1 vref o1nn 411699.330459582
Vo1nm o1nm 0 DC 0
Fo1nm o1d 0 Vo1nm 0.01
Vo1nn o1nn 0 DC 0
Fo1nn o1d 0 Vo1nn 1
Vo1pm o1pm 0 DC 0
Fo1pm 0 o1d Vo1pm 0.01
Vo1pn o1pn 0 DC 0
Fo1pn 0 o1d Vo1pn 1
Vo1d o1d 0 DC 0
Ho1 o1lin 0 Vo1d 33333.3333333333

* o2 input 1 w=-0.195521390350609 w-  bank=n alpha=1 R=170484.330505015 G_phys=5.86564171051827e-06 G_eff=5.86564171051827e-06
Ro2n1n1 h1buf o2nn 170484.330505015
* o2 input 2 w=+0.386445174905558 w+  bank=n alpha=1 R=86256.3061926689 G_phys=1.15933552471668e-05 G_eff=1.15933552471668e-05
Ro2p2n1 h2buf o2pn 86256.3061926689
* o2 input 3 w=+0.296294588630229 w+  bank=n alpha=1 R=112500.648383197 G_phys=8.88883765890688e-06 G_eff=8.88883765890688e-06
Ro2p3n1 h3buf o2pn 112500.648383197
* o2 input 4 w=-0.299308681857295 w-  bank=n alpha=1 R=111367.746256108 G_phys=8.97926045571886e-06 G_eff=8.97926045571886e-06
Ro2n4n1 h4buf o2nn 111367.746256108
* o2 input 5 w=+0.732671792857329 w+  bank=n alpha=1 R=45495.5870531571 G_phys=2.19801537857199e-05 G_eff=2.19801537857199e-05
Ro2p5n1 h5buf o2pn 45495.5870531571
* o2 input 6 w=+0.124925987288217 w+  bank=n alpha=1 R=266824.65399637 G_phys=3.7477796186465e-06 G_eff=3.7477796186465e-06
Ro2p6n1 h6buf o2pn 266824.65399637
* o2 input 7 w=-0.0857938493267301 w-  bank=n alpha=1 R=388528.240601368 G_phys=2.5738154798019e-06 G_eff=2.5738154798019e-06
Ro2n7n1 h7buf o2nn 388528.240601368
* o2 input 8 w=-0.0609936542707342 w-  bank=n alpha=1 R=546504.939438057 G_phys=1.82980962812202e-06 G_eff=1.82980962812202e-06
Ro2n8n1 h8buf o2nn 546504.939438057
* o2 input 9 w=+0.256981204903229 w+  bank=n alpha=1 R=129711.172246568 G_phys=7.70943614709688e-06 G_eff=7.70943614709688e-06
Ro2p9n1 h9buf o2pn 129711.172246568
* o2 input 10 w=+0.073638013162671 w+  bank=n alpha=1 R=452664.756987643 G_phys=2.20914039488013e-06 G_eff=2.20914039488013e-06
Ro2p10n1 h10buf o2pn 452664.756987643
* o2 input 11 w=-0.149208279345328 w-  bank=n alpha=1 R=223401.365390634 G_phys=4.47624838035983e-06 G_eff=4.47624838035983e-06
Ro2n11n1 h11buf o2nn 223401.365390634
* o2 input 12 w=-0.475362564845884 w-  bank=n alpha=1 R=70121.9149306388 G_phys=1.42608769453765e-05 G_eff=1.42608769453765e-05
Ro2n12n1 h12buf o2nn 70121.9149306388
* o2 input 13 w=-0.0533811781970356 w-  bank=n alpha=1 R=624439.820535554 G_phys=1.60143534591107e-06 G_eff=1.60143534591107e-06
Ro2n13n1 h13buf o2nn 624439.820535554
* o2 input 14 w=+0.279456004632752 w+  bank=n alpha=1 R=119279.359830319 G_phys=8.38368013898257e-06 G_eff=8.38368013898257e-06
Ro2p14n1 h14buf o2pn 119279.359830319
* o2 input 15 w=-0.0744870090943736 w-  bank=n alpha=1 R=447505.326614748 G_phys=2.23461027283121e-06 G_eff=2.23461027283121e-06
Ro2n15n1 h15buf o2nn 447505.326614748
* o2 input 16 w=-0.0222148593491043 w-  bank=m alpha=0.01 R=15004.9715865869 G_phys=6.66445780473128e-05 G_eff=6.66445780473128e-07
Ro2n16m1 h16buf o2nm 15004.9715865869
* o2 input 17 w=+0.0088751960388594 w+  bank=m alpha=0.01 R=37557.8558348297 G_phys=2.66255881165782e-05 G_eff=2.66255881165782e-07
Ro2p17m1 h17buf o2pm 37557.8558348297
* o2 input 18 w=-0.194172060066752 w-  bank=n alpha=1 R=171669.051262443 G_phys=5.82516180200256e-06 G_eff=5.82516180200256e-06
Ro2n18n1 h18buf o2nn 171669.051262443
* o2 input 19 w=+0.341327626188232 w+  bank=n alpha=1 R=97657.8828546125 G_phys=1.0239828785647e-05 G_eff=1.0239828785647e-05
Ro2p19n1 h19buf o2pn 97657.8828546125
* o2 input 20 w=-0.0323870183321868 w-  bank=m alpha=0.01 R=10292.1896024637 G_phys=9.71610549965604e-05 G_eff=9.71610549965604e-07
Ro2n20m1 h20buf o2nm 10292.1896024637
* o2 input 21 w=-0.0999542141187652 w-  bank=n alpha=1 R=333486.022847689 G_phys=2.99862642356296e-06 G_eff=2.99862642356296e-06
Ro2n21n1 h21buf o2nn 333486.022847689
* o2 input 22 w=+0.693789300406694 w+  bank=n alpha=1 R=48045.3263170729 G_phys=2.08136790122008e-05 G_eff=2.08136790122008e-05
Ro2p22n1 h22buf o2pn 48045.3263170729
* o2 input 23 w=+0.0972685864670828 w+  bank=n alpha=1 R=342693.715864925 G_phys=2.91805759401248e-06 G_eff=2.91805759401248e-06
Ro2p23n1 h23buf o2pn 342693.715864925
* o2 input 24 w=-0.0293783170287994 w-  bank=m alpha=0.01 R=11346.236512002 G_phys=8.81349510863982e-05 G_eff=8.81349510863982e-07
Ro2n24m1 h24buf o2nm 11346.236512002
* o2 input 25 w=+0.0497492024826392 w+  bank=n alpha=1 R=670027.491294269 G_phys=1.49247607447918e-06 G_eff=1.49247607447918e-06
Ro2p25n1 h25buf o2pn 670027.491294269
* o2 input 26 w=-0.466063512962686 w-  bank=n alpha=1 R=71521.0103477937 G_phys=1.39819053888806e-05 G_eff=1.39819053888806e-05
Ro2n26n1 h26buf o2nn 71521.0103477937
* o2 input 27 w=+0.194887582685885 w+  bank=n alpha=1 R=171038.774630702 G_phys=5.84662748057655e-06 G_eff=5.84662748057655e-06
Ro2p27n1 h27buf o2pn 171038.774630702
* o2 input 28 w=+0.209047565197081 w+  bank=n alpha=1 R=159453.344036359 G_phys=6.27142695591242e-06 G_eff=6.27142695591242e-06
Ro2p28n1 h28buf o2pn 159453.344036359
* o2 input 29 w=+0.00919963467526149 w+  bank=m alpha=0.01 R=36233.3228546229 G_phys=2.75989040257845e-05 G_eff=2.75989040257845e-07
Ro2p29m1 h29buf o2pm 36233.3228546229
* o2 input 30 w=-0.379437042796868 w-  bank=n alpha=1 R=87849.4442388387 G_phys=1.13831112839061e-05 G_eff=1.13831112839061e-05
Ro2n30n1 h30buf o2nn 87849.4442388387
* o2 input 31 w=-0.216631724491884 w-  bank=n alpha=1 R=153870.96885979 G_phys=6.49895173475653e-06 G_eff=6.49895173475653e-06
Ro2n31n1 h31buf o2nn 153870.96885979
* o2 input 32 w=+0.139103822260271 w+  bank=n alpha=1 R=239629.169002738 G_phys=4.17311466780814e-06 G_eff=4.17311466780814e-06
Ro2p32n1 h32buf o2pn 239629.169002738
* o2 bias=+0.0322130531942455 b+  bank=m alpha=0.01 R=10347.7721072674 G_phys=9.66391595827364e-05 G_eff=9.66391595827364e-07
Ro2bpm1 vref o2pm 10347.7721072674
Vo2nm o2nm 0 DC 0
Fo2nm o2d 0 Vo2nm 0.01
Vo2nn o2nn 0 DC 0
Fo2nn o2d 0 Vo2nn 1
Vo2pm o2pm 0 DC 0
Fo2pm 0 o2d Vo2pm 0.01
Vo2pn o2pn 0 DC 0
Fo2pn 0 o2d Vo2pn 1
Vo2d o2d 0 DC 0
Ho2 o2lin 0 Vo2d 33333.3333333333

* o3 input 1 w=-0.100595944434035 w-  bank=n alpha=1 R=331358.620080271 G_phys=3.01787833302104e-06 G_eff=3.01787833302104e-06
Ro3n1n1 h1buf o3nn 331358.620080271
* o3 input 2 w=-0.265315115107159 w-  bank=n alpha=1 R=125636.767132058 G_phys=7.95945345321476e-06 G_eff=7.95945345321476e-06
Ro3n2n1 h2buf o3nn 125636.767132058
* o3 input 3 w=-0.0591677372187977 w-  bank=n alpha=1 R=563370.088162562 G_phys=1.77503211656393e-06 G_eff=1.77503211656393e-06
Ro3n3n1 h3buf o3nn 563370.088162562
* o3 input 4 w=-0.0695954531730398 w-  bank=n alpha=1 R=478958.492452868 G_phys=2.08786359519119e-06 G_eff=2.08786359519119e-06
Ro3n4n1 h4buf o3nn 478958.492452868
* o3 input 5 w=-0.284313347850547 w-  bank=n alpha=1 R=117241.53503639 G_phys=8.52940043551641e-06 G_eff=8.52940043551641e-06
Ro3n5n1 h5buf o3nn 117241.53503639
* o3 input 6 w=+0.314440272159438 w+  bank=n alpha=1 R=106008.473737841 G_phys=9.43320816478313e-06 G_eff=9.43320816478313e-06
Ro3p6n1 h6buf o3pn 106008.473737841
* o3 input 7 w=-0.349535009995164 w-  bank=n alpha=1 R=95364.7914519193 G_phys=1.04860502998549e-05 G_eff=1.04860502998549e-05
Ro3n7n1 h7buf o3nn 95364.7914519193
* o3 input 8 w=-0.295696300813859 w-  bank=n alpha=1 R=112728.273034152 G_phys=8.87088902441576e-06 G_eff=8.87088902441576e-06
Ro3n8n1 h8buf o3nn 112728.273034152
* o3 input 9 w=-0.735854867565559 w-  bank=n alpha=1 R=45298.7875769723 G_phys=2.20756460269668e-05 G_eff=2.20756460269668e-05
Ro3n9n1 h9buf o3nn 45298.7875769723
* o3 input 10 w=-0.0859238760568894 w-  bank=n alpha=1 R=387940.289277262 G_phys=2.57771628170668e-06 G_eff=2.57771628170668e-06
Ro3n10n1 h10buf o3nn 387940.289277262
* o3 input 11 w=-0.105996934570411 w-  bank=n alpha=1 R=314474.503139436 G_phys=3.17990803711233e-06 G_eff=3.17990803711233e-06
Ro3n11n1 h11buf o3nn 314474.503139436
* o3 input 12 w=-0.193541479603888 w-  bank=n alpha=1 R=172228.36883109 G_phys=5.80624438811663e-06 G_eff=5.80624438811663e-06
Ro3n12n1 h12buf o3nn 172228.36883109
* o3 input 13 w=-0.351950930756974 w-  bank=n alpha=1 R=94710.172414206 G_phys=1.05585279227092e-05 G_eff=1.05585279227092e-05
Ro3n13n1 h13buf o3nn 94710.172414206
* o3 input 14 w=+0.0402342325324318 w+  bank=n alpha=1 R=828481.898007229 G_phys=1.20702697597296e-06 G_eff=1.20702697597296e-06
Ro3p14n1 h14buf o3pn 828481.898007229
* o3 input 15 w=+0.188158881095559 w+  bank=n alpha=1 R=177155.248475381 G_phys=5.64476643286676e-06 G_eff=5.64476643286676e-06
Ro3p15n1 h15buf o3pn 177155.248475381
* o3 input 16 w=+0.204693314484602 w+  bank=n alpha=1 R=162845.246886853 G_phys=6.14079943453807e-06 G_eff=6.14079943453807e-06
Ro3p16n1 h16buf o3pn 162845.246886853
* o3 input 17 w=+0.153640089266272 w+  bank=n alpha=1 R=216957.263514496 G_phys=4.60920267798816e-06 G_eff=4.60920267798816e-06
Ro3p17n1 h17buf o3pn 216957.263514496
* o3 input 18 w=+0.463153650429953 w+  bank=n alpha=1 R=71970.3564948468 G_phys=1.38946095128986e-05 G_eff=1.38946095128986e-05
Ro3p18n1 h18buf o3pn 71970.3564948468
* o3 input 19 w=-0.0426705918571366 w-  bank=n alpha=1 R=781178.134227318 G_phys=1.2801177557141e-06 G_eff=1.2801177557141e-06
Ro3n19n1 h19buf o3nn 781178.134227318
* o3 input 20 w=+0.210331327799834 w+  bank=n alpha=1 R=158480.116500076 G_phys=6.30993983399502e-06 G_eff=6.30993983399502e-06
Ro3p20n1 h20buf o3pn 158480.116500076
* o3 input 21 w=-0.0625815721904128 w-  bank=n alpha=1 R=532638.157953466 G_phys=1.87744716571238e-06 G_eff=1.87744716571238e-06
Ro3n21n1 h21buf o3nn 532638.157953466
* o3 input 22 w=+0.238697201684848 w+  bank=n alpha=1 R=139646.938037185 G_phys=7.16091605054544e-06 G_eff=7.16091605054544e-06
Ro3p22n1 h22buf o3pn 139646.938037185
* o3 input 23 w=-0.0558624260671465 w-  bank=n alpha=1 R=596704.004463873 G_phys=1.67587278201439e-06 G_eff=1.67587278201439e-06
Ro3n23n1 h23buf o3nn 596704.004463873
* o3 input 24 w=+0.439236044835332 w+  bank=n alpha=1 R=75889.3395140872 G_phys=1.317708134506e-05 G_eff=1.317708134506e-05
Ro3p24n1 h24buf o3pn 75889.3395140872
* o3 input 25 w=+0.113742741787302 w+  bank=n alpha=1 R=293058.992684265 G_phys=3.41228225361907e-06 G_eff=3.41228225361907e-06
Ro3p25n1 h25buf o3pn 293058.992684265
* o3 input 26 w=-0.433617266896606 w-  bank=n alpha=1 R=76872.7075190056 G_phys=1.30085180068982e-05 G_eff=1.30085180068982e-05
Ro3n26n1 h26buf o3nn 76872.7075190056
* o3 input 27 w=+0.230315174630548 w+  bank=n alpha=1 R=144729.210252012 G_phys=6.90945523891643e-06 G_eff=6.90945523891643e-06
Ro3p27n1 h27buf o3pn 144729.210252012
* o3 input 28 w=-0.12398109066818 w-  bank=n alpha=1 R=268858.203728388 G_phys=3.71943272004541e-06 G_eff=3.71943272004541e-06
Ro3n28n1 h28buf o3nn 268858.203728388
* o3 input 29 w=-0.26178305647614 w-  bank=n alpha=1 R=127331.897572108 G_phys=7.85349169428421e-06 G_eff=7.85349169428421e-06
Ro3n29n1 h29buf o3nn 127331.897572108
* o3 input 30 w=-0.44647126763401 w-  bank=n alpha=1 R=74659.5262668906 G_phys=1.33941380290203e-05 G_eff=1.33941380290203e-05
Ro3n30n1 h30buf o3nn 74659.5262668906
* o3 input 31 w=-0.53039390006668 w-  bank=n alpha=1 R=62846.3738537392 G_phys=1.59118170020004e-05 G_eff=1.59118170020004e-05
Ro3n31n1 h31buf o3nn 62846.3738537392
* o3 input 32 w=+0.288818654520262 w+  bank=n alpha=1 R=115412.674394946 G_phys=8.66455963560785e-06 G_eff=8.66455963560785e-06
Ro3p32n1 h32buf o3pn 115412.674394946
* o3 bias=+0.0635007025703613 b+  bank=n alpha=1 R=524928.575339756 G_phys=1.90502107711084e-06 G_eff=1.90502107711084e-06
Ro3bpn1 vref o3pn 524928.575339756
Vo3nn o3nn 0 DC 0
Fo3nn o3d 0 Vo3nn 1
Vo3pn o3pn 0 DC 0
Fo3pn 0 o3d Vo3pn 1
Vo3d o3d 0 DC 0
Ho3 o3lin 0 Vo3d 33333.3333333333

* o4 input 1 w=+0.274757256178841 w+  bank=n alpha=1 R=121319.210261863 G_phys=8.24271768536522e-06 G_eff=8.24271768536522e-06
Ro4p1n1 h1buf o4pn 121319.210261863
* o4 input 2 w=-0.133159767354893 w-  bank=n alpha=1 R=250325.860396666 G_phys=3.99479302064678e-06 G_eff=3.99479302064678e-06
Ro4n2n1 h2buf o4nn 250325.860396666
* o4 input 3 w=-0.106623598682841 w-  bank=n alpha=1 R=312626.226699453 G_phys=3.19870796048523e-06 G_eff=3.19870796048523e-06
Ro4n3n1 h3buf o4nn 312626.226699453
* o4 input 4 w=+0.10049322803724 w+  bank=n alpha=1 R=331697.309205562 G_phys=3.01479684111719e-06 G_eff=3.01479684111719e-06
Ro4p4n1 h4buf o4pn 331697.309205562
* o4 input 5 w=-0.195742340683107 w-  bank=n alpha=1 R=170291.890947078 G_phys=5.87227022049321e-06 G_eff=5.87227022049321e-06
Ro4n5n1 h5buf o4nn 170291.890947078
* o4 input 6 w=-0.202179592890339 w-  bank=n alpha=1 R=164869.920137851 G_phys=6.06538778671016e-06 G_eff=6.06538778671016e-06
Ro4n6n1 h6buf o4nn 164869.920137851
* o4 input 7 w=-0.112561544712497 w-  bank=n alpha=1 R=296134.291853162 G_phys=3.37684634137491e-06 G_eff=3.37684634137491e-06
Ro4n7n1 h7buf o4nn 296134.291853162
* o4 input 8 w=+0.0264861793940817 w+  bank=m alpha=0.01 R=12585.179930021 G_phys=7.94585381822452e-05 G_eff=7.94585381822452e-07
Ro4p8m1 h8buf o4pm 12585.179930021
* o4 input 9 w=-0.0974936293293829 w-  bank=n alpha=1 R=341902.681873874 G_phys=2.92480887988149e-06 G_eff=2.92480887988149e-06
Ro4n9n1 h9buf o4nn 341902.681873874
* o4 input 10 w=-0.296895349286464 w-  bank=n alpha=1 R=112273.006005127 G_phys=8.90686047859392e-06 G_eff=8.90686047859392e-06
Ro4n10n1 h10buf o4nn 112273.006005127
* o4 input 11 w=-0.580818210763829 w-  bank=n alpha=1 R=57390.303395441 G_phys=1.74245463229149e-05 G_eff=1.74245463229149e-05
Ro4n11n1 h11buf o4nn 57390.303395441
* o4 input 12 w=-0.276549005245937 w-  bank=n alpha=1 R=120533.188335607 G_phys=8.29647015737811e-06 G_eff=8.29647015737811e-06
Ro4n12n1 h12buf o4nn 120533.188335607
* o4 input 13 w=-0.164579538023522 w-  bank=n alpha=1 R=202536.316079398 G_phys=4.93738614070565e-06 G_eff=4.93738614070565e-06
Ro4n13n1 h13buf o4nn 202536.316079398
* o4 input 14 w=-0.00939321676538441 w-  bank=m alpha=0.01 R=35486.6007736267 G_phys=2.81796502961532e-05 G_eff=2.81796502961532e-07
Ro4n14m1 h14buf o4nm 35486.6007736267
* o4 input 15 w=-0.0690593814994067 w-  bank=n alpha=1 R=482676.395438319 G_phys=2.0717814449822e-06 G_eff=2.0717814449822e-06
Ro4n15n1 h15buf o4nn 482676.395438319
* o4 input 16 w=-0.272869230842632 w-  bank=n alpha=1 R=122158.637052623 G_phys=8.18607692527895e-06 G_eff=8.18607692527895e-06
Ro4n16n1 h16buf o4nn 122158.637052623
* o4 input 17 w=+0.168866320874711 w+  bank=n alpha=1 R=197394.798208843 G_phys=5.06598962624132e-06 G_eff=5.06598962624132e-06
Ro4p17n1 h17buf o4pn 197394.798208843
* o4 input 18 w=-0.0339148293163791 w-  bank=n alpha=1 R=982854.226461786 G_phys=1.01744487949137e-06 G_eff=1.01744487949137e-06
Ro4n18n1 h18buf o4nn 982854.226461786
* o4 input 19 w=-0.0805852645818897 w-  bank=n alpha=1 R=413640.552106898 G_phys=2.41755793745669e-06 G_eff=2.41755793745669e-06
Ro4n19n1 h19buf o4nn 413640.552106898
* o4 input 20 w=+0.0499049155841609 w+  bank=n alpha=1 R=667936.874417093 G_phys=1.49714746752483e-06 G_eff=1.49714746752483e-06
Ro4p20n1 h20buf o4pn 667936.874417093
* o4 input 21 w=+0.0630428027700635 w+  bank=n alpha=1 R=528741.29747864 G_phys=1.8912840831019e-06 G_eff=1.8912840831019e-06
Ro4p21n1 h21buf o4pn 528741.29747864
* o4 input 22 w=+0.077534797791833 w+  bank=n alpha=1 R=429914.493655189 G_phys=2.32604393375499e-06 G_eff=2.32604393375499e-06
Ro4p22n1 h22buf o4pn 429914.493655189
* o4 input 23 w=+0.0744829629231984 w+  bank=n alpha=1 R=447529.636645958 G_phys=2.23448888769595e-06 G_eff=2.23448888769595e-06
Ro4p23n1 h23buf o4pn 447529.636645958
* o4 input 24 w=-0.00836970221956497 w-  bank=m alpha=0.01 R=39826.1879083506 G_phys=2.51091066586949e-05 G_eff=2.51091066586949e-07
Ro4n24m1 h24buf o4nm 39826.1879083506
* o4 input 25 w=-0.0959555339157937 w-  bank=n alpha=1 R=347383.126048626 G_phys=2.87866601747381e-06 G_eff=2.87866601747381e-06
Ro4n25n1 h25buf o4nn 347383.126048626
* o4 input 26 w=-0.27047998771669 w-  bank=n alpha=1 R=123237.706474047 G_phys=8.1143996315007e-06 G_eff=8.1143996315007e-06
Ro4n26n1 h26buf o4nn 123237.706474047
* o4 input 27 w=-0.0478904255869687 w-  bank=n alpha=1 R=696033.349563792 G_phys=1.43671276760906e-06 G_eff=1.43671276760906e-06
Ro4n27n1 h27buf o4nn 696033.349563792
* o4 input 28 w=-0.311644423649809 w-  bank=n alpha=1 R=106959.505140351 G_phys=9.34933270949427e-06 G_eff=9.34933270949427e-06
Ro4n28n1 h28buf o4nn 106959.505140351
* o4 input 29 w=-0.0286856006407659 w-  bank=m alpha=0.01 R=11620.2319591532 G_phys=8.60568019222978e-05 G_eff=8.60568019222978e-07
Ro4n29m1 h29buf o4nm 11620.2319591532
* o4 input 30 w=-0.016265879828258 w-  bank=m alpha=0.01 R=20492.7945400314 G_phys=4.87976394847741e-05 G_eff=4.87976394847741e-07
Ro4n30m1 h30buf o4nm 20492.7945400314
* o4 input 31 w=-0.119685509607977 w-  bank=n alpha=1 R=278507.677683913 G_phys=3.59056528823931e-06 G_eff=3.59056528823931e-06
Ro4n31n1 h31buf o4nn 278507.677683913
* o4 input 32 w=-0.0356690164245122 w-  bank=n alpha=1 R=934517.872223306 G_phys=1.07007049273537e-06 G_eff=1.07007049273537e-06
Ro4n32n1 h32buf o4nn 934517.872223306
* o4 bias=+0.0671312079863495 b+  bank=n alpha=1 R=496540.049452281 G_phys=2.01393623959048e-06 G_eff=2.01393623959048e-06
Ro4bpn1 vref o4pn 496540.049452281
Vo4nm o4nm 0 DC 0
Fo4nm o4d 0 Vo4nm 0.01
Vo4nn o4nn 0 DC 0
Fo4nn o4d 0 Vo4nn 1
Vo4pm o4pm 0 DC 0
Fo4pm 0 o4d Vo4pm 0.01
Vo4pn o4pn 0 DC 0
Fo4pn 0 o4d Vo4pn 1
Vo4d o4d 0 DC 0
Ho4 o4lin 0 Vo4d 33333.3333333333

* o5 input 1 w=+0.0860510418468527 w+  bank=n alpha=1 R=387366.99309995 G_phys=2.58153125540558e-06 G_eff=2.58153125540558e-06
Ro5p1n1 h1buf o5pn 387366.99309995
* o5 input 2 w=-0.140209371980717 w-  bank=n alpha=1 R=237739.695017803 G_phys=4.20628115942151e-06 G_eff=4.20628115942151e-06
Ro5n2n1 h2buf o5nn 237739.695017803
* o5 input 3 w=-0.298670153474102 w-  bank=n alpha=1 R=111605.839906008 G_phys=8.96010460422305e-06 G_eff=8.96010460422305e-06
Ro5n3n1 h3buf o5nn 111605.839906008
* o5 input 4 w=+0.194023589749981 w+  bank=n alpha=1 R=171800.415487038 G_phys=5.82070769249943e-06 G_eff=5.82070769249943e-06
Ro5p4n1 h4buf o5pn 171800.415487038
* o5 input 5 w=+0.104223096266613 w+  bank=n alpha=1 R=319826.74212694 G_phys=3.1266928879984e-06 G_eff=3.1266928879984e-06
Ro5p5n1 h5buf o5pn 319826.74212694
* o5 input 6 w=+0.179601423642336 w+  bank=n alpha=1 R=185596.153178131 G_phys=5.38804270927008e-06 G_eff=5.38804270927008e-06
Ro5p6n1 h6buf o5pn 185596.153178131
* o5 input 7 w=-0.15816414054373 w-  bank=n alpha=1 R=210751.521923626 G_phys=4.74492421631189e-06 G_eff=4.74492421631189e-06
Ro5n7n1 h7buf o5nn 210751.521923626
* o5 input 8 w=-0.249576912278698 w-  bank=n alpha=1 R=133559.362638923 G_phys=7.48730736836095e-06 G_eff=7.48730736836095e-06
Ro5n8n1 h8buf o5nn 133559.362638923
* o5 input 9 w=-0.031381439286146 w-  bank=m alpha=0.01 R=10621.9899697364 G_phys=9.4144317858438e-05 G_eff=9.4144317858438e-07
Ro5n9m1 h9buf o5nm 10621.9899697364
* o5 input 10 w=+0.375618440651073 w+  bank=n alpha=1 R=88742.5369094113 G_phys=1.12685532195322e-05 G_eff=1.12685532195322e-05
Ro5p10n1 h10buf o5pn 88742.5369094113
* o5 input 11 w=+0.0953608962368974 w+  bank=n alpha=1 R=349549.287482848 G_phys=2.86082688710692e-06 G_eff=2.86082688710692e-06
Ro5p11n1 h11buf o5pn 349549.287482848
* o5 input 12 w=+0.235920649298708 w+  bank=n alpha=1 R=141290.44419138 G_phys=7.07761947896125e-06 G_eff=7.07761947896125e-06
Ro5p12n1 h12buf o5pn 141290.44419138
* o5 input 13 w=-0.0940916695355706 w-  bank=n alpha=1 R=354264.447616502 G_phys=2.82275008606712e-06 G_eff=2.82275008606712e-06
Ro5n13n1 h13buf o5nn 354264.447616502
* o5 input 14 w=+0.00295126144933853 w+  bank=m alpha=0.01 R=112946.053426762 G_phys=8.85378434801559e-06 G_eff=8.85378434801559e-08
Ro5p14m1 h14buf o5pm 112946.053426762
* o5 input 15 w=+0.529616924207031 w+  bank=n alpha=1 R=62938.572786815 G_phys=1.58885077262109e-05 G_eff=1.58885077262109e-05
Ro5p15n1 h15buf o5pn 62938.572786815
* o5 input 16 w=+0.319042125899952 w+  bank=n alpha=1 R=104479.410796637 G_phys=9.57126377699856e-06 G_eff=9.57126377699856e-06
Ro5p16n1 h16buf o5pn 104479.410796637
* o5 input 17 w=-0.466616152697173 w-  bank=n alpha=1 R=71436.3039956017 G_phys=1.39984845809152e-05 G_eff=1.39984845809152e-05
Ro5n17n1 h17buf o5nn 71436.3039956017
* o5 input 18 w=-0.243973793531226 w-  bank=n alpha=1 R=136626.696051546 G_phys=7.31921380593677e-06 G_eff=7.31921380593677e-06
Ro5n18n1 h18buf o5nn 136626.696051546
* o5 input 19 w=-0.167620412829882 w-  bank=n alpha=1 R=198862.01668745 G_phys=5.02861238489647e-06 G_eff=5.02861238489647e-06
Ro5n19n1 h19buf o5nn 198862.01668745
* o5 input 20 w=+0.191248887162316 w+  bank=n alpha=1 R=174292.953166534 G_phys=5.73746661486949e-06 G_eff=5.73746661486949e-06
Ro5p20n1 h20buf o5pn 174292.953166534
* o5 input 21 w=+0.174220054558956 w+  bank=n alpha=1 R=191328.91111599 G_phys=5.22660163676868e-06 G_eff=5.22660163676868e-06
Ro5p21n1 h21buf o5pn 191328.91111599
* o5 input 22 w=-0.14737880105185 w-  bank=n alpha=1 R=226174.545426015 G_phys=4.4213640315555e-06 G_eff=4.4213640315555e-06
Ro5n22n1 h22buf o5nn 226174.545426015
* o5 input 23 w=-0.261133636281725 w-  bank=n alpha=1 R=127648.562659203 G_phys=7.83400908845174e-06 G_eff=7.83400908845174e-06
Ro5n23n1 h23buf o5nn 127648.562659203
* o5 input 24 w=+0.130521837388059 w+  bank=n alpha=1 R=255385.106434174 G_phys=3.91565512164177e-06 G_eff=3.91565512164177e-06
Ro5p24n1 h24buf o5pn 255385.106434174
* o5 input 25 w=-0.326372621774105 w-  bank=n alpha=1 R=102132.749837101 G_phys=9.79117865322314e-06 G_eff=9.79117865322314e-06
Ro5n25n1 h25buf o5nn 102132.749837101
* o5 input 26 w=+0.16696553546102 w+  bank=n alpha=1 R=199641.99941799 G_phys=5.00896606383059e-06 G_eff=5.00896606383059e-06
Ro5p26n1 h26buf o5pn 199641.99941799
* o5 input 27 w=-0.105618085709112 w-  bank=n alpha=1 R=315602.513618153 G_phys=3.16854257127337e-06 G_eff=3.16854257127337e-06
Ro5n27n1 h27buf o5nn 315602.513618153
* o5 input 28 w=+0.0630335864648206 w+  bank=n alpha=1 R=528818.606124163 G_phys=1.89100759394462e-06 G_eff=1.89100759394462e-06
Ro5p28n1 h28buf o5pn 528818.606124163
* o5 input 29 w=+0.231531157265063 w+  bank=n alpha=1 R=143969.104318744 G_phys=6.94593471795189e-06 G_eff=6.94593471795189e-06
Ro5p29n1 h29buf o5pn 143969.104318744
* o5 input 30 w=-0.0894419530377066 w-  bank=n alpha=1 R=372681.188203491 G_phys=2.6832585911312e-06 G_eff=2.6832585911312e-06
Ro5n30n1 h30buf o5nn 372681.188203491
* o5 input 31 w=+0.216486138811528 w+  bank=n alpha=1 R=153974.446199316 G_phys=6.49458416434585e-06 G_eff=6.49458416434585e-06
Ro5p31n1 h31buf o5pn 153974.446199316
* o5 input 32 w=-0.32037829849107 w-  bank=n alpha=1 R=104043.668033472 G_phys=9.6113489547321e-06 G_eff=9.6113489547321e-06
Ro5n32n1 h32buf o5nn 104043.668033472
* o5 bias=+0.0022999314168152 b+  bank=m alpha=0.01 R=144931.85792249 G_phys=6.89979425044561e-06 G_eff=6.89979425044561e-08
Ro5bpm1 vref o5pm 144931.85792249
Vo5nm o5nm 0 DC 0
Fo5nm o5d 0 Vo5nm 0.01
Vo5nn o5nn 0 DC 0
Fo5nn o5d 0 Vo5nn 1
Vo5pm o5pm 0 DC 0
Fo5pm 0 o5d Vo5pm 0.01
Vo5pn o5pn 0 DC 0
Fo5pn 0 o5d Vo5pn 1
Vo5d o5d 0 DC 0
Ho5 o5lin 0 Vo5d 33333.3333333333

* o6 input 1 w=+0.177051530119574 w+  bank=n alpha=1 R=188269.106236028 G_phys=5.31154590358722e-06 G_eff=5.31154590358722e-06
Ro6p1n1 h1buf o6pn 188269.106236028
* o6 input 2 w=+0.301592495922723 w+  bank=n alpha=1 R=110524.412191855 G_phys=9.04777487768168e-06 G_eff=9.04777487768168e-06
Ro6p2n1 h2buf o6pn 110524.412191855
* o6 input 3 w=+0.171870982949934 w+  bank=n alpha=1 R=193943.92678282 G_phys=5.15612948849803e-06 G_eff=5.15612948849803e-06
Ro6p3n1 h3buf o6pn 193943.92678282
* o6 input 4 w=-0.3405205591368 w-  bank=n alpha=1 R=97889.3415946205 G_phys=1.0215616774104e-05 G_eff=1.0215616774104e-05
Ro6n4n1 h4buf o6nn 97889.3415946205
* o6 input 5 w=-0.19025500833844 w-  bank=n alpha=1 R=175203.447333368 G_phys=5.70765025015321e-06 G_eff=5.70765025015321e-06
Ro6n5n1 h5buf o6nn 175203.447333368
* o6 input 6 w=+0.141724280050197 w+  bank=n alpha=1 R=235198.466497956 G_phys=4.25172840150592e-06 G_eff=4.25172840150592e-06
Ro6p6n1 h6buf o6pn 235198.466497956
* o6 input 7 w=-0.0326153624876146 w-  bank=m alpha=0.01 R=10220.1327199694 G_phys=9.78460874628438e-05 G_eff=9.78460874628438e-07
Ro6n7m1 h7buf o6nm 10220.1327199694
* o6 input 8 w=+0.106637930601 w+  bank=n alpha=1 R=312584.210378712 G_phys=3.19913791802999e-06 G_eff=3.19913791802999e-06
Ro6p8n1 h8buf o6pn 312584.210378712
* o6 input 9 w=+0.167194950685368 w+  bank=n alpha=1 R=199368.062233296 G_phys=5.01584852056104e-06 G_eff=5.01584852056104e-06
Ro6p9n1 h9buf o6pn 199368.062233296
* o6 input 10 w=-0.113695758135469 w-  bank=n alpha=1 R=293180.096425556 G_phys=3.41087274406406e-06 G_eff=3.41087274406406e-06
Ro6n10n1 h10buf o6nn 293180.096425556
* o6 input 11 w=+0.174899957381211 w+  bank=n alpha=1 R=190585.142686343 G_phys=5.24699872143633e-06 G_eff=5.24699872143633e-06
Ro6p11n1 h11buf o6pn 190585.142686343
* o6 input 12 w=-0.244360694504916 w-  bank=n alpha=1 R=136410.372383611 G_phys=7.33082083514748e-06 G_eff=7.33082083514748e-06
Ro6n12n1 h12buf o6nn 136410.372383611
* o6 input 13 w=+0.255772583539878 w+  bank=n alpha=1 R=130324.106172764 G_phys=7.67317750619635e-06 G_eff=7.67317750619635e-06
Ro6p13n1 h13buf o6pn 130324.106172764
* o6 input 14 w=+0.139949769298614 w+  bank=n alpha=1 R=238180.695119327 G_phys=4.19849307895843e-06 G_eff=4.19849307895843e-06
Ro6p14n1 h14buf o6pn 238180.695119327
* o6 input 15 w=-0.401168375335584 w-  bank=n alpha=1 R=83090.6307244419 G_phys=1.20350512600675e-05 G_eff=1.20350512600675e-05
Ro6n15n1 h15buf o6nn 83090.6307244419
* o6 input 16 w=+0.405832076822582 w+  bank=n alpha=1 R=82135.777916603 G_phys=1.21749623046775e-05 G_eff=1.21749623046775e-05
Ro6p16n1 h16buf o6pn 82135.777916603
* o6 input 17 w=-0.113061682974004 w-  bank=n alpha=1 R=294824.315864798 G_phys=3.39185048922012e-06 G_eff=3.39185048922012e-06
Ro6n17n1 h17buf o6nn 294824.315864798
* o6 input 18 w=-0.197513353657142 w-  bank=n alpha=1 R=168764.960526141 G_phys=5.92540060971425e-06 G_eff=5.92540060971425e-06
Ro6n18n1 h18buf o6nn 168764.960526141
* o6 input 19 w=-0.228990652840289 w-  bank=n alpha=1 R=145566.349193222 G_phys=6.86971958520868e-06 G_eff=6.86971958520868e-06
Ro6n19n1 h19buf o6nn 145566.349193222
* o6 input 20 w=-0.216778558754084 w-  bank=n alpha=1 R=153766.744852045 G_phys=6.50335676262251e-06 G_eff=6.50335676262251e-06
Ro6n20n1 h20buf o6nn 153766.744852045
* o6 input 21 w=-0.139531541535413 w-  bank=n alpha=1 R=238894.610971336 G_phys=4.18594624606239e-06 G_eff=4.18594624606239e-06
Ro6n21n1 h21buf o6nn 238894.610971336
* o6 input 22 w=-0.394983843934915 w-  bank=n alpha=1 R=84391.6373927081 G_phys=1.18495153180474e-05 G_eff=1.18495153180474e-05
Ro6n22n1 h22buf o6nn 84391.6373927081
* o6 input 23 w=-0.193849822273603 w-  bank=n alpha=1 R=171954.41781879 G_phys=5.81549466820809e-06 G_eff=5.81549466820809e-06
Ro6n23n1 h23buf o6nn 171954.41781879
* o6 input 24 w=-0.0741873589980665 w-  bank=n alpha=1 R=449312.844984846 G_phys=2.22562076994199e-06 G_eff=2.22562076994199e-06
Ro6n24n1 h24buf o6nn 449312.844984846
* o6 input 25 w=-0.172655508406202 w-  bank=n alpha=1 R=193062.669364194 G_phys=5.17966525218605e-06 G_eff=5.17966525218605e-06
Ro6n25n1 h25buf o6nn 193062.669364194
* o6 input 26 w=+0.0670699610875517 w+  bank=n alpha=1 R=496993.479537295 G_phys=2.01209883262655e-06 G_eff=2.01209883262655e-06
Ro6p26n1 h26buf o6pn 496993.479537295
* o6 input 27 w=+0.25363855276468 w+  bank=n alpha=1 R=131420.610037384 G_phys=7.60915658294039e-06 G_eff=7.60915658294039e-06
Ro6p27n1 h27buf o6pn 131420.610037384
* o6 input 28 w=-0.179185579156039 w-  bank=n alpha=1 R=186026.874988115 G_phys=5.37556737468116e-06 G_eff=5.37556737468116e-06
Ro6n28n1 h28buf o6nn 186026.874988115
* o6 input 29 w=-0.129923130427228 w-  bank=n alpha=1 R=256561.962629155 G_phys=3.89769391281685e-06 G_eff=3.89769391281685e-06
Ro6n29n1 h29buf o6nn 256561.962629155
* o6 input 30 w=-0.169171092451912 w-  bank=n alpha=1 R=197039.179981701 G_phys=5.07513277355737e-06 G_eff=5.07513277355737e-06
Ro6n30n1 h30buf o6nn 197039.179981701
* o6 input 31 w=+0.218686712022964 w+  bank=n alpha=1 R=152425.051458238 G_phys=6.56060136068893e-06 G_eff=6.56060136068893e-06
Ro6p31n1 h31buf o6pn 152425.051458238
* o6 input 32 w=+0.133370937368681 w+  bank=n alpha=1 R=249929.512313385 G_phys=4.00112812106042e-06 G_eff=4.00112812106042e-06
Ro6p32n1 h32buf o6pn 249929.512313385
* o6 bias=+0.0648246120847975 b+  bank=n alpha=1 R=514207.987696552 G_phys=1.94473836254393e-06 G_eff=1.94473836254393e-06
Ro6bpn1 vref o6pn 514207.987696552
Vo6nm o6nm 0 DC 0
Fo6nm o6d 0 Vo6nm 0.01
Vo6nn o6nn 0 DC 0
Fo6nn o6d 0 Vo6nn 1
Vo6pn o6pn 0 DC 0
Fo6pn 0 o6d Vo6pn 1
Vo6d o6d 0 DC 0
Ho6 o6lin 0 Vo6d 33333.3333333333

* o7 input 1 w=+0.130193574665561 w+  bank=n alpha=1 R=256029.020010853 G_phys=3.90580723996683e-06 G_eff=3.90580723996683e-06
Ro7p1n1 h1buf o7pn 256029.020010853
* o7 input 2 w=+0.394190134763453 w+  bank=n alpha=1 R=84561.5615249634 G_phys=1.18257040429036e-05 G_eff=1.18257040429036e-05
Ro7p2n1 h2buf o7pn 84561.5615249634
* o7 input 3 w=+0.206617853142924 w+  bank=n alpha=1 R=161328.427463021 G_phys=6.19853559428773e-06 G_eff=6.19853559428773e-06
Ro7p3n1 h3buf o7pn 161328.427463021
* o7 input 4 w=-0.378033462280536 w-  bank=n alpha=1 R=88175.6158098959 G_phys=1.13410038684161e-05 G_eff=1.13410038684161e-05
Ro7n4n1 h4buf o7nn 88175.6158098959
* o7 input 5 w=-0.580108461232067 w-  bank=n alpha=1 R=57460.5191286783 G_phys=1.7403253836962e-05 G_eff=1.7403253836962e-05
Ro7n5n1 h5buf o7nn 57460.5191286783
* o7 input 6 w=+0.107934080055711 w+  bank=n alpha=1 R=308830.476121427 G_phys=3.23802240167132e-06 G_eff=3.23802240167132e-06
Ro7p6n1 h6buf o7pn 308830.476121427
* o7 input 7 w=+0.101501144533757 w+  bank=n alpha=1 R=328403.521816913 G_phys=3.04503433601271e-06 G_eff=3.04503433601271e-06
Ro7p7n1 h7buf o7pn 328403.521816913
* o7 input 8 w=+0.0692471666647439 w+  bank=n alpha=1 R=481367.468718463 G_phys=2.07741499994232e-06 G_eff=2.07741499994232e-06
Ro7p8n1 h8buf o7pn 481367.468718463
* o7 input 9 w=-0.335430638558454 w-  bank=n alpha=1 R=99374.7424999297 G_phys=1.00629191567536e-05 G_eff=1.00629191567536e-05
Ro7n9n1 h9buf o7nn 99374.7424999297
* o7 input 10 w=+0.101094797691112 w+  bank=n alpha=1 R=329723.527764315 G_phys=3.03284393073337e-06 G_eff=3.03284393073337e-06
Ro7p10n1 h10buf o7pn 329723.527764315
* o7 input 11 w=-0.148243371766924 w-  bank=n alpha=1 R=224855.472025703 G_phys=4.44730115300771e-06 G_eff=4.44730115300771e-06
Ro7n11n1 h11buf o7nn 224855.472025703
* o7 input 12 w=-0.334713947003149 w-  bank=n alpha=1 R=99587.5243077928 G_phys=1.00414184100945e-05 G_eff=1.00414184100945e-05
Ro7n12n1 h12buf o7nn 99587.5243077928
* o7 input 13 w=-0.322800486422993 w-  bank=n alpha=1 R=103262.958809962 G_phys=9.68401459268979e-06 G_eff=9.68401459268979e-06
Ro7n13n1 h13buf o7nn 103262.958809962
* o7 input 14 w=-0.104357857187523 w-  bank=n alpha=1 R=319413.73876081 G_phys=3.13073571562568e-06 G_eff=3.13073571562568e-06
Ro7n14n1 h14buf o7nn 319413.73876081
* o7 input 15 w=+0.182195051802482 w+  bank=n alpha=1 R=182954.108816688 G_phys=5.46585155407446e-06 G_eff=5.46585155407446e-06
Ro7p15n1 h15buf o7pn 182954.108816688
* o7 input 16 w=+0.0146234127477982 w+  bank=m alpha=0.01 R=22794.4966802309 G_phys=4.38702382433947e-05 G_eff=4.38702382433947e-07
Ro7p16m1 h16buf o7pm 22794.4966802309
* o7 input 17 w=-0.0268461940667064 w-  bank=m alpha=0.01 R=12416.4092871071 G_phys=8.05385822001192e-05 G_eff=8.05385822001192e-07
Ro7n17m1 h17buf o7nm 12416.4092871071
* o7 input 18 w=+0.263886686193095 w+  bank=n alpha=1 R=126316.843847674 G_phys=7.91660058579284e-06 G_eff=7.91660058579284e-06
Ro7p18n1 h18buf o7pn 126316.843847674
* o7 input 19 w=+0.184182739421503 w+  bank=n alpha=1 R=180979.680495738 G_phys=5.52548218264508e-06 G_eff=5.52548218264508e-06
Ro7p19n1 h19buf o7pn 180979.680495738
* o7 input 20 w=-0.16994338127458 w-  bank=n alpha=1 R=196143.757311009 G_phys=5.09830143823739e-06 G_eff=5.09830143823739e-06
Ro7n20n1 h20buf o7nn 196143.757311009
* o7 input 21 w=-0.17515931490212 w-  bank=n alpha=1 R=190302.94421944 G_phys=5.25477944706359e-06 G_eff=5.25477944706359e-06
Ro7n21n1 h21buf o7nn 190302.94421944
* o7 input 22 w=+0.170460541565249 w+  bank=n alpha=1 R=195548.67670401 G_phys=5.11381624695746e-06 G_eff=5.11381624695746e-06
Ro7p22n1 h22buf o7pn 195548.67670401
* o7 input 23 w=-0.342102206419994 w-  bank=n alpha=1 R=97436.7680412165 G_phys=1.02630661925998e-05 G_eff=1.02630661925998e-05
Ro7n23n1 h23buf o7nn 97436.7680412165
* o7 input 24 w=-0.0940891241579366 w-  bank=n alpha=1 R=354274.031474461 G_phys=2.8226737247381e-06 G_eff=2.8226737247381e-06
Ro7n24n1 h24buf o7nn 354274.031474461
* o7 input 25 w=-0.147263798833488 w-  bank=n alpha=1 R=226351.171145758 G_phys=4.41791396500465e-06 G_eff=4.41791396500465e-06
Ro7n25n1 h25buf o7nn 226351.171145758
* o7 input 26 w=-0.0975787524659246 w-  bank=n alpha=1 R=341604.421976738 G_phys=2.92736257397774e-06 G_eff=2.92736257397774e-06
Ro7n26n1 h26buf o7nn 341604.421976738
* o7 input 27 w=-0.201262065009158 w-  bank=n alpha=1 R=165621.540908947 G_phys=6.03786195027474e-06 G_eff=6.03786195027474e-06
Ro7n27n1 h27buf o7nn 165621.540908947
* o7 input 28 w=-0.060609790215781 w-  bank=n alpha=1 R=549966.155874506 G_phys=1.81829370647343e-06 G_eff=1.81829370647343e-06
Ro7n28n1 h28buf o7nn 549966.155874506
* o7 input 29 w=-0.355920486311588 w-  bank=n alpha=1 R=93653.8766811862 G_phys=1.06776145893477e-05 G_eff=1.06776145893477e-05
Ro7n29n1 h29buf o7nn 93653.8766811862
* o7 input 30 w=+0.0702967455487947 w+  bank=n alpha=1 R=474180.320484337 G_phys=2.10890236646384e-06 G_eff=2.10890236646384e-06
Ro7p30n1 h30buf o7pn 474180.320484337
* o7 input 31 w=+0.188674793501044 w+  bank=n alpha=1 R=176670.835116874 G_phys=5.66024380503133e-06 G_eff=5.66024380503133e-06
Ro7p31n1 h31buf o7pn 176670.835116874
* o7 input 32 w=-0.221533996080022 w-  bank=n alpha=1 R=150465.995843332 G_phys=6.64601988240065e-06 G_eff=6.64601988240065e-06
Ro7n32n1 h32buf o7nn 150465.995843332
* o7 bias=+0.0479731403374592 b+  bank=n alpha=1 R=694833.256669366 G_phys=1.43919421012378e-06 G_eff=1.43919421012378e-06
Ro7bpn1 vref o7pn 694833.256669366
Vo7nm o7nm 0 DC 0
Fo7nm o7d 0 Vo7nm 0.01
Vo7nn o7nn 0 DC 0
Fo7nn o7d 0 Vo7nn 1
Vo7pm o7pm 0 DC 0
Fo7pm 0 o7d Vo7pm 0.01
Vo7pn o7pn 0 DC 0
Fo7pn 0 o7d Vo7pn 1
Vo7d o7d 0 DC 0
Ho7 o7lin 0 Vo7d 33333.3333333333

* o8 input 1 w=-0.264579445854062 w-  bank=n alpha=1 R=125986.103061534 G_phys=7.93738337562187e-06 G_eff=7.93738337562187e-06
Ro8n1n1 h1buf o8nn 125986.103061534
* o8 input 2 w=-0.461651647659873 w-  bank=n alpha=1 R=72204.5150327114 G_phys=1.38495494297962e-05 G_eff=1.38495494297962e-05
Ro8n2n1 h2buf o8nn 72204.5150327114
* o8 input 3 w=-0.248506615035073 w-  bank=n alpha=1 R=134134.591663199 G_phys=7.45519845105219e-06 G_eff=7.45519845105219e-06
Ro8n3n1 h3buf o8nn 134134.591663199
* o8 input 4 w=-0.0596907059046396 w-  bank=n alpha=1 R=558434.22905043 G_phys=1.79072117713919e-06 G_eff=1.79072117713919e-06
Ro8n4n1 h4buf o8nn 558434.22905043
* o8 input 5 w=-0.142952779428107 w-  bank=n alpha=1 R=233177.231437442 G_phys=4.28858338284322e-06 G_eff=4.28858338284322e-06
Ro8n5n1 h5buf o8nn 233177.231437442
* o8 input 6 w=+0.230947580946818 w+  bank=n alpha=1 R=144332.896654195 G_phys=6.92842742840454e-06 G_eff=6.92842742840454e-06
Ro8p6n1 h6buf o8pn 144332.896654195
* o8 input 7 w=+0.224542704495923 w+  bank=n alpha=1 R=148449.861277673 G_phys=6.7362811348777e-06 G_eff=6.7362811348777e-06
Ro8p7n1 h7buf o8pn 148449.861277673
* o8 input 8 w=-0.0814289785611842 w-  bank=n alpha=1 R=409354.678424307 G_phys=2.44286935683553e-06 G_eff=2.44286935683553e-06
Ro8n8n1 h8buf o8nn 409354.678424307
* o8 input 9 w=+0.151871407153412 w+  bank=n alpha=1 R=219483.93024147 G_phys=4.55614221460235e-06 G_eff=4.55614221460235e-06
Ro8p9n1 h9buf o8pn 219483.93024147
* o8 input 10 w=-0.0439376442611886 w-  bank=n alpha=1 R=758650.899333209 G_phys=1.31812932783566e-06 G_eff=1.31812932783566e-06
Ro8n10n1 h10buf o8nn 758650.899333209
* o8 input 11 w=-0.0114777570667242 w-  bank=m alpha=0.01 R=29041.6787352748 G_phys=3.44332712001725e-05 G_eff=3.44332712001725e-07
Ro8n11m1 h11buf o8nm 29041.6787352748
* o8 input 12 w=-0.184091969163629 w-  bank=n alpha=1 R=181068.91617692 G_phys=5.52275907490888e-06 G_eff=5.52275907490888e-06
Ro8n12n1 h12buf o8nn 181068.91617692
* o8 input 13 w=+0.167375709493599 w+  bank=n alpha=1 R=199152.753014069 G_phys=5.02127128480798e-06 G_eff=5.02127128480798e-06
Ro8p13n1 h13buf o8pn 199152.753014069
* o8 input 14 w=+0.639794426458427 w+  bank=n alpha=1 R=52100.068326399 G_phys=1.91938327937528e-05 G_eff=1.91938327937528e-05
Ro8p14n1 h14buf o8pn 52100.068326399
* o8 input 15 w=+0.00251732875304732 w+  bank=m alpha=0.01 R=132415.495167177 G_phys=7.55198625914195e-06 G_eff=7.55198625914195e-08
Ro8p15m1 h15buf o8pm 132415.495167177
* o8 input 16 w=+0.510552134317183 w+  bank=n alpha=1 R=65288.7944106113 G_phys=1.53165640295155e-05 G_eff=1.53165640295155e-05
Ro8p16n1 h16buf o8pn 65288.7944106113
* o8 input 17 w=-0.402994248540282 w-  bank=n alpha=1 R=82714.166403299 G_phys=1.20898274562085e-05 G_eff=1.20898274562085e-05
Ro8n17n1 h17buf o8nn 82714.166403299
* o8 input 18 w=+0.141582671709231 w+  bank=n alpha=1 R=235433.707606466 G_phys=4.24748015127692e-06 G_eff=4.24748015127692e-06
Ro8p18n1 h18buf o8pn 235433.707606466
* o8 input 19 w=+0.181760587882604 w+  bank=n alpha=1 R=183391.425620073 G_phys=5.45281763647812e-06 G_eff=5.45281763647812e-06
Ro8p19n1 h19buf o8pn 183391.425620073
* o8 input 20 w=+0.465247625040388 w+  bank=n alpha=1 R=71646.4341552301 G_phys=1.39574287512116e-05 G_eff=1.39574287512116e-05
Ro8p20n1 h20buf o8pn 71646.4341552301
* o8 input 21 w=-0.129997678502292 w-  bank=n alpha=1 R=256414.835382969 G_phys=3.89993035506876e-06 G_eff=3.89993035506876e-06
Ro8n21n1 h21buf o8nn 256414.835382969
* o8 input 22 w=+0.727771195072513 w+  bank=n alpha=1 R=45801.9409932982 G_phys=2.18331358521754e-05 G_eff=2.18331358521754e-05
Ro8p22n1 h22buf o8pn 45801.9409932982
* o8 input 23 w=+0.0590279674258587 w+  bank=n alpha=1 R=564704.068036922 G_phys=1.77083902277576e-06 G_eff=1.77083902277576e-06
Ro8p23n1 h23buf o8pn 564704.068036922
* o8 input 24 w=-0.0219880792573176 w-  bank=m alpha=0.01 R=15159.7294803456 G_phys=6.59642377719527e-05 G_eff=6.59642377719527e-07
Ro8n24m1 h24buf o8nm 15159.7294803456
* o8 input 25 w=-0.000673889145733125 w-  bank=m alpha=0.01 R=494641.196469635 G_phys=2.02166743719938e-06 G_eff=2.02166743719938e-08
Ro8n25m1 h25buf o8nm 494641.196469635
* o8 input 26 w=-0.0895992045192751 w-  bank=n alpha=1 R=372027.112430027 G_phys=2.68797613557825e-06 G_eff=2.68797613557825e-06
Ro8n26n1 h26buf o8nn 372027.112430027
* o8 input 27 w=-0.161030155307918 w-  bank=n alpha=1 R=207000.56625788 G_phys=4.83090465923753e-06 G_eff=4.83090465923753e-06
Ro8n27n1 h27buf o8nn 207000.56625788
* o8 input 28 w=-0.0515875057732319 w-  bank=n alpha=1 R=646151.288644577 G_phys=1.54762517319696e-06 G_eff=1.54762517319696e-06
Ro8n28n1 h28buf o8nn 646151.288644577
* o8 input 29 w=-0.167333727666792 w-  bank=n alpha=1 R=199202.71781496 G_phys=5.02001183000377e-06 G_eff=5.02001183000377e-06
Ro8n29n1 h29buf o8nn 199202.71781496
* o8 input 30 w=+0.117154510339097 w+  bank=n alpha=1 R=284524.541452582 G_phys=3.5146353101729e-06 G_eff=3.5146353101729e-06
Ro8p30n1 h30buf o8pn 284524.541452582
* o8 input 31 w=-0.114263857072683 w-  bank=n alpha=1 R=291722.458766031 G_phys=3.42791571218049e-06 G_eff=3.42791571218049e-06
Ro8n31n1 h31buf o8nn 291722.458766031
* o8 input 32 w=+0.185068242761295 w+  bank=n alpha=1 R=180113.739861503 G_phys=5.55204728283885e-06 G_eff=5.55204728283885e-06
Ro8p32n1 h32buf o8pn 180113.739861503
* o8 bias=+0.070334250370477 b+  bank=n alpha=1 R=473927.47001289 G_phys=2.11002751111431e-06 G_eff=2.11002751111431e-06
Ro8bpn1 vref o8pn 473927.47001289
Vo8nm o8nm 0 DC 0
Fo8nm o8d 0 Vo8nm 0.01
Vo8nn o8nn 0 DC 0
Fo8nn o8d 0 Vo8nn 1
Vo8pm o8pm 0 DC 0
Fo8pm 0 o8d Vo8pm 0.01
Vo8pn o8pn 0 DC 0
Fo8pn 0 o8d Vo8pn 1
Vo8d o8d 0 DC 0
Ho8 o8lin 0 Vo8d 33333.3333333333

* o9 input 1 w=-0.342788496026982 w-  bank=n alpha=1 R=97241.6919461309 G_phys=1.02836548808095e-05 G_eff=1.02836548808095e-05
Ro9n1n1 h1buf o9nn 97241.6919461309
* o9 input 2 w=+0.117901804588507 w+  bank=n alpha=1 R=282721.146208671 G_phys=3.5370541376552e-06 G_eff=3.5370541376552e-06
Ro9p2n1 h2buf o9pn 282721.146208671
* o9 input 3 w=-0.555835720214104 w-  bank=n alpha=1 R=59969.7574680763 G_phys=1.66750716064231e-05 G_eff=1.66750716064231e-05
Ro9n3n1 h3buf o9nn 59969.7574680763
* o9 input 4 w=+0.355136587925528 w+  bank=n alpha=1 R=93860.6003060526 G_phys=1.06540976377658e-05 G_eff=1.06540976377658e-05
Ro9p4n1 h4buf o9pn 93860.6003060526
* o9 input 5 w=+0.236432436172994 w+  bank=n alpha=1 R=140984.603774686 G_phys=7.09297308518982e-06 G_eff=7.09297308518982e-06
Ro9p5n1 h5buf o9pn 140984.603774686
* o9 input 6 w=-0.00589463242951189 w-  bank=m alpha=0.01 R=56548.6206848924 G_phys=1.76838972885357e-05 G_eff=1.76838972885357e-07
Ro9n6m1 h6buf o9nm 56548.6206848924
* o9 input 7 w=-0.175810166557473 w-  bank=n alpha=1 R=189598.440101794 G_phys=5.27430499672418e-06 G_eff=5.27430499672418e-06
Ro9n7n1 h7buf o9nn 189598.440101794
* o9 input 8 w=+0.162552656301944 w+  bank=n alpha=1 R=205061.757166343 G_phys=4.87657968905832e-06 G_eff=4.87657968905832e-06
Ro9p8n1 h8buf o9pn 205061.757166343
* o9 input 9 w=-0.443497798175432 w-  bank=n alpha=1 R=75160.0875370025 G_phys=1.3304933945263e-05 G_eff=1.3304933945263e-05
Ro9n9n1 h9buf o9nn 75160.0875370025
* o9 input 10 w=+0.114863161009978 w+  bank=n alpha=1 R=290200.383136224 G_phys=3.44589483029933e-06 G_eff=3.44589483029933e-06
Ro9p10n1 h10buf o9pn 290200.383136224
* o9 input 11 w=-0.051706338551111 w-  bank=n alpha=1 R=644666.287874624 G_phys=1.55119015653333e-06 G_eff=1.55119015653333e-06
Ro9n11n1 h11buf o9nn 644666.287874624
* o9 input 12 w=-0.247913853258797 w-  bank=n alpha=1 R=134455.307338298 G_phys=7.43741559776392e-06 G_eff=7.43741559776392e-06
Ro9n12n1 h12buf o9nn 134455.307338298
* o9 input 13 w=+0.0720916431840902 w+  bank=n alpha=1 R=462374.442599605 G_phys=2.16274929552271e-06 G_eff=2.16274929552271e-06
Ro9p13n1 h13buf o9pn 462374.442599605
* o9 input 14 w=+0.00473033723811417 w+  bank=m alpha=0.01 R=70467.1393505597 G_phys=1.41910117143425e-05 G_eff=1.41910117143425e-07
Ro9p14m1 h14buf o9pm 70467.1393505597
* o9 input 15 w=-0.290577914446662 w-  bank=n alpha=1 R=114713.925856371 G_phys=8.71733743339986e-06 G_eff=8.71733743339986e-06
Ro9n15n1 h15buf o9nn 114713.925856371
* o9 input 16 w=-0.0531648681945055 w-  bank=n alpha=1 R=626980.456556052 G_phys=1.59494604583516e-06 G_eff=1.59494604583516e-06
Ro9n16n1 h16buf o9nn 626980.456556052
* o9 input 17 w=+0.0157425177085947 w+  bank=m alpha=0.01 R=21174.0802521917 G_phys=4.72275531257841e-05 G_eff=4.72275531257841e-07
Ro9p17m1 h17buf o9pm 21174.0802521917
* o9 input 18 w=-0.104777957691913 w-  bank=n alpha=1 R=318133.06985183 G_phys=3.14333873075738e-06 G_eff=3.14333873075738e-06
Ro9n18n1 h18buf o9nn 318133.06985183
* o9 input 19 w=-0.368259428743895 w-  bank=n alpha=1 R=90515.8992046201 G_phys=1.10477828623168e-05 G_eff=1.10477828623168e-05
Ro9n19n1 h19buf o9nn 90515.8992046201
* o9 input 20 w=+0.100989358745228 w+  bank=n alpha=1 R=330067.778897631 G_phys=3.02968076235683e-06 G_eff=3.02968076235683e-06
Ro9p20n1 h20buf o9pn 330067.778897631
* o9 input 21 w=+0.084258883556939 w+  bank=n alpha=1 R=395606.15956664 G_phys=2.52776650670817e-06 G_eff=2.52776650670817e-06
Ro9p21n1 h21buf o9pn 395606.15956664
* o9 input 22 w=+0.093068688723566 w+  bank=n alpha=1 R=358158.40741391 G_phys=2.79206066170698e-06 G_eff=2.79206066170698e-06
Ro9p22n1 h22buf o9pn 358158.40741391
* o9 input 23 w=+0.153137872499505 w+  bank=n alpha=1 R=217668.776438311 G_phys=4.59413617498515e-06 G_eff=4.59413617498515e-06
Ro9p23n1 h23buf o9pn 217668.776438311
* o9 input 24 w=+0.0107021071757068 w+  bank=m alpha=0.01 R=31146.5142201137 G_phys=3.21063215271205e-05 G_eff=3.21063215271205e-07
Ro9p24m1 h24buf o9pm 31146.5142201137
* o9 input 25 w=+0.151859492007221 w+  bank=n alpha=1 R=219501.151312611 G_phys=4.55578476021664e-06 G_eff=4.55578476021664e-06
Ro9p25n1 h25buf o9pn 219501.151312611
* o9 input 26 w=-0.0745603298060184 w-  bank=n alpha=1 R=447065.261380358 G_phys=2.23680989418055e-06 G_eff=2.23680989418055e-06
Ro9n26n1 h26buf o9nn 447065.261380358
* o9 input 27 w=+0.475223780202243 w+  bank=n alpha=1 R=70142.3933775947 G_phys=1.42567134060673e-05 G_eff=1.42567134060673e-05
Ro9p27n1 h27buf o9pn 70142.3933775947
* o9 input 28 w=+0.715956917954612 w+  bank=n alpha=1 R=46557.736223238 G_phys=2.14787075386384e-05 G_eff=2.14787075386384e-05
Ro9p28n1 h28buf o9pn 46557.736223238
* o9 input 29 w=-0.520384445309866 w-  bank=n alpha=1 R=64055.2069412544 G_phys=1.5611533359296e-05 G_eff=1.5611533359296e-05
Ro9n29n1 h29buf o9nn 64055.2069412544
* o9 input 30 w=+0.217731604854565 w+  bank=n alpha=1 R=153093.683186685 G_phys=6.53194814563695e-06 G_eff=6.53194814563695e-06
Ro9p30n1 h30buf o9pn 153093.683186685
* o9 input 31 w=-0.123913004875871 w-  bank=n alpha=1 R=269005.931756111 G_phys=3.71739014627614e-06 G_eff=3.71739014627614e-06
Ro9n31n1 h31buf o9nn 269005.931756111
* o9 input 32 w=+0.0869405958454977 w+  bank=n alpha=1 R=383403.552841644 G_phys=2.60821787536493e-06 G_eff=2.60821787536493e-06
Ro9p32n1 h32buf o9pn 383403.552841644
* o9 bias=-0.00785769582167887 b-  bank=m alpha=0.01 R=42421.2569305226 G_phys=2.35730874650366e-05 G_eff=2.35730874650366e-07
Ro9bnm1 vref o9nm 42421.2569305226
Vo9nm o9nm 0 DC 0
Fo9nm o9d 0 Vo9nm 0.01
Vo9nn o9nn 0 DC 0
Fo9nn o9d 0 Vo9nn 1
Vo9pm o9pm 0 DC 0
Fo9pm 0 o9d Vo9pm 0.01
Vo9pn o9pn 0 DC 0
Fo9pn 0 o9d Vo9pn 1
Vo9d o9d 0 DC 0
Ho9 o9lin 0 Vo9d 33333.3333333333

* o10 input 1 w=-0.0381763956958746 w-  bank=n alpha=1 R=873139.874148344 G_phys=1.14529187087624e-06 G_eff=1.14529187087624e-06
Ro10n1n1 h1buf o10nn 873139.874148344
* o10 input 2 w=+0.410781186996451 w+  bank=n alpha=1 R=81146.2023785947 G_phys=1.23234356098935e-05 G_eff=1.23234356098935e-05
Ro10p2n1 h2buf o10pn 81146.2023785947
* o10 input 3 w=+0.475033421735393 w+  bank=n alpha=1 R=70170.5012913827 G_phys=1.42510026520618e-05 G_eff=1.42510026520618e-05
Ro10p3n1 h3buf o10pn 70170.5012913827
* o10 input 4 w=+0.0271427582394968 w+  bank=m alpha=0.01 R=12280.7465030685 G_phys=8.14282747184905e-05 G_eff=8.14282747184905e-07
Ro10p4m1 h4buf o10pm 12280.7465030685
* o10 input 5 w=+0.0212799641995083 w+  bank=m alpha=0.01 R=15664.1867537087 G_phys=6.3839892598525e-05 G_eff=6.3839892598525e-07
Ro10p5m1 h5buf o10pm 15664.1867537087
* o10 input 6 w=+0.0201273268189427 w+  bank=m alpha=0.01 R=16561.2322158758 G_phys=6.0381980456828e-05 G_eff=6.0381980456828e-07
Ro10p6m1 h6buf o10pm 16561.2322158758
* o10 input 7 w=-0.036291550108304 w-  bank=n alpha=1 R=918487.450490747 G_phys=1.08874650324912e-06 G_eff=1.08874650324912e-06
Ro10n7n1 h7buf o10nn 918487.450490747
* o10 input 8 w=+0.0509688710938526 w+  bank=n alpha=1 R=653993.949992621 G_phys=1.52906613281558e-06 G_eff=1.52906613281558e-06
Ro10p8n1 h8buf o10pn 653993.949992621
* o10 input 9 w=-0.135969386219015 w-  bank=n alpha=1 R=245153.223532546 G_phys=4.07908158657046e-06 G_eff=4.07908158657046e-06
Ro10n9n1 h9buf o10nn 245153.223532546
* o10 input 10 w=+0.542965243347564 w+  bank=n alpha=1 R=61391.2837731971 G_phys=1.62889573004269e-05 G_eff=1.62889573004269e-05
Ro10p10n1 h10buf o10pn 61391.2837731971
* o10 input 11 w=+0.200790198383509 w+  bank=n alpha=1 R=166010.759497666 G_phys=6.02370595150528e-06 G_eff=6.02370595150528e-06
Ro10p11n1 h11buf o10pn 166010.759497666
* o10 input 12 w=-0.0602452386161185 w-  bank=n alpha=1 R=553294.071017507 G_phys=1.80735715848356e-06 G_eff=1.80735715848356e-06
Ro10n12n1 h12buf o10nn 553294.071017507
* o10 input 13 w=-0.18784742953156 w-  bank=n alpha=1 R=177448.972373258 G_phys=5.6354228859468e-06 G_eff=5.6354228859468e-06
Ro10n13n1 h13buf o10nn 177448.972373258
* o10 input 14 w=-0.0121063802780956 w-  bank=m alpha=0.01 R=27533.6909692523 G_phys=3.63191408342867e-05 G_eff=3.63191408342867e-07
Ro10n14m1 h14buf o10nm 27533.6909692523
* o10 input 15 w=+0.162912924713055 w+  bank=n alpha=1 R=204608.280110646 G_phys=4.88738774139165e-06 G_eff=4.88738774139165e-06
Ro10p15n1 h15buf o10pn 204608.280110646
* o10 input 16 w=+0.000496602144198326 w+  bank=m alpha=0.01 R=671228.139522916 G_phys=1.48980643259498e-06 G_eff=1.48980643259498e-08
Ro10p16m1 h16buf o10pm 671228.139522916
* o10 input 17 w=+0.150471984074884 w+  bank=n alpha=1 R=221525.179841748 G_phys=4.51415952224652e-06 G_eff=4.51415952224652e-06
Ro10p17n1 h17buf o10pn 221525.179841748
* o10 input 18 w=-0.0993574349593851 w-  bank=n alpha=1 R=335489.068804556 G_phys=2.98072304878155e-06 G_eff=2.98072304878155e-06
Ro10n18n1 h18buf o10nn 335489.068804556
* o10 input 19 w=-0.0430450321763909 w-  bank=n alpha=1 R=774382.818364248 G_phys=1.29135096529173e-06 G_eff=1.29135096529173e-06
Ro10n19n1 h19buf o10nn 774382.818364248
* o10 input 20 w=-0.498578232263262 w-  bank=n alpha=1 R=66856.7762816658 G_phys=1.49573469678979e-05 G_eff=1.49573469678979e-05
Ro10n20n1 h20buf o10nn 66856.7762816658
* o10 input 21 w=-0.135185117923925 w-  bank=n alpha=1 R=246575.465149141 G_phys=4.05555353771776e-06 G_eff=4.05555353771776e-06
Ro10n21n1 h21buf o10nn 246575.465149141
* o10 input 22 w=+0.00794231626553338 w+  bank=m alpha=0.01 R=41969.2848016985 G_phys=2.38269487966002e-05 G_eff=2.38269487966002e-07
Ro10p22m1 h22buf o10pm 41969.2848016985
* o10 input 23 w=-0.411689837989046 w-  bank=n alpha=1 R=80967.1025550556 G_phys=1.23506951396714e-05 G_eff=1.23506951396714e-05
Ro10n23n1 h23buf o10nn 80967.1025550556
* o10 input 24 w=+0.321047972853849 w+  bank=n alpha=1 R=103826.643217921 G_phys=9.63143918561547e-06 G_eff=9.63143918561547e-06
Ro10p24n1 h24buf o10pn 103826.643217921
* o10 input 25 w=-0.130972309748016 w-  bank=n alpha=1 R=254506.722813891 G_phys=3.92916929244047e-06 G_eff=3.92916929244047e-06
Ro10n25n1 h25buf o10nn 254506.722813891
* o10 input 26 w=+0.0365278526067883 w+  bank=n alpha=1 R=912545.659120916 G_phys=1.09583557820365e-06 G_eff=1.09583557820365e-06
Ro10p26n1 h26buf o10pn 912545.659120916
* o10 input 27 w=-0.205674584301975 w-  bank=n alpha=1 R=162068.315083563 G_phys=6.17023752905924e-06 G_eff=6.17023752905924e-06
Ro10n27n1 h27buf o10nn 162068.315083563
* o10 input 28 w=-0.0123163999797875 w-  bank=m alpha=0.01 R=27064.1854665624 G_phys=3.69491999393624e-05 G_eff=3.69491999393624e-07
Ro10n28m1 h28buf o10nm 27064.1854665624
* o10 input 29 w=-0.120487475126756 w-  bank=n alpha=1 R=276653.928537102 G_phys=3.61462425380267e-06 G_eff=3.61462425380267e-06
Ro10n29n1 h29buf o10nn 276653.928537102
* o10 input 30 w=-0.421650115672696 w-  bank=n alpha=1 R=79054.486396034 G_phys=1.26495034701809e-05 G_eff=1.26495034701809e-05
Ro10n30n1 h30buf o10nn 79054.486396034
* o10 input 31 w=+0.15176529701113 w+  bank=n alpha=1 R=219637.387398838 G_phys=4.55295891033391e-06 G_eff=4.55295891033391e-06
Ro10p31n1 h31buf o10pn 219637.387398838
* o10 input 32 w=+0.00307524765960727 w+  bank=m alpha=0.01 R=108392.354122107 G_phys=9.22574297882182e-06 G_eff=9.22574297882182e-08
Ro10p32m1 h32buf o10pm 108392.354122107
* o10 bias=-0.031263579434271 b-  bank=m alpha=0.01 R=10662.0335663783 G_phys=9.37907383028131e-05 G_eff=9.37907383028131e-07
Ro10bnm1 vref o10nm 10662.0335663783
Vo10nm o10nm 0 DC 0
Fo10nm o10d 0 Vo10nm 0.01
Vo10nn o10nn 0 DC 0
Fo10nn o10d 0 Vo10nn 1
Vo10pm o10pm 0 DC 0
Fo10pm 0 o10d Vo10pm 0.01
Vo10pn o10pn 0 DC 0
Fo10pn 0 o10d Vo10pn 1
Vo10d o10d 0 DC 0
Ho10 o10lin 0 Vo10d 33333.3333333333

* o11 input 1 w=-0.160102279955593 w-  bank=n alpha=1 R=208200.241386812 G_phys=4.80306839866778e-06 G_eff=4.80306839866778e-06
Ro11n1n1 h1buf o11nn 208200.241386812
* o11 input 2 w=+0.011469223690656 w+  bank=m alpha=0.01 R=29063.2864371544 G_phys=3.4407671071968e-05 G_eff=3.4407671071968e-07
Ro11p2m1 h2buf o11pm 29063.2864371544
* o11 input 3 w=+0.0176041755498141 w+  bank=m alpha=0.01 R=18934.9016879608 G_phys=5.28125266494424e-05 G_eff=5.28125266494424e-07
Ro11p3m1 h3buf o11pm 18934.9016879608
* o11 input 4 w=-0.0193710750418404 w-  bank=m alpha=0.01 R=17207.7870027013 G_phys=5.81132251255212e-05 G_eff=5.81132251255212e-07
Ro11n4m1 h4buf o11nm 17207.7870027013
* o11 input 5 w=+0.112602634979867 w+  bank=n alpha=1 R=296026.228331984 G_phys=3.37807904939602e-06 G_eff=3.37807904939602e-06
Ro11p5n1 h5buf o11pn 296026.228331984
* o11 input 6 w=+0.00163262396170036 w+  bank=m alpha=0.01 R=204170.305687643 G_phys=4.89787188510109e-06 G_eff=4.89787188510109e-08
Ro11p6m1 h6buf o11pm 204170.305687643
* o11 input 7 w=-0.0344149127536822 w-  bank=n alpha=1 R=968572.361984759 G_phys=1.03244738261047e-06 G_eff=1.03244738261047e-06
Ro11n7n1 h7buf o11nn 968572.361984759
* o11 input 8 w=+0.0140339587694358 w+  bank=m alpha=0.01 R=23751.9105485255 G_phys=4.21018763083073e-05 G_eff=4.21018763083073e-07
Ro11p8m1 h8buf o11pm 23751.9105485255
* o11 input 9 w=+0.200472625000294 w+  bank=n alpha=1 R=166273.741032146 G_phys=6.01417875000882e-06 G_eff=6.01417875000882e-06
Ro11p9n1 h9buf o11pn 166273.741032146
* o11 input 10 w=+0.127220756971711 w+  bank=n alpha=1 R=262011.751280064 G_phys=3.81662270915132e-06 G_eff=3.81662270915132e-06
Ro11p10n1 h10buf o11pn 262011.751280064
* o11 input 11 w=-0.215899699488286 w-  bank=n alpha=1 R=154392.680547209 G_phys=6.47699098464857e-06 G_eff=6.47699098464857e-06
Ro11n11n1 h11buf o11nn 154392.680547209
* o11 input 12 w=-0.0276713436872213 w-  bank=m alpha=0.01 R=12046.1563811687 G_phys=8.30140310616638e-05 G_eff=8.30140310616639e-07
Ro11n12m1 h12buf o11nm 12046.1563811687
* o11 input 13 w=+0.188664634231365 w+  bank=n alpha=1 R=176680.34854087 G_phys=5.65993902694096e-06 G_eff=5.65993902694096e-06
Ro11p13n1 h13buf o11pn 176680.34854087
* o11 input 14 w=-0.119078372545684 w-  bank=n alpha=1 R=279927.686453265 G_phys=3.57235117637052e-06 G_eff=3.57235117637052e-06
Ro11n14n1 h14buf o11nn 279927.686453265
* o11 input 15 w=+0.15422975355602 w+  bank=n alpha=1 R=216127.774082359 G_phys=4.6268926066806e-06 G_eff=4.6268926066806e-06
Ro11p15n1 h15buf o11pn 216127.774082359
* o11 input 16 w=-0.104607206722078 w-  bank=n alpha=1 R=318652.360366468 G_phys=3.13821620166235e-06 G_eff=3.13821620166235e-06
Ro11n16n1 h16buf o11nn 318652.360366468
* o11 input 17 w=+0.106639727219858 w+  bank=n alpha=1 R=312578.944098482 G_phys=3.19919181659573e-06 G_eff=3.19919181659573e-06
Ro11p17n1 h17buf o11pn 312578.944098482
* o11 input 18 w=+0.310905721051453 w+  bank=n alpha=1 R=107213.637692492 G_phys=9.32717163154358e-06 G_eff=9.32717163154358e-06
Ro11p18n1 h18buf o11pn 107213.637692492
* o11 input 19 w=+0.210141672521531 w+  bank=n alpha=1 R=158623.146629415 G_phys=6.30425017564592e-06 G_eff=6.30425017564592e-06
Ro11p19n1 h19buf o11pn 158623.146629415
* o11 input 20 w=+0.009349861892821 w+  bank=m alpha=0.01 R=35651.1504826903 G_phys=2.8049585678463e-05 G_eff=2.8049585678463e-07
Ro11p20m1 h20buf o11pm 35651.1504826903
* o11 input 21 w=-0.148461029214851 w-  bank=n alpha=1 R=224525.81333714 G_phys=4.45383087644554e-06 G_eff=4.45383087644554e-06
Ro11n21n1 h21buf o11nn 224525.81333714
* o11 input 22 w=-0.118671866129314 w-  bank=n alpha=1 R=280886.56916384 G_phys=3.56015598387941e-06 G_eff=3.56015598387941e-06
Ro11n22n1 h22buf o11nn 280886.56916384
* o11 input 23 w=-0.109207143921327 w-  bank=n alpha=1 R=305230.336921427 G_phys=3.2762143176398e-06 G_eff=3.2762143176398e-06
Ro11n23n1 h23buf o11nn 305230.336921427
* o11 input 24 w=-0.0902417819363344 w-  bank=n alpha=1 R=369378.048816124 G_phys=2.70725345809003e-06 G_eff=2.70725345809003e-06
Ro11n24n1 h24buf o11nn 369378.048816124
* o11 input 25 w=+0.314745464583241 w+  bank=n alpha=1 R=105905.68279505 G_phys=9.44236393749723e-06 G_eff=9.44236393749723e-06
Ro11p25n1 h25buf o11pn 105905.68279505
* o11 input 26 w=+0.0956381358816812 w+  bank=n alpha=1 R=348536.000059346 G_phys=2.86914407645044e-06 G_eff=2.86914407645044e-06
Ro11p26n1 h26buf o11pn 348536.000059346
* o11 input 27 w=-0.150311342322866 w-  bank=n alpha=1 R=221761.929726726 G_phys=4.50934026968598e-06 G_eff=4.50934026968598e-06
Ro11n27n1 h27buf o11nn 221761.929726726
* o11 input 28 w=-0.0832874521070705 w-  bank=n alpha=1 R=400220.351205864 G_phys=2.49862356321211e-06 G_eff=2.49862356321211e-06
Ro11n28n1 h28buf o11nn 400220.351205864
* o11 input 29 w=+0.0404370827831914 w+  bank=n alpha=1 R=824325.86722574 G_phys=1.21311248349574e-06 G_eff=1.21311248349574e-06
Ro11p29n1 h29buf o11pn 824325.86722574
* o11 input 30 w=-0.0722629324126473 w-  bank=n alpha=1 R=461278.448305807 G_phys=2.16788797237942e-06 G_eff=2.16788797237942e-06
Ro11n30n1 h30buf o11nn 461278.448305807
* o11 input 31 w=-0.0830409064130833 w-  bank=n alpha=1 R=401408.592140338 G_phys=2.4912271923925e-06 G_eff=2.4912271923925e-06
Ro11n31n1 h31buf o11nn 401408.592140338
* o11 input 32 w=-0.390143512242536 w-  bank=n alpha=1 R=85438.6457479045 G_phys=1.17043053672761e-05 G_eff=1.17043053672761e-05
Ro11n32n1 h32buf o11nn 85438.6457479045
* o11 bias=-0.00144268984703634 b-  bank=m alpha=0.01 R=231049.891990359 G_phys=4.32806954110901e-06 G_eff=4.32806954110901e-08
Ro11bnm1 vref o11nm 231049.891990359
Vo11nm o11nm 0 DC 0
Fo11nm o11d 0 Vo11nm 0.01
Vo11nn o11nn 0 DC 0
Fo11nn o11d 0 Vo11nn 1
Vo11pm o11pm 0 DC 0
Fo11pm 0 o11d Vo11pm 0.01
Vo11pn o11pn 0 DC 0
Fo11pn 0 o11d Vo11pn 1
Vo11d o11d 0 DC 0
Ho11 o11lin 0 Vo11d 33333.3333333333

* o12 input 1 w=-0.0568819810826339 w-  bank=n alpha=1 R=586008.656852319 G_phys=1.70645943247902e-06 G_eff=1.70645943247902e-06
Ro12n1n1 h1buf o12nn 586008.656852319
* o12 input 2 w=-0.116449760348513 w-  bank=n alpha=1 R=286246.47430422 G_phys=3.4934928104554e-06 G_eff=3.4934928104554e-06
Ro12n2n1 h2buf o12nn 286246.47430422
* o12 input 3 w=-0.394245634375715 w-  bank=n alpha=1 R=84549.6574391152 G_phys=1.18273690312714e-05 G_eff=1.18273690312714e-05
Ro12n3n1 h3buf o12nn 84549.6574391152
* o12 input 4 w=-0.0304757769901363 w-  bank=m alpha=0.01 R=10937.6483966666 G_phys=9.14273309704087e-05 G_eff=9.14273309704087e-07
Ro12n4m1 h4buf o12nm 10937.6483966666
* o12 input 5 w=-0.225077356892672 w-  bank=n alpha=1 R=148097.231074329 G_phys=6.75232070678017e-06 G_eff=6.75232070678017e-06
Ro12n5n1 h5buf o12nn 148097.231074329
* o12 input 6 w=-0.48876360312342 w-  bank=n alpha=1 R=68199.2953655269 G_phys=1.46629080937026e-05 G_eff=1.46629080937026e-05
Ro12n6n1 h6buf o12nn 68199.2953655269
* o12 input 7 w=+0.269859073889073 w+  bank=n alpha=1 R=123521.261868093 G_phys=8.09577221667219e-06 G_eff=8.09577221667219e-06
Ro12p7n1 h7buf o12pn 123521.261868093
* o12 input 8 w=-0.0167144075003679 w-  bank=m alpha=0.01 R=19942.8746323192 G_phys=5.01432225011038e-05 G_eff=5.01432225011038e-07
Ro12n8m1 h8buf o12nm 19942.8746323192
* o12 input 9 w=-0.271168635938693 w-  bank=n alpha=1 R=122924.737287352 G_phys=8.13505907816079e-06 G_eff=8.13505907816079e-06
Ro12n9n1 h9buf o12nn 122924.737287352
* o12 input 10 w=-0.229866523415109 w-  bank=n alpha=1 R=145011.691298509 G_phys=6.89599570245327e-06 G_eff=6.89599570245327e-06
Ro12n10n1 h10buf o12nn 145011.691298509
* o12 input 11 w=+0.111794037161303 w+  bank=n alpha=1 R=298167.363660355 G_phys=3.35382111483908e-06 G_eff=3.35382111483908e-06
Ro12p11n1 h11buf o12pn 298167.363660355
* o12 input 12 w=-0.187970289472281 w-  bank=n alpha=1 R=177332.989308658 G_phys=5.63910868416843e-06 G_eff=5.63910868416843e-06
Ro12n12n1 h12buf o12nn 177332.989308658
* o12 input 13 w=+0.219867348390274 w+  bank=n alpha=1 R=151606.564491628 G_phys=6.59602045170821e-06 G_eff=6.59602045170821e-06
Ro12p13n1 h13buf o12pn 151606.564491628
* o12 input 14 w=-0.127058880326711 w-  bank=n alpha=1 R=262345.561739739 G_phys=3.81176640980134e-06 G_eff=3.81176640980134e-06
Ro12n14n1 h14buf o12nn 262345.561739739
* o12 input 15 w=+0.40629100094033 w+  bank=n alpha=1 R=82043.0018291959 G_phys=1.21887300282099e-05 G_eff=1.21887300282099e-05
Ro12p15n1 h15buf o12pn 82043.0018291959
* o12 input 16 w=-0.479164967789437 w-  bank=n alpha=1 R=69565.4640344684 G_phys=1.43749490336831e-05 G_eff=1.43749490336831e-05
Ro12n16n1 h16buf o12nn 69565.4640344684
* o12 input 17 w=-0.142691971348636 w-  bank=n alpha=1 R=233603.425744892 G_phys=4.28075914045907e-06 G_eff=4.28075914045907e-06
Ro12n17n1 h17buf o12nn 233603.425744892
* o12 input 18 w=+0.0750962927559542 w+  bank=n alpha=1 R=443874.552391808 G_phys=2.25288878267863e-06 G_eff=2.25288878267863e-06
Ro12p18n1 h18buf o12pn 443874.552391808
* o12 input 19 w=-0.0357891000093011 w-  bank=n alpha=1 R=931382.273504235 G_phys=1.07367300027903e-06 G_eff=1.07367300027903e-06
Ro12n19n1 h19buf o12nn 931382.273504235
* o12 input 20 w=-0.274882313904053 w-  bank=n alpha=1 R=121264.016079871 G_phys=8.24646941712159e-06 G_eff=8.24646941712159e-06
Ro12n20n1 h20buf o12nn 121264.016079871
* o12 input 21 w=+0.0723735016816067 w+  bank=n alpha=1 R=460573.726002328 G_phys=2.1712050504482e-06 G_eff=2.1712050504482e-06
Ro12p21n1 h21buf o12pn 460573.726002328
* o12 input 22 w=-0.42830678611073 w-  bank=n alpha=1 R=77825.8351589968 G_phys=1.28492035833219e-05 G_eff=1.28492035833219e-05
Ro12n22n1 h22buf o12nn 77825.8351589968
* o12 input 23 w=-0.495732058756383 w-  bank=n alpha=1 R=67240.6247377966 G_phys=1.48719617626915e-05 G_eff=1.48719617626915e-05
Ro12n23n1 h23buf o12nn 67240.6247377966
* o12 input 24 w=-0.0511653226482421 w-  bank=n alpha=1 R=651482.910847599 G_phys=1.53495967944726e-06 G_eff=1.53495967944726e-06
Ro12n24n1 h24buf o12nn 651482.910847599
* o12 input 25 w=+0.0558940521557335 w+  bank=n alpha=1 R=596366.376165735 G_phys=1.676821564672e-06 G_eff=1.676821564672e-06
Ro12p25n1 h25buf o12pn 596366.376165735
* o12 input 26 w=+0.307817092263132 w+  bank=n alpha=1 R=108289.416576123 G_phys=9.23451276789396e-06 G_eff=9.23451276789396e-06
Ro12p26n1 h26buf o12pn 108289.416576123
* o12 input 27 w=-0.124284155438311 w-  bank=n alpha=1 R=268202.597634244 G_phys=3.72852466314934e-06 G_eff=3.72852466314934e-06
Ro12n27n1 h27buf o12nn 268202.597634244
* o12 input 28 w=+0.511620988407946 w+  bank=n alpha=1 R=65152.3961850343 G_phys=1.53486296522384e-05 G_eff=1.53486296522384e-05
Ro12p28n1 h28buf o12pn 65152.3961850343
* o12 input 29 w=-0.110998740438628 w-  bank=n alpha=1 R=300303.70796652 G_phys=3.32996221315884e-06 G_eff=3.32996221315884e-06
Ro12n29n1 h29buf o12nn 300303.70796652
* o12 input 30 w=+0.0696620617055659 w+  bank=n alpha=1 R=478500.528368227 G_phys=2.08986185116698e-06 G_eff=2.08986185116698e-06
Ro12p30n1 h30buf o12pn 478500.528368227
* o12 input 31 w=+0.219973071991933 w+  bank=n alpha=1 R=151533.699245496 G_phys=6.59919215975798e-06 G_eff=6.59919215975798e-06
Ro12p31n1 h31buf o12pn 151533.699245496
* o12 input 32 w=+0.138023444689957 w+  bank=n alpha=1 R=241504.864685924 G_phys=4.14070334069872e-06 G_eff=4.14070334069872e-06
Ro12p32n1 h32buf o12pn 241504.864685924
* o12 bias=+0.00625312847600372 b+  bank=m alpha=0.01 R=53306.6503610944 G_phys=1.87593854280111e-05 G_eff=1.87593854280111e-07
Ro12bpm1 vref o12pm 53306.6503610944
Vo12nm o12nm 0 DC 0
Fo12nm o12d 0 Vo12nm 0.01
Vo12nn o12nn 0 DC 0
Fo12nn o12d 0 Vo12nn 1
Vo12pm o12pm 0 DC 0
Fo12pm 0 o12d Vo12pm 0.01
Vo12pn o12pn 0 DC 0
Fo12pn 0 o12d Vo12pn 1
Vo12d o12d 0 DC 0
Ho12 o12lin 0 Vo12d 33333.3333333333

* o13 input 1 w=+0.00200007413415942 w+  bank=m alpha=0.01 R=166660.489049035 G_phys=6.00022240247825e-06 G_eff=6.00022240247825e-08
Ro13p1m1 h1buf o13pm 166660.489049035
* o13 input 2 w=-0.0237460165980216 w-  bank=m alpha=0.01 R=14037.4421098108 G_phys=7.12380497940648e-05 G_eff=7.12380497940648e-07
Ro13n2m1 h2buf o13nm 14037.4421098108
* o13 input 3 w=-0.481641955158027 w-  bank=n alpha=1 R=69207.7028929023 G_phys=1.44492586547408e-05 G_eff=1.44492586547408e-05
Ro13n3n1 h3buf o13nn 69207.7028929023
* o13 input 4 w=-0.401500412219866 w-  bank=n alpha=1 R=83021.9155916573 G_phys=1.2045012366596e-05 G_eff=1.2045012366596e-05
Ro13n4n1 h4buf o13nn 83021.9155916573
* o13 input 5 w=-0.324731283585407 w-  bank=n alpha=1 R=102648.974762441 G_phys=9.7419385075622e-06 G_eff=9.7419385075622e-06
Ro13n5n1 h5buf o13nn 102648.974762441
* o13 input 6 w=+0.0791891194793975 w+  bank=n alpha=1 R=420933.248815901 G_phys=2.37567358438193e-06 G_eff=2.37567358438193e-06
Ro13p6n1 h6buf o13pn 420933.248815901
* o13 input 7 w=+0.286949833874567 w+  bank=n alpha=1 R=116164.323509956 G_phys=8.60849501623701e-06 G_eff=8.60849501623701e-06
Ro13p7n1 h7buf o13pn 116164.323509956
* o13 input 8 w=-0.153846131933853 w-  bank=n alpha=1 R=216666.697526495 G_phys=4.61538395801558e-06 G_eff=4.61538395801558e-06
Ro13n8n1 h8buf o13nn 216666.697526495
* o13 input 9 w=-0.0455077430770376 w-  bank=n alpha=1 R=732476.081639671 G_phys=1.36523229231113e-06 G_eff=1.36523229231113e-06
Ro13n9n1 h9buf o13nn 732476.081639671
* o13 input 10 w=+0.122909253832841 w+  bank=n alpha=1 R=271202.796322133 G_phys=3.68727761498523e-06 G_eff=3.68727761498523e-06
Ro13p10n1 h10buf o13pn 271202.796322133
* o13 input 11 w=+0.0797228425783465 w+  bank=n alpha=1 R=418115.213347736 G_phys=2.3916852773504e-06 G_eff=2.3916852773504e-06
Ro13p11n1 h11buf o13pn 418115.213347736
* o13 input 12 w=-0.0916703213430956 w-  bank=n alpha=1 R=363621.866324394 G_phys=2.75010964029287e-06 G_eff=2.75010964029287e-06
Ro13n12n1 h12buf o13nn 363621.866324394
* o13 input 13 w=-0.00253109868008519 w-  bank=m alpha=0.01 R=131695.115625486 G_phys=7.59329604025557e-06 G_eff=7.59329604025557e-08
Ro13n13m1 h13buf o13nm 131695.115625486
* o13 input 14 w=+0.523873822520012 w+  bank=n alpha=1 R=63628.5530988905 G_phys=1.57162146756004e-05 G_eff=1.57162146756004e-05
Ro13p14n1 h14buf o13pn 63628.5530988905
* o13 input 15 w=+0.0718975606852002 w+  bank=n alpha=1 R=463622.590469816 G_phys=2.15692682055601e-06 G_eff=2.15692682055601e-06
Ro13p15n1 h15buf o13pn 463622.590469816
* o13 input 16 w=+0.212010526629755 w+  bank=n alpha=1 R=157224.897570982 G_phys=6.36031579889266e-06 G_eff=6.36031579889266e-06
Ro13p16n1 h16buf o13pn 157224.897570982
* o13 input 17 w=+0.50252589011925 w+  bank=n alpha=1 R=66331.5741312817 G_phys=1.50757767035775e-05 G_eff=1.50757767035775e-05
Ro13p17n1 h17buf o13pn 66331.5741312817
* o13 input 18 w=-0.0631368164337741 w-  bank=n alpha=1 R=527953.97703173 G_phys=1.89410449301322e-06 G_eff=1.89410449301322e-06
Ro13n18n1 h18buf o13nn 527953.97703173
* o13 input 19 w=+0.124615759492256 w+  bank=n alpha=1 R=267488.907254983 G_phys=3.73847278476769e-06 G_eff=3.73847278476769e-06
Ro13p19n1 h19buf o13pn 267488.907254983
* o13 input 20 w=-0.0825374863137293 w-  bank=n alpha=1 R=403856.899719863 G_phys=2.47612458941188e-06 G_eff=2.47612458941188e-06
Ro13n20n1 h20buf o13nn 403856.899719863
* o13 input 21 w=-0.0332297714786912 w-  bank=m alpha=0.01 R=10031.1653827377 G_phys=9.96893144360737e-05 G_eff=9.96893144360737e-07
Ro13n21m1 h21buf o13nm 10031.1653827377
* o13 input 22 w=+0.217350752944783 w+  bank=n alpha=1 R=153361.940925972 G_phys=6.5205225883435e-06 G_eff=6.5205225883435e-06
Ro13p22n1 h22buf o13pn 153361.940925972
* o13 input 23 w=+0.00620341639632115 w+  bank=m alpha=0.01 R=53733.8318174179 G_phys=1.86102491889634e-05 G_eff=1.86102491889634e-07
Ro13p23m1 h23buf o13pm 53733.8318174179
* o13 input 24 w=-0.56329887647671 w-  bank=n alpha=1 R=59175.2171455139 G_phys=1.68989662943013e-05 G_eff=1.68989662943013e-05
Ro13n24n1 h24buf o13nn 59175.2171455139
* o13 input 25 w=+0.121217122487375 w+  bank=n alpha=1 R=274988.653824918 G_phys=3.63651367462124e-06 G_eff=3.63651367462124e-06
Ro13p25n1 h25buf o13pn 274988.653824918
* o13 input 26 w=-0.0619389520134905 w-  bank=n alpha=1 R=538164.309368251 G_phys=1.85816856040471e-06 G_eff=1.85816856040471e-06
Ro13n26n1 h26buf o13nn 538164.309368251
* o13 input 27 w=-0.148385692307615 w-  bank=n alpha=1 R=224639.807349019 G_phys=4.45157076922844e-06 G_eff=4.45157076922844e-06
Ro13n27n1 h27buf o13nn 224639.807349019
* o13 input 28 w=+0.0960859107643036 w+  bank=n alpha=1 R=346911.769563169 G_phys=2.88257732292911e-06 G_eff=2.88257732292911e-06
Ro13p28n1 h28buf o13pn 346911.769563169
* o13 input 29 w=-0.0967464729103534 w-  bank=n alpha=1 R=344543.137652372 G_phys=2.9023941873106e-06 G_eff=2.9023941873106e-06
Ro13n29n1 h29buf o13nn 344543.137652372
* o13 input 30 w=+0.0502110731232858 w+  bank=n alpha=1 R=663864.188910847 G_phys=1.50633219369857e-06 G_eff=1.50633219369857e-06
Ro13p30n1 h30buf o13pn 663864.188910847
* o13 input 31 w=+0.0717291842082243 w+  bank=n alpha=1 R=464710.894195719 G_phys=2.15187552624673e-06 G_eff=2.15187552624673e-06
Ro13p31n1 h31buf o13pn 464710.894195719
* o13 input 32 w=+0.117218732023777 w+  bank=n alpha=1 R=284368.656424059 G_phys=3.51656196071332e-06 G_eff=3.51656196071332e-06
Ro13p32n1 h32buf o13pn 284368.656424059
* o13 bias=+0.00474280842399728 b+  bank=m alpha=0.01 R=70281.846436546 G_phys=1.42284252719918e-05 G_eff=1.42284252719918e-07
Ro13bpm1 vref o13pm 70281.846436546
Vo13nm o13nm 0 DC 0
Fo13nm o13d 0 Vo13nm 0.01
Vo13nn o13nn 0 DC 0
Fo13nn o13d 0 Vo13nn 1
Vo13pm o13pm 0 DC 0
Fo13pm 0 o13d Vo13pm 0.01
Vo13pn o13pn 0 DC 0
Fo13pn 0 o13d Vo13pn 1
Vo13d o13d 0 DC 0
Ho13 o13lin 0 Vo13d 33333.3333333333

* o14 input 1 w=-0.25477230027339 w-  bank=n alpha=1 R=130835.782765882 G_phys=7.64316900820172e-06 G_eff=7.64316900820172e-06
Ro14n1n1 h1buf o14nn 130835.782765882
* o14 input 2 w=+0.102637632071701 w+  bank=n alpha=1 R=324767.170291372 G_phys=3.07912896215104e-06 G_eff=3.07912896215104e-06
Ro14p2n1 h2buf o14pn 324767.170291372
* o14 input 3 w=+0.107208211835011 w+  bank=n alpha=1 R=310921.456134648 G_phys=3.21624635505032e-06 G_eff=3.21624635505032e-06
Ro14p3n1 h3buf o14pn 310921.456134648
* o14 input 4 w=-0.361346054145307 w-  bank=n alpha=1 R=92247.6749114552 G_phys=1.08403816243592e-05 G_eff=1.08403816243592e-05
Ro14n4n1 h4buf o14nn 92247.6749114552
* o14 input 5 w=+0.0565127294479513 w+  bank=n alpha=1 R=589837.611082537 G_phys=1.69538188343854e-06 G_eff=1.69538188343854e-06
Ro14p5n1 h5buf o14pn 589837.611082537
* o14 input 6 w=-0.166023137794918 w-  bank=n alpha=1 R=200775.22793545 G_phys=4.98069413384754e-06 G_eff=4.98069413384754e-06
Ro14n6n1 h6buf o14nn 200775.22793545
* o14 input 7 w=+0.0533068959488943 w+  bank=n alpha=1 R=625309.96674971 G_phys=1.59920687846683e-06 G_eff=1.59920687846683e-06
Ro14p7n1 h7buf o14pn 625309.96674971
* o14 input 8 w=-0.334728977765226 w-  bank=n alpha=1 R=99583.0524022118 G_phys=1.00418693329568e-05 G_eff=1.00418693329568e-05
Ro14n8n1 h8buf o14nn 99583.0524022118
* o14 input 9 w=-0.184424571200296 w-  bank=n alpha=1 R=180742.365924394 G_phys=5.53273713600887e-06 G_eff=5.53273713600887e-06
Ro14n9n1 h9buf o14nn 180742.365924394
* o14 input 10 w=+0.263838736865495 w+  bank=n alpha=1 R=126339.800324039 G_phys=7.91516210596486e-06 G_eff=7.91516210596486e-06
Ro14p10n1 h10buf o14pn 126339.800324039
* o14 input 11 w=+0.0215454170832462 w+  bank=m alpha=0.01 R=15471.1942704759 G_phys=6.46362512497387e-05 G_eff=6.46362512497387e-07
Ro14p11m1 h11buf o14pm 15471.1942704759
* o14 input 12 w=-0.0509620245346412 w-  bank=n alpha=1 R=654081.811657133 G_phys=1.52886073603923e-06 G_eff=1.52886073603923e-06
Ro14n12n1 h12buf o14nn 654081.811657133
* o14 input 13 w=-0.289718223355261 w-  bank=n alpha=1 R=115054.320530121 G_phys=8.69154670065782e-06 G_eff=8.69154670065782e-06
Ro14n13n1 h13buf o14nn 115054.320530121
* o14 input 14 w=+0.114352462647064 w+  bank=n alpha=1 R=291496.41871914 G_phys=3.43057387941191e-06 G_eff=3.43057387941191e-06
Ro14p14n1 h14buf o14pn 291496.41871914
* o14 input 15 w=-0.172686817087866 w-  bank=n alpha=1 R=193027.666474232 G_phys=5.18060451263599e-06 G_eff=5.18060451263599e-06
Ro14n15n1 h15buf o14nn 193027.666474232
* o14 input 16 w=-0.0880371911025684 w-  bank=n alpha=1 R=378627.860746921 G_phys=2.64111573307705e-06 G_eff=2.64111573307705e-06
Ro14n16n1 h16buf o14nn 378627.860746921
* o14 input 17 w=-0.0970577820037651 w-  bank=n alpha=1 R=343438.028823286 G_phys=2.91173346011295e-06 G_eff=2.91173346011295e-06
Ro14n17n1 h17buf o14nn 343438.028823286
* o14 input 18 w=+0.279065168461303 w+  bank=n alpha=1 R=119446.412883145 G_phys=8.3719550538391e-06 G_eff=8.3719550538391e-06
Ro14p18n1 h18buf o14pn 119446.412883145
* o14 input 19 w=+0.12574844379754 w+  bank=n alpha=1 R=265079.489866303 G_phys=3.7724533139262e-06 G_eff=3.7724533139262e-06
Ro14p19n1 h19buf o14pn 265079.489866303
* o14 input 20 w=+0.196093228285189 w+  bank=n alpha=1 R=169987.172044793 G_phys=5.88279684855566e-06 G_eff=5.88279684855566e-06
Ro14p20n1 h20buf o14pn 169987.172044793
* o14 input 21 w=+0.0606582432664274 w+  bank=n alpha=1 R=549526.849746115 G_phys=1.81974729799282e-06 G_eff=1.81974729799282e-06
Ro14p21n1 h21buf o14pn 549526.849746115
* o14 input 22 w=+0.471542863591523 w+  bank=n alpha=1 R=70689.9327867011 G_phys=1.41462859077457e-05 G_eff=1.41462859077457e-05
Ro14p22n1 h22buf o14pn 70689.9327867011
* o14 input 23 w=+0.132895212526076 w+  bank=n alpha=1 R=250824.184707127 G_phys=3.98685637578228e-06 G_eff=3.98685637578228e-06
Ro14p23n1 h23buf o14pn 250824.184707127
* o14 input 24 w=-0.150700282102261 w-  bank=n alpha=1 R=221189.588156937 G_phys=4.52100846306782e-06 G_eff=4.52100846306782e-06
Ro14n24n1 h24buf o14nn 221189.588156937
* o14 input 25 w=-0.172018927572569 w-  bank=n alpha=1 R=193777.125597247 G_phys=5.16056782717707e-06 G_eff=5.16056782717707e-06
Ro14n25n1 h25buf o14nn 193777.125597247
* o14 input 26 w=-0.144277203051731 w-  bank=n alpha=1 R=231036.730878278 G_phys=4.32831609155192e-06 G_eff=4.32831609155192e-06
Ro14n26n1 h26buf o14nn 231036.730878278
* o14 input 27 w=-0.0456897569368309 w-  bank=n alpha=1 R=729558.12348529 G_phys=1.37069270810493e-06 G_eff=1.37069270810493e-06
Ro14n27n1 h27buf o14nn 729558.12348529
* o14 input 28 w=-0.269930966859316 w-  bank=n alpha=1 R=123488.363418141 G_phys=8.09792900577949e-06 G_eff=8.09792900577949e-06
Ro14n28n1 h28buf o14nn 123488.363418141
* o14 input 29 w=-0.380176315173873 w-  bank=n alpha=1 R=87678.6164811146 G_phys=1.14052894552162e-05 G_eff=1.14052894552162e-05
Ro14n29n1 h29buf o14nn 87678.6164811146
* o14 input 30 w=+0.211443520189348 w+  bank=n alpha=1 R=157646.511482042 G_phys=6.34330560568043e-06 G_eff=6.34330560568043e-06
Ro14p30n1 h30buf o14pn 157646.511482042
* o14 input 31 w=+0.0784944631218348 w+  bank=n alpha=1 R=424658.402741034 G_phys=2.35483389365504e-06 G_eff=2.35483389365504e-06
Ro14p31n1 h31buf o14pn 424658.402741034
* o14 input 32 w=+0.0843025902123393 w+  bank=n alpha=1 R=395401.057658776 G_phys=2.52907770637018e-06 G_eff=2.52907770637018e-06
Ro14p32n1 h32buf o14pn 395401.057658776
* o14 bias=-0.0124822366617376 b-  bank=m alpha=0.01 R=26704.6157164376 G_phys=3.74467099852129e-05 G_eff=3.74467099852129e-07
Ro14bnm1 vref o14nm 26704.6157164376
Vo14nm o14nm 0 DC 0
Fo14nm o14d 0 Vo14nm 0.01
Vo14nn o14nn 0 DC 0
Fo14nn o14d 0 Vo14nn 1
Vo14pm o14pm 0 DC 0
Fo14pm 0 o14d Vo14pm 0.01
Vo14pn o14pn 0 DC 0
Fo14pn 0 o14d Vo14pn 1
Vo14d o14d 0 DC 0
Ho14 o14lin 0 Vo14d 33333.3333333333

* o15 input 1 w=-0.113449668897813 w-  bank=n alpha=1 R=293816.047743229 G_phys=3.40349006693439e-06 G_eff=3.40349006693439e-06
Ro15n1n1 h1buf o15nn 293816.047743229
* o15 input 2 w=-0.169978823552936 w-  bank=n alpha=1 R=196102.85938326 G_phys=5.09936470658807e-06 G_eff=5.09936470658807e-06
Ro15n2n1 h2buf o15nn 196102.85938326
* o15 input 3 w=+0.0133598434574407 w+  bank=m alpha=0.01 R=24950.3921505672 G_phys=4.0079530372322e-05 G_eff=4.0079530372322e-07
Ro15p3m1 h3buf o15pm 24950.3921505672
* o15 input 4 w=-0.169966115485037 w-  bank=n alpha=1 R=196117.52164959 G_phys=5.0989834645511e-06 G_eff=5.0989834645511e-06
Ro15n4n1 h4buf o15nn 196117.52164959
* o15 input 5 w=-0.0418903282162887 w-  bank=n alpha=1 R=795728.626455878 G_phys=1.25670984648866e-06 G_eff=1.25670984648866e-06
Ro15n5n1 h5buf o15nn 795728.626455878
* o15 input 6 w=-0.324291927905124 w-  bank=n alpha=1 R=102788.045168628 G_phys=9.72875783715372e-06 G_eff=9.72875783715372e-06
Ro15n6n1 h6buf o15nn 102788.045168628
* o15 input 7 w=+0.558916704640692 w+  bank=n alpha=1 R=59639.1788911769 G_phys=1.67675011392208e-05 G_eff=1.67675011392208e-05
Ro15p7n1 h7buf o15pn 59639.1788911769
* o15 input 8 w=-0.047599242693459 w-  bank=n alpha=1 R=700291.253539501 G_phys=1.42797728080377e-06 G_eff=1.42797728080377e-06
Ro15n8n1 h8buf o15nn 700291.253539501
* o15 input 9 w=-0.103084990895521 w-  bank=n alpha=1 R=323357.775402217 G_phys=3.09254972686562e-06 G_eff=3.09254972686562e-06
Ro15n9n1 h9buf o15nn 323357.775402217
* o15 input 10 w=-0.115049291784761 w-  bank=n alpha=1 R=289730.886789766 G_phys=3.45147875354283e-06 G_eff=3.45147875354283e-06
Ro15n10n1 h10buf o15nn 289730.886789766
* o15 input 11 w=+0.0920546297717411 w+  bank=n alpha=1 R=362103.822653861 G_phys=2.76163889315223e-06 G_eff=2.76163889315223e-06
Ro15p11n1 h11buf o15pn 362103.822653861
* o15 input 12 w=+0.0505985364133342 w+  bank=n alpha=1 R=658780.583316418 G_phys=1.51795609240003e-06 G_eff=1.51795609240003e-06
Ro15p12n1 h12buf o15pn 658780.583316418
* o15 input 13 w=-0.145296396139138 w-  bank=n alpha=1 R=229416.105416771 G_phys=4.35889188417414e-06 G_eff=4.35889188417414e-06
Ro15n13n1 h13buf o15nn 229416.105416771
* o15 input 14 w=-0.379881852318272 w-  bank=n alpha=1 R=87746.579969306 G_phys=1.13964555695482e-05 G_eff=1.13964555695482e-05
Ro15n14n1 h14buf o15nn 87746.579969306
* o15 input 15 w=+0.223112491519187 w+  bank=n alpha=1 R=149401.466078231 G_phys=6.69337474557561e-06 G_eff=6.69337474557561e-06
Ro15p15n1 h15buf o15pn 149401.466078231
* o15 input 16 w=-0.14757878301826 w-  bank=n alpha=1 R=225868.059429714 G_phys=4.42736349054781e-06 G_eff=4.42736349054781e-06
Ro15n16n1 h16buf o15nn 225868.059429714
* o15 input 17 w=+0.173921977011029 w+  bank=n alpha=1 R=191656.821674811 G_phys=5.21765931033087e-06 G_eff=5.21765931033087e-06
Ro15p17n1 h17buf o15pn 191656.821674811
* o15 input 18 w=+0.133725887369399 w+  bank=n alpha=1 R=249266.121833648 G_phys=4.01177662108198e-06 G_eff=4.01177662108198e-06
Ro15p18n1 h18buf o15pn 249266.121833648
* o15 input 19 w=+0.209560948195519 w+  bank=n alpha=1 R=159062.714787077 G_phys=6.28682844586558e-06 G_eff=6.28682844586558e-06
Ro15p19n1 h19buf o15pn 159062.714787077
* o15 input 20 w=-0.0239329977507233 w-  bank=m alpha=0.01 R=13927.771890726 G_phys=7.17989932521699e-05 G_eff=7.179899325217e-07
Ro15n20m1 h20buf o15nm 13927.771890726
* o15 input 21 w=+0.196041920231295 w+  bank=n alpha=1 R=170031.661054972 G_phys=5.88125760693885e-06 G_eff=5.88125760693885e-06
Ro15p21n1 h21buf o15pn 170031.661054972
* o15 input 22 w=-0.0995510863910355 w-  bank=n alpha=1 R=334836.459769011 G_phys=2.98653259173107e-06 G_eff=2.98653259173107e-06
Ro15n22n1 h22buf o15nn 334836.459769011
* o15 input 23 w=+0.102107365264583 w+  bank=n alpha=1 R=326453.760186243 G_phys=3.06322095793749e-06 G_eff=3.06322095793749e-06
Ro15p23n1 h23buf o15pn 326453.760186243
* o15 input 24 w=-0.21795159550845 w-  bank=n alpha=1 R=152939.157226958 G_phys=6.53854786525351e-06 G_eff=6.53854786525351e-06
Ro15n24n1 h24buf o15nn 152939.157226958
* o15 input 25 w=+0.202525001628457 w+  bank=n alpha=1 R=164588.732577744 G_phys=6.07575004885372e-06 G_eff=6.07575004885372e-06
Ro15p25n1 h25buf o15pn 164588.732577744
* o15 input 26 w=-0.281017181998367 w-  bank=n alpha=1 R=118616.709114701 G_phys=8.43051545995101e-06 G_eff=8.43051545995101e-06
Ro15n26n1 h26buf o15nn 118616.709114701
* o15 input 27 w=+0.141610254018665 w+  bank=n alpha=1 R=235387.850719764 G_phys=4.24830762055994e-06 G_eff=4.24830762055994e-06
Ro15p27n1 h27buf o15pn 235387.850719764
* o15 input 28 w=+0.444984802739648 w+  bank=n alpha=1 R=74908.9252669063 G_phys=1.33495440821894e-05 G_eff=1.33495440821894e-05
Ro15p28n1 h28buf o15pn 74908.9252669063
* o15 input 29 w=-0.120073433142323 w-  bank=n alpha=1 R=277607.897608986 G_phys=3.60220299426968e-06 G_eff=3.60220299426968e-06
Ro15n29n1 h29buf o15nn 277607.897608986
* o15 input 30 w=-0.0538706707421541 w-  bank=n alpha=1 R=618765.886411172 G_phys=1.61612012226462e-06 G_eff=1.61612012226462e-06
Ro15n30n1 h30buf o15nn 618765.886411172
* o15 input 31 w=+0.148090323839994 w+  bank=n alpha=1 R=225087.854959036 G_phys=4.44270971519983e-06 G_eff=4.44270971519983e-06
Ro15p31n1 h31buf o15pn 225087.854959036
* o15 input 32 w=-0.347735979661958 w-  bank=n alpha=1 R=95858.1662033862 G_phys=1.04320793898588e-05 G_eff=1.04320793898588e-05
Ro15n32n1 h32buf o15nn 95858.1662033862
* o15 bias=+0.0711229172621247 b+  bank=n alpha=1 R=468672.189169108 G_phys=2.13368751786374e-06 G_eff=2.13368751786374e-06
Ro15bpn1 vref o15pn 468672.189169108
Vo15nm o15nm 0 DC 0
Fo15nm o15d 0 Vo15nm 0.01
Vo15nn o15nn 0 DC 0
Fo15nn o15d 0 Vo15nn 1
Vo15pm o15pm 0 DC 0
Fo15pm 0 o15d Vo15pm 0.01
Vo15pn o15pn 0 DC 0
Fo15pn 0 o15d Vo15pn 1
Vo15d o15d 0 DC 0
Ho15 o15lin 0 Vo15d 33333.3333333333

* o16 input 1 w=-0.0239168211298723 w-  bank=m alpha=0.01 R=13937.1922181162 G_phys=7.17504633896169e-05 G_eff=7.17504633896169e-07
Ro16n1m1 h1buf o16nm 13937.1922181162
* o16 input 2 w=-0.455843018824687 w-  bank=n alpha=1 R=73124.5888535874 G_phys=1.36752905647406e-05 G_eff=1.36752905647406e-05
Ro16n2n1 h2buf o16nn 73124.5888535874
* o16 input 3 w=-0.360558107273835 w-  bank=n alpha=1 R=92449.2686778431 G_phys=1.0816743218215e-05 G_eff=1.0816743218215e-05
Ro16n3n1 h3buf o16nn 92449.2686778431
* o16 input 4 w=+0.281324980833712 w+  bank=n alpha=1 R=118486.930078336 G_phys=8.43974942501135e-06 G_eff=8.43974942501135e-06
Ro16p4n1 h4buf o16pn 118486.930078336
* o16 input 5 w=-0.0789059543438914 w-  bank=n alpha=1 R=422443.827091407 G_phys=2.36717863031674e-06 G_eff=2.36717863031674e-06
Ro16n5n1 h5buf o16nn 422443.827091407
* o16 input 6 w=+0.0459206910877794 w+  bank=n alpha=1 R=725889.191641633 G_phys=1.37762073263338e-06 G_eff=1.37762073263338e-06
Ro16p6n1 h6buf o16pn 725889.191641633
* o16 input 7 w=-0.348093944852844 w-  bank=n alpha=1 R=95759.5896918717 G_phys=1.04428183455853e-05 G_eff=1.04428183455853e-05
Ro16n7n1 h7buf o16nn 95759.5896918717
* o16 input 8 w=-0.0796710739452782 w-  bank=n alpha=1 R=418386.896055 G_phys=2.39013221835835e-06 G_eff=2.39013221835835e-06
Ro16n8n1 h8buf o16nn 418386.896055
* o16 input 9 w=-0.173339228342165 w-  bank=n alpha=1 R=192301.15220967 G_phys=5.20017685026494e-06 G_eff=5.20017685026494e-06
Ro16n9n1 h9buf o16nn 192301.15220967
* o16 input 10 w=+0.194262181446587 w+  bank=n alpha=1 R=171589.411202501 G_phys=5.82786544339762e-06 G_eff=5.82786544339762e-06
Ro16p10n1 h10buf o16pn 171589.411202501
* o16 input 11 w=+0.155708231075043 w+  bank=n alpha=1 R=214075.602190025 G_phys=4.67124693225129e-06 G_eff=4.67124693225129e-06
Ro16p11n1 h11buf o16pn 214075.602190025
* o16 input 12 w=+0.124882648574468 w+  bank=n alpha=1 R=266917.251626487 G_phys=3.74647945723404e-06 G_eff=3.74647945723404e-06
Ro16p12n1 h12buf o16pn 266917.251626487
* o16 input 13 w=+0.270423516346849 w+  bank=n alpha=1 R=123263.441669694 G_phys=8.11270549040547e-06 G_eff=8.11270549040547e-06
Ro16p13n1 h13buf o16pn 123263.441669694
* o16 input 14 w=-0.22936067173287 w-  bank=n alpha=1 R=145331.512510374 G_phys=6.88082015198609e-06 G_eff=6.88082015198609e-06
Ro16n14n1 h14buf o16nn 145331.512510374
* o16 input 15 w=+0.0349795005301705 w+  bank=n alpha=1 R=952939.087983336 G_phys=1.04938501590512e-06 G_eff=1.04938501590512e-06
Ro16p15n1 h15buf o16pn 952939.087983336
* o16 input 16 w=+0.104322324768401 w+  bank=n alpha=1 R=319522.531800691 G_phys=3.12966974305203e-06 G_eff=3.12966974305203e-06
Ro16p16n1 h16buf o16pn 319522.531800691
* o16 input 17 w=-0.351176137449102 w-  bank=n alpha=1 R=94919.129686494 G_phys=1.05352841234731e-05 G_eff=1.05352841234731e-05
Ro16n17n1 h17buf o16nn 94919.129686494
* o16 input 18 w=+0.119462358831177 w+  bank=n alpha=1 R=279027.918580107 G_phys=3.58387076493532e-06 G_eff=3.58387076493532e-06
Ro16p18n1 h18buf o16pn 279027.918580107
* o16 input 19 w=+0.230688311648174 w+  bank=n alpha=1 R=144495.111586626 G_phys=6.92064934944523e-06 G_eff=6.92064934944523e-06
Ro16p19n1 h19buf o16pn 144495.111586626
* o16 input 20 w=-0.0614748986253126 w-  bank=n alpha=1 R=542226.731214294 G_phys=1.84424695875938e-06 G_eff=1.84424695875938e-06
Ro16n20n1 h20buf o16nn 542226.731214294
* o16 input 21 w=+0.36727529530057 w+  bank=n alpha=1 R=90758.4413104999 G_phys=1.10182588590171e-05 G_eff=1.10182588590171e-05
Ro16p21n1 h21buf o16pn 90758.4413104999
* o16 input 22 w=+0.579638140801163 w+  bank=n alpha=1 R=57507.1427964708 G_phys=1.73891442240349e-05 G_eff=1.73891442240349e-05
Ro16p22n1 h22buf o16pn 57507.1427964708
* o16 input 23 w=-0.0387096142803063 w-  bank=n alpha=1 R=861112.515664923 G_phys=1.16128842840919e-06 G_eff=1.16128842840919e-06
Ro16n23n1 h23buf o16nn 861112.515664923
* o16 input 24 w=+0.0384174368738491 w+  bank=n alpha=1 R=867661.563232072 G_phys=1.15252310621547e-06 G_eff=1.15252310621547e-06
Ro16p24n1 h24buf o16pn 867661.563232072
* o16 input 25 w=+0.201641208818347 w+  bank=n alpha=1 R=165310.12449624 G_phys=6.04923626455041e-06 G_eff=6.04923626455041e-06
Ro16p25n1 h25buf o16pn 165310.12449624
* o16 input 26 w=-0.606109769372092 w-  bank=n alpha=1 R=54995.5387913735 G_phys=1.81832930811628e-05 G_eff=1.81832930811628e-05
Ro16n26n1 h26buf o16nn 54995.5387913735
* o16 input 27 w=-0.101484914332963 w-  bank=n alpha=1 R=328456.04248105 G_phys=3.04454742998888e-06 G_eff=3.04454742998888e-06
Ro16n27n1 h27buf o16nn 328456.04248105
* o16 input 28 w=+0.04265872854179 w+  bank=n alpha=1 R=781395.378455286 G_phys=1.2797618562537e-06 G_eff=1.2797618562537e-06
Ro16p28n1 h28buf o16pn 781395.378455286
* o16 input 29 w=+0.0889131834636398 w+  bank=n alpha=1 R=374897.535267812 G_phys=2.66739550390919e-06 G_eff=2.66739550390919e-06
Ro16p29n1 h29buf o16pn 374897.535267812
* o16 input 30 w=+0.0420485970959956 w+  bank=n alpha=1 R=792733.54250641 G_phys=1.26145791287987e-06 G_eff=1.26145791287987e-06
Ro16p30n1 h30buf o16pn 792733.54250641
* o16 input 31 w=-0.332324220948992 w-  bank=n alpha=1 R=100303.652975236 G_phys=9.96972662846976e-06 G_eff=9.96972662846976e-06
Ro16n31n1 h31buf o16nn 100303.652975236
* o16 input 32 w=+0.137132637809711 w+  bank=n alpha=1 R=243073.668425948 G_phys=4.11397913429134e-06 G_eff=4.11397913429134e-06
Ro16p32n1 h32buf o16pn 243073.668425948
* o16 bias=+0.0410780079484629 b+  bank=n alpha=1 R=811464.21158382 G_phys=1.23234023845389e-06 G_eff=1.23234023845389e-06
Ro16bpn1 vref o16pn 811464.21158382
Vo16nm o16nm 0 DC 0
Fo16nm o16d 0 Vo16nm 0.01
Vo16nn o16nn 0 DC 0
Fo16nn o16d 0 Vo16nn 1
Vo16pn o16pn 0 DC 0
Fo16pn 0 o16d Vo16pn 1
Vo16d o16d 0 DC 0
Ho16 o16lin 0 Vo16d 33333.3333333333
.control
set numdgt=15
alter Vin1 DC 0.632568504068692
alter Vin2 DC 0.130751912471634
alter Vin3 DC 0.498395519129232
alter Vin4 DC 0.508991138596361
alter Vin5 DC 0.741696432510955
alter Vin6 DC -0.174816274310903
alter Vin7 DC -0.711636899513491
alter Vin8 DC -0.992297390491566
alter Vin9 DC 0.124859661764151
alter Vin10 DC 0.927115220977617
alter Vin11 DC 0.757625693253616
alter Vin12 DC -0.349962125380286
alter Vin13 DC 0.772046924490164
alter Vin14 DC 0.809792344935797
alter Vin15 DC 0.311400434804866
alter Vin16 DC 0.38369938347353
op
print v(o1lin)
print v(o2lin)
print v(o3lin)
print v(o4lin)
print v(o5lin)
print v(o6lin)
print v(o7lin)
print v(o8lin)
print v(o9lin)
print v(o10lin)
print v(o11lin)
print v(o12lin)
print v(o13lin)
print v(o14lin)
print v(o15lin)
print v(o16lin)
alter Vin1 DC -0.974788209071848
alter Vin2 DC -0.200637826852555
alter Vin3 DC 0.823173051424639
alter Vin4 DC 0.925543502570132
alter Vin5 DC -0.235735032734585
alter Vin6 DC -0.141680228154392
alter Vin7 DC -0.886626844533918
alter Vin8 DC 0.40575230866322
alter Vin9 DC -0.9068934262577
alter Vin10 DC -0.71518146061856
alter Vin11 DC 0.507768822660382
alter Vin12 DC -0.423033389400712
alter Vin13 DC -0.189634986503447
alter Vin14 DC -0.729894999162038
alter Vin15 DC -0.822420852539174
alter Vin16 DC 0.729238013944139
op
print v(o1lin)
print v(o2lin)
print v(o3lin)
print v(o4lin)
print v(o5lin)
print v(o6lin)
print v(o7lin)
print v(o8lin)
print v(o9lin)
print v(o10lin)
print v(o11lin)
print v(o12lin)
print v(o13lin)
print v(o14lin)
print v(o15lin)
print v(o16lin)
alter Vin1 DC 0.847734806115268
alter Vin2 DC -0.795676825133873
alter Vin3 DC -0.576906573311323
alter Vin4 DC 0.808070915111557
alter Vin5 DC -0.272832325997157
alter Vin6 DC 0.984764551383679
alter Vin7 DC 0.873557149180198
alter Vin8 DC -0.395997821263188
alter Vin9 DC -0.91476403063532
alter Vin10 DC -0.814982443313317
alter Vin11 DC 0.386244963375333
alter Vin12 DC 0.97673536509706
alter Vin13 DC 0.859516677956838
alter Vin14 DC -0.48344879964576
alter Vin15 DC -0.389119391902879
alter Vin16 DC -0.0777429346880354
op
print v(o1lin)
print v(o2lin)
print v(o3lin)
print v(o4lin)
print v(o5lin)
print v(o6lin)
print v(o7lin)
print v(o8lin)
print v(o9lin)
print v(o10lin)
print v(o11lin)
print v(o12lin)
print v(o13lin)
print v(o14lin)
print v(o15lin)
print v(o16lin)
alter Vin1 DC -0.634763869503377
alter Vin2 DC 0.66136408923338
alter Vin3 DC -0.0583013778475243
alter Vin4 DC 0.720990552465887
alter Vin5 DC 0.260016013717853
alter Vin6 DC 0.577414589397466
alter Vin7 DC 0.854892175873237
alter Vin8 DC -0.100267864923785
alter Vin9 DC -0.2976521369567
alter Vin10 DC 0.530570623968421
alter Vin11 DC 0.0982353459122769
alter Vin12 DC -0.228498741708201
alter Vin13 DC -0.423704441504684
alter Vin14 DC -0.324453707550555
alter Vin15 DC 0.963733756086886
alter Vin16 DC 0.888564654599973
op
print v(o1lin)
print v(o2lin)
print v(o3lin)
print v(o4lin)
print v(o5lin)
print v(o6lin)
print v(o7lin)
print v(o8lin)
print v(o9lin)
print v(o10lin)
print v(o11lin)
print v(o12lin)
print v(o13lin)
print v(o14lin)
print v(o15lin)
print v(o16lin)
alter Vin1 DC 0.399419993562847
alter Vin2 DC 0.822754861286246
alter Vin3 DC -0.217979993499255
alter Vin4 DC -0.524840716208239
alter Vin5 DC -0.343585224682448
alter Vin6 DC 0.597298680392867
alter Vin7 DC 0.745769924406716
alter Vin8 DC -0.31122778594332
alter Vin9 DC -0.551408564506993
alter Vin10 DC 0.508813890470598
alter Vin11 DC 0.967095039058534
alter Vin12 DC 0.436711939252078
alter Vin13 DC -0.637944426107168
alter Vin14 DC -0.610126039852947
alter Vin15 DC -0.0266004623343832
alter Vin16 DC 0.865503835859949
op
print v(o1lin)
print v(o2lin)
print v(o3lin)
print v(o4lin)
print v(o5lin)
print v(o6lin)
print v(o7lin)
print v(o8lin)
print v(o9lin)
print v(o10lin)
print v(o11lin)
print v(o12lin)
print v(o13lin)
print v(o14lin)
print v(o15lin)
print v(o16lin)
alter Vin1 DC -0.39950651162754
alter Vin2 DC 0.845146280157393
alter Vin3 DC -0.293453062060104
alter Vin4 DC -0.935486140839395
alter Vin5 DC -0.0810356399901349
alter Vin6 DC -0.902253265490345
alter Vin7 DC -0.555846545167458
alter Vin8 DC 0.760951343886015
alter Vin9 DC 0.759556104325771
alter Vin10 DC -0.949711300869059
alter Vin11 DC 0.0303569257790743
alter Vin12 DC -0.0286488050711204
alter Vin13 DC -0.578375740619194
alter Vin14 DC 0.906957053187536
alter Vin15 DC -0.073548295446664
alter Vin16 DC 0.0683418880828401
op
print v(o1lin)
print v(o2lin)
print v(o3lin)
print v(o4lin)
print v(o5lin)
print v(o6lin)
print v(o7lin)
print v(o8lin)
print v(o9lin)
print v(o10lin)
print v(o11lin)
print v(o12lin)
print v(o13lin)
print v(o14lin)
print v(o15lin)
print v(o16lin)
alter Vin1 DC -0.269700131318679
alter Vin2 DC -0.0587851098186172
alter Vin3 DC -0.93859148153159
alter Vin4 DC 0.37397748574996
alter Vin5 DC -0.640198473614279
alter Vin6 DC 0.28300439655269
alter Vin7 DC 0.495573806278234
alter Vin8 DC 0.4844036398211
alter Vin9 DC 0.865719664227782
alter Vin10 DC -0.637807257193159
alter Vin11 DC 0.140608503083495
alter Vin12 DC -0.793259398029265
alter Vin13 DC 0.803362583110163
alter Vin14 DC 0.644880503300019
alter Vin15 DC 0.80511980776248
alter Vin16 DC 0.00183769605351314
op
print v(o1lin)
print v(o2lin)
print v(o3lin)
print v(o4lin)
print v(o5lin)
print v(o6lin)
print v(o7lin)
print v(o8lin)
print v(o9lin)
print v(o10lin)
print v(o11lin)
print v(o12lin)
print v(o13lin)
print v(o14lin)
print v(o15lin)
print v(o16lin)
alter Vin1 DC -0.681053369759573
alter Vin2 DC 0.971345998932643
alter Vin3 DC 0.0228486000093842
alter Vin4 DC -0.68100585488642
alter Vin5 DC 0.935892877213541
alter Vin6 DC 0.408157507560112
alter Vin7 DC 0.0488412507809939
alter Vin8 DC 0.828266383636528
alter Vin9 DC 0.784246855742534
alter Vin10 DC 0.207324880526272
alter Vin11 DC 0.218839873002423
alter Vin12 DC -0.64711694724826
alter Vin13 DC -0.45152559776989
alter Vin14 DC -0.16638824613438
alter Vin15 DC 0.56955443939986
alter Vin16 DC -0.894236938055073
op
print v(o1lin)
print v(o2lin)
print v(o3lin)
print v(o4lin)
print v(o5lin)
print v(o6lin)
print v(o7lin)
print v(o8lin)
print v(o9lin)
print v(o10lin)
print v(o11lin)
print v(o12lin)
print v(o13lin)
print v(o14lin)
print v(o15lin)
print v(o16lin)
alter Vin1 DC -0.924906884178613
alter Vin2 DC 0.267791334016869
alter Vin3 DC 0.386698050737095
alter Vin4 DC -0.375678093248884
alter Vin5 DC -0.481472424709471
alter Vin6 DC -0.590426934613701
alter Vin7 DC 0.274930056654101
alter Vin8 DC -0.495416670165966
alter Vin9 DC 0.662447960935986
alter Vin10 DC -0.39828366695253
alter Vin11 DC -0.435305893543825
alter Vin12 DC -0.673137852956615
alter Vin13 DC 0.399291241842683
alter Vin14 DC -0.135245929167714
alter Vin15 DC 0.191750308509824
alter Vin16 DC -0.317239774769057
op
print v(o1lin)
print v(o2lin)
print v(o3lin)
print v(o4lin)
print v(o5lin)
print v(o6lin)
print v(o7lin)
print v(o8lin)
print v(o9lin)
print v(o10lin)
print v(o11lin)
print v(o12lin)
print v(o13lin)
print v(o14lin)
print v(o15lin)
print v(o16lin)
alter Vin1 DC 0.691315307576891
alter Vin2 DC -0.966597973272848
alter Vin3 DC 0.337819856228323
alter Vin4 DC 0.445958641593821
alter Vin5 DC 0.28794565803369
alter Vin6 DC -0.437558044466196
alter Vin7 DC 0.335767271835964
alter Vin8 DC 0.741106323711654
alter Vin9 DC -0.498474688285342
alter Vin10 DC -0.937258343994007
alter Vin11 DC 0.628549591207388
alter Vin12 DC 0.0809865794436
alter Vin13 DC -0.792347081447127
alter Vin14 DC 0.290895831462678
alter Vin15 DC 0.917514644221665
alter Vin16 DC -0.636405891470935
op
print v(o1lin)
print v(o2lin)
print v(o3lin)
print v(o4lin)
print v(o5lin)
print v(o6lin)
print v(o7lin)
print v(o8lin)
print v(o9lin)
print v(o10lin)
print v(o11lin)
print v(o12lin)
print v(o13lin)
print v(o14lin)
print v(o15lin)
print v(o16lin)
alter Vin1 DC -0.436056235334991
alter Vin2 DC 0.359995773967924
alter Vin3 DC -0.862040082296962
alter Vin4 DC -0.613020281079166
alter Vin5 DC -0.682661118108276
alter Vin6 DC 0.0327240219234706
alter Vin7 DC -0.254762451719826
alter Vin8 DC -0.628386977446209
alter Vin9 DC -0.435404154442101
alter Vin10 DC -0.560268250029906
alter Vin11 DC -0.34004922102946
alter Vin12 DC 0.828462300998657
alter Vin13 DC -0.258762364783062
alter Vin14 DC 0.0615557520793739
alter Vin15 DC -0.749003484831865
alter Vin16 DC -0.461728905661948
op
print v(o1lin)
print v(o2lin)
print v(o3lin)
print v(o4lin)
print v(o5lin)
print v(o6lin)
print v(o7lin)
print v(o8lin)
print v(o9lin)
print v(o10lin)
print v(o11lin)
print v(o12lin)
print v(o13lin)
print v(o14lin)
print v(o15lin)
print v(o16lin)
alter Vin1 DC 0.402941317710264
alter Vin2 DC 0.676235321348749
alter Vin3 DC 0.422742637816617
alter Vin4 DC 0.294030371745866
alter Vin5 DC -0.638561187867718
alter Vin6 DC -0.0501402124484349
alter Vin7 DC -0.126876472940439
alter Vin8 DC 0.249620810954959
alter Vin9 DC 0.800022887685632
alter Vin10 DC -0.267525733933315
alter Vin11 DC -0.0493799961815793
alter Vin12 DC 0.412930540027973
alter Vin13 DC 0.168971578589697
alter Vin14 DC 0.402529908662486
alter Vin15 DC 0.590508734712441
alter Vin16 DC -0.809797572982249
op
print v(o1lin)
print v(o2lin)
print v(o3lin)
print v(o4lin)
print v(o5lin)
print v(o6lin)
print v(o7lin)
print v(o8lin)
print v(o9lin)
print v(o10lin)
print v(o11lin)
print v(o12lin)
print v(o13lin)
print v(o14lin)
print v(o15lin)
print v(o16lin)
alter Vin1 DC -0.720940644465072
alter Vin2 DC 0.811090286911281
alter Vin3 DC 0.0887704649024641
alter Vin4 DC -0.703881870777446
alter Vin5 DC 0.792271352370679
alter Vin6 DC -0.611577475657032
alter Vin7 DC 0.630598962593579
alter Vin8 DC -0.909175170042211
alter Vin9 DC 0.45028681887581
alter Vin10 DC -0.610646509410917
alter Vin11 DC 0.942769230832138
alter Vin12 DC 0.253399891858326
alter Vin13 DC 0.239806152599995
alter Vin14 DC -0.424323687911083
alter Vin15 DC -0.132402036224528
alter Vin16 DC 0.499567887714755
op
print v(o1lin)
print v(o2lin)
print v(o3lin)
print v(o4lin)
print v(o5lin)
print v(o6lin)
print v(o7lin)
print v(o8lin)
print v(o9lin)
print v(o10lin)
print v(o11lin)
print v(o12lin)
print v(o13lin)
print v(o14lin)
print v(o15lin)
print v(o16lin)
alter Vin1 DC -0.553601012740836
alter Vin2 DC -0.0853827874775894
alter Vin3 DC 0.472526855220367
alter Vin4 DC 0.983320104826496
alter Vin5 DC -0.32589641106305
alter Vin6 DC 0.620602426134993
alter Vin7 DC -0.529649272081957
alter Vin8 DC -0.400401658684954
alter Vin9 DC 0.506127142109278
alter Vin10 DC -0.0613843649963521
alter Vin11 DC 0.194508563247131
alter Vin12 DC -0.0888973979013215
alter Vin13 DC 0.304485213029303
alter Vin14 DC 0.571192626328441
alter Vin15 DC 0.39987631868635
alter Vin16 DC 0.458594801121468
op
print v(o1lin)
print v(o2lin)
print v(o3lin)
print v(o4lin)
print v(o5lin)
print v(o6lin)
print v(o7lin)
print v(o8lin)
print v(o9lin)
print v(o10lin)
print v(o11lin)
print v(o12lin)
print v(o13lin)
print v(o14lin)
print v(o15lin)
print v(o16lin)
alter Vin1 DC 0.941921702845139
alter Vin2 DC -0.797590224953611
alter Vin3 DC -0.353544884625478
alter Vin4 DC -0.223679714692619
alter Vin5 DC 0.934853237163932
alter Vin6 DC 0.813220120283511
alter Vin7 DC 0.620477689684263
alter Vin8 DC -0.971969304466214
alter Vin9 DC -0.591538023713506
alter Vin10 DC 0.157162778762541
alter Vin11 DC -0.00954942079742005
alter Vin12 DC -0.766378178791702
alter Vin13 DC 0.781165514171662
alter Vin14 DC -0.870653903905813
alter Vin15 DC -0.855576259711061
alter Vin16 DC 0.576744547964966
op
print v(o1lin)
print v(o2lin)
print v(o3lin)
print v(o4lin)
print v(o5lin)
print v(o6lin)
print v(o7lin)
print v(o8lin)
print v(o9lin)
print v(o10lin)
print v(o11lin)
print v(o12lin)
print v(o13lin)
print v(o14lin)
print v(o15lin)
print v(o16lin)
alter Vin1 DC 0.0847980140064368
alter Vin2 DC -0.546436186199117
alter Vin3 DC 0.157551439199196
alter Vin4 DC -0.675094911660673
alter Vin5 DC 0.251984062858915
alter Vin6 DC 0.533034777990185
alter Vin7 DC -0.636309229712619
alter Vin8 DC 0.205266715162125
alter Vin9 DC 0.355151588504783
alter Vin10 DC -0.763079400779309
alter Vin11 DC 0.279208117784239
alter Vin12 DC -0.046053502725351
alter Vin13 DC -0.0674199792200116
alter Vin14 DC -0.0988424326224195
alter Vin15 DC 0.341224431366531
alter Vin16 DC -0.128234288046615
op
print v(o1lin)
print v(o2lin)
print v(o3lin)
print v(o4lin)
print v(o5lin)
print v(o6lin)
print v(o7lin)
print v(o8lin)
print v(o9lin)
print v(o10lin)
print v(o11lin)
print v(o12lin)
print v(o13lin)
print v(o14lin)
print v(o15lin)
print v(o16lin)
alter Vin1 DC -0.595380417251091
alter Vin2 DC -0.170465926726426
alter Vin3 DC -0.165712373937593
alter Vin4 DC 0.484522499674577
alter Vin5 DC 0.78085882899596
alter Vin6 DC -0.00693757328167033
alter Vin7 DC -0.498016397952294
alter Vin8 DC -0.76057897931883
alter Vin9 DC -0.343082475402419
alter Vin10 DC 0.0125577265451373
alter Vin11 DC 0.60192661275731
alter Vin12 DC -0.0810399461010238
alter Vin13 DC 0.308396489131115
alter Vin14 DC -0.555444513107257
alter Vin15 DC -0.388314730894595
alter Vin16 DC 0.923801824090698
op
print v(o1lin)
print v(o2lin)
print v(o3lin)
print v(o4lin)
print v(o5lin)
print v(o6lin)
print v(o7lin)
print v(o8lin)
print v(o9lin)
print v(o10lin)
print v(o11lin)
print v(o12lin)
print v(o13lin)
print v(o14lin)
print v(o15lin)
print v(o16lin)
alter Vin1 DC -0.344075298305219
alter Vin2 DC -0.299983052907286
alter Vin3 DC -0.203058505077156
alter Vin4 DC 0.435239788418766
alter Vin5 DC 0.363815756954568
alter Vin6 DC 0.837980352083505
alter Vin7 DC -0.538527300440037
alter Vin8 DC -0.938627722316779
alter Vin9 DC 0.4922043173456
alter Vin10 DC 0.207737109101553
alter Vin11 DC 0.020741026962491
alter Vin12 DC 0.25637018547913
alter Vin13 DC -0.83211091299048
alter Vin14 DC 0.766421841791898
alter Vin15 DC -0.927411256783522
alter Vin16 DC 0.369430588094565
op
print v(o1lin)
print v(o2lin)
print v(o3lin)
print v(o4lin)
print v(o5lin)
print v(o6lin)
print v(o7lin)
print v(o8lin)
print v(o9lin)
print v(o10lin)
print v(o11lin)
print v(o12lin)
print v(o13lin)
print v(o14lin)
print v(o15lin)
print v(o16lin)
alter Vin1 DC 0.627063489212866
alter Vin2 DC -0.582648694346974
alter Vin3 DC -0.765786006835309
alter Vin4 DC 0.102836606226475
alter Vin5 DC -0.66611661718385
alter Vin6 DC 0.412069103904774
alter Vin7 DC -0.320626602803983
alter Vin8 DC 0.664935939224919
alter Vin9 DC -0.907582410736682
alter Vin10 DC 0.138301736499832
alter Vin11 DC -0.124043342050667
alter Vin12 DC -0.444462469724564
alter Vin13 DC 0.993018090945098
alter Vin14 DC 0.384970115288437
alter Vin15 DC 0.988144749211259
alter Vin16 DC 0.83719280846034
op
print v(o1lin)
print v(o2lin)
print v(o3lin)
print v(o4lin)
print v(o5lin)
print v(o6lin)
print v(o7lin)
print v(o8lin)
print v(o9lin)
print v(o10lin)
print v(o11lin)
print v(o12lin)
print v(o13lin)
print v(o14lin)
print v(o15lin)
print v(o16lin)
alter Vin1 DC -0.45182957480955
alter Vin2 DC -0.662024952982424
alter Vin3 DC -0.229489946519203
alter Vin4 DC 0.68091685978688
alter Vin5 DC -0.524794188274996
alter Vin6 DC -0.775298122631856
alter Vin7 DC 0.477695002661498
alter Vin8 DC 0.318249373784927
alter Vin9 DC 0.0674353216224022
alter Vin10 DC -0.757574746285693
alter Vin11 DC 0.194480016220294
alter Vin12 DC -0.986058532734065
alter Vin13 DC -0.858099129281211
alter Vin14 DC 0.875413943263164
alter Vin15 DC -0.355937045022594
alter Vin16 DC -0.909269999495478
op
print v(o1lin)
print v(o2lin)
print v(o3lin)
print v(o4lin)
print v(o5lin)
print v(o6lin)
print v(o7lin)
print v(o8lin)
print v(o9lin)
print v(o10lin)
print v(o11lin)
print v(o12lin)
print v(o13lin)
print v(o14lin)
print v(o15lin)
print v(o16lin)
alter Vin1 DC -0.166134124041978
alter Vin2 DC 0.326271636139386
alter Vin3 DC 0.0377865575229868
alter Vin4 DC 0.642967168503026
alter Vin5 DC -0.0313452796975957
alter Vin6 DC -0.898196834887308
alter Vin7 DC -0.0223210703281855
alter Vin8 DC 0.0240743286141054
alter Vin9 DC -0.32939698929494
alter Vin10 DC 0.156138339259947
alter Vin11 DC 0.998037514156259
alter Vin12 DC 0.996329734012833
alter Vin13 DC -0.792547573290175
alter Vin14 DC 0.272037484511549
alter Vin15 DC 0.144597423090336
alter Vin16 DC 0.648759180262861
op
print v(o1lin)
print v(o2lin)
print v(o3lin)
print v(o4lin)
print v(o5lin)
print v(o6lin)
print v(o7lin)
print v(o8lin)
print v(o9lin)
print v(o10lin)
print v(o11lin)
print v(o12lin)
print v(o13lin)
print v(o14lin)
print v(o15lin)
print v(o16lin)
alter Vin1 DC 0.513767503102245
alter Vin2 DC -0.993130673228192
alter Vin3 DC -0.741368455463561
alter Vin4 DC -0.673172294979255
alter Vin5 DC 0.53329038934038
alter Vin6 DC 0.273011112722964
alter Vin7 DC -0.22429483417346
alter Vin8 DC -0.904486174889755
alter Vin9 DC -0.0476389722976311
alter Vin10 DC 0.0830713748633647
alter Vin11 DC -0.0631237690576123
alter Vin12 DC -0.387190151349574
alter Vin13 DC 0.490599598157352
alter Vin14 DC -0.431150162403273
alter Vin15 DC -0.494227353798093
alter Vin16 DC 0.199587837072336
op
print v(o1lin)
print v(o2lin)
print v(o3lin)
print v(o4lin)
print v(o5lin)
print v(o6lin)
print v(o7lin)
print v(o8lin)
print v(o9lin)
print v(o10lin)
print v(o11lin)
print v(o12lin)
print v(o13lin)
print v(o14lin)
print v(o15lin)
print v(o16lin)
alter Vin1 DC -0.527641643915313
alter Vin2 DC -0.760469900825891
alter Vin3 DC -0.971812928614647
alter Vin4 DC -0.462029484155251
alter Vin5 DC -0.0990347067926469
alter Vin6 DC -0.431709782876269
alter Vin7 DC 0.582115295594787
alter Vin8 DC 0.490760521778589
alter Vin9 DC -0.597773697850127
alter Vin10 DC -0.146377118439857
alter Vin11 DC 0.77673031103089
alter Vin12 DC -0.958686104499727
alter Vin13 DC -0.651792165711311
alter Vin14 DC -0.771428363238295
alter Vin15 DC -0.274616062196005
alter Vin16 DC 0.797804290304925
op
print v(o1lin)
print v(o2lin)
print v(o3lin)
print v(o4lin)
print v(o5lin)
print v(o6lin)
print v(o7lin)
print v(o8lin)
print v(o9lin)
print v(o10lin)
print v(o11lin)
print v(o12lin)
print v(o13lin)
print v(o14lin)
print v(o15lin)
print v(o16lin)
alter Vin1 DC -0.0660406839746723
alter Vin2 DC -0.199767810717373
alter Vin3 DC 0.433496899757818
alter Vin4 DC 0.179118988466795
alter Vin5 DC -0.213841522026575
alter Vin6 DC 0.556646137550105
alter Vin7 DC -0.700676048926627
alter Vin8 DC -0.447891404812417
alter Vin9 DC -0.03646969314408
alter Vin10 DC 0.356038664374622
alter Vin11 DC -0.898261479878571
alter Vin12 DC -0.522238075094493
alter Vin13 DC 0.470385125738646
alter Vin14 DC -0.934570154871633
alter Vin15 DC -0.215637621907727
alter Vin16 DC -0.839313330640211
op
print v(o1lin)
print v(o2lin)
print v(o3lin)
print v(o4lin)
print v(o5lin)
print v(o6lin)
print v(o7lin)
print v(o8lin)
print v(o9lin)
print v(o10lin)
print v(o11lin)
print v(o12lin)
print v(o13lin)
print v(o14lin)
print v(o15lin)
print v(o16lin)
alter Vin1 DC 0.944694975466901
alter Vin2 DC 0.557429746816729
alter Vin3 DC 0.0879434025868335
alter Vin4 DC -0.971277715280804
alter Vin5 DC 0.469272183979264
alter Vin6 DC 0.0553351732696565
alter Vin7 DC 0.319789179040026
alter Vin8 DC 0.105605881218313
alter Vin9 DC -0.808751474487991
alter Vin10 DC 0.345207050357025
alter Vin11 DC 0.887488099386043
alter Vin12 DC -0.946434379958131
alter Vin13 DC -0.756800857731664
alter Vin14 DC 0.584597058025779
alter Vin15 DC -0.172504938226507
alter Vin16 DC 0.057467887193803
op
print v(o1lin)
print v(o2lin)
print v(o3lin)
print v(o4lin)
print v(o5lin)
print v(o6lin)
print v(o7lin)
print v(o8lin)
print v(o9lin)
print v(o10lin)
print v(o11lin)
print v(o12lin)
print v(o13lin)
print v(o14lin)
print v(o15lin)
print v(o16lin)
alter Vin1 DC 0.268139611364692
alter Vin2 DC -0.0761352932592003
alter Vin3 DC 0.257679787771012
alter Vin4 DC 0.647151913043588
alter Vin5 DC 0.688559040420576
alter Vin6 DC 0.195725091292368
alter Vin7 DC -0.650874124907297
alter Vin8 DC 0.757864910663943
alter Vin9 DC -0.801870229804984
alter Vin10 DC 0.0650107507341318
alter Vin11 DC 0.76839506437409
alter Vin12 DC 0.626485114847845
alter Vin13 DC -0.916744432608743
alter Vin14 DC -0.0381884442222795
alter Vin15 DC -0.39538459366548
alter Vin16 DC -0.53577973836249
op
print v(o1lin)
print v(o2lin)
print v(o3lin)
print v(o4lin)
print v(o5lin)
print v(o6lin)
print v(o7lin)
print v(o8lin)
print v(o9lin)
print v(o10lin)
print v(o11lin)
print v(o12lin)
print v(o13lin)
print v(o14lin)
print v(o15lin)
print v(o16lin)
alter Vin1 DC -0.399980891864974
alter Vin2 DC -0.311058824105357
alter Vin3 DC -0.121767102063513
alter Vin4 DC -0.1825017503415
alter Vin5 DC -0.384605419902336
alter Vin6 DC 0.330631581125283
alter Vin7 DC -0.386290416681561
alter Vin8 DC -0.384489741601594
alter Vin9 DC 0.461619066894131
alter Vin10 DC 0.340745152205258
alter Vin11 DC 0.0704341709189509
alter Vin12 DC -0.729253158394329
alter Vin13 DC -0.938300926484224
alter Vin14 DC -0.138387864413021
alter Vin15 DC -0.774754191520238
alter Vin16 DC -0.06472577537549
op
print v(o1lin)
print v(o2lin)
print v(o3lin)
print v(o4lin)
print v(o5lin)
print v(o6lin)
print v(o7lin)
print v(o8lin)
print v(o9lin)
print v(o10lin)
print v(o11lin)
print v(o12lin)
print v(o13lin)
print v(o14lin)
print v(o15lin)
print v(o16lin)
alter Vin1 DC 0.829033111352976
alter Vin2 DC 0.280583414286498
alter Vin3 DC -0.120742403743087
alter Vin4 DC 0.0243484731867412
alter Vin5 DC 0.814584378326768
alter Vin6 DC 0.126953925080522
alter Vin7 DC -0.480745642214154
alter Vin8 DC 0.58301448926957
alter Vin9 DC -0.81340983633115
alter Vin10 DC -0.0371270227098195
alter Vin11 DC 0.20534777858118
alter Vin12 DC 0.195891870031178
alter Vin13 DC 0.970242611575792
alter Vin14 DC -0.260742875944806
alter Vin15 DC -0.707389032009879
alter Vin16 DC -0.834880031964718
op
print v(o1lin)
print v(o2lin)
print v(o3lin)
print v(o4lin)
print v(o5lin)
print v(o6lin)
print v(o7lin)
print v(o8lin)
print v(o9lin)
print v(o10lin)
print v(o11lin)
print v(o12lin)
print v(o13lin)
print v(o14lin)
print v(o15lin)
print v(o16lin)
alter Vin1 DC 0.857714478615315
alter Vin2 DC -0.977990911511488
alter Vin3 DC 0.522120406530206
alter Vin4 DC -0.818687889680604
alter Vin5 DC -0.375725178244296
alter Vin6 DC 0.0646773078474716
alter Vin7 DC -0.0696743243817957
alter Vin8 DC -0.260504274511249
alter Vin9 DC 0.991412947690472
alter Vin10 DC -0.736994622705201
alter Vin11 DC -0.989748939020532
alter Vin12 DC 0.745774856471066
alter Vin13 DC 0.801402815326226
alter Vin14 DC -0.709499539722716
alter Vin15 DC 0.652792790844334
alter Vin16 DC 0.832995677945966
op
print v(o1lin)
print v(o2lin)
print v(o3lin)
print v(o4lin)
print v(o5lin)
print v(o6lin)
print v(o7lin)
print v(o8lin)
print v(o9lin)
print v(o10lin)
print v(o11lin)
print v(o12lin)
print v(o13lin)
print v(o14lin)
print v(o15lin)
print v(o16lin)
alter Vin1 DC 0.578295068169871
alter Vin2 DC -0.645738590777075
alter Vin3 DC -0.438695216585002
alter Vin4 DC 0.354791332621486
alter Vin5 DC 0.572376875240838
alter Vin6 DC 0.283557785900749
alter Vin7 DC 0.801480336715229
alter Vin8 DC 0.837498240545797
alter Vin9 DC -0.162628392977149
alter Vin10 DC 0.0188708173241798
alter Vin11 DC 0.732770034383577
alter Vin12 DC 0.829886941830955
alter Vin13 DC -0.215883555562326
alter Vin14 DC 0.778511642633058
alter Vin15 DC 0.726117246545339
alter Vin16 DC -0.836770051577228
op
print v(o1lin)
print v(o2lin)
print v(o3lin)
print v(o4lin)
print v(o5lin)
print v(o6lin)
print v(o7lin)
print v(o8lin)
print v(o9lin)
print v(o10lin)
print v(o11lin)
print v(o12lin)
print v(o13lin)
print v(o14lin)
print v(o15lin)
print v(o16lin)
alter Vin1 DC 0.512666764012534
alter Vin2 DC -0.91042789183315
alter Vin3 DC -0.674618340260172
alter Vin4 DC 0.77595275679209
alter Vin5 DC 0.541729157541262
alter Vin6 DC 0.434965717552227
alter Vin7 DC 0.812555641142557
alter Vin8 DC -0.696450119180847
alter Vin9 DC 0.349416262802516
alter Vin10 DC 0.238837808121401
alter Vin11 DC -0.606665588660031
alter Vin12 DC 0.394312915601357
alter Vin13 DC -0.299226531600345
alter Vin14 DC -0.590822138784816
alter Vin15 DC -0.900583331081588
alter Vin16 DC 0.969002954577666
op
print v(o1lin)
print v(o2lin)
print v(o3lin)
print v(o4lin)
print v(o5lin)
print v(o6lin)
print v(o7lin)
print v(o8lin)
print v(o9lin)
print v(o10lin)
print v(o11lin)
print v(o12lin)
print v(o13lin)
print v(o14lin)
print v(o15lin)
print v(o16lin)
alter Vin1 DC 0.996964849631111
alter Vin2 DC -0.382670628895657
alter Vin3 DC -0.589629194051136
alter Vin4 DC -0.257488018342011
alter Vin5 DC -0.0225875667849409
alter Vin6 DC 0.316086952435916
alter Vin7 DC 0.923082372784055
alter Vin8 DC 0.0720344794803358
alter Vin9 DC -0.570888117083981
alter Vin10 DC 0.636196022229113
alter Vin11 DC -0.59824376349448
alter Vin12 DC 0.724608074730714
alter Vin13 DC -0.224915642937104
alter Vin14 DC 0.262010847512565
alter Vin15 DC -0.401587833404117
alter Vin16 DC 0.438103800930035
op
print v(o1lin)
print v(o2lin)
print v(o3lin)
print v(o4lin)
print v(o5lin)
print v(o6lin)
print v(o7lin)
print v(o8lin)
print v(o9lin)
print v(o10lin)
print v(o11lin)
print v(o12lin)
print v(o13lin)
print v(o14lin)
print v(o15lin)
print v(o16lin)
alter Vin1 DC 0.146388210996796
alter Vin2 DC 0.851378176855976
alter Vin3 DC -0.545296719530172
alter Vin4 DC 0.936320371011729
alter Vin5 DC -0.659971945152452
alter Vin6 DC 0.637939687045485
alter Vin7 DC 0.775987953987478
alter Vin8 DC -0.7151329644111
alter Vin9 DC -0.403349246529835
alter Vin10 DC -0.818560699155668
alter Vin11 DC 0.66658468821056
alter Vin12 DC 0.229852048443837
alter Vin13 DC 0.152309271507268
alter Vin14 DC -0.0441514852931166
alter Vin15 DC 0.0779565043300003
alter Vin16 DC -0.122549087436726
op
print v(o1lin)
print v(o2lin)
print v(o3lin)
print v(o4lin)
print v(o5lin)
print v(o6lin)
print v(o7lin)
print v(o8lin)
print v(o9lin)
print v(o10lin)
print v(o11lin)
print v(o12lin)
print v(o13lin)
print v(o14lin)
print v(o15lin)
print v(o16lin)
alter Vin1 DC -0.926439381972823
alter Vin2 DC -0.615234894251263
alter Vin3 DC -0.0340238055806736
alter Vin4 DC 0.109946635985621
alter Vin5 DC -0.227895739326049
alter Vin6 DC 0.455407156960182
alter Vin7 DC 0.400984605846592
alter Vin8 DC -0.461739950266764
alter Vin9 DC 0.962599087089418
alter Vin10 DC 0.712808562717367
alter Vin11 DC 0.514105913709235
alter Vin12 DC 0.33339311864586
alter Vin13 DC 0.983543769948446
alter Vin14 DC 0.536587909150327
alter Vin15 DC 0.0318213121438755
alter Vin16 DC 0.666927443816752
op
print v(o1lin)
print v(o2lin)
print v(o3lin)
print v(o4lin)
print v(o5lin)
print v(o6lin)
print v(o7lin)
print v(o8lin)
print v(o9lin)
print v(o10lin)
print v(o11lin)
print v(o12lin)
print v(o13lin)
print v(o14lin)
print v(o15lin)
print v(o16lin)
alter Vin1 DC -0.322834862686127
alter Vin2 DC -0.584062888919473
alter Vin3 DC -0.720596149709497
alter Vin4 DC -0.678155702025423
alter Vin5 DC -0.50355911783956
alter Vin6 DC 0.493391744831513
alter Vin7 DC 0.77110097674651
alter Vin8 DC 0.35657120941032
alter Vin9 DC -0.299379898988419
alter Vin10 DC 0.913130383361827
alter Vin11 DC 0.047342951298037
alter Vin12 DC -0.309370616770426
alter Vin13 DC 0.192831131458793
alter Vin14 DC 0.116497038265849
alter Vin15 DC 0.128520413216278
alter Vin16 DC 0.177999850779134
op
print v(o1lin)
print v(o2lin)
print v(o3lin)
print v(o4lin)
print v(o5lin)
print v(o6lin)
print v(o7lin)
print v(o8lin)
print v(o9lin)
print v(o10lin)
print v(o11lin)
print v(o12lin)
print v(o13lin)
print v(o14lin)
print v(o15lin)
print v(o16lin)
alter Vin1 DC -0.727341455542907
alter Vin2 DC 0.529599033013268
alter Vin3 DC 0.521024787135614
alter Vin4 DC -0.866776027386548
alter Vin5 DC 0.776840732388895
alter Vin6 DC -0.717793598737009
alter Vin7 DC -0.591867360923596
alter Vin8 DC -0.0815920521485731
alter Vin9 DC -0.0328119134751146
alter Vin10 DC 0.509073071940425
alter Vin11 DC -0.546284331957509
alter Vin12 DC 0.481384262792588
alter Vin13 DC -0.859595413394354
alter Vin14 DC -0.291234569240053
alter Vin15 DC -0.870152250182007
alter Vin16 DC -0.435785443442337
op
print v(o1lin)
print v(o2lin)
print v(o3lin)
print v(o4lin)
print v(o5lin)
print v(o6lin)
print v(o7lin)
print v(o8lin)
print v(o9lin)
print v(o10lin)
print v(o11lin)
print v(o12lin)
print v(o13lin)
print v(o14lin)
print v(o15lin)
print v(o16lin)
alter Vin1 DC 0.308674565966459
alter Vin2 DC 0.476522030460678
alter Vin3 DC 0.176116940403099
alter Vin4 DC -0.269696616647023
alter Vin5 DC -0.835425825203222
alter Vin6 DC -0.257374488996112
alter Vin7 DC 0.861825960245245
alter Vin8 DC -0.757200981805819
alter Vin9 DC 0.219570221593069
alter Vin10 DC -0.737313772662746
alter Vin11 DC 0.916532670163939
alter Vin12 DC -0.326724749976099
alter Vin13 DC -0.258958621423432
alter Vin14 DC 0.110523904762884
alter Vin15 DC -0.262524879020353
alter Vin16 DC 0.595305764490593
op
print v(o1lin)
print v(o2lin)
print v(o3lin)
print v(o4lin)
print v(o5lin)
print v(o6lin)
print v(o7lin)
print v(o8lin)
print v(o9lin)
print v(o10lin)
print v(o11lin)
print v(o12lin)
print v(o13lin)
print v(o14lin)
print v(o15lin)
print v(o16lin)
alter Vin1 DC -0.121565718815817
alter Vin2 DC 0.85026137362778
alter Vin3 DC -0.725882120507907
alter Vin4 DC 0.0407127903627837
alter Vin5 DC 0.486714139870312
alter Vin6 DC -0.174725929659921
alter Vin7 DC 0.197358954375944
alter Vin8 DC 0.807395499014515
alter Vin9 DC 0.843354973338086
alter Vin10 DC 0.282953221647761
alter Vin11 DC -0.999304235886526
alter Vin12 DC -0.950389802844308
alter Vin13 DC 0.771638055757985
alter Vin14 DC -0.140350408284357
alter Vin15 DC 0.438700172314504
alter Vin16 DC 0.766208145137089
op
print v(o1lin)
print v(o2lin)
print v(o3lin)
print v(o4lin)
print v(o5lin)
print v(o6lin)
print v(o7lin)
print v(o8lin)
print v(o9lin)
print v(o10lin)
print v(o11lin)
print v(o12lin)
print v(o13lin)
print v(o14lin)
print v(o15lin)
print v(o16lin)
alter Vin1 DC 0.524565147427742
alter Vin2 DC -0.228728707561463
alter Vin3 DC 0.622966092889961
alter Vin4 DC 0.442099278822348
alter Vin5 DC -0.68185971324033
alter Vin6 DC -0.657022993439861
alter Vin7 DC 0.606146642396182
alter Vin8 DC -0.234310724429887
alter Vin9 DC 0.330684414271566
alter Vin10 DC 0.118943468091141
alter Vin11 DC -0.905603957323895
alter Vin12 DC -0.647082133976604
alter Vin13 DC -0.988277487148225
alter Vin14 DC -0.0351159487862691
alter Vin15 DC 0.0357885445778272
alter Vin16 DC -0.573737602016074
op
print v(o1lin)
print v(o2lin)
print v(o3lin)
print v(o4lin)
print v(o5lin)
print v(o6lin)
print v(o7lin)
print v(o8lin)
print v(o9lin)
print v(o10lin)
print v(o11lin)
print v(o12lin)
print v(o13lin)
print v(o14lin)
print v(o15lin)
print v(o16lin)
alter Vin1 DC 0.420805696758339
alter Vin2 DC -0.616530557983683
alter Vin3 DC 0.364821943112122
alter Vin4 DC -0.395523393484615
alter Vin5 DC -0.679355100506025
alter Vin6 DC -0.65784113684798
alter Vin7 DC 0.438381846487236
alter Vin8 DC -0.85021400464495
alter Vin9 DC -0.420415477822893
alter Vin10 DC 0.0361561564656332
alter Vin11 DC -0.815551896898906
alter Vin12 DC -0.241219421510256
alter Vin13 DC -0.0373494349822094
alter Vin14 DC -0.135841212962577
alter Vin15 DC 0.57727959838417
alter Vin16 DC -0.210802787968692
op
print v(o1lin)
print v(o2lin)
print v(o3lin)
print v(o4lin)
print v(o5lin)
print v(o6lin)
print v(o7lin)
print v(o8lin)
print v(o9lin)
print v(o10lin)
print v(o11lin)
print v(o12lin)
print v(o13lin)
print v(o14lin)
print v(o15lin)
print v(o16lin)
.endc

.end
