* Physical AI - Experiment 13 architecture A: current-gain multi-range (Experiment 11 baseline)
* CCCS alpha on every bank, including unity
* Frozen Experiment 9 network A. Weights were not edited.
* Behavioral circuit analysis. Not transistor-level or PCB power.
* scale_error=0.001 Ileak=1e-08 rail=15 linear=False relu=direct
* shape: 2 -> 4 -> 1

Vin1 in1 0 DC 0
Vin2 in2 0 DC 0
Vref vref 0 DC 1

* h1 input 1 w=+0.683760795348816 w+  bank=n alpha=1 R=487499.920441162 G_phys=2.05128238604645e-06 G_eff=2.05128238604645e-06
Rh1p1n1 in1 h1pn 477062.409534048
* h1 input 2 w=+0.309366783045794 w+  bank=m alpha=0.01 R=10774.6969487669 G_phys=9.28100349137381e-05 G_eff=9.28100349137381e-07
Rh1p2m1 in2 h1pm 10294.5562111646
* h1 bias=-0.0265987962576462 b-  bank=m alpha=0.01 R=125318.954325804 G_phys=7.97963887729386e-06 G_eff=7.97963887729386e-08
Rh1bnm1 vref h1nm 128886.623163356
Vh1nm h1nm 0 DC 0
Fh1nm h1d 0 Vh1nm 0.01001
Vh1pm h1pm 0 DC 0
Fh1pm 0 h1d Vh1pm 0.01001
Vh1pn h1pn 0 DC 0
Fh1pn 0 h1d Vh1pn 1.001
Bh1leak 0 h1d I = 1e-08
Vh1d h1d 0 DC 0
Hh1 h1lin 0 Vh1d 333333.333333333
* direct bounded ReLU: y=max(0, min(15, v(h1lin))) no high-gain op-amp loop
Bh1relu h1y 0 V = max(0, min(15, v(h1lin)))
Eh1 h1buf 0 h1y 0 1

* h2 input 1 w=-0.884821731731664 w-  bank=n alpha=1 R=376723.718890781 G_phys=2.65446519519499e-06 G_eff=2.65446519519499e-06
Rh2n1n1 in1 h2nn 379776.142839065
* h2 input 2 w=+0.782653240240456 w+  bank=n alpha=1 R=425901.684417639 G_phys=2.34795972072137e-06 G_eff=2.34795972072137e-06
Rh2p2n1 in2 h2pn 410672.041167067
* h2 bias=+5.94215208512688e-05 b+  bank=f alpha=0.0001 R=560963.988396833 G_phys=1.78264562553806e-06 G_eff=1.78264562553806e-10
Rh2bpf1 vref h2pf 542014.362857226
Vh2nn h2nn 0 DC 0
Fh2nn h2d 0 Vh2nn 1.001
Vh2pf h2pf 0 DC 0
Fh2pf 0 h2d Vh2pf 0.0001001
Vh2pn h2pn 0 DC 0
Fh2pn 0 h2d Vh2pn 1.001
Bh2leak 0 h2d I = 1e-08
Vh2d h2d 0 DC 0
Hh2 h2lin 0 Vh2d 333333.333333333
* direct bounded ReLU: y=max(0, min(15, v(h2lin))) no high-gain op-amp loop
Bh2relu h2y 0 V = max(0, min(15, v(h2lin)))
Eh2 h2buf 0 h2y 0 1

* h3 input 1 w=+0.80723931339229 w+  bank=n alpha=1 R=412930.004526854 G_phys=2.42171794017687e-06 G_eff=2.42171794017687e-06
Rh3p1n1 in1 h3pn 432703.686914932
* h3 input 2 w=+1.71882311343666 w+  bank=n alpha=1 R=193931.144355429 G_phys=5.15646934030999e-06 G_eff=5.15646934030999e-06
Rh3p2n1 in2 h3pn 188401.711275221
* h3 bias=+0.0173783581286745 b+  bank=m alpha=0.01 R=191809.451080035 G_phys=5.21350743860236e-06 G_eff=5.21350743860236e-08
Rh3bpm1 vref h3pm 187052.971452689
Vh3pm h3pm 0 DC 0
Fh3pm 0 h3d Vh3pm 0.01001
Vh3pn h3pn 0 DC 0
Fh3pn 0 h3d Vh3pn 1.001
Bh3leak 0 h3d I = 1e-08
Vh3d h3d 0 DC 0
Hh3 h3lin 0 Vh3d 333333.333333333
* direct bounded ReLU: y=max(0, min(15, v(h3lin))) no high-gain op-amp loop
Bh3relu h3y 0 V = max(0, min(15, v(h3lin)))
Eh3 h3buf 0 h3y 0 1

* h4 input 1 w=-2.16286246457598 w-  bank=n alpha=1 R=154116.749813161 G_phys=6.48858739372794e-06 G_eff=6.48858739372794e-06
Rh4n1n1 in1 h4nn 147679.459956819
* h4 input 2 w=+0.726967919426763 w+  bank=n alpha=1 R=458525.506319697 G_phys=2.18090375828029e-06 G_eff=2.18090375828029e-06
Rh4p2n1 in2 h4pn 454408.418130943
* h4 bias=-0.0184151286231249 b-  bank=m alpha=0.01 R=181010.591973139 G_phys=5.52453858693748e-06 G_eff=5.52453858693748e-08
Rh4bnm1 vref h4nm 178631.484304106
Vh4nm h4nm 0 DC 0
Fh4nm h4d 0 Vh4nm 0.01001
Vh4nn h4nn 0 DC 0
Fh4nn h4d 0 Vh4nn 1.001
Vh4pn h4pn 0 DC 0
Fh4pn 0 h4d Vh4pn 1.001
Bh4leak 0 h4d I = 1e-08
Vh4d h4d 0 DC 0
Hh4 h4lin 0 Vh4d 333333.333333333
* direct bounded ReLU: y=max(0, min(15, v(h4lin))) no high-gain op-amp loop
Bh4relu h4y 0 V = max(0, min(15, v(h4lin)))
Eh4 h4buf 0 h4y 0 1

* o1 input 1 w=+0.601889648539537 w+  bank=n alpha=1 R=553811.374131711 G_phys=1.80566894561861e-06 G_eff=1.80566894561861e-06
Ro1p1n1 h1buf o1pn 550191.100233513
* o1 input 2 w=+0.347315954504283 w+  bank=n alpha=1 R=959740.918925228 G_phys=1.04194786351285e-06 G_eff=1.04194786351285e-06
Ro1p2n1 h2buf o1pn 958012.36658362
* o1 input 3 w=+0.876922607606196 w+  bank=n alpha=1 R=380117.16249768 G_phys=2.63076782281859e-06 G_eff=2.63076782281859e-06
Ro1p3n1 h3buf o1pn 367875.603977832
* o1 input 4 w=+0.929527796434486 w+  bank=n alpha=1 R=358605.019249499 G_phys=2.78858338930346e-06 G_eff=2.78858338930346e-06
Ro1p4n1 h4buf o1pn 368418.993551867
* o1 bias=+0.0103504514823374 b+  bank=m alpha=0.01 R=322047.143452777 G_phys=3.10513544470123e-06 G_eff=3.10513544470123e-08
Ro1bpm1 vref o1pm 312604.172473349
Vo1pm o1pm 0 DC 0
Fo1pm 0 o1d Vo1pm 0.01001
Vo1pn o1pn 0 DC 0
Fo1pn 0 o1d Vo1pn 1.001
Bo1leak 0 o1d I = 1e-08
Vo1d o1d 0 DC 0
Ho1 o1lin 0 Vo1d 333333.333333333
.control
set numdgt=15
alter Vin1 DC 0.495890381998429
alter Vin2 DC -0.228340775408503
op
print v(o1lin)
alter Vin1 DC 0.756803450731949
alter Vin2 DC -0.493463154782852
op
print v(o1lin)
alter Vin1 DC 0.0197598265208218
alter Vin2 DC -0.497753533777523
op
print v(o1lin)
alter Vin1 DC 0.719708492698105
alter Vin2 DC 0.918599350896533
op
print v(o1lin)
alter Vin1 DC 0.851156813442857
alter Vin2 DC 0.47470967080281
op
print v(o1lin)
alter Vin1 DC -0.991631560552765
alter Vin2 DC 0.373910178628484
op
print v(o1lin)
alter Vin1 DC -0.493782461673535
alter Vin2 DC -0.617768058094302
op
print v(o1lin)
alter Vin1 DC 0.477274001997098
alter Vin2 DC 0.376215395320717
op
print v(o1lin)
.endc

.end
