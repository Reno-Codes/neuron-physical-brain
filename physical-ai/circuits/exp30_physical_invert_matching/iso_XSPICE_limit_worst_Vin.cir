* Experiment 30 isolated invert bench mode=limit
* Vin=2.60818 R1=10000 R2=10000 Rload=4914.01 A=100000
* Frozen-map invert identity: Vout should equal -Vin.
.model liminv limit(gain=100000 in_offset=0 out_lower_limit=-15 out_upper_limit=15 fraction=false limit_range=0.05)

Vin in 0 DC 2.60817586522917
Rinvbia in mid 10000
Rinvbib out mid 10000
Rload out 0 4914.01304862554
* XSPICE limit invert invb (LEVEL 2). Rails ±15 V.
Ainvbinv %vd(0 mid) out liminv
.control
set numdgt=15
op
print v(out)
print v(mid)
print v(in)
.endc
.end
