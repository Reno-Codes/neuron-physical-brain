* Physical AI - Experiment 12: A L1_cccs
* non-ideal behavioral circuit analysis
* Frozen Experiment 9/11 weights. Mapping not retrained.
* Not transistor-level. Not a PCB or silicon power model.
* rail=+/-15 V  gain_err=0.01 Ileak=1e-08 Rsense=1
* buf A=1e+12 Vos=0 Rout=0
* ReLU Aol=100000 Vos=0 diode Is=1e-14 N=1
* Gw1=3e-06 Gw2=3e-06 banks=f:0.0001+m:0.01+n:1
* shape: 2 -> 4 -> 1

Vin1 in1 0 DC 0
Vin2 in2 0 DC 0
Vref vref 0 DC 1

* --- neuron h1 non-ideal behavioral ---
* h1 input 1 w=+0.683760795348816 w+  bank=n alpha=1 R=487499.920441162 G_phys=2.05128238604645e-06 G_eff=2.05128238604645e-06
Rh1p1n1 in1 h1pn 487499.920441162
* h1 input 2 w=+0.309366783045794 w+  bank=m alpha=0.01 R=10774.6969487669 G_phys=9.28100349137381e-05 G_eff=9.28100349137381e-07
Rh1p2m1 in2 h1pm 10774.6969487669
* h1 bias=-0.0265987962576462 b-  bank=m alpha=0.01 R=125318.954325804 G_phys=7.97963887729386e-06 G_eff=7.97963887729386e-08
Rh1bnm1 vref h1nm 125318.954325804
Vh1nm h1nm h1nms DC 0
Rh1nms h1nms 0 1
Bh1nm h1d 0 I = max(-0.01, min(0.01, 0.0101 * i(Vh1nm) + 1e-08))
* CCCS Rout=1000000 is idle: h1d is 0 V
Vh1pm h1pm h1pms DC 0
Rh1pms h1pms 0 1
Bh1pm 0 h1d I = max(-0.01, min(0.01, 0.0101 * i(Vh1pm) + 1e-08))
* CCCS Rout=1000000 is idle: h1d is 0 V
Vh1pn h1pn h1pns DC 0
Rh1pns h1pns 0 1
Bh1pn 0 h1d I = max(-0.01, min(0.01, 1.01 * i(Vh1pn) + 1e-08))
* CCCS Rout=1000000 is idle: h1d is 0 V
Vh1d h1d 0 DC 0
Hh1 h1lin 0 Vh1d 333333.333333333
Bh1 h1amp 0 V = max(-15, min(15, 100000 * (v(h1lin) - v(h1y) + 0)))
Dh1 h1amp h1y Dsi
RLh1 h1y 0 10000
Bh1be h1buf 0 V = max(-15, min(15, 0.999999999999 * (v(h1y) + 0)))

* --- neuron h2 non-ideal behavioral ---
* h2 input 1 w=-0.884821731731664 w-  bank=n alpha=1 R=376723.718890781 G_phys=2.65446519519499e-06 G_eff=2.65446519519499e-06
Rh2n1n1 in1 h2nn 376723.718890781
* h2 input 2 w=+0.782653240240456 w+  bank=n alpha=1 R=425901.684417639 G_phys=2.34795972072137e-06 G_eff=2.34795972072137e-06
Rh2p2n1 in2 h2pn 425901.684417639
* h2 bias=+5.94215208512688e-05 b+  bank=f alpha=0.0001 R=560963.988396833 G_phys=1.78264562553806e-06 G_eff=1.78264562553806e-10
Rh2bpf1 vref h2pf 560963.988396833
Vh2nn h2nn h2nns DC 0
Rh2nns h2nns 0 1
Bh2nn h2d 0 I = max(-0.01, min(0.01, 1.01 * i(Vh2nn) + 1e-08))
* CCCS Rout=1000000 is idle: h2d is 0 V
Vh2pf h2pf h2pfs DC 0
Rh2pfs h2pfs 0 1
Bh2pf 0 h2d I = max(-0.01, min(0.01, 0.000101 * i(Vh2pf) + 1e-08))
* CCCS Rout=1000000 is idle: h2d is 0 V
Vh2pn h2pn h2pns DC 0
Rh2pns h2pns 0 1
Bh2pn 0 h2d I = max(-0.01, min(0.01, 1.01 * i(Vh2pn) + 1e-08))
* CCCS Rout=1000000 is idle: h2d is 0 V
Vh2d h2d 0 DC 0
Hh2 h2lin 0 Vh2d 333333.333333333
Bh2 h2amp 0 V = max(-15, min(15, 100000 * (v(h2lin) - v(h2y) + 0)))
Dh2 h2amp h2y Dsi
RLh2 h2y 0 10000
Bh2be h2buf 0 V = max(-15, min(15, 0.999999999999 * (v(h2y) + 0)))

* --- neuron h3 non-ideal behavioral ---
* h3 input 1 w=+0.80723931339229 w+  bank=n alpha=1 R=412930.004526854 G_phys=2.42171794017687e-06 G_eff=2.42171794017687e-06
Rh3p1n1 in1 h3pn 412930.004526854
* h3 input 2 w=+1.71882311343666 w+  bank=n alpha=1 R=193931.144355429 G_phys=5.15646934030999e-06 G_eff=5.15646934030999e-06
Rh3p2n1 in2 h3pn 193931.144355429
* h3 bias=+0.0173783581286745 b+  bank=m alpha=0.01 R=191809.451080035 G_phys=5.21350743860236e-06 G_eff=5.21350743860236e-08
Rh3bpm1 vref h3pm 191809.451080035
Vh3pm h3pm h3pms DC 0
Rh3pms h3pms 0 1
Bh3pm 0 h3d I = max(-0.01, min(0.01, 0.0101 * i(Vh3pm) + 1e-08))
* CCCS Rout=1000000 is idle: h3d is 0 V
Vh3pn h3pn h3pns DC 0
Rh3pns h3pns 0 1
Bh3pn 0 h3d I = max(-0.01, min(0.01, 1.01 * i(Vh3pn) + 1e-08))
* CCCS Rout=1000000 is idle: h3d is 0 V
Vh3d h3d 0 DC 0
Hh3 h3lin 0 Vh3d 333333.333333333
Bh3 h3amp 0 V = max(-15, min(15, 100000 * (v(h3lin) - v(h3y) + 0)))
Dh3 h3amp h3y Dsi
RLh3 h3y 0 10000
Bh3be h3buf 0 V = max(-15, min(15, 0.999999999999 * (v(h3y) + 0)))

* --- neuron h4 non-ideal behavioral ---
* h4 input 1 w=-2.16286246457598 w-  bank=n alpha=1 R=154116.749813161 G_phys=6.48858739372794e-06 G_eff=6.48858739372794e-06
Rh4n1n1 in1 h4nn 154116.749813161
* h4 input 2 w=+0.726967919426763 w+  bank=n alpha=1 R=458525.506319697 G_phys=2.18090375828029e-06 G_eff=2.18090375828029e-06
Rh4p2n1 in2 h4pn 458525.506319697
* h4 bias=-0.0184151286231249 b-  bank=m alpha=0.01 R=181010.591973139 G_phys=5.52453858693748e-06 G_eff=5.52453858693748e-08
Rh4bnm1 vref h4nm 181010.591973139
Vh4nm h4nm h4nms DC 0
Rh4nms h4nms 0 1
Bh4nm h4d 0 I = max(-0.01, min(0.01, 0.0101 * i(Vh4nm) + 1e-08))
* CCCS Rout=1000000 is idle: h4d is 0 V
Vh4nn h4nn h4nns DC 0
Rh4nns h4nns 0 1
Bh4nn h4d 0 I = max(-0.01, min(0.01, 1.01 * i(Vh4nn) + 1e-08))
* CCCS Rout=1000000 is idle: h4d is 0 V
Vh4pn h4pn h4pns DC 0
Rh4pns h4pns 0 1
Bh4pn 0 h4d I = max(-0.01, min(0.01, 1.01 * i(Vh4pn) + 1e-08))
* CCCS Rout=1000000 is idle: h4d is 0 V
Vh4d h4d 0 DC 0
Hh4 h4lin 0 Vh4d 333333.333333333
Bh4 h4amp 0 V = max(-15, min(15, 100000 * (v(h4lin) - v(h4y) + 0)))
Dh4 h4amp h4y Dsi
RLh4 h4y 0 10000
Bh4be h4buf 0 V = max(-15, min(15, 0.999999999999 * (v(h4y) + 0)))

* --- neuron o1 non-ideal behavioral ---
* o1 input 1 w=+0.601889648539537 w+  bank=n alpha=1 R=553811.374131711 G_phys=1.80566894561861e-06 G_eff=1.80566894561861e-06
Ro1p1n1 h1buf o1pn 553811.374131711
* o1 input 2 w=+0.347315954504283 w+  bank=n alpha=1 R=959740.918925228 G_phys=1.04194786351285e-06 G_eff=1.04194786351285e-06
Ro1p2n1 h2buf o1pn 959740.918925228
* o1 input 3 w=+0.876922607606196 w+  bank=n alpha=1 R=380117.16249768 G_phys=2.63076782281859e-06 G_eff=2.63076782281859e-06
Ro1p3n1 h3buf o1pn 380117.16249768
* o1 input 4 w=+0.929527796434486 w+  bank=n alpha=1 R=358605.019249499 G_phys=2.78858338930346e-06 G_eff=2.78858338930346e-06
Ro1p4n1 h4buf o1pn 358605.019249499
* o1 bias=+0.0103504514823374 b+  bank=m alpha=0.01 R=322047.143452777 G_phys=3.10513544470123e-06 G_eff=3.10513544470123e-08
Ro1bpm1 vref o1pm 322047.143452777
Vo1pm o1pm o1pms DC 0
Ro1pms o1pms 0 1
Bo1pm 0 o1d I = max(-0.01, min(0.01, 0.0101 * i(Vo1pm) + 1e-08))
* CCCS Rout=1000000 is idle: o1d is 0 V
Vo1pn o1pn o1pns DC 0
Ro1pns o1pns 0 1
Bo1pn 0 o1d I = max(-0.01, min(0.01, 1.01 * i(Vo1pn) + 1e-08))
* CCCS Rout=1000000 is idle: o1d is 0 V
Vo1d o1d 0 DC 0
Ho1 o1lin 0 Vo1d 333333.333333333

.model Dsi D(Is=1e-14 N=1 Rs=1 Eg=1.11 Xti=3)
.control
set numdgt=15
alter Vin1 DC 0.494125531810799
alter Vin2 DC -0.229451673774848
op
print v(o1lin)
alter Vin1 DC 0.756925898000261
alter Vin2 DC -0.494115472466579
op
print v(o1lin)
alter Vin1 DC 0.0208787503964407
alter Vin2 DC -0.496416458868835
op
print v(o1lin)
alter Vin1 DC 0.718610447200065
alter Vin2 DC 0.919157890410241
op
print v(o1lin)
alter Vin1 DC 0.853272914872112
alter Vin2 DC 0.475051693668985
op
print v(o1lin)
alter Vin1 DC -0.990532770398839
alter Vin2 DC 0.373831316331627
op
print v(o1lin)
alter Vin1 DC -0.493372271299048
alter Vin2 DC -0.61799069167069
op
print v(o1lin)
alter Vin1 DC 0.476619483972029
alter Vin2 DC 0.37665129561251
op
print v(o1lin)
alter Vin1 DC -0.166798248487805
alter Vin2 DC -0.000404175318413857
op
print v(o1lin)
alter Vin1 DC 0.18150665644273
alter Vin2 DC -0.735489925406268
op
print v(o1lin)
alter Vin1 DC 0.772841139347941
alter Vin2 DC 0.795568033782143
op
print v(o1lin)
alter Vin1 DC 0.491939899885726
alter Vin2 DC 0.912367171191028
op
print v(o1lin)
alter Vin1 DC 0.646424244361182
alter Vin2 DC 0.697387258684806
op
print v(o1lin)
alter Vin1 DC 0.678718572351171
alter Vin2 DC 0.816124800632943
op
print v(o1lin)
alter Vin1 DC 0.204505365496075
alter Vin2 DC 0.892256550867501
op
print v(o1lin)
alter Vin1 DC -0.028175304528099
alter Vin2 DC -0.443649933815301
op
print v(o1lin)
alter Vin1 DC -0.649209044506585
alter Vin2 DC -0.350339571089671
op
print v(o1lin)
alter Vin1 DC -0.164843579883155
alter Vin2 DC -0.969930859516805
op
print v(o1lin)
alter Vin1 DC -0.164337864934806
alter Vin2 DC -0.364943096208236
op
print v(o1lin)
alter Vin1 DC -0.122904661020625
alter Vin2 DC -0.252533239188821
op
print v(o1lin)
alter Vin1 DC -0.365098063802175
alter Vin2 DC 0.323957710963749
op
print v(o1lin)
alter Vin1 DC -0.543034150522386
alter Vin2 DC -0.900314745282992
op
print v(o1lin)
alter Vin1 DC 0.217581813106662
alter Vin2 DC -0.976416227612227
op
print v(o1lin)
alter Vin1 DC -0.344824507457971
alter Vin2 DC 0.680242680370169
op
print v(o1lin)
alter Vin1 DC 0.893825641807484
alter Vin2 DC 0.495025514424448
op
print v(o1lin)
alter Vin1 DC -0.258238275392076
alter Vin2 DC -0.0413629042784598
op
print v(o1lin)
alter Vin1 DC -0.57476676503804
alter Vin2 DC -0.653709379284627
op
print v(o1lin)
alter Vin1 DC -0.983643692241332
alter Vin2 DC -0.554747336360839
op
print v(o1lin)
alter Vin1 DC 0.312144637983373
alter Vin2 DC 0.249297594097893
op
print v(o1lin)
alter Vin1 DC -0.977955925495645
alter Vin2 DC -0.92121265824112
op
print v(o1lin)
alter Vin1 DC 0.329824884024595
alter Vin2 DC -0.0128286722719948
op
print v(o1lin)
alter Vin1 DC -0.102095985090061
alter Vin2 DC 0.438853693943533
op
print v(o1lin)
alter Vin1 DC -0.0920894299696038
alter Vin2 DC 0.0290955113827749
op
print v(o1lin)
alter Vin1 DC 0.0564098383802392
alter Vin2 DC -0.326033699070369
op
print v(o1lin)
alter Vin1 DC -0.0080468212358018
alter Vin2 DC 0.529170893799519
op
print v(o1lin)
alter Vin1 DC 0.0258459959783872
alter Vin2 DC -0.595558885777529
op
print v(o1lin)
alter Vin1 DC 0.395238417494952
alter Vin2 DC -0.921669246705814
op
print v(o1lin)
alter Vin1 DC -0.950988914190423
alter Vin2 DC -0.179513311262701
op
print v(o1lin)
alter Vin1 DC -0.562841841953594
alter Vin2 DC 0.260293730896667
op
print v(o1lin)
alter Vin1 DC 0.126589804302968
alter Vin2 DC -0.109397829816838
op
print v(o1lin)
alter Vin1 DC -0.97053964487994
alter Vin2 DC 0.316730778980369
op
print v(o1lin)
alter Vin1 DC -0.398001421771874
alter Vin2 DC -0.85629232079933
op
print v(o1lin)
alter Vin1 DC 0.353806786915147
alter Vin2 DC -0.248858397301301
op
print v(o1lin)
alter Vin1 DC -0.45118408624285
alter Vin2 DC 0.650095303577948
op
print v(o1lin)
alter Vin1 DC -0.322036687993003
alter Vin2 DC 0.666755358311601
op
print v(o1lin)
alter Vin1 DC -0.155814296943536
alter Vin2 DC -0.864372159358772
op
print v(o1lin)
alter Vin1 DC 0.400265794959002
alter Vin2 DC -0.126511509363025
op
print v(o1lin)
alter Vin1 DC 0.616607767207071
alter Vin2 DC 0.766887005834141
op
print v(o1lin)
alter Vin1 DC 0.857256620202542
alter Vin2 DC -0.741559131452572
op
print v(o1lin)
alter Vin1 DC 0.962166098354699
alter Vin2 DC 0.935577078016126
op
print v(o1lin)
alter Vin1 DC -0.123921828403455
alter Vin2 DC -0.700319306089896
op
print v(o1lin)
alter Vin1 DC -0.859720298698937
alter Vin2 DC 0.685343104794945
op
print v(o1lin)
alter Vin1 DC 0.84967530082301
alter Vin2 DC 0.626844077561085
op
print v(o1lin)
alter Vin1 DC 0.845462501865124
alter Vin2 DC 0.468819321252311
op
print v(o1lin)
alter Vin1 DC 0.799053253134693
alter Vin2 DC 0.696364847330122
op
print v(o1lin)
alter Vin1 DC -0.408195484166435
alter Vin2 DC 0.663631434617312
op
print v(o1lin)
alter Vin1 DC -0.145997640956839
alter Vin2 DC -0.159190488911873
op
print v(o1lin)
alter Vin1 DC -0.462001749824661
alter Vin2 DC 0.535488522985226
op
print v(o1lin)
alter Vin1 DC -0.996696813542455
alter Vin2 DC 0.721142136181737
op
print v(o1lin)
alter Vin1 DC 0.559197027523379
alter Vin2 DC 0.596376145136797
op
print v(o1lin)
alter Vin1 DC -0.531079157156619
alter Vin2 DC 0.148233509541648
op
print v(o1lin)
alter Vin1 DC 0.829916799823154
alter Vin2 DC 0.458697346949797
op
print v(o1lin)
alter Vin1 DC -0.807235932862922
alter Vin2 DC -0.995917896273476
op
print v(o1lin)
alter Vin1 DC 0.835292174965049
alter Vin2 DC -0.894252040513066
op
print v(o1lin)
alter Vin1 DC -0.5326684147243
alter Vin2 DC -0.520546553040435
op
print v(o1lin)
alter Vin1 DC -0.745338666987647
alter Vin2 DC -0.898401496710104
op
print v(o1lin)
alter Vin1 DC 0.728942802834616
alter Vin2 DC -0.93145858770378
op
print v(o1lin)
alter Vin1 DC -0.111496864259755
alter Vin2 DC 0.637875924037882
op
print v(o1lin)
alter Vin1 DC 0.834541098349276
alter Vin2 DC -0.487063768782508
op
print v(o1lin)
alter Vin1 DC 0.312357067124326
alter Vin2 DC 0.675204379994759
op
print v(o1lin)
alter Vin1 DC 0.200037506192144
alter Vin2 DC -0.944429998564484
op
print v(o1lin)
alter Vin1 DC 0.929695571108279
alter Vin2 DC -0.972095759934753
op
print v(o1lin)
alter Vin1 DC -0.14580253586134
alter Vin2 DC 0.062665313360073
op
print v(o1lin)
alter Vin1 DC 0.0560431538273569
alter Vin2 DC -0.0992521356580947
op
print v(o1lin)
alter Vin1 DC -0.52844072958778
alter Vin2 DC -0.130421305583021
op
print v(o1lin)
alter Vin1 DC 0.692481972672301
alter Vin2 DC -0.986917528866133
op
print v(o1lin)
alter Vin1 DC -0.98932360736982
alter Vin2 DC -0.0255671148006911
op
print v(o1lin)
alter Vin1 DC 0.0195341632687061
alter Vin2 DC -0.260657662798826
op
print v(o1lin)
alter Vin1 DC 0.727339017117884
alter Vin2 DC -0.158159577547142
op
print v(o1lin)
alter Vin1 DC -0.423046760348361
alter Vin2 DC -0.601433972833087
op
print v(o1lin)
alter Vin1 DC 0.120550667571564
alter Vin2 DC 0.841313480103287
op
print v(o1lin)
alter Vin1 DC -0.937764411832047
alter Vin2 DC 0.292687730488676
op
print v(o1lin)
alter Vin1 DC -0.705043172229545
alter Vin2 DC 0.525712545824091
op
print v(o1lin)
alter Vin1 DC 0.0477527072589001
alter Vin2 DC -0.45067333675129
op
print v(o1lin)
alter Vin1 DC 0.471721425366481
alter Vin2 DC -0.852097327458262
op
print v(o1lin)
alter Vin1 DC 0.62345390099261
alter Vin2 DC -0.0591548150933154
op
print v(o1lin)
alter Vin1 DC -0.365426042283103
alter Vin2 DC -0.972678439087882
op
print v(o1lin)
alter Vin1 DC 0.564177568850622
alter Vin2 DC -0.675213746145502
op
print v(o1lin)
alter Vin1 DC 0.9342654522602
alter Vin2 DC 0.464370694176317
op
print v(o1lin)
alter Vin1 DC 0.588010157049794
alter Vin2 DC 0.0156599028294069
op
print v(o1lin)
alter Vin1 DC -0.801178545873072
alter Vin2 DC -0.362178618327375
op
print v(o1lin)
alter Vin1 DC -0.480692616787561
alter Vin2 DC 0.0890702746459724
op
print v(o1lin)
alter Vin1 DC -0.786608209290503
alter Vin2 DC -0.973358173155743
op
print v(o1lin)
alter Vin1 DC -0.852961484826042
alter Vin2 DC -0.371971259779148
op
print v(o1lin)
alter Vin1 DC 0.960910980760414
alter Vin2 DC 0.845541179957265
op
print v(o1lin)
alter Vin1 DC 0.886802155582765
alter Vin2 DC -0.0465513567594051
op
print v(o1lin)
alter Vin1 DC -0.583777801934753
alter Vin2 DC -0.871835877549175
op
print v(o1lin)
alter Vin1 DC 0.607439628010615
alter Vin2 DC 0.0574683131459883
op
print v(o1lin)
alter Vin1 DC -0.356844137263404
alter Vin2 DC -0.495126561038811
op
print v(o1lin)
alter Vin1 DC -0.126012937887524
alter Vin2 DC -0.675532698507865
op
print v(o1lin)
.endc

.end
