* Exp 34 isolated N=32 shared=True Vin=2.60818 Rload=4914.01
.include "C:/dev/neuron-physical-brain/physical-ai/models/vendor/ti/opa189/OPAx189.LIB"
.option reltol=0.001
Vdd vdd 0 DC 15
Vss vss 0 DC -15
Vin1 in1 0 DC 2.60817586522917
Vcm1 inp1 0 DC 0
R1_1 in1 mid1 10000
R2_1 out1 mid1 10000
Rload1 out1 0 4914.01304862554
Xinv1 inp1 mid1 vdd vss out1 OPAx189
Ccl1 out1 0 1e-12
Vin2 in2 0 DC 2.60817586522917
Vcm2 inp2 0 DC 0
R1_2 in2 mid2 10000
R2_2 out2 mid2 10000
Rload2 out2 0 4914.01304862554
Xinv2 inp2 mid2 vdd vss out2 OPAx189
Ccl2 out2 0 1e-12
Vin3 in3 0 DC 2.60817586522917
Vcm3 inp3 0 DC 0
R1_3 in3 mid3 10000
R2_3 out3 mid3 10000
Rload3 out3 0 4914.01304862554
Xinv3 inp3 mid3 vdd vss out3 OPAx189
Ccl3 out3 0 1e-12
Vin4 in4 0 DC 2.60817586522917
Vcm4 inp4 0 DC 0
R1_4 in4 mid4 10000
R2_4 out4 mid4 10000
Rload4 out4 0 4914.01304862554
Xinv4 inp4 mid4 vdd vss out4 OPAx189
Ccl4 out4 0 1e-12
Vin5 in5 0 DC 2.60817586522917
Vcm5 inp5 0 DC 0
R1_5 in5 mid5 10000
R2_5 out5 mid5 10000
Rload5 out5 0 4914.01304862554
Xinv5 inp5 mid5 vdd vss out5 OPAx189
Ccl5 out5 0 1e-12
Vin6 in6 0 DC 2.60817586522917
Vcm6 inp6 0 DC 0
R1_6 in6 mid6 10000
R2_6 out6 mid6 10000
Rload6 out6 0 4914.01304862554
Xinv6 inp6 mid6 vdd vss out6 OPAx189
Ccl6 out6 0 1e-12
Vin7 in7 0 DC 2.60817586522917
Vcm7 inp7 0 DC 0
R1_7 in7 mid7 10000
R2_7 out7 mid7 10000
Rload7 out7 0 4914.01304862554
Xinv7 inp7 mid7 vdd vss out7 OPAx189
Ccl7 out7 0 1e-12
Vin8 in8 0 DC 2.60817586522917
Vcm8 inp8 0 DC 0
R1_8 in8 mid8 10000
R2_8 out8 mid8 10000
Rload8 out8 0 4914.01304862554
Xinv8 inp8 mid8 vdd vss out8 OPAx189
Ccl8 out8 0 1e-12
Vin9 in9 0 DC 2.60817586522917
Vcm9 inp9 0 DC 0
R1_9 in9 mid9 10000
R2_9 out9 mid9 10000
Rload9 out9 0 4914.01304862554
Xinv9 inp9 mid9 vdd vss out9 OPAx189
Ccl9 out9 0 1e-12
Vin10 in10 0 DC 2.60817586522917
Vcm10 inp10 0 DC 0
R1_10 in10 mid10 10000
R2_10 out10 mid10 10000
Rload10 out10 0 4914.01304862554
Xinv10 inp10 mid10 vdd vss out10 OPAx189
Ccl10 out10 0 1e-12
Vin11 in11 0 DC 2.60817586522917
Vcm11 inp11 0 DC 0
R1_11 in11 mid11 10000
R2_11 out11 mid11 10000
Rload11 out11 0 4914.01304862554
Xinv11 inp11 mid11 vdd vss out11 OPAx189
Ccl11 out11 0 1e-12
Vin12 in12 0 DC 2.60817586522917
Vcm12 inp12 0 DC 0
R1_12 in12 mid12 10000
R2_12 out12 mid12 10000
Rload12 out12 0 4914.01304862554
Xinv12 inp12 mid12 vdd vss out12 OPAx189
Ccl12 out12 0 1e-12
Vin13 in13 0 DC 2.60817586522917
Vcm13 inp13 0 DC 0
R1_13 in13 mid13 10000
R2_13 out13 mid13 10000
Rload13 out13 0 4914.01304862554
Xinv13 inp13 mid13 vdd vss out13 OPAx189
Ccl13 out13 0 1e-12
Vin14 in14 0 DC 2.60817586522917
Vcm14 inp14 0 DC 0
R1_14 in14 mid14 10000
R2_14 out14 mid14 10000
Rload14 out14 0 4914.01304862554
Xinv14 inp14 mid14 vdd vss out14 OPAx189
Ccl14 out14 0 1e-12
Vin15 in15 0 DC 2.60817586522917
Vcm15 inp15 0 DC 0
R1_15 in15 mid15 10000
R2_15 out15 mid15 10000
Rload15 out15 0 4914.01304862554
Xinv15 inp15 mid15 vdd vss out15 OPAx189
Ccl15 out15 0 1e-12
Vin16 in16 0 DC 2.60817586522917
Vcm16 inp16 0 DC 0
R1_16 in16 mid16 10000
R2_16 out16 mid16 10000
Rload16 out16 0 4914.01304862554
Xinv16 inp16 mid16 vdd vss out16 OPAx189
Ccl16 out16 0 1e-12
Vin17 in17 0 DC 2.60817586522917
Vcm17 inp17 0 DC 0
R1_17 in17 mid17 10000
R2_17 out17 mid17 10000
Rload17 out17 0 4914.01304862554
Xinv17 inp17 mid17 vdd vss out17 OPAx189
Ccl17 out17 0 1e-12
Vin18 in18 0 DC 2.60817586522917
Vcm18 inp18 0 DC 0
R1_18 in18 mid18 10000
R2_18 out18 mid18 10000
Rload18 out18 0 4914.01304862554
Xinv18 inp18 mid18 vdd vss out18 OPAx189
Ccl18 out18 0 1e-12
Vin19 in19 0 DC 2.60817586522917
Vcm19 inp19 0 DC 0
R1_19 in19 mid19 10000
R2_19 out19 mid19 10000
Rload19 out19 0 4914.01304862554
Xinv19 inp19 mid19 vdd vss out19 OPAx189
Ccl19 out19 0 1e-12
Vin20 in20 0 DC 2.60817586522917
Vcm20 inp20 0 DC 0
R1_20 in20 mid20 10000
R2_20 out20 mid20 10000
Rload20 out20 0 4914.01304862554
Xinv20 inp20 mid20 vdd vss out20 OPAx189
Ccl20 out20 0 1e-12
Vin21 in21 0 DC 2.60817586522917
Vcm21 inp21 0 DC 0
R1_21 in21 mid21 10000
R2_21 out21 mid21 10000
Rload21 out21 0 4914.01304862554
Xinv21 inp21 mid21 vdd vss out21 OPAx189
Ccl21 out21 0 1e-12
Vin22 in22 0 DC 2.60817586522917
Vcm22 inp22 0 DC 0
R1_22 in22 mid22 10000
R2_22 out22 mid22 10000
Rload22 out22 0 4914.01304862554
Xinv22 inp22 mid22 vdd vss out22 OPAx189
Ccl22 out22 0 1e-12
Vin23 in23 0 DC 2.60817586522917
Vcm23 inp23 0 DC 0
R1_23 in23 mid23 10000
R2_23 out23 mid23 10000
Rload23 out23 0 4914.01304862554
Xinv23 inp23 mid23 vdd vss out23 OPAx189
Ccl23 out23 0 1e-12
Vin24 in24 0 DC 2.60817586522917
Vcm24 inp24 0 DC 0
R1_24 in24 mid24 10000
R2_24 out24 mid24 10000
Rload24 out24 0 4914.01304862554
Xinv24 inp24 mid24 vdd vss out24 OPAx189
Ccl24 out24 0 1e-12
Vin25 in25 0 DC 2.60817586522917
Vcm25 inp25 0 DC 0
R1_25 in25 mid25 10000
R2_25 out25 mid25 10000
Rload25 out25 0 4914.01304862554
Xinv25 inp25 mid25 vdd vss out25 OPAx189
Ccl25 out25 0 1e-12
Vin26 in26 0 DC 2.60817586522917
Vcm26 inp26 0 DC 0
R1_26 in26 mid26 10000
R2_26 out26 mid26 10000
Rload26 out26 0 4914.01304862554
Xinv26 inp26 mid26 vdd vss out26 OPAx189
Ccl26 out26 0 1e-12
Vin27 in27 0 DC 2.60817586522917
Vcm27 inp27 0 DC 0
R1_27 in27 mid27 10000
R2_27 out27 mid27 10000
Rload27 out27 0 4914.01304862554
Xinv27 inp27 mid27 vdd vss out27 OPAx189
Ccl27 out27 0 1e-12
Vin28 in28 0 DC 2.60817586522917
Vcm28 inp28 0 DC 0
R1_28 in28 mid28 10000
R2_28 out28 mid28 10000
Rload28 out28 0 4914.01304862554
Xinv28 inp28 mid28 vdd vss out28 OPAx189
Ccl28 out28 0 1e-12
Vin29 in29 0 DC 2.60817586522917
Vcm29 inp29 0 DC 0
R1_29 in29 mid29 10000
R2_29 out29 mid29 10000
Rload29 out29 0 4914.01304862554
Xinv29 inp29 mid29 vdd vss out29 OPAx189
Ccl29 out29 0 1e-12
Vin30 in30 0 DC 2.60817586522917
Vcm30 inp30 0 DC 0
R1_30 in30 mid30 10000
R2_30 out30 mid30 10000
Rload30 out30 0 4914.01304862554
Xinv30 inp30 mid30 vdd vss out30 OPAx189
Ccl30 out30 0 1e-12
Vin31 in31 0 DC 2.60817586522917
Vcm31 inp31 0 DC 0
R1_31 in31 mid31 10000
R2_31 out31 mid31 10000
Rload31 out31 0 4914.01304862554
Xinv31 inp31 mid31 vdd vss out31 OPAx189
Ccl31 out31 0 1e-12
Vin32 in32 0 DC 2.60817586522917
Vcm32 inp32 0 DC 0
R1_32 in32 mid32 10000
R2_32 out32 mid32 10000
Rload32 out32 0 4914.01304862554
Xinv32 inp32 mid32 vdd vss out32 OPAx189
Ccl32 out32 0 1e-12
.control
set numdgt=15
op
print v(out1)
print v(mid1)
print v(in1)
print v(inp1)
print i(Rload1)
print v(out2)
print v(mid2)
print v(in2)
print v(inp2)
print i(Rload2)
print v(out3)
print v(mid3)
print v(in3)
print v(inp3)
print i(Rload3)
print v(out4)
print v(mid4)
print v(in4)
print v(inp4)
print i(Rload4)
print v(out5)
print v(mid5)
print v(in5)
print v(inp5)
print i(Rload5)
print v(out6)
print v(mid6)
print v(in6)
print v(inp6)
print i(Rload6)
print v(out7)
print v(mid7)
print v(in7)
print v(inp7)
print i(Rload7)
print v(out8)
print v(mid8)
print v(in8)
print v(inp8)
print i(Rload8)
print v(out9)
print v(mid9)
print v(in9)
print v(inp9)
print i(Rload9)
print v(out10)
print v(mid10)
print v(in10)
print v(inp10)
print i(Rload10)
print v(out11)
print v(mid11)
print v(in11)
print v(inp11)
print i(Rload11)
print v(out12)
print v(mid12)
print v(in12)
print v(inp12)
print i(Rload12)
print v(out13)
print v(mid13)
print v(in13)
print v(inp13)
print i(Rload13)
print v(out14)
print v(mid14)
print v(in14)
print v(inp14)
print i(Rload14)
print v(out15)
print v(mid15)
print v(in15)
print v(inp15)
print i(Rload15)
print v(out16)
print v(mid16)
print v(in16)
print v(inp16)
print i(Rload16)
print v(out17)
print v(mid17)
print v(in17)
print v(inp17)
print i(Rload17)
print v(out18)
print v(mid18)
print v(in18)
print v(inp18)
print i(Rload18)
print v(out19)
print v(mid19)
print v(in19)
print v(inp19)
print i(Rload19)
print v(out20)
print v(mid20)
print v(in20)
print v(inp20)
print i(Rload20)
print v(out21)
print v(mid21)
print v(in21)
print v(inp21)
print i(Rload21)
print v(out22)
print v(mid22)
print v(in22)
print v(inp22)
print i(Rload22)
print v(out23)
print v(mid23)
print v(in23)
print v(inp23)
print i(Rload23)
print v(out24)
print v(mid24)
print v(in24)
print v(inp24)
print i(Rload24)
print v(out25)
print v(mid25)
print v(in25)
print v(inp25)
print i(Rload25)
print v(out26)
print v(mid26)
print v(in26)
print v(inp26)
print i(Rload26)
print v(out27)
print v(mid27)
print v(in27)
print v(inp27)
print i(Rload27)
print v(out28)
print v(mid28)
print v(in28)
print v(inp28)
print i(Rload28)
print v(out29)
print v(mid29)
print v(in29)
print v(inp29)
print i(Rload29)
print v(out30)
print v(mid30)
print v(in30)
print v(inp30)
print i(Rload30)
print v(out31)
print v(mid31)
print v(in31)
print v(inp31)
print i(Rload31)
print v(out32)
print v(mid32)
print v(in32)
print v(inp32)
print i(Rload32)
print i(Vdd)
.endc
.end
