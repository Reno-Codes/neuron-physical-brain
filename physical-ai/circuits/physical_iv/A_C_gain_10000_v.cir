* Physical AI - Experiment 17 architecture C: current-mode ReLU then TIA
* Hidden: I_y = max(0, I_sum) in SPICE, then TIA. Output: feedback TIA. Current-domain ReLU is a B-source.
* Frozen Experiment 9 network A. Weights were not edited.
* Behavioral circuit analysis. Not transistor-level or PCB power.
* A_tia=10000 A_inv=100000 rail=15 vos=0 rout=0 Ileak=0 clip=False linear=False
* shape: 2 -> 4 -> 1

Vin1 in1 0 DC 0
* passive invert in1 -> in1n: R2/R1=1.0000200002 closed-loop -1 at A=100000
Rinv1ia in1 inv1m 10000
Rinv1ib in1n inv1m 10000.200002
Einv1amp in1n 0 0 inv1m 100000
Vin2 in2 0 DC 0
Vref vref 0 DC 1
* passive invert vref -> vrefn: R2/R1=1.0000200002 closed-loop -1 at A=100000
Rinvrefia vref invrefm 10000
Rinvrefib vrefn invrefm 10000.200002
Einvrefamp vrefn 0 0 invrefm 100000
* load-compensated divider vref->tapref: G_load=0.000523133389485774 Ra=655884.774699393 Rb=1000 target beta=0.001 (no tap buffer)
Rdivrefa vref tapref 655884.774699393
Rdivrefb tapref 0 1000
* load-compensated divider vrefn->taprefn: G_load=0.00166093129089326 Ra=375432.46735418 Rb=1000 target beta=0.001 (no tap buffer)
Rdivrefna vrefn taprefn 375432.46735418
Rdivrefnb taprefn 0 1000

* h1 input 1 w=+0.683760795348816 w+  bank=n alpha=1 R=48749.9920441162 G_phys=2.05128238604645e-05 G_eff=2.05128238604645e-05
Rh1p1n1 in1 h1p 48749.9920441162
* h1 input 2 w=+0.309366783045794 w+  bank=n alpha=1 R=107746.969487669 G_phys=9.28100349137382e-06 G_eff=9.28100349137382e-06
Rh1p2n1 in2 h1p 107746.969487669
* h1 bias w-  bank=f alpha=0.001 R=1253.18954325804 G_phys=0.000797963887729386 G_eff=7.97963887729385e-07
Rh1bnf1 taprefn h1p 1253.18954325804
* current-mode ReLU + TIA h1: I_y=max(0, i(Vh1p)), then feedback TIA Rf=33333.3333333333
Vh1p h1p 0 DC 0
Bh1crelu h1ir 0 I = max(0, i(Vh1p))
* feedback TIA h1: Rf=33333.3333333333 A=10000 V(h1lin) = -I(h1ir)*Rf*A/(A+1)  (uncompensated)
Eh1tia h1lin 0 0 h1ir 10000
Rh1f h1lin h1ir 33333.3333333333
Bh1relu h1y 0 V = max(0, min(15, v(h1lin)))

* h2 input 1 w=-0.884821731731664 w-  bank=n alpha=1 R=37672.3718890781 G_phys=2.65446519519499e-05 G_eff=2.65446519519499e-05
Rh2n1n1 in1n h2p 37672.3718890781
* h2 input 2 w=+0.782653240240456 w+  bank=n alpha=1 R=42590.1684417639 G_phys=2.34795972072137e-05 G_eff=2.34795972072137e-05
Rh2p2n1 in2 h2p 42590.1684417639
* h2 bias w+  bank=f alpha=0.001 R=560963.988396833 G_phys=1.78264562553806e-06 G_eff=1.78264562553806e-09
Rh2bpf1 tapref h2p 560963.988396833
* current-mode ReLU + TIA h2: I_y=max(0, i(Vh2p)), then feedback TIA Rf=33333.3333333333
Vh2p h2p 0 DC 0
Bh2crelu h2ir 0 I = max(0, i(Vh2p))
* feedback TIA h2: Rf=33333.3333333333 A=10000 V(h2lin) = -I(h2ir)*Rf*A/(A+1)  (uncompensated)
Eh2tia h2lin 0 0 h2ir 10000
Rh2f h2lin h2ir 33333.3333333333
Bh2relu h2y 0 V = max(0, min(15, v(h2lin)))

* h3 input 1 w=+0.80723931339229 w+  bank=n alpha=1 R=41293.0004526854 G_phys=2.42171794017687e-05 G_eff=2.42171794017687e-05
Rh3p1n1 in1 h3p 41293.0004526854
* h3 input 2 w=+1.71882311343666 w+  bank=n alpha=1 R=19393.1144355429 G_phys=5.15646934030999e-05 G_eff=5.15646934030999e-05
Rh3p2n1 in2 h3p 19393.1144355429
* h3 bias w+  bank=f alpha=0.001 R=1918.09451080035 G_phys=0.000521350743860236 G_eff=5.21350743860236e-07
Rh3bpf1 tapref h3p 1918.09451080035
* current-mode ReLU + TIA h3: I_y=max(0, i(Vh3p)), then feedback TIA Rf=33333.3333333333
Vh3p h3p 0 DC 0
Bh3crelu h3ir 0 I = max(0, i(Vh3p))
* feedback TIA h3: Rf=33333.3333333333 A=10000 V(h3lin) = -I(h3ir)*Rf*A/(A+1)  (uncompensated)
Eh3tia h3lin 0 0 h3ir 10000
Rh3f h3lin h3ir 33333.3333333333
Bh3relu h3y 0 V = max(0, min(15, v(h3lin)))

* h4 input 1 w=-2.16286246457598 w-  bank=n alpha=1 R=15411.6749813161 G_phys=6.48858739372794e-05 G_eff=6.48858739372794e-05
Rh4n1n1 in1n h4p 15411.6749813161
* h4 input 2 w=+0.726967919426763 w+  bank=n alpha=1 R=45852.5506319697 G_phys=2.18090375828029e-05 G_eff=2.18090375828029e-05
Rh4p2n1 in2 h4p 45852.5506319697
* h4 bias w-  bank=f alpha=0.001 R=1810.10591973139 G_phys=0.000552453858693748 G_eff=5.52453858693748e-07
Rh4bnf1 taprefn h4p 1810.10591973139
* current-mode ReLU + TIA h4: I_y=max(0, i(Vh4p)), then feedback TIA Rf=33333.3333333333
Vh4p h4p 0 DC 0
Bh4crelu h4ir 0 I = max(0, i(Vh4p))
* feedback TIA h4: Rf=33333.3333333333 A=10000 V(h4lin) = -I(h4ir)*Rf*A/(A+1)  (uncompensated)
Eh4tia h4lin 0 0 h4ir 10000
Rh4f h4lin h4ir 33333.3333333333
Bh4relu h4y 0 V = max(0, min(15, v(h4lin)))

* passive invert h1y -> h1yn: R2/R1=1.0000200002 closed-loop -1 at A=100000
Rinvh1ia h1y invh1m 10000
Rinvh1ib h1yn invh1m 10000.200002
Einvh1amp h1yn 0 0 invh1m 100000
* passive invert h2y -> h2yn: R2/R1=1.0000200002 closed-loop -1 at A=100000
Rinvh2ia h2y invh2m 10000
Rinvh2ib h2yn invh2m 10000.200002
Einvh2amp h2yn 0 0 invh2m 100000
* passive invert h3y -> h3yn: R2/R1=1.0000200002 closed-loop -1 at A=100000
Rinvh3ia h3y invh3m 10000
Rinvh3ib h3yn invh3m 10000.200002
Einvh3amp h3yn 0 0 invh3m 100000
* passive invert h4y -> h4yn: R2/R1=1.0000200002 closed-loop -1 at A=100000
Rinvh4ia h4y invh4m 10000
Rinvh4ib h4yn invh4m 10000.200002
Einvh4amp h4yn 0 0 invh4m 100000

* o1 input 1 w=+0.601889648539537 w+  bank=n alpha=1 R=55381.137413171 G_phys=1.80566894561861e-05 G_eff=1.80566894561861e-05
Ro1p1n1 h1yn o1p 55381.137413171
* o1 input 2 w=+0.347315954504283 w+  bank=n alpha=1 R=95974.0918925228 G_phys=1.04194786351285e-05 G_eff=1.04194786351285e-05
Ro1p2n1 h2yn o1p 95974.0918925228
* o1 input 3 w=+0.876922607606196 w+  bank=n alpha=1 R=38011.716249768 G_phys=2.63076782281859e-05 G_eff=2.63076782281859e-05
Ro1p3n1 h3yn o1p 38011.716249768
* o1 input 4 w=+0.929527796434486 w+  bank=n alpha=1 R=35860.5019249499 G_phys=2.78858338930346e-05 G_eff=2.78858338930346e-05
Ro1p4n1 h4yn o1p 35860.5019249499
* o1 bias w+  bank=f alpha=0.001 R=3220.47143452777 G_phys=0.000310513544470123 G_eff=3.10513544470123e-07
Ro1bpf1 taprefn o1p 3220.47143452777
* feedback TIA o1: Rf=33333.3333333333 A=10000 V(o1lin) = -I(o1p)*Rf*A/(A+1)  (uncompensated)
Eo1tia o1lin 0 0 o1p 10000
Ro1f o1lin o1p 33333.3333333333
.control
set numdgt=15
alter Vin1 DC 0.494125531810799
alter Vin2 DC -0.229451673774848
op
print v(h1ir)
print v(h2ir)
print v(h3ir)
print v(h4ir)
print v(o1p)
.endc

.end
