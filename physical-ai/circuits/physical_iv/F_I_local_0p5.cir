* Physical AI - Experiment 16 architecture I: current-mode invert-and-sum, unbuffered compensated dividers
* Passive inverting amplifiers (R ratio) create -Vin. One 0 V summing node per neuron. One current dump onto physical R_IV. Fine taps load-compensated, no isolation buffer. No dual CCCS.
* Frozen Experiment 9 network F. Weights were not edited.
* Behavioral circuit analysis. Not transistor-level or PCB power.
* invert A=100000 R_INV=10000 Ileak=0 rail=15 linear=False vos=0
* shape: 16 -> 32 -> 16

Vin1 in1 0 DC 0
* passive invert in1 -> in1n: R2/R1=1.0000200002 closed-loop -1 at A=100000
Rinv1ia in1 inv1m 10046.7846914359
Rinv1ib in1n inv1m 9956.87101647486
Einv1amp in1n 0 0 inv1m 100000
* load-compensated divider in1->tap1: G_load=0.00138944868118558 Ra=418088.075239315 Rb=1000 target beta=0.001 (no tap buffer)
Rdiv1a in1 tap1 418803.652439803
Rdiv1b tap1 0 999.234513781542
* load-compensated divider in1n->tap1n: G_load=0.000710070664287583 Ra=584186.385313021 Rb=1000 target beta=0.001 (no tap buffer)
Rdiv1na in1n tap1n 584854.521776047
Rdiv1nb tap1n 0 999.337473507536
Vin2 in2 0 DC 0
* passive invert in2 -> in2n: R2/R1=1.0000200002 closed-loop -1 at A=100000
Rinv2ia in2 inv2m 10000.2923254614
Rinv2ib in2n inv2m 10008.771360326
Einv2amp in2n 0 0 inv2m 100000
* load-compensated divider in2->tap2: G_load=0.000578042323514278 Ra=633062.868539065 Rb=1000 target beta=0.001 (no tap buffer)
Rdiv2a in2 tap2 630945.420147294
Rdiv2b tap2 0 1003.49136227017
* load-compensated divider in2n->tap2n: G_load=0.000564213455228197 Ra=638659.638594056 Rb=1000 target beta=0.001 (no tap buffer)
Rdiv2na in2n tap2n 641481.216320326
Rdiv2nb tap2n 0 997.023729638793
Vin3 in3 0 DC 0
* passive invert in3 -> in3n: R2/R1=1.0000200002 closed-loop -1 at A=100000
Rinv3ia in3 inv3m 10028.6919048219
Rinv3ib in3n inv3m 9961.71390061285
Einv3amp in3n 0 0 inv3m 100000
* load-compensated divider in3n->tap3n: G_load=0.000475353763139489 Ra=677125.734152175 Rb=1000 target beta=0.001 (no tap buffer)
Rdiv3na in3n tap3n 675893.427622721
Rdiv3nb tap3n 0 998.403692370995
Vin4 in4 0 DC 0
* passive invert in4 -> in4n: R2/R1=1.0000200002 closed-loop -1 at A=100000
Rinv4ia in4 inv4m 9989.38941776041
Rinv4ib in4n inv4m 9997.24386396664
Einv4amp in4n 0 0 inv4m 100000
* load-compensated divider in4->tap4: G_load=0.000838243797048297 Ra=543453.486204666 Rb=1000 target beta=0.001 (no tap buffer)
Rdiv4a in4 tap4 545378.831445744
Rdiv4b tap4 0 1003.91597496605
* load-compensated divider in4n->tap4n: G_load=0.000604265102392725 Ra=622715.035382877 Rb=1000 target beta=0.001 (no tap buffer)
Rdiv4na in4n tap4n 625016.547982254
Rdiv4nb tap4n 0 1003.15325206855
Vin5 in5 0 DC 0
* passive invert in5 -> in5n: R2/R1=1.0000200002 closed-loop -1 at A=100000
Rinv5ia in5 inv5m 10008.4151798269
Rinv5ib in5n inv5m 9974.86731927571
Einv5amp in5n 0 0 inv5m 100000
* load-compensated divider in5->tap5: G_load=0.000124571614130361 Ra=888338.268054662 Rb=1000 target beta=0.001 (no tap buffer)
Rdiv5a in5 tap5 884015.749470915
Rdiv5b tap5 0 1001.39583157732
Vin6 in6 0 DC 0
* passive invert in6 -> in6n: R2/R1=1.0000200002 closed-loop -1 at A=100000
Rinv6ia in6 inv6m 10042.4559275766
Rinv6ib in6n inv6m 10048.8064412141
Einv6amp in6n 0 0 inv6m 100000
Vin7 in7 0 DC 0
* passive invert in7 -> in7n: R2/R1=1.0000200002 closed-loop -1 at A=100000
Rinv7ia in7 inv7m 9956.44867298347
Rinv7ib in7n inv7m 9965.71451128982
Einv7amp in7n 0 0 inv7m 100000
* load-compensated divider in7->tap7: G_load=0.000379458526114055 Ra=724197.198457419 Rb=1000 target beta=0.001 (no tap buffer)
Rdiv7a in7 tap7 726711.981596013
Rdiv7b tap7 0 1002.32389797682
* load-compensated divider in7n->tap7n: G_load=0.000876983911873088 Ra=532236.847466142 Rb=1000 target beta=0.001 (no tap buffer)
Rdiv7na in7n tap7n 532272.706297886
Rdiv7nb tap7n 0 995.926066635148
Vin8 in8 0 DC 0
* passive invert in8 -> in8n: R2/R1=1.0000200002 closed-loop -1 at A=100000
Rinv8ia in8 inv8m 9993.30844387138
Rinv8ib in8n inv8m 9977.27093141716
Einv8amp in8n 0 0 inv8m 100000
* load-compensated divider in8n->tap8n: G_load=0.00202030909723981 Ra=330760.848587637 Rb=1000 target beta=0.001 (no tap buffer)
Rdiv8na in8n tap8n 331066.466316877
Rdiv8nb tap8n 0 995.690014547727
Vin9 in9 0 DC 0
* passive invert in9 -> in9n: R2/R1=1.0000200002 closed-loop -1 at A=100000
Rinv9ia in9 inv9m 9957.29753927345
Rinv9ib in9n inv9m 10010.7148125764
Einv9amp in9n 0 0 inv9m 100000
* load-compensated divider in9->tap9: G_load=0.0021264464173835 Ra=319532.103427525 Rb=1000 target beta=0.001 (no tap buffer)
Rdiv9a in9 tap9 320029.968840542
Rdiv9b tap9 0 1002.78858171446
Vin10 in10 0 DC 0
* passive invert in10 -> in10n: R2/R1=1.0000200002 closed-loop -1 at A=100000
Rinv10ia in10 inv10m 10023.0352705571
Rinv10ib in10n inv10m 9980.70287524924
Einv10amp in10n 0 0 inv10m 100000
* load-compensated divider in10->tap10: G_load=0.000661819331650786 Ra=601148.380556888 Rb=1000 target beta=0.001 (no tap buffer)
Rdiv10a in10 tap10 602424.799148233
Rdiv10b tap10 0 1001.85565319297
* load-compensated divider in10n->tap10n: G_load=0.00154386072332109 Ra=392710.178997446 Rb=1000 target beta=0.001 (no tap buffer)
Rdiv10na in10n tap10n 391814.580392076
Rdiv10nb tap10n 0 995.042435169572
Vin11 in11 0 DC 0
* passive invert in11 -> in11n: R2/R1=1.0000200002 closed-loop -1 at A=100000
Rinv11ia in11 inv11m 10020.2775470431
Rinv11ib in11n inv11m 9961.15542884435
Einv11amp in11n 0 0 inv11m 100000
* load-compensated divider in11n->tap11n: G_load=0.000923704741727117 Ra=519310.462947183 Rb=1000 target beta=0.001 (no tap buffer)
Rdiv11na in11n tap11n 518667.252984017
Rdiv11nb tap11n 0 996.232540863266
Vin12 in12 0 DC 0
* passive invert in12 -> in12n: R2/R1=1.0000200002 closed-loop -1 at A=100000
Rinv12ia in12 inv12m 9982.13280809516
Rinv12ib in12n inv12m 9992.30221709643
Einv12amp in12n 0 0 inv12m 100000
* load-compensated divider in12->tap12: G_load=0.000192713812047279 Ra=837585.6721951 Rb=1000 target beta=0.001 (no tap buffer)
Rdiv12a in12 tap12 837147.454901259
Rdiv12b tap12 0 1002.80815229908
Vin13 in13 0 DC 0
* passive invert in13 -> in13n: R2/R1=1.0000200002 closed-loop -1 at A=100000
Rinv13ia in13 inv13m 10023.872984848
Rinv13ib in13n inv13m 10001.1453190052
Einv13amp in13n 0 0 inv13m 100000
* load-compensated divider in13->tap13: G_load=0.00155701882010588 Ra=390689.341879241 Rb=1000 target beta=0.001 (no tap buffer)
Rdiv13a in13 tap13 389130.848687167
Rdiv13b tap13 0 1004.17545968544
* load-compensated divider in13n->tap13n: G_load=0.00071375434054134 Ra=582930.689870309 Rb=1000 target beta=0.001 (no tap buffer)
Rdiv13na in13n tap13n 584337.04305787
Rdiv13nb tap13n 0 1001.83785087539
Vin14 in14 0 DC 0
* passive invert in14 -> in14n: R2/R1=1.0000200002 closed-loop -1 at A=100000
Rinv14ia in14 inv14m 10035.5625099783
Rinv14ib in14n inv14m 10032.7832206251
Einv14amp in14n 0 0 inv14m 100000
* load-compensated divider in14n->tap14n: G_load=0.000700934410618815 Ra=587324.234117032 Rb=1000 target beta=0.001 (no tap buffer)
Rdiv14na in14n tap14n 588656.131048877
Rdiv14nb tap14n 0 999.133695133357
Vin15 in15 0 DC 0
* passive invert in15 -> in15n: R2/R1=1.0000200002 closed-loop -1 at A=100000
Rinv15ia in15 inv15m 9987.43100532133
Rinv15ib in15n inv15m 10025.3567868836
Einv15amp in15n 0 0 inv15m 100000
* load-compensated divider in15n->tap15n: G_load=0.00161191394702755 Ra=382478.144479797 Rb=1000 target beta=0.001 (no tap buffer)
Rdiv15na in15n tap15n 382600.39498841
Rdiv15nb tap15n 0 995.577059041777
Vin16 in16 0 DC 0
* passive invert in16 -> in16n: R2/R1=1.0000200002 closed-loop -1 at A=100000
Rinv16ia in16 inv16m 10025.9713220385
Rinv16ib in16n inv16m 10010.1880161366
Einv16amp in16n 0 0 inv16m 100000
* load-compensated divider in16->tap16: G_load=0.00225822429382311 Ra=306608.726076314 Rb=1000 target beta=0.001 (no tap buffer)
Rdiv16a in16 tap16 306592.966176923
Rdiv16b tap16 0 1002.94517958906
Vref vref 0 DC 1
* passive invert vref -> vrefn: R2/R1=1.0000200002 closed-loop -1 at A=100000
Rinvrefia vref invrefm 10032.2258118782
Rinvrefib vrefn invrefm 10010.9585035919
Einvrefamp vrefn 0 0 invrefm 100000
* load-compensated divider vref->tapref: G_load=0.00666252414777637 Ra=130374.79304909 Rb=1000 target beta=0.001 (no tap buffer)
Rdivrefa vref tapref 130254.236366656
Rdivrefb tapref 0 1000.89260868461
* load-compensated divider vrefn->taprefn: G_load=0.00551473635150906 Ra=153344.655270446 Rb=1000 target beta=0.001 (no tap buffer)
Rdivrefna vrefn taprefn 153214.014374093
Rdivrefnb taprefn 0 997.427441770054

* h1 input 1 w=-0.0168555731920106 w-  bank=f alpha=0.001 R=1977.58527423636 G_phys=0.000505667195760317 G_eff=5.05667195760317e-07
Rh1n1f1 tap1n h1p 1974.66208370033
* h1 input 2 w=+0.167421682129858 w+  bank=n alpha=1 R=199098.067283059 G_phys=5.02265046389574e-06 G_eff=5.02265046389574e-06
Rh1p2n1 in2 h1p 199319.946566228
* h1 input 3 w=-0.175338604042315 w-  bank=n alpha=1 R=190108.353579049 G_phys=5.26015812126946e-06 G_eff=5.26015812126946e-06
Rh1n3n1 in3n h1p 189451.933777716
* h1 input 4 w=-0.3026243730549 w-  bank=n alpha=1 R=110147.55023478 G_phys=9.078731191647e-06 G_eff=9.078731191647e-06
Rh1n4n1 in4n h1p 109979.922166854
* h1 input 5 w=-0.0731653551060092 w-  bank=n alpha=1 R=455589.032336913 G_phys=2.19496065318027e-06 G_eff=2.19496065318027e-06
Rh1n5n1 in5n h1p 455502.289879081
* h1 input 6 w=+0.135452999280782 w+  bank=n alpha=1 R=246087.820205711 G_phys=4.06358997842346e-06 G_eff=4.06358997842346e-06
Rh1p6n1 in6 h1p 246485.380951181
* h1 input 7 w=+0.21541693193391 w+  bank=n alpha=1 R=154738.687595643 G_phys=6.46250795801731e-06 G_eff=6.46250795801731e-06
Rh1p7n1 in7 h1p 154713.937668324
* h1 input 8 w=-0.0225117532106789 w-  bank=f alpha=0.001 R=1480.70801156087 G_phys=0.000675352596320366 G_eff=6.75352596320366e-07
Rh1n8f1 tap8n h1p 1484.17299907308
* h1 input 9 w=-0.120865686071453 w-  bank=n alpha=1 R=275788.227550601 G_phys=3.62597058214359e-06 G_eff=3.62597058214359e-06
Rh1n9n1 in9n h1p 276952.246674036
* h1 input 10 w=+0.732018397911567 w+  bank=n alpha=1 R=45536.19612353 G_phys=2.1960551937347e-05 G_eff=2.1960551937347e-05
Rh1p10n1 in10 h1p 45517.4670103879
* h1 input 11 w=+0.435334885703784 w+  bank=n alpha=1 R=76569.405365814 G_phys=1.30600465711135e-05 G_eff=1.30600465711135e-05
Rh1p11n1 in11 h1p 76608.7372771922
* h1 input 12 w=+0.385479984810207 w+  bank=n alpha=1 R=86472.2803954274 G_phys=1.15643995443062e-05 G_eff=1.15643995443062e-05
Rh1p12n1 in12 h1p 86693.2031482309
* h1 input 13 w=-0.42800728852471 w-  bank=n alpha=1 R=77880.2936936643 G_phys=1.28402186557413e-05 G_eff=1.28402186557413e-05
Rh1n13n1 in13n h1p 77876.3624343661
* h1 input 14 w=+0.104452911276431 w+  bank=n alpha=1 R=319123.066327159 G_phys=3.13358733829293e-06 G_eff=3.13358733829293e-06
Rh1p14n1 in14 h1p 317541.164085682
* h1 input 15 w=-0.361295245628978 w-  bank=n alpha=1 R=92260.6475911506 G_phys=1.08388573688693e-05 G_eff=1.08388573688693e-05
Rh1n15n1 in15n h1p 92221.2148044798
* h1 input 16 w=+0.0759383856082483 w+  bank=n alpha=1 R=438952.356786904 G_phys=2.27815156824745e-06 G_eff=2.27815156824745e-06
Rh1p16n1 in16 h1p 439417.203010291
* h1 bias w-  bank=n alpha=1 R=365943.245315286 G_phys=2.73266418441043e-06 G_eff=2.73266418441043e-06
Rh1bnn1 vrefn h1p 366046.904569058
* single-copy I-to-V: 0 V sum h1p, I dump onto R_IV=33333.3333333333
Vh1p h1p 0 DC 0
Bh1iv 0 h1lin I = i(Vh1p)
Rh1iv h1lin 0 33413.8566002187
* direct bounded ReLU, no output buffer: y=max(0, min(15, v(h1lin)))
Bh1relu h1y 0 V = max(0, min(15, v(h1lin)))

* h2 input 1 w=+0.0248542194622879 w+  bank=f alpha=0.001 R=1341.15389879417 G_phys=0.000745626583868636 G_eff=7.45626583868636e-07
Rh2p1f1 tap1 h2p 1347.69183348583
* h2 input 2 w=+0.400223191665755 w+  bank=n alpha=1 R=83286.8610002279 G_phys=1.20066957499727e-05 G_eff=1.20066957499727e-05
Rh2p2n1 in2 h2p 83070.4735301544
* h2 input 3 w=+0.358260577298724 w+  bank=n alpha=1 R=93042.1471004872 G_phys=1.07478173189617e-05 G_eff=1.07478173189617e-05
Rh2p3n1 in3 h2p 93225.6242479486
* h2 input 4 w=+0.348073132477087 w+  bank=n alpha=1 R=95765.315455733 G_phys=1.04421939743126e-05 G_eff=1.04421939743126e-05
Rh2p4n1 in4 h2p 95971.2789260838
* h2 input 5 w=-0.489776715185261 w-  bank=n alpha=1 R=68058.2238800895 G_phys=1.46933014555578e-05 G_eff=1.46933014555578e-05
Rh2n5n1 in5n h2p 67794.0121956106
* h2 input 6 w=-0.262585224656684 w-  bank=n alpha=1 R=126942.913017726 G_phys=7.87755673970051e-06 G_eff=7.87755673970051e-06
Rh2n6n1 in6n h2p 127072.170553204
* h2 input 7 w=+0.634452480443638 w+  bank=n alpha=1 R=52538.7390873232 G_phys=1.90335744133091e-05 G_eff=1.90335744133091e-05
Rh2p7n1 in7 h2p 52420.1056674424
* h2 input 8 w=-0.0150494358056585 w-  bank=f alpha=0.001 R=2214.92245714621 G_phys=0.000451483074169756 G_eff=4.51483074169756e-07
Rh2n8f1 tap8n h2p 2204.73821716343
* h2 input 9 w=+0.317089980091076 w+  bank=n alpha=1 R=105122.632142962 G_phys=9.51269940273229e-06 G_eff=9.51269940273229e-06
Rh2p9n1 in9 h2p 104895.179273999
* h2 input 10 w=-0.171694565495531 w-  bank=n alpha=1 R=194143.2056229 G_phys=5.15083696486594e-06 G_eff=5.15083696486594e-06
Rh2n10n1 in10n h2p 194885.85439904
* h2 input 11 w=+0.113535277026032 w+  bank=n alpha=1 R=293594.503897589 G_phys=3.40605831078097e-06 G_eff=3.40605831078097e-06
Rh2p11n1 in11 h2p 292846.013668612
* h2 input 12 w=+0.342235951147447 w+  bank=n alpha=1 R=97398.6900603912 G_phys=1.02670785344234e-05 G_eff=1.02670785344234e-05
Rh2p12n1 in12 h2p 97344.3556119721
* h2 input 13 w=-0.268945400148547 w-  bank=n alpha=1 R=123940.89400645 G_phys=8.0683620044564e-06 G_eff=8.0683620044564e-06
Rh2n13n1 in13n h2p 123715.440309497
* h2 input 14 w=+0.239258603190851 w+  bank=n alpha=1 R=139319.267473714 G_phys=7.17775809572554e-06 G_eff=7.17775809572554e-06
Rh2p14n1 in14 h2p 139729.377309102
* h2 input 15 w=+0.347826837541335 w+  bank=n alpha=1 R=95833.1265320264 G_phys=1.043480512624e-05 G_eff=1.043480512624e-05
Rh2p15n1 in15 h2p 96189.1460866147
* h2 input 16 w=+0.00438097035906581 w+  bank=f alpha=0.001 R=7608.66442849918 G_phys=0.000131429110771974 G_eff=1.31429110771974e-07
Rh2p16f1 tap16 h2p 7630.91920774811
* h2 bias w-  bank=n alpha=1 R=664931.752911819 G_phys=1.50391374095293e-06 G_eff=1.50391374095293e-06
Rh2bnn1 vrefn h2p 663998.143445743
* single-copy I-to-V: 0 V sum h2p, I dump onto R_IV=33333.3333333333
Vh2p h2p 0 DC 0
Bh2iv 0 h2lin I = i(Vh2p)
Rh2iv h2lin 0 33443.373566993
* direct bounded ReLU, no output buffer: y=max(0, min(15, v(h2lin)))
Bh2relu h2y 0 V = max(0, min(15, v(h2lin)))

* h3 input 1 w=-0.916033562434709 w-  bank=n alpha=1 R=36388.7686000689 G_phys=2.74810068730413e-05 G_eff=2.74810068730413e-05
Rh3n1n1 in1n h3p 36405.0844857672
* h3 input 2 w=+0.507521982744407 w+  bank=n alpha=1 R=65678.6000738028 G_phys=1.52256594823322e-05 G_eff=1.52256594823322e-05
Rh3p2n1 in2 h3p 65423.9663698411
* h3 input 3 w=+0.0871477019742823 w+  bank=n alpha=1 R=382492.395991924 G_phys=2.61443105922847e-06 G_eff=2.61443105922847e-06
Rh3p3n1 in3 h3p 381282.280599964
* h3 input 4 w=-0.0658557100969535 w-  bank=n alpha=1 R=506157.071030889 G_phys=1.97567130290861e-06 G_eff=1.97567130290861e-06
Rh3n4n1 in4n h3p 505399.188066063
* h3 input 5 w=-0.179053685151098 w-  bank=n alpha=1 R=186163.905563878 G_phys=5.37161055453294e-06 G_eff=5.37161055453294e-06
Rh3n5n1 in5n h3p 186390.86456291
* h3 input 6 w=+0.315007728496672 w+  bank=n alpha=1 R=105817.509597024 G_phys=9.45023185490017e-06 G_eff=9.45023185490017e-06
Rh3p6n1 in6 h3p 106263.349193504
* h3 input 7 w=+0.677608935484657 w+  bank=n alpha=1 R=49192.5823107569 G_phys=2.03282680645397e-05 G_eff=2.03282680645397e-05
Rh3p7n1 in7 h3p 48950.0164265858
* h3 input 8 w=+0.295351776524173 w+  bank=n alpha=1 R=112859.769206789 G_phys=8.8605532957252e-06 G_eff=8.8605532957252e-06
Rh3p8n1 in8 h3p 112661.92969206
* h3 input 9 w=+0.00172302579693755 w+  bank=f alpha=0.001 R=19345.8121129578 G_phys=5.16907739081266e-05 G_eff=5.16907739081266e-08
Rh3p9f1 tap9 h3p 19322.3606480958
* h3 input 10 w=+0.317835264102281 w+  bank=n alpha=1 R=104876.132695604 G_phys=9.53505792306844e-06 G_eff=9.53505792306844e-06
Rh3p10n1 in10 h3p 105251.915147836
* h3 input 11 w=-0.530129158700576 w-  bank=n alpha=1 R=62877.7587240027 G_phys=1.59038747610173e-05 G_eff=1.59038747610173e-05
Rh3n11n1 in11n h3p 63086.7470745537
* h3 input 12 w=-0.291249394999097 w-  bank=n alpha=1 R=114449.450902505 G_phys=8.7374818499729e-06 G_eff=8.7374818499729e-06
Rh3n12n1 in12n h3p 114895.378857376
* h3 input 13 w=-0.395820894073244 w-  bank=n alpha=1 R=84213.1727567804 G_phys=1.18746268221973e-05 G_eff=1.18746268221973e-05
Rh3n13n1 in13n h3p 84432.2583466658
* h3 input 14 w=-0.0451489915790311 w-  bank=n alpha=1 R=738296.297825057 G_phys=1.35446974737093e-06 G_eff=1.35446974737093e-06
Rh3n14n1 in14n h3p 736715.984791516
* h3 input 15 w=+0.0633187763010491 w+  bank=n alpha=1 R=526436.789852823 G_phys=1.89956328903147e-06 G_eff=1.89956328903147e-06
Rh3p15n1 in15 h3p 525371.454538106
* h3 input 16 w=-0.149745176344707 w-  bank=n alpha=1 R=222600.381174225 G_phys=4.49235529034122e-06 G_eff=4.49235529034122e-06
Rh3n16n1 in16n h3p 223136.093001064
* h3 bias w-  bank=n alpha=1 R=602168.780003591 G_phys=1.66066397529616e-06 G_eff=1.66066397529616e-06
Rh3bnn1 vrefn h3p 600497.184821244
* single-copy I-to-V: 0 V sum h3p, I dump onto R_IV=33333.3333333333
Vh3p h3p 0 DC 0
Bh3iv 0 h3lin I = i(Vh3p)
Rh3iv h3lin 0 33489.679805728
* direct bounded ReLU, no output buffer: y=max(0, min(15, v(h3lin)))
Bh3relu h3y 0 V = max(0, min(15, v(h3lin)))

* h4 input 1 w=+0.0673940677866904 w+  bank=n alpha=1 R=494603.374273786 G_phys=2.02182203360071e-06 G_eff=2.02182203360071e-06
Rh4p1n1 in1 h4p 493545.038292936
* h4 input 2 w=-0.087995350925692 w-  bank=n alpha=1 R=378807.891356463 G_phys=2.63986052777076e-06 G_eff=2.63986052777076e-06
Rh4n2n1 in2n h4p 377588.057232271
* h4 input 3 w=-0.354237391786533 w-  bank=n alpha=1 R=94098.8560389478 G_phys=1.0627121753596e-05 G_eff=1.0627121753596e-05
Rh4n3n1 in3n h4p 94338.3501927048
* h4 input 4 w=-0.0201421700797575 w-  bank=f alpha=0.001 R=1654.90278362969 G_phys=0.000604265102392725 G_eff=6.04265102392725e-07
Rh4n4f1 tap4n h4p 1663.03912142248
* h4 input 5 w=-0.808084436849872 w-  bank=n alpha=1 R=41249.814763511 G_phys=2.42425331054962e-05 G_eff=2.42425331054962e-05
Rh4n5n1 in5n h4p 41227.3829705978
* h4 input 6 w=-0.290030636557288 w-  bank=n alpha=1 R=114930.387110153 G_phys=8.70091909671864e-06 G_eff=8.70091909671864e-06
Rh4n6n1 in6n h4p 115090.209118222
* h4 input 7 w=+0.344262354214072 w+  bank=n alpha=1 R=96825.3801942158 G_phys=1.03278706264222e-05 G_eff=1.03278706264222e-05
Rh4p7n1 in7 h4p 96989.2221003354
* h4 input 8 w=-0.872472737770673 w-  bank=n alpha=1 R=38205.5872811637 G_phys=2.61741821331202e-05 G_eff=2.61741821331202e-05
Rh4n8n1 in8n h4p 38259.8102595589
* h4 input 9 w=+0.163024654235771 w+  bank=n alpha=1 R=204468.051103029 G_phys=4.89073962707314e-06 G_eff=4.89073962707314e-06
Rh4p9n1 in9 h4p 205144.329349756
* h4 input 10 w=-0.143734302026109 w-  bank=n alpha=1 R=231909.383240185 G_phys=4.31202906078326e-06 G_eff=4.31202906078326e-06
Rh4n10n1 in10n h4p 232038.519430813
* h4 input 11 w=-0.110414936368951 w-  bank=n alpha=1 R=301891.523280421 G_phys=3.31244809106853e-06 G_eff=3.31244809106853e-06
Rh4n11n1 in11n h4p 302067.685579821
* h4 input 12 w=+0.321561566587255 w+  bank=n alpha=1 R=103660.812724298 G_phys=9.64684699761765e-06 G_eff=9.64684699761765e-06
Rh4p12n1 in12 h4p 103918.590836142
* h4 input 13 w=-0.501486514423905 w-  bank=n alpha=1 R=66469.0522568205 G_phys=1.50445954327172e-05 G_eff=1.50445954327172e-05
Rh4n13n1 in13n h4p 66705.4548222939
* h4 input 14 w=-0.0233644803539605 w-  bank=f alpha=0.001 R=1426.66701028012 G_phys=0.000700934410618815 G_eff=7.00934410618815e-07
Rh4n14f1 tap14n h4p 1426.95650892623
* h4 input 15 w=-0.211065663454959 w-  bank=n alpha=1 R=157928.735483053 G_phys=6.33196990364878e-06 G_eff=6.33196990364878e-06
Rh4n15n1 in15n h4p 157158.678043688
* h4 input 16 w=+0.18002446765288 w+  bank=n alpha=1 R=185160.016124064 G_phys=5.40073402958641e-06 G_eff=5.40073402958641e-06
Rh4p16n1 in16 h4p 185545.693084304
* h4 bias w+  bank=n alpha=1 R=704963.006730694 G_phys=1.41851414961128e-06 G_eff=1.41851414961128e-06
Rh4bpn1 vref h4p 707033.977636137
* single-copy I-to-V: 0 V sum h4p, I dump onto R_IV=33333.3333333333
Vh4p h4p 0 DC 0
Bh4iv 0 h4lin I = i(Vh4p)
Rh4iv h4lin 0 33181.7786712011
* direct bounded ReLU, no output buffer: y=max(0, min(15, v(h4lin)))
Bh4relu h4y 0 V = max(0, min(15, v(h4lin)))

* h5 input 1 w=-0.122756848133934 w-  bank=n alpha=1 R=271539.501380525 G_phys=3.68270544401802e-06 G_eff=3.68270544401802e-06
Rh5n1n1 in1n h5p 270839.865970311
* h5 input 2 w=+0.794704720471975 w+  bank=n alpha=1 R=41944.300159104 G_phys=2.38411416141592e-05 G_eff=2.38411416141592e-05
Rh5p2n1 in2 h5p 42050.1293603284
* h5 input 3 w=-0.26372184795707 w-  bank=n alpha=1 R=126395.797661631 G_phys=7.91165543871211e-06 G_eff=7.91165543871211e-06
Rh5n3n1 in3n h5p 126517.798180118
* h5 input 4 w=+0.65217090039031 w+  bank=n alpha=1 R=51111.3472149464 G_phys=1.95651270117093e-05 G_eff=1.95651270117093e-05
Rh5p4n1 in4 h5p 51020.5167120848
* h5 input 5 w=-0.272670344884174 w-  bank=n alpha=1 R=122247.739656077 G_phys=8.18011034652521e-06 G_eff=8.18011034652521e-06
Rh5n5n1 in5n h5p 122070.140018854
* h5 input 6 w=+0.0607101548077554 w+  bank=n alpha=1 R=549056.964833751 G_phys=1.82130464423266e-06 G_eff=1.82130464423266e-06
Rh5p6n1 in6 h5p 550390.400082252
* h5 input 7 w=+0.629980287413506 w+  bank=n alpha=1 R=52911.7085078791 G_phys=1.88994086224052e-05 G_eff=1.88994086224052e-05
Rh5p7n1 in7 h5p 52771.997340513
* h5 input 8 w=-0.369402487956774 w-  bank=n alpha=1 R=90235.8116690157 G_phys=1.10820746387032e-05 G_eff=1.10820746387032e-05
Rh5n8n1 in8n h5p 90229.8093665433
* h5 input 9 w=-0.0924511829208223 w-  bank=n alpha=1 R=360550.641757401 G_phys=2.77353548762467e-06 G_eff=2.77353548762467e-06
Rh5n9n1 in9n h5p 362314.107870197
* h5 input 10 w=-0.00426485730080124 w-  bank=f alpha=0.001 R=7815.81445340996 G_phys=0.000127945719024037 G_eff=1.27945719024037e-07
Rh5n10f1 tap10n h5p 7799.73686385121
* h5 input 11 w=+0.540478898079688 w+  bank=n alpha=1 R=61673.6998461292 G_phys=1.62143669423906e-05 G_eff=1.62143669423906e-05
Rh5p11n1 in11 h5p 61723.7650777514
* h5 input 12 w=+0.161688921548601 w+  bank=n alpha=1 R=206157.187604928 G_phys=4.85066764645802e-06 G_eff=4.85066764645802e-06
Rh5p12n1 in12 h5p 206518.306790408
* h5 input 13 w=+0.0259557799028364 w+  bank=f alpha=0.001 R=1284.23547503154 G_phys=0.000778673397085092 G_eff=7.78673397085092e-07
Rh5p13f1 tap13 h5p 1280.14917583944
* h5 input 14 w=+0.470073429319239 w+  bank=n alpha=1 R=70910.907220616 G_phys=1.41022028795772e-05 G_eff=1.41022028795772e-05
Rh5p14n1 in14 h5p 70986.7948058854
* h5 input 15 w=+0.188749264833093 w+  bank=n alpha=1 R=176601.129349083 G_phys=5.66247794499279e-06 G_eff=5.66247794499279e-06
Rh5p15n1 in15 h5p 176038.296646414
* h5 input 16 w=+0.031866913791992 w+  bank=f alpha=0.001 R=1046.01699276288 G_phys=0.000956007413759761 G_eff=9.56007413759761e-07
Rh5p16f1 tap16 h5p 1050.63777444452
* h5 bias w+  bank=f alpha=0.001 R=1837.62567566174 G_phys=0.000544180467896375 G_eff=5.44180467896375e-07
Rh5bpf1 tapref h5p 1831.60731241432
* single-copy I-to-V: 0 V sum h5p, I dump onto R_IV=33333.3333333333
Vh5p h5p 0 DC 0
Bh5iv 0 h5lin I = i(Vh5p)
Rh5iv h5lin 0 33280.8013765038
* direct bounded ReLU, no output buffer: y=max(0, min(15, v(h5lin)))
Bh5relu h5y 0 V = max(0, min(15, v(h5lin)))

* h6 input 1 w=-0.340583473625464 w-  bank=n alpha=1 R=97871.2589266431 G_phys=1.02175042087639e-05 G_eff=1.02175042087639e-05
Rh6n1n1 in1n h6p 97753.9146782909
* h6 input 2 w=-0.593797589144587 w-  bank=n alpha=1 R=56135.8515809279 G_phys=1.78139276743376e-05 G_eff=1.78139276743376e-05
Rh6n2n1 in2n h6p 56062.8721287783
* h6 input 3 w=-0.388639564922933 w-  bank=n alpha=1 R=85769.2740057059 G_phys=1.1659186947688e-05 G_eff=1.1659186947688e-05
Rh6n3n1 in3n h6p 86111.5140730148
* h6 input 4 w=+0.284617429170421 w+  bank=n alpha=1 R=117116.275803947 G_phys=8.53852287511263e-06 G_eff=8.53852287511263e-06
Rh6p4n1 in4 h6p 116701.457590208
* h6 input 5 w=-0.270576674342045 w-  bank=n alpha=1 R=123193.669278364 G_phys=8.11730023026134e-06 G_eff=8.11730023026134e-06
Rh6n5n1 in5n h6p 123512.259452848
* h6 input 6 w=+0.0593082278184784 w+  bank=n alpha=1 R=562035.565037534 G_phys=1.77924683455435e-06 G_eff=1.77924683455435e-06
Rh6p6n1 in6 h6p 561343.895337865
* h6 input 7 w=+0.460681196235491 w+  bank=n alpha=1 R=72356.6179946576 G_phys=1.38204358870647e-05 G_eff=1.38204358870647e-05
Rh6p7n1 in7 h6p 72451.8569940957
* h6 input 8 w=+0.530418434730864 w+  bank=n alpha=1 R=62843.46687582 G_phys=1.59125530419259e-05 G_eff=1.59125530419259e-05
Rh6p8n1 in8 h6p 62857.6884316757
* h6 input 9 w=+0.069052799324409 w+  bank=n alpha=1 R=482722.40458687 G_phys=2.07158397973227e-06 G_eff=2.07158397973227e-06
Rh6p9n1 in9 h6p 484605.933690942
* h6 input 10 w=+0.150678240315211 w+  bank=n alpha=1 R=221221.944612585 G_phys=4.52034720945633e-06 G_eff=4.52034720945633e-06
Rh6p10n1 in10 h6p 220286.176681369
* h6 input 11 w=+0.0896190095447204 w+  bank=n alpha=1 R=371944.897658123 G_phys=2.68857028634161e-06 G_eff=2.68857028634161e-06
Rh6p11n1 in11 h6p 373021.289141201
* h6 input 12 w=-0.177342454994274 w-  bank=n alpha=1 R=187960.256524077 G_phys=5.32027364982823e-06 G_eff=5.32027364982823e-06
Rh6n12n1 in12n h6p 188618.660939372
* h6 input 13 w=+0.643544080066549 w+  bank=n alpha=1 R=51796.5037140678 G_phys=1.93063224019965e-05 G_eff=1.93063224019965e-05
Rh6p13n1 in13 h6p 52006.751212901
* h6 input 14 w=+0.0993069474158396 w+  bank=n alpha=1 R=335659.63108052 G_phys=2.97920842247519e-06 G_eff=2.97920842247519e-06
Rh6p14n1 in14 h6p 336800.098943931
* h6 input 15 w=-0.324176483950696 w-  bank=n alpha=1 R=102824.649484455 G_phys=9.72529451852089e-06 G_eff=9.72529451852089e-06
Rh6n15n1 in15n h6p 102314.785589879
* h6 input 16 w=+0.0932186969347454 w+  bank=n alpha=1 R=357582.056276406 G_phys=2.79656090804236e-06 G_eff=2.79656090804236e-06
Rh6p16n1 in16 h6p 357163.419614434
* h6 bias w-  bank=f alpha=0.001 R=1678.78030803583 G_phys=0.000595670556304058 G_eff=5.95670556304058e-07
Rh6bnf1 taprefn h6p 1673.64143872496
* single-copy I-to-V: 0 V sum h6p, I dump onto R_IV=33333.3333333333
Vh6p h6p 0 DC 0
Bh6iv 0 h6lin I = i(Vh6p)
Rh6iv h6lin 0 33452.9338372046
* direct bounded ReLU, no output buffer: y=max(0, min(15, v(h6lin)))
Bh6relu h6y 0 V = max(0, min(15, v(h6lin)))

* h7 input 1 w=+0.32217720874051 w+  bank=n alpha=1 R=103462.729296227 G_phys=9.6653162622153e-06 G_eff=9.6653162622153e-06
Rh7p1n1 in1 h7p 103614.442245728
* h7 input 2 w=-0.146738476402048 w-  bank=n alpha=1 R=227161.50631143 G_phys=4.40215429206143e-06 G_eff=4.40215429206143e-06
Rh7n2n1 in2n h7p 227942.494623183
* h7 input 3 w=+0.524171111363509 w+  bank=n alpha=1 R=63592.4655340589 G_phys=1.57251333409053e-05 G_eff=1.57251333409053e-05
Rh7p3n1 in3 h7p 63761.0692297801
* h7 input 4 w=-0.439531494343149 w-  bank=n alpha=1 R=75838.3273151968 G_phys=1.31859448302945e-05 G_eff=1.31859448302945e-05
Rh7n4n1 in4n h7p 75919.6584154649
* h7 input 5 w=+0.367500929015048 w+  bank=n alpha=1 R=90702.718555491 G_phys=1.10250278704514e-05 G_eff=1.10250278704514e-05
Rh7p5n1 in5 h7p 90293.9978516939
* h7 input 6 w=-1.05409273633464 w-  bank=n alpha=1 R=31622.7711133294 G_phys=3.16227820900391e-05 G_eff=3.16227820900391e-05
Rh7n6n1 in6n h7p 31635.4967907674
* h7 input 7 w=-0.045065971974084 w-  bank=n alpha=1 R=739656.372051673 G_phys=1.35197915922252e-06 G_eff=1.35197915922252e-06
Rh7n7n1 in7n h7p 737172.40574047
* h7 input 8 w=-0.167915862386558 w-  bank=n alpha=1 R=198512.117077998 G_phys=5.03747587159673e-06 G_eff=5.03747587159673e-06
Rh7n8n1 in8n h7p 198225.224813614
* h7 input 9 w=+0.0197430594045346 w+  bank=f alpha=0.001 R=1688.35703982521 G_phys=0.000592291782136037 G_eff=5.92291782136037e-07
Rh7p9f1 tap9 h7p 1682.52586691007
* h7 input 10 w=-0.287534460104587 w-  bank=n alpha=1 R=115928.133696423 G_phys=8.6260338031376e-06 G_eff=8.6260338031376e-06
Rh7n10n1 in10n h7p 116433.526930914
* h7 input 11 w=-0.517871662481308 w-  bank=n alpha=1 R=64366.0114044885 G_phys=1.55361498744393e-05 G_eff=1.55361498744393e-05
Rh7n11n1 in11n h7p 64575.0670950374
* h7 input 12 w=+0.348150035983652 w+  bank=n alpha=1 R=95744.1616777503 G_phys=1.04445010795096e-05 G_eff=1.04445010795096e-05
Rh7p12n1 in12 h7p 95508.1881957852
* h7 input 13 w=-0.408247593362815 w-  bank=n alpha=1 R=81649.7975132203 G_phys=1.22474278008844e-05 G_eff=1.22474278008844e-05
Rh7n13n1 in13n h7p 81497.3885804776
* h7 input 14 w=-0.41711419269885 w-  bank=n alpha=1 R=79914.1671916195 G_phys=1.25134257809655e-05 G_eff=1.25134257809655e-05
Rh7n14n1 in14n h7p 79667.7220690887
* h7 input 15 w=-0.341449872918214 w-  bank=n alpha=1 R=97622.9191372918 G_phys=1.02434961875464e-05 G_eff=1.02434961875464e-05
Rh7n15n1 in15n h7p 97278.7809422942
* h7 input 16 w=-0.0335582003371702 w-  bank=n alpha=1 R=993299.193592697 G_phys=1.00674601011511e-06 G_eff=1.00674601011511e-06
Rh7n16n1 in16n h7p 990011.944811008
* h7 bias w-  bank=f alpha=0.001 R=1569.92559182808 G_phys=0.000636972863685573 G_eff=6.36972863685573e-07
Rh7bnf1 taprefn h7p 1564.6180036763
* single-copy I-to-V: 0 V sum h7p, I dump onto R_IV=33333.3333333333
Vh7p h7p 0 DC 0
Bh7iv 0 h7lin I = i(Vh7p)
Rh7iv h7lin 0 33283.9817403457
* direct bounded ReLU, no output buffer: y=max(0, min(15, v(h7lin)))
Bh7relu h7y 0 V = max(0, min(15, v(h7lin)))

* h8 input 1 w=+0.185544590700454 w+  bank=n alpha=1 R=179651.334525549 G_phys=5.56633772101363e-06 G_eff=5.56633772101363e-06
Rh8p1n1 in1 h8p 179953.628724387
* h8 input 2 w=-0.385658106289114 w-  bank=n alpha=1 R=86432.3419882805 G_phys=1.15697431886734e-05 G_eff=1.15697431886734e-05
Rh8n2n1 in2n h8p 86340.7481117386
* h8 input 3 w=+0.230915543832556 w+  bank=n alpha=1 R=144352.92133259 G_phys=6.92746631497669e-06 G_eff=6.92746631497669e-06
Rh8p3n1 in3 h8p 143640.299142773
* h8 input 4 w=+0.205353187615931 w+  bank=n alpha=1 R=162321.966950307 G_phys=6.16059562847793e-06 G_eff=6.16059562847793e-06
Rh8p4n1 in4 h8p 162869.598641197
* h8 input 5 w=+0.00415238713767869 w+  bank=f alpha=0.001 R=8027.51097817138 G_phys=0.000124571614130361 G_eff=1.24571614130361e-07
Rh8p5f1 tap5 h8p 8052.98250806068
* h8 input 6 w=-0.514726379917983 w-  bank=n alpha=1 R=64759.3257968335 G_phys=1.54417913975395e-05 G_eff=1.54417913975395e-05
Rh8n6n1 in6n h8p 64844.4395290234
* h8 input 7 w=+0.210716479044664 w+  bank=n alpha=1 R=158190.443787113 G_phys=6.32149437133992e-06 G_eff=6.32149437133992e-06
Rh8p7n1 in7 h8p 158211.870578821
* h8 input 8 w=+0.375574589425665 w+  bank=n alpha=1 R=88752.8982839526 G_phys=1.126723768277e-05 G_eff=1.126723768277e-05
Rh8p8n1 in8 h8p 88596.6727665469
* h8 input 9 w=+0.00572491873576676 w+  bank=f alpha=0.001 R=5822.49895096002 G_phys=0.000171747562073003 G_eff=1.71747562073003e-07
Rh8p9f1 tap9 h8p 5796.33772557758
* h8 input 10 w=-0.367556769900021 w-  bank=n alpha=1 R=90688.9385887256 G_phys=1.10267030970006e-05 G_eff=1.10267030970006e-05
Rh8n10n1 in10n h8p 90566.303876353
* h8 input 11 w=+0.41225604099869 w+  bank=n alpha=1 R=80855.9002618455 G_phys=1.23676812299607e-05 G_eff=1.23676812299607e-05
Rh8p11n1 in11 h8p 81047.6020187576
* h8 input 12 w=+0.21126612483399 w+  bank=n alpha=1 R=157778.883668767 G_phys=6.33798374501969e-06 G_eff=6.33798374501969e-06
Rh8p12n1 in12 h8p 158445.77142535
* h8 input 13 w=+0.318427374873886 w+  bank=n alpha=1 R=104681.117151235 G_phys=9.55282124621658e-06 G_eff=9.55282124621658e-06
Rh8p13n1 in13 h8p 104619.784933705
* h8 input 14 w=-0.262828471961964 w-  bank=n alpha=1 R=126825.427566909 G_phys=7.88485415885892e-06 G_eff=7.88485415885892e-06
Rh8n14n1 in14n h8p 126983.660959949
* h8 input 15 w=+0.319620775512722 w+  bank=n alpha=1 R=104290.258603689 G_phys=9.58862326538165e-06 G_eff=9.58862326538165e-06
Rh8p15n1 in15 h8p 103853.493422811
* h8 input 16 w=+0.15331491024055 w+  bank=n alpha=1 R=217417.427183263 G_phys=4.59944730721651e-06 G_eff=4.59944730721651e-06
Rh8p16n1 in16 h8p 216757.133266856
* h8 bias w-  bank=f alpha=0.001 R=1092.27499465772 G_phys=0.00091552036336176 G_eff=9.1552036336176e-07
Rh8bnf1 taprefn h8p 1088.67567026785
* single-copy I-to-V: 0 V sum h8p, I dump onto R_IV=33333.3333333333
Vh8p h8p 0 DC 0
Bh8iv 0 h8lin I = i(Vh8p)
Rh8iv h8lin 0 33297.0881825398
* direct bounded ReLU, no output buffer: y=max(0, min(15, v(h8lin)))
Bh8relu h8y 0 V = max(0, min(15, v(h8lin)))

* h9 input 1 w=-0.192368051906404 w-  bank=n alpha=1 R=173278.946285486 G_phys=5.77104155719211e-06 G_eff=5.77104155719211e-06
Rh9n1n1 in1n h9p 173485.884968315
* h9 input 2 w=-0.0188071151742732 w-  bank=f alpha=0.001 R=1772.37885898263 G_phys=0.000564213455228197 G_eff=5.64213455228197e-07
Rh9n2f1 tap2n h9p 1771.06746220015
* h9 input 3 w=+0.675590388456855 w+  bank=n alpha=1 R=49339.5612235861 G_phys=2.02677116537057e-05 G_eff=2.02677116537057e-05
Rh9p3n1 in3 h9p 49531.666862174
* h9 input 4 w=-0.777819910920126 w-  bank=n alpha=1 R=42854.8213607717 G_phys=2.33345973276038e-05 G_eff=2.33345973276038e-05
Rh9n4n1 in4n h9p 42852.2528853368
* h9 input 5 w=-0.0591658911038067 w-  bank=n alpha=1 R=563387.666634648 G_phys=1.7749767331142e-06 G_eff=1.7749767331142e-06
Rh9n5n1 in5n h9p 565023.767649435
* h9 input 6 w=-0.373077376819092 w-  bank=n alpha=1 R=89346.9703725748 G_phys=1.11923213045728e-05 G_eff=1.11923213045728e-05
Rh9n6n1 in6n h9p 88912.9919112063
* h9 input 7 w=+0.173600484730372 w+  bank=n alpha=1 R=192011.752646342 G_phys=5.20801454191117e-06 G_eff=5.20801454191117e-06
Rh9p7n1 in7 h9p 191371.048740476
* h9 input 8 w=+0.21285190098274 w+  bank=n alpha=1 R=156603.409128286 G_phys=6.38555702948219e-06 G_eff=6.38555702948219e-06
Rh9p8n1 in8 h9p 157122.118600038
* h9 input 9 w=+0.47939396555815 w+  bank=n alpha=1 R=69532.2338789223 G_phys=1.43818189667445e-05 G_eff=1.43818189667445e-05
Rh9p9n1 in9 h9p 69443.3798783668
* h9 input 10 w=-0.695860852133009 w-  bank=n alpha=1 R=47902.2971778874 G_phys=2.08758255639903e-05 G_eff=2.08758255639903e-05
Rh9n10n1 in10n h9p 48121.9137688768
* h9 input 11 w=+0.426719797848979 w+  bank=n alpha=1 R=78115.2726012736 G_phys=1.28015939354694e-05 G_eff=1.28015939354694e-05
Rh9p11n1 in11 h9p 78125.7875944017
* h9 input 12 w=+0.190883817865507 w+  bank=n alpha=1 R=174626.292087365 G_phys=5.7265145359652e-06 G_eff=5.7265145359652e-06
Rh9p12n1 in12 h9p 175115.500930392
* h9 input 13 w=-0.203891646942192 w-  bank=n alpha=1 R=163485.526912165 G_phys=6.11674940826577e-06 G_eff=6.11674940826577e-06
Rh9n13n1 in13n h9p 163773.28589105
* h9 input 14 w=-0.0564974778722501 w-  bank=n alpha=1 R=589996.838597032 G_phys=1.6949243361675e-06 G_eff=1.6949243361675e-06
Rh9n14n1 in14n h9p 588425.774945927
* h9 input 15 w=-0.251891815788561 w-  bank=n alpha=1 R=132331.942699216 G_phys=7.55675447365683e-06 G_eff=7.55675447365683e-06
Rh9n15n1 in15n h9p 132582.855357782
* h9 input 16 w=-0.340248378281639 w-  bank=n alpha=1 R=97967.6479331866 G_phys=1.02074513484492e-05 G_eff=1.02074513484492e-05
Rh9n16n1 in16n h9p 97850.1142429185
* h9 bias w-  bank=f alpha=0.001 R=1259.76757958347 G_phys=0.000793797218000037 G_eff=7.93797218000037e-07
Rh9bnf1 taprefn h9p 1259.13228714501
* single-copy I-to-V: 0 V sum h9p, I dump onto R_IV=33333.3333333333
Vh9p h9p 0 DC 0
Bh9iv 0 h9lin I = i(Vh9p)
Rh9iv h9lin 0 33347.9783791589
* direct bounded ReLU, no output buffer: y=max(0, min(15, v(h9lin)))
Bh9relu h9y 0 V = max(0, min(15, v(h9lin)))

* h10 input 1 w=+0.0856004623316453 w+  bank=n alpha=1 R=389405.996479186 G_phys=2.56801386994936e-06 G_eff=2.56801386994936e-06
Rh10p1n1 in1 h10p 387965.349703461
* h10 input 2 w=+0.717707405140542 w+  bank=n alpha=1 R=46444.1819808254 G_phys=2.15312221542163e-05 G_eff=2.15312221542163e-05
Rh10p2n1 in2 h10p 46362.4681488704
* h10 input 3 w=+0.367326370670395 w+  bank=n alpha=1 R=90745.8216857607 G_phys=1.10197911201119e-05 G_eff=1.10197911201119e-05
Rh10p3n1 in3 h10p 90410.1127510936
* h10 input 4 w=+0.5220921972442 w+  bank=n alpha=1 R=63845.6837878046 G_phys=1.5662765917326e-05 G_eff=1.5662765917326e-05
Rh10p4n1 in4 h10p 63803.9276107094
* h10 input 5 w=+0.0909071116243784 w+  bank=n alpha=1 R=366674.649955487 G_phys=2.72721334873135e-06 G_eff=2.72721334873135e-06
Rh10p5n1 in5 h10p 366844.690897007
* h10 input 6 w=-0.0568053629833511 w-  bank=n alpha=1 R=586799.055277631 G_phys=1.70416088950053e-06 G_eff=1.70416088950053e-06
Rh10n6n1 in6n h10p 589536.159007711
* h10 input 7 w=+0.372078007523385 w+  bank=n alpha=1 R=89586.9485950155 G_phys=1.11623402257016e-05 G_eff=1.11623402257016e-05
Rh10p7n1 in7 h10p 89547.9157268747
* h10 input 8 w=+0.384900055079612 w+  bank=n alpha=1 R=86602.568363984 G_phys=1.15470016523884e-05 G_eff=1.15470016523884e-05
Rh10p8n1 in8 h10p 86383.6891090701
* h10 input 9 w=+0.617655459577812 w+  bank=n alpha=1 R=53967.5199440765 G_phys=1.85296637873344e-05 G_eff=1.85296637873344e-05
Rh10p9n1 in9 h10p 53758.8742760376
* h10 input 10 w=+0.306521845436409 w+  bank=n alpha=1 R=108747.007202293 G_phys=9.19565536309227e-06 G_eff=9.19565536309227e-06
Rh10p10n1 in10 h10p 108995.415445526
* h10 input 11 w=-0.0307901580575706 w-  bank=f alpha=0.001 R=1082.5970191841 G_phys=0.000923704741727117 G_eff=9.23704741727117e-07
Rh10n11f1 tap11n h10p 1078.48656454049
* h10 input 12 w=+0.163538031424557 w+  bank=n alpha=1 R=203826.186746724 G_phys=4.9061409427367e-06 G_eff=4.9061409427367e-06
Rh10p12n1 in12 h10p 203458.594811407
* h10 input 13 w=-0.0170713095619708 w-  bank=f alpha=0.001 R=1952.59380730749 G_phys=0.000512139286859123 G_eff=5.12139286859123e-07
Rh10n13f1 tap13n h10p 1957.441968083
* h10 input 14 w=-0.123347220224403 w-  bank=n alpha=1 R=270239.842233093 G_phys=3.7004166067321e-06 G_eff=3.7004166067321e-06
Rh10n14n1 in14n h10p 270981.52679677
* h10 input 15 w=-0.136765368652097 w-  bank=n alpha=1 R=243726.417453869 G_phys=4.10296105956291e-06 G_eff=4.10296105956291e-06
Rh10n15n1 in15n h10p 242802.906256316
* h10 input 16 w=+0.269183781267177 w+  bank=n alpha=1 R=123831.1356517 G_phys=8.07551343801532e-06 G_eff=8.07551343801532e-06
Rh10p16n1 in16 h10p 123532.440934355
* h10 bias w-  bank=n alpha=1 R=519656.094343386 G_phys=1.92434960522027e-06 G_eff=1.92434960522027e-06
Rh10bnn1 vrefn h10p 518480.92378463
* single-copy I-to-V: 0 V sum h10p, I dump onto R_IV=33333.3333333333
Vh10p h10p 0 DC 0
Bh10iv 0 h10lin I = i(Vh10p)
Rh10iv h10lin 0 33222.3262629327
* direct bounded ReLU, no output buffer: y=max(0, min(15, v(h10lin)))
Bh10relu h10y 0 V = max(0, min(15, v(h10lin)))

* h11 input 1 w=+0.100174494534941 w+  bank=n alpha=1 R=332752.69806035 G_phys=3.00523483604823e-06 G_eff=3.00523483604823e-06
Rh11p1n1 in1 h11p 333415.012319213
* h11 input 2 w=-0.350357054027393 w-  bank=n alpha=1 R=95141.0366943178 G_phys=1.05107116208218e-05 G_eff=1.05107116208218e-05
Rh11n2n1 in2n h11p 94706.3586896782
* h11 input 3 w=-0.364058373495884 w-  bank=n alpha=1 R=91560.4083302596 G_phys=1.09217512048765e-05 G_eff=1.09217512048765e-05
Rh11n3n1 in3n h11p 91622.4562173335
* h11 input 4 w=+0.201551043415431 w+  bank=n alpha=1 R=165384.077246515 G_phys=6.04653130246294e-06 G_eff=6.04653130246294e-06
Rh11p4n1 in4 h11p 164859.995193906
* h11 input 5 w=+0.30370864041576 w+  bank=n alpha=1 R=109754.313501591 G_phys=9.1112592124728e-06 G_eff=9.1112592124728e-06
Rh11p5n1 in5 h11p 110293.784944353
* h11 input 6 w=+0.221531530750713 w+  bank=n alpha=1 R=150467.670314809 G_phys=6.64594592252139e-06 G_eff=6.64594592252139e-06
Rh11p6n1 in6 h11p 150205.770768931
* h11 input 7 w=-0.554388667333083 w-  bank=n alpha=1 R=60126.2891856812 G_phys=1.66316600199925e-05 G_eff=1.66316600199925e-05
Rh11n7n1 in7n h11p 60314.3193008504
* h11 input 8 w=+0.382929077760783 w+  bank=n alpha=1 R=87048.3211362621 G_phys=1.14878723328235e-05 G_eff=1.14878723328235e-05
Rh11p8n1 in8 h11p 87122.4487421767
* h11 input 9 w=-0.415059943002996 w-  bank=n alpha=1 R=80309.6851316552 G_phys=1.24517982900899e-05 G_eff=1.24517982900899e-05
Rh11n9n1 in9n h11p 79957.8096995164
* h11 input 10 w=-0.579957638432045 w-  bank=n alpha=1 R=57475.4622138477 G_phys=1.73987291529614e-05 G_eff=1.73987291529614e-05
Rh11n10n1 in10n h11p 57591.5847527978
* h11 input 11 w=+0.208304459025755 w+  bank=n alpha=1 R=160022.178542092 G_phys=6.24913377077265e-06 G_eff=6.24913377077265e-06
Rh11p11n1 in11 h11p 160461.903161252
* h11 input 12 w=+0.150185585205542 w+  bank=n alpha=1 R=221947.620923232 G_phys=4.50556755616625e-06 G_eff=4.50556755616625e-06
Rh11p12n1 in12 h11p 221841.981612177
* h11 input 13 w=-0.130595100347527 w-  bank=n alpha=1 R=255241.837133476 G_phys=3.9178530104258e-06 G_eff=3.9178530104258e-06
Rh11n13n1 in13n h11p 254393.298767031
* h11 input 14 w=+0.223944918125423 w+  bank=n alpha=1 R=148846.125254178 G_phys=6.71834754376269e-06 G_eff=6.71834754376269e-06
Rh11p14n1 in14 h11p 148600.00493836
* h11 input 15 w=+0.219816736012751 w+  bank=n alpha=1 R=151641.471609331 G_phys=6.59450208038254e-06 G_eff=6.59450208038254e-06
Rh11p15n1 in15 h11p 151792.030761938
* h11 input 16 w=-0.0825561420887272 w-  bank=n alpha=1 R=403765.637419301 G_phys=2.47668426266182e-06 G_eff=2.47668426266182e-06
Rh11n16n1 in16n h11p 402275.780140469
* h11 bias w-  bank=f alpha=0.001 R=2978.62482206369 G_phys=0.000335725396697381 G_eff=3.35725396697381e-07
Rh11bnf1 taprefn h11p 2982.57788991879
* single-copy I-to-V: 0 V sum h11p, I dump onto R_IV=33333.3333333333
Vh11p h11p 0 DC 0
Bh11iv 0 h11lin I = i(Vh11p)
Rh11iv h11lin 0 33315.2271075683
* direct bounded ReLU, no output buffer: y=max(0, min(15, v(h11lin)))
Bh11relu h11y 0 V = max(0, min(15, v(h11lin)))

* h12 input 1 w=-0.0647804813106503 w-  bank=n alpha=1 R=514558.284516066 G_phys=1.94341443931951e-06 G_eff=1.94341443931951e-06
Rh12n1n1 in1n h12p 512239.650589484
* h12 input 2 w=-0.668825239918342 w-  bank=n alpha=1 R=49838.6295011879 G_phys=2.00647571975503e-05 G_eff=2.00647571975503e-05
Rh12n2n1 in2n h12p 49755.2296459799
* h12 input 3 w=+0.43152134817872 w+  bank=n alpha=1 R=77246.0817385283 G_phys=1.29456404453616e-05 G_eff=1.29456404453616e-05
Rh12p3n1 in3 h12p 77196.091481829
* h12 input 4 w=+0.0766102486579458 w+  bank=n alpha=1 R=435102.795216892 G_phys=2.29830745973837e-06 G_eff=2.29830745973837e-06
Rh12p4n1 in4 h12p 436068.041426037
* h12 input 5 w=+0.112143595115044 w+  bank=n alpha=1 R=297237.959057206 G_phys=3.36430785345132e-06 G_eff=3.36430785345132e-06
Rh12p5n1 in5 h12p 297376.995188585
* h12 input 6 w=-0.214387519256146 w-  bank=n alpha=1 R=155481.687781961 G_phys=6.43162557768439e-06 G_eff=6.43162557768439e-06
Rh12n6n1 in6n h12p 154814.875377296
* h12 input 7 w=+0.0362945018752433 w+  bank=n alpha=1 R=918412.751548746 G_phys=1.0888350562573e-06 G_eff=1.0888350562573e-06
Rh12p7n1 in7 h12p 920482.503249824
* h12 input 8 w=-0.654320698371061 w-  bank=n alpha=1 R=50943.4187491196 G_phys=1.96296209511318e-05 G_eff=1.96296209511318e-05
Rh12n8n1 in8n h12p 50965.8002175559
* h12 input 9 w=-0.424313635659581 w-  bank=n alpha=1 R=78558.2421397273 G_phys=1.27294090697874e-05 G_eff=1.27294090697874e-05
Rh12n9n1 in9n h12p 78645.889017988
* h12 input 10 w=-0.147731830075345 w-  bank=n alpha=1 R=225634.064888609 G_phys=4.43195490226035e-06 G_eff=4.43195490226035e-06
Rh12n10n1 in10n h12p 225909.221320082
* h12 input 11 w=+0.422841356490785 w+  bank=n alpha=1 R=78831.7718256581 G_phys=1.26852406947236e-05 G_eff=1.26852406947236e-05
Rh12p11n1 in11 h12p 78891.8038009379
* h12 input 12 w=+0.250573650346706 w+  bank=n alpha=1 R=133028.086900644 G_phys=7.51720951040119e-06 G_eff=7.51720951040119e-06
Rh12p12n1 in12 h12p 133620.584888634
* h12 input 13 w=+0.0601122436783251 w+  bank=n alpha=1 R=554518.202842467 G_phys=1.80336731034975e-06 G_eff=1.80336731034975e-06
Rh12p13n1 in13 h12p 553402.516108168
* h12 input 14 w=-0.651755086554606 w-  bank=n alpha=1 R=51143.9557910386 G_phys=1.95526525966382e-05 G_eff=1.95526525966382e-05
Rh12n14n1 in14n h12p 51391.3015449729
* h12 input 15 w=+0.130109285988943 w+  bank=n alpha=1 R=256194.88324735 G_phys=3.90327857966829e-06 G_eff=3.90327857966829e-06
Rh12p15n1 in15 h12p 257340.174851091
* h12 input 16 w=-0.0778767908450736 w-  bank=n alpha=1 R=428026.54002071 G_phys=2.33630372535221e-06 G_eff=2.33630372535221e-06
Rh12n16n1 in16n h12p 428199.626991012
* h12 bias w+  bank=f alpha=0.001 R=1892.24272993526 G_phys=0.000528473426891809 G_eff=5.28473426891809e-07
Rh12bpf1 tapref h12p 1900.09079937698
* single-copy I-to-V: 0 V sum h12p, I dump onto R_IV=33333.3333333333
Vh12p h12p 0 DC 0
Bh12iv 0 h12lin I = i(Vh12p)
Rh12iv h12lin 0 33310.9453560747
* direct bounded ReLU, no output buffer: y=max(0, min(15, v(h12lin)))
Bh12relu h12y 0 V = max(0, min(15, v(h12lin)))

* h13 input 1 w=+0.034343742118514 w+  bank=n alpha=1 R=970579.537264929 G_phys=1.03031226355542e-06 G_eff=1.03031226355542e-06
Rh13p1n1 in1 h13p 971523.12180245
* h13 input 2 w=-0.102232912320493 w-  bank=n alpha=1 R=326052.858876169 G_phys=3.06698736961478e-06 G_eff=3.06698736961478e-06
Rh13n2n1 in2n h13p 326540.532739986
* h13 input 3 w=+1.31993068300228 w+  bank=n alpha=1 R=25253.8514049194 G_phys=3.95979204900683e-05 G_eff=3.95979204900683e-05
Rh13p3n1 in3 h13p 25201.2510089544
* h13 input 4 w=-0.233319639483811 w-  bank=n alpha=1 R=142865.527338714 G_phys=6.99958918451433e-06 G_eff=6.99958918451433e-06
Rh13n4n1 in4n h13p 142964.61513902
* h13 input 5 w=-0.375430599339701 w-  bank=n alpha=1 R=88786.9379639253 G_phys=1.1262917980191e-05 G_eff=1.1262917980191e-05
Rh13n5n1 in5n h13p 89169.1122794937
* h13 input 6 w=+0.442115486842334 w+  bank=n alpha=1 R=75395.0818855177 G_phys=1.326346460527e-05 G_eff=1.326346460527e-05
Rh13p6n1 in6 h13p 75359.9790196073
* h13 input 7 w=-0.102130412545238 w-  bank=n alpha=1 R=326380.090930979 G_phys=3.06391237635715e-06 G_eff=3.06391237635715e-06
Rh13n7n1 in7n h13p 325018.039477615
* h13 input 8 w=-0.136235661297007 w-  bank=n alpha=1 R=244674.067098066 G_phys=4.08706983891021e-06 G_eff=4.08706983891021e-06
Rh13n8n1 in8n h13p 243875.212482514
* h13 input 9 w=+0.0915800560074952 w+  bank=n alpha=1 R=363980.268046628 G_phys=2.74740168022485e-06 G_eff=2.74740168022485e-06
Rh13p9n1 in9 h13p 362194.684846853
* h13 input 10 w=-0.194905587913072 w-  bank=n alpha=1 R=171022.974201232 G_phys=5.84716763739217e-06 G_eff=5.84716763739217e-06
Rh13n10n1 in10n h13p 170454.140704791
* h13 input 11 w=-0.611958537828416 w-  bank=n alpha=1 R=54469.9212002489 G_phys=1.83587561348525e-05 G_eff=1.83587561348525e-05
Rh13n11n1 in11n h13p 54520.6735248834
* h13 input 12 w=+0.19411196838682 w+  bank=n alpha=1 R=171722.195237894 G_phys=5.8233590516046e-06 G_eff=5.8233590516046e-06
Rh13p12n1 in12 h13p 171321.827479561
* h13 input 13 w=+0.146421986160596 w+  bank=n alpha=1 R=227652.514539539 G_phys=4.39265958481789e-06 G_eff=4.39265958481789e-06
Rh13p13n1 in13 h13p 227743.134346898
* h13 input 14 w=+0.246088955287688 w+  bank=n alpha=1 R=135452.374505655 G_phys=7.38266865863065e-06 G_eff=7.38266865863065e-06
Rh13p14n1 in14 h13p 135178.66884129
* h13 input 15 w=-0.101801651380703 w-  bank=n alpha=1 R=327434.112131228 G_phys=3.05404954142109e-06 G_eff=3.05404954142109e-06
Rh13n15n1 in15n h13p 326048.378798872
* h13 input 16 w=-0.212672591801914 w-  bank=n alpha=1 R=156735.445084435 G_phys=6.38017775405741e-06 G_eff=6.38017775405741e-06
Rh13n16n1 in16n h13p 156551.038507696
* h13 bias w+  bank=f alpha=0.001 R=1569.64655542844 G_phys=0.000637086098486067 G_eff=6.37086098486067e-07
Rh13bpf1 tapref h13p 1567.26121737023
* single-copy I-to-V: 0 V sum h13p, I dump onto R_IV=33333.3333333333
Vh13p h13p 0 DC 0
Bh13iv 0 h13lin I = i(Vh13p)
Rh13iv h13lin 0 33197.9562137685
* direct bounded ReLU, no output buffer: y=max(0, min(15, v(h13lin)))
Bh13relu h13y 0 V = max(0, min(15, v(h13lin)))

* h14 input 1 w=-0.089975491938664 w-  bank=n alpha=1 R=370471.254061679 G_phys=2.69926475815992e-06 G_eff=2.69926475815992e-06
Rh14n1n1 in1n h14p 370612.559913703
* h14 input 2 w=-0.0792638889786837 w-  bank=n alpha=1 R=420536.183157725 G_phys=2.37791666936051e-06 G_eff=2.37791666936051e-06
Rh14n2n1 in2n h14p 419049.390640036
* h14 input 3 w=-0.392380373690676 w-  bank=n alpha=1 R=84951.5815987547 G_phys=1.17714112107203e-05 G_eff=1.17714112107203e-05
Rh14n3n1 in3n h14p 85328.9702061317
* h14 input 4 w=+0.471386854681532 w+  bank=n alpha=1 R=70713.3281343902 G_phys=1.4141605640446e-05 G_eff=1.4141605640446e-05
Rh14p4n1 in4 h14p 70498.0167832697
* h14 input 5 w=-0.118903138220599 w-  bank=n alpha=1 R=280340.231823744 G_phys=3.56709414661796e-06 G_eff=3.56709414661796e-06
Rh14n5n1 in5n h14p 281677.736288103
* h14 input 6 w=+0.618408634475196 w+  bank=n alpha=1 R=53901.7915906385 G_phys=1.85522590342559e-05 G_eff=1.85522590342559e-05
Rh14p6n1 in6 h14p 54083.460261703
* h14 input 7 w=-0.0462466843022721 w-  bank=n alpha=1 R=720772.393442608 G_phys=1.38740052906816e-06 G_eff=1.38740052906816e-06
Rh14n7n1 in7n h14p 717207.921294488
* h14 input 8 w=-0.0297824475583231 w-  bank=f alpha=0.001 R=1119.22746671698 G_phys=0.000893473426749692 G_eff=8.93473426749692e-07
Rh14n8f1 tap8n h14p 1116.42452393742
* h14 input 9 w=+0.0766531636417715 w+  bank=n alpha=1 R=434859.198885937 G_phys=2.29959490925314e-06 G_eff=2.29959490925314e-06
Rh14p9n1 in9 h14p 436646.122790374
* h14 input 10 w=-0.0192124865162136 w-  bank=f alpha=0.001 R=1734.98278347277 G_phys=0.000576374595486407 G_eff=5.76374595486407e-07
Rh14n10f1 tap10n h14p 1730.38144048218
* h14 input 11 w=-0.118584174544602 w-  bank=n alpha=1 R=281094.281436313 G_phys=3.55752523633807e-06 G_eff=3.55752523633807e-06
Rh14n11n1 in11n h14p 281603.734357777
* h14 input 12 w=+0.498792575097448 w+  bank=n alpha=1 R=66828.0463613979 G_phys=1.49637772529234e-05 G_eff=1.49637772529234e-05
Rh14p12n1 in12 h14p 66878.9133944661
* h14 input 13 w=+0.131240430694277 w+  bank=n alpha=1 R=253986.771888785 G_phys=3.93721292082832e-06 G_eff=3.93721292082832e-06
Rh14p13n1 in13 h14p 253203.789183341
* h14 input 14 w=-0.699789872634837 w-  bank=n alpha=1 R=47633.346289833 G_phys=2.09936961790451e-05 G_eff=2.09936961790451e-05
Rh14n14n1 in14n h14p 47840.3047203857
* h14 input 15 w=+0.0882030102342884 w+  bank=n alpha=1 R=377916.051218569 G_phys=2.64609030702865e-06 G_eff=2.64609030702865e-06
Rh14p15n1 in15 h14p 378601.254672113
* h14 input 16 w=-0.409062788225599 w-  bank=n alpha=1 R=81487.082894839 G_phys=1.2271883646768e-05 G_eff=1.2271883646768e-05
Rh14n16n1 in16n h14p 81682.9238896758
* h14 bias w+  bank=n alpha=1 R=404190.380335226 G_phys=2.47408164234543e-06 G_eff=2.47408164234543e-06
Rh14bpn1 vref h14p 404241.966047354
* single-copy I-to-V: 0 V sum h14p, I dump onto R_IV=33333.3333333333
Vh14p h14p 0 DC 0
Bh14iv 0 h14lin I = i(Vh14p)
Rh14iv h14lin 0 33193.5005856337
* direct bounded ReLU, no output buffer: y=max(0, min(15, v(h14lin)))
Bh14relu h14y 0 V = max(0, min(15, v(h14lin)))

* h15 input 1 w=-0.104362920527351 w-  bank=n alpha=1 R=319398.241874589 G_phys=3.13088761582053e-06 G_eff=3.13088761582053e-06
Rh15n1n1 in1n h15p 320396.743316941
* h15 input 2 w=+0.0920701784982539 w+  bank=n alpha=1 R=362042.670895501 G_phys=2.76210535494762e-06 G_eff=2.76210535494762e-06
Rh15p2n1 in2 h15p 361242.828134234
* h15 input 3 w=+0.710914651543076 w+  bank=n alpha=1 R=46887.9537944276 G_phys=2.13274395462923e-05 G_eff=2.13274395462923e-05
Rh15p3n1 in3 h15p 46867.8314004828
* h15 input 4 w=+0.0431405504557543 w+  bank=n alpha=1 R=772668.243246468 G_phys=1.29421651367263e-06 G_eff=1.29421651367263e-06
Rh15p4n1 in4 h15p 771219.638398733
* h15 input 5 w=-0.544653793286569 w-  bank=n alpha=1 R=61200.9569091444 G_phys=1.63396137985971e-05 G_eff=1.63396137985971e-05
Rh15n5n1 in5n h15p 61438.7393757385
* h15 input 6 w=+0.236607896967987 w+  bank=n alpha=1 R=140880.054133795 G_phys=7.0982369090396e-06 G_eff=7.0982369090396e-06
Rh15p6n1 in6 h15p 140343.57733071
* h15 input 7 w=+0.205722108048513 w+  bank=n alpha=1 R=162030.875774774 G_phys=6.17166324145539e-06 G_eff=6.17166324145539e-06
Rh15p7n1 in7 h15p 161710.111993531
* h15 input 8 w=+0.119910326826568 w+  bank=n alpha=1 R=277985.509801377 G_phys=3.59730980479705e-06 G_eff=3.59730980479705e-06
Rh15p8n1 in8 h15p 278542.400084659
* h15 input 9 w=-0.0351999996705356 w-  bank=n alpha=1 R=946969.705833129 G_phys=1.05599999011607e-06 G_eff=1.05599999011607e-06
Rh15n9n1 in9n h15p 948365.20410777
* h15 input 10 w=-0.0279846802936883 w-  bank=f alpha=0.001 R=1191.12789510236 G_phys=0.000839540408810648 G_eff=8.39540408810648e-07
Rh15n10f1 tap10n h15p 1196.77809131244
* h15 input 11 w=-0.155672537202176 w-  bank=n alpha=1 R=214124.68719542 G_phys=4.67017611606528e-06 G_eff=4.67017611606528e-06
Rh15n11n1 in11n h15p 213736.317748172
* h15 input 12 w=-0.248740189524738 w-  bank=n alpha=1 R=134008.635263254 G_phys=7.46220568574215e-06 G_eff=7.46220568574215e-06
Rh15n12n1 in12n h15p 133830.83370566
* h15 input 13 w=+0.142944744841187 w+  bank=n alpha=1 R=233190.337779587 G_phys=4.28834234523561e-06 G_eff=4.28834234523561e-06
Rh15p13n1 in13 h15p 232746.921080064
* h15 input 14 w=-0.364164748984914 w-  bank=n alpha=1 R=91533.6627892949 G_phys=1.09249424695474e-05 G_eff=1.09249424695474e-05
Rh15n14n1 in14n h15p 91333.6807581208
* h15 input 15 w=-0.240848341925517 w-  bank=n alpha=1 R=138399.679511357 G_phys=7.22545025776552e-06 G_eff=7.22545025776552e-06
Rh15n15n1 in15n h15p 138779.583819054
* h15 input 16 w=-0.736896288827917 w-  bank=n alpha=1 R=45234.7689066968 G_phys=2.21068886648375e-05 G_eff=2.21068886648375e-05
Rh15n16n1 in16n h15p 45135.3965497537
* h15 bias w+  bank=f alpha=0.001 R=23679.3163125671 G_phys=4.22309490189663e-05 G_eff=4.22309490189663e-08
Rh15bpf1 tapref h15p 23785.1364567173
* single-copy I-to-V: 0 V sum h15p, I dump onto R_IV=33333.3333333333
Vh15p h15p 0 DC 0
Bh15iv 0 h15lin I = i(Vh15p)
Rh15iv h15lin 0 33331.8133104121
* direct bounded ReLU, no output buffer: y=max(0, min(15, v(h15lin)))
Bh15relu h15y 0 V = max(0, min(15, v(h15lin)))

* h16 input 1 w=-0.211528252190937 w-  bank=n alpha=1 R=157583.362922343 G_phys=6.3458475657281e-06 G_eff=6.3458475657281e-06
Rh16n1n1 in1n h16p 157689.919861205
* h16 input 2 w=-0.194947045242045 w-  bank=n alpha=1 R=170986.604551748 G_phys=5.84841135726135e-06 G_eff=5.84841135726135e-06
Rh16n2n1 in2n h16p 170908.961527536
* h16 input 3 w=-0.281660896127353 w-  bank=n alpha=1 R=118345.619827403 G_phys=8.44982688382059e-06 G_eff=8.44982688382059e-06
Rh16n3n1 in3n h16p 118206.996850104
* h16 input 4 w=-0.246854224570453 w-  bank=n alpha=1 R=135032.460519305 G_phys=7.4056267371136e-06 G_eff=7.4056267371136e-06
Rh16n4n1 in4n h16p 134964.545793846
* h16 input 5 w=+0.785179968580328 w+  bank=n alpha=1 R=42453.112238208 G_phys=2.35553990574098e-05 G_eff=2.35553990574098e-05
Rh16p5n1 in5 h16p 42653.3435329556
* h16 input 6 w=-0.342055263707418 w-  bank=n alpha=1 R=97450.1399921314 G_phys=1.02616579112226e-05 G_eff=1.02616579112226e-05
Rh16n6n1 in6n h16p 97502.6872233563
* h16 input 7 w=-0.213390213186068 w-  bank=n alpha=1 R=156208.351056231 G_phys=6.40170639558203e-06 G_eff=6.40170639558203e-06
Rh16n7n1 in7n h16p 156296.432379472
* h16 input 8 w=-0.06183287092446 w-  bank=n alpha=1 R=539087.589415927 G_phys=1.8549861277338e-06 G_eff=1.8549861277338e-06
Rh16n8n1 in8n h16p 537005.646660549
* h16 input 9 w=+0.114369297885863 w+  bank=n alpha=1 R=291453.510247121 G_phys=3.43107893657588e-06 G_eff=3.43107893657588e-06
Rh16p9n1 in9 h16p 291633.845305589
* h16 input 10 w=+0.418702574206734 w+  bank=n alpha=1 R=79611.0064440994 G_phys=1.2561077226202e-05 G_eff=1.2561077226202e-05
Rh16p10n1 in10 h16p 79839.446583458
* h16 input 11 w=-0.38263995973155 w-  bank=n alpha=1 R=87114.0937729534 G_phys=1.14791987919465e-05 G_eff=1.14791987919465e-05
Rh16n11n1 in11n h16p 86727.9486235469
* h16 input 12 w=-0.447982918675276 w-  bank=n alpha=1 R=74407.5989144918 G_phys=1.34394875602583e-05 G_eff=1.34394875602583e-05
Rh16n12n1 in12n h16p 74726.8792194138
* h16 input 13 w=-0.354860709093241 w-  bank=n alpha=1 R=93933.5702126856 G_phys=1.06458212727972e-05 G_eff=1.06458212727972e-05
Rh16n13n1 in13n h16p 94358.1960126083
* h16 input 14 w=-0.245379266072843 w-  bank=n alpha=1 R=135844.131685674 G_phys=7.36137798218528e-06 G_eff=7.36137798218528e-06
Rh16n14n1 in14n h16p 135773.73375607
* h16 input 15 w=-0.0999148922371372 w-  bank=n alpha=1 R=333617.267526249 G_phys=2.99744676711412e-06 G_eff=2.99744676711412e-06
Rh16n15n1 in15n h16p 334132.656504767
* h16 input 16 w=-0.428765175056332 w-  bank=n alpha=1 R=77742.632267077 G_phys=1.286295525169e-05 G_eff=1.286295525169e-05
Rh16n16n1 in16n h16p 78059.2115426227
* h16 bias w+  bank=n alpha=1 R=388758.166916054 G_phys=2.572293227774e-06 G_eff=2.572293227774e-06
Rh16bpn1 vref h16p 387112.301882123
* single-copy I-to-V: 0 V sum h16p, I dump onto R_IV=33333.3333333333
Vh16p h16p 0 DC 0
Bh16iv 0 h16lin I = i(Vh16p)
Rh16iv h16lin 0 33312.9719474036
* direct bounded ReLU, no output buffer: y=max(0, min(15, v(h16lin)))
Bh16relu h16y 0 V = max(0, min(15, v(h16lin)))

* h17 input 1 w=+0.690050155404084 w+  bank=n alpha=1 R=48305.667453714 G_phys=2.07015046621225e-05 G_eff=2.07015046621225e-05
Rh17p1n1 in1 h17p 48069.2249418991
* h17 input 2 w=-0.128803090681736 w-  bank=n alpha=1 R=258792.961852894 G_phys=3.86409272045207e-06 G_eff=3.86409272045207e-06
Rh17n2n1 in2n h17p 259693.204674471
* h17 input 3 w=-0.49836012605351 w-  bank=n alpha=1 R=66886.036002315 G_phys=1.49508037816053e-05 G_eff=1.49508037816053e-05
Rh17n3n1 in3n h17p 66852.278673228
* h17 input 4 w=-0.0597081457071854 w-  bank=n alpha=1 R=558271.119267432 G_phys=1.79124437121556e-06 G_eff=1.79124437121556e-06
Rh17n4n1 in4n h17p 556380.418703203
* h17 input 5 w=+0.0531710366485299 w+  bank=n alpha=1 R=626907.71958562 G_phys=1.5951310994559e-06 G_eff=1.5951310994559e-06
Rh17p5n1 in5 h17p 626171.010631352
* h17 input 6 w=+0.325686197829899 w+  bank=n alpha=1 R=102348.007239603 G_phys=9.77058593489698e-06 G_eff=9.77058593489698e-06
Rh17p6n1 in6 h17p 101908.214176935
* h17 input 7 w=-0.138446110206034 w-  bank=n alpha=1 R=240767.568577601 G_phys=4.15338330618101e-06 G_eff=4.15338330618101e-06
Rh17n7n1 in7n h17p 239823.09657535
* h17 input 8 w=-0.354640771144099 w-  bank=n alpha=1 R=93991.8250961316 G_phys=1.0639223134323e-05 G_eff=1.0639223134323e-05
Rh17n8n1 in8n h17p 93616.4890097601
* h17 input 9 w=+0.283153126675736 w+  bank=n alpha=1 R=117721.932738911 G_phys=8.49459380027208e-06 G_eff=8.49459380027208e-06
Rh17p9n1 in9 h17p 118186.939423192
* h17 input 10 w=+0.187509087652136 w+  bank=n alpha=1 R=177769.161754831 G_phys=5.62527262956408e-06 G_eff=5.62527262956408e-06
Rh17p10n1 in10 h17p 177980.269707732
* h17 input 11 w=+0.286891884918939 w+  bank=n alpha=1 R=116187.78740553 G_phys=8.60675654756817e-06 G_eff=8.60675654756817e-06
Rh17p11n1 in11 h17p 116545.009925211
* h17 input 12 w=-0.663420236101193 w-  bank=n alpha=1 R=50244.6737670041 G_phys=1.99026070830358e-05 G_eff=1.99026070830358e-05
Rh17n12n1 in12n h17p 50064.0932738134
* h17 input 13 w=-0.00672050178940724 w-  bank=f alpha=0.001 R=4959.94709589586 G_phys=0.000201615053682217 G_eff=2.01615053682217e-07
Rh17n13f1 tap13n h17p 4977.49827994898
* h17 input 14 w=+0.213870810385993 w+  bank=n alpha=1 R=155857.32935305 G_phys=6.41612431157979e-06 G_eff=6.41612431157979e-06
Rh17p14n1 in14 h17p 155983.568150795
* h17 input 15 w=+0.856655380645102 w+  bank=n alpha=1 R=38911.0184637278 G_phys=2.56996614193531e-05 G_eff=2.56996614193531e-05
Rh17p15n1 in15 h17p 39079.239389025
* h17 input 16 w=-0.153994690926048 w-  bank=n alpha=1 R=216457.6787218 G_phys=4.61984072778143e-06 G_eff=4.61984072778143e-06
Rh17n16n1 in16n h17p 215937.17531492
* h17 bias w+  bank=n alpha=1 R=358017.249275869 G_phys=2.79316150834244e-06 G_eff=2.79316150834244e-06
Rh17bpn1 vref h17p 358811.339796193
* single-copy I-to-V: 0 V sum h17p, I dump onto R_IV=33333.3333333333
Vh17p h17p 0 DC 0
Bh17iv 0 h17lin I = i(Vh17p)
Rh17iv h17lin 0 33348.7460877643
* direct bounded ReLU, no output buffer: y=max(0, min(15, v(h17lin)))
Bh17relu h17y 0 V = max(0, min(15, v(h17lin)))

* h18 input 1 w=+0.00309692999044255 w+  bank=f alpha=0.001 R=10763.3473911917 G_phys=9.29078997132766e-05 G_eff=9.29078997132766e-08
Rh18p1f1 tap1 h18p 10745.9461978742
* h18 input 2 w=-0.290006429631547 w-  bank=n alpha=1 R=114939.98038486 G_phys=8.70019288894641e-06 G_eff=8.70019288894641e-06
Rh18n2n1 in2n h18p 114379.415122091
* h18 input 3 w=+0.161902441115013 w+  bank=n alpha=1 R=205885.304160755 G_phys=4.8570732334504e-06 G_eff=4.8570732334504e-06
Rh18p3n1 in3 h18p 205830.364428497
* h18 input 4 w=-0.201165440039706 w-  bank=n alpha=1 R=165701.093223339 G_phys=6.03496320119118e-06 G_eff=6.03496320119118e-06
Rh18n4n1 in4n h18p 166183.281438665
* h18 input 5 w=+0.167521926893116 w+  bank=n alpha=1 R=198978.927424831 G_phys=5.02565780679349e-06 G_eff=5.02565780679349e-06
Rh18p5n1 in5 h18p 198961.738024121
* h18 input 6 w=+0.306365656745506 w+  bank=n alpha=1 R=108802.447661498 G_phys=9.19096970236517e-06 G_eff=9.19096970236517e-06
Rh18p6n1 in6 h18p 108716.052905618
* h18 input 7 w=+0.567135277617062 w+  bank=n alpha=1 R=58774.9248704654 G_phys=1.70140583285119e-05 G_eff=1.70140583285119e-05
Rh18p7n1 in7 h18p 58579.7586240319
* h18 input 8 w=+0.27754647202065 w+  bank=n alpha=1 R=120100.007363283 G_phys=8.3263941606195e-06 G_eff=8.3263941606195e-06
Rh18p8n1 in8 h18p 120680.012709131
* h18 input 9 w=-0.295299170614896 w-  bank=n alpha=1 R=112879.874548662 G_phys=8.85897511844687e-06 G_eff=8.85897511844687e-06
Rh18n9n1 in9n h18p 113264.442475085
* h18 input 10 w=+0.627786354607437 w+  bank=n alpha=1 R=53096.6197157584 G_phys=1.88335906382231e-05 G_eff=1.88335906382231e-05
Rh18p10n1 in10 h18p 53349.5507175713
* h18 input 11 w=+0.158870042328046 w+  bank=n alpha=1 R=209815.09694889 G_phys=4.76610126984139e-06 G_eff=4.76610126984139e-06
Rh18p11n1 in11 h18p 209128.580117625
* h18 input 12 w=+0.503831351799562 w+  bank=n alpha=1 R=66159.704461175 G_phys=1.51149405539869e-05 G_eff=1.51149405539869e-05
Rh18p12n1 in12 h18p 66051.5438322652
* h18 input 13 w=+0.0259448474340262 w+  bank=f alpha=0.001 R=1284.77661771166 G_phys=0.000778345423020786 G_eff=7.78345423020786e-07
Rh18p13f1 tap13 h18p 1288.78333044137
* h18 input 14 w=-0.0445667146819355 w-  bank=n alpha=1 R=747942.350501428 G_phys=1.33700144045806e-06 G_eff=1.33700144045806e-06
Rh18n14n1 in14n h18p 748188.890420947
* h18 input 15 w=-0.425048584977393 w-  bank=n alpha=1 R=78422.4074880905 G_phys=1.27514575493218e-05 G_eff=1.27514575493218e-05
Rh18n15n1 in15n h18p 78743.5541164747
* h18 input 16 w=-0.290071708244206 w-  bank=n alpha=1 R=114914.113944786 G_phys=8.70215124732617e-06 G_eff=8.70215124732617e-06
Rh18n16n1 in16n h18p 114770.976989818
* h18 bias w+  bank=n alpha=1 R=322935.946819115 G_phys=3.09658930772463e-06 G_eff=3.09658930772463e-06
Rh18bpn1 vref h18p 321951.919216463
* single-copy I-to-V: 0 V sum h18p, I dump onto R_IV=33333.3333333333
Vh18p h18p 0 DC 0
Bh18iv 0 h18lin I = i(Vh18p)
Rh18iv h18lin 0 33486.4917863819
* direct bounded ReLU, no output buffer: y=max(0, min(15, v(h18lin)))
Bh18relu h18y 0 V = max(0, min(15, v(h18lin)))

* h19 input 1 w=+0.361917529899694 w+  bank=n alpha=1 R=92102.0138001377 G_phys=1.08575258969908e-05 G_eff=1.08575258969908e-05
Rh19p1n1 in1 h19p 92075.2753325573
* h19 input 2 w=+0.460196491117441 w+  bank=n alpha=1 R=72432.8281000013 G_phys=1.38058947335232e-05 G_eff=1.38058947335232e-05
Rh19p2n1 in2 h19p 72635.1601599205
* h19 input 3 w=+0.284766719035728 w+  bank=n alpha=1 R=117054.877220927 G_phys=8.54300157107185e-06 G_eff=8.54300157107185e-06
Rh19p3n1 in3 h19p 116875.197297789
* h19 input 4 w=-0.664899666016021 w-  bank=n alpha=1 R=50132.8772400529 G_phys=1.99469899804806e-05 G_eff=1.99469899804806e-05
Rh19n4n1 in4n h19p 50017.0974621609
* h19 input 5 w=+0.507213486118456 w+  bank=n alpha=1 R=65718.5470134534 G_phys=1.52164045835537e-05 G_eff=1.52164045835537e-05
Rh19p5n1 in5 h19p 65668.4937150539
* h19 input 6 w=+0.130688397719858 w+  bank=n alpha=1 R=255059.622085094 G_phys=3.92065193159573e-06 G_eff=3.92065193159573e-06
Rh19p6n1 in6 h19p 254596.408641636
* h19 input 7 w=+0.0897047942241856 w+  bank=n alpha=1 R=371589.206815729 G_phys=2.69114382672557e-06 G_eff=2.69114382672557e-06
Rh19p7n1 in7 h19p 371122.083144193
* h19 input 8 w=+0.0897866911799249 w+  bank=n alpha=1 R=371250.269892853 G_phys=2.69360073539775e-06 G_eff=2.69360073539775e-06
Rh19p8n1 in8 h19p 371038.762492867
* h19 input 9 w=-0.272382660879323 w-  bank=n alpha=1 R=122376.854773812 G_phys=8.17147982637969e-06 G_eff=8.17147982637969e-06
Rh19n9n1 in9n h19p 122628.104042599
* h19 input 10 w=+0.0908546616405757 w+  bank=n alpha=1 R=366886.329566679 G_phys=2.72563984921727e-06 G_eff=2.72563984921727e-06
Rh19p10n1 in10 h19p 365228.849648653
* h19 input 11 w=-0.0411180740799587 w-  bank=n alpha=1 R=810673.507434053 G_phys=1.23354222239876e-06 G_eff=1.23354222239876e-06
Rh19n11n1 in11n h19p 812614.523547368
* h19 input 12 w=-0.14910928160707 w-  bank=n alpha=1 R=223549.687679219 G_phys=4.47327844821211e-06 G_eff=4.47327844821211e-06
Rh19n12n1 in12n h19p 224082.614961998
* h19 input 13 w=-0.0351824330179761 w-  bank=n alpha=1 R=947442.529523243 G_phys=1.05547299053928e-06 G_eff=1.05547299053928e-06
Rh19n13n1 in13n h19p 948039.871683067
* h19 input 14 w=+0.491588757414346 w+  bank=n alpha=1 R=67807.3548887889 G_phys=1.47476627224304e-05 G_eff=1.47476627224304e-05
Rh19p14n1 in14 h19p 67794.3516058707
* h19 input 15 w=-0.0385925197286318 w-  bank=n alpha=1 R=863725.239184197 G_phys=1.15777559185895e-06 G_eff=1.15777559185895e-06
Rh19n15n1 in15n h19p 865076.828119928
* h19 input 16 w=-0.690622583753164 w-  bank=n alpha=1 R=48265.628894127 G_phys=2.07186775125949e-05 G_eff=2.07186775125949e-05
Rh19n16n1 in16n h19p 48173.5937645663
* h19 bias w+  bank=f alpha=0.001 R=1659.50290630424 G_phys=0.000602590086586248 G_eff=6.02590086586248e-07
Rh19bpf1 tapref h19p 1655.9089987732
* single-copy I-to-V: 0 V sum h19p, I dump onto R_IV=33333.3333333333
Vh19p h19p 0 DC 0
Bh19iv 0 h19lin I = i(Vh19p)
Rh19iv h19lin 0 33177.86913758
* direct bounded ReLU, no output buffer: y=max(0, min(15, v(h19lin)))
Bh19relu h19y 0 V = max(0, min(15, v(h19lin)))

* h20 input 1 w=-0.0810043123301717 w-  bank=n alpha=1 R=411500.72600416 G_phys=2.43012936990515e-06 G_eff=2.43012936990515e-06
Rh20n1n1 in1n h20p 410372.115513917
* h20 input 2 w=+0.646296718361532 w+  bank=n alpha=1 R=51575.8975503369 G_phys=1.9388901550846e-05 G_eff=1.9388901550846e-05
Rh20p2n1 in2 h20p 51806.1794093412
* h20 input 3 w=-0.000929252010170944 w-  bank=f alpha=0.001 R=35871.1447147705 G_phys=2.78775603051283e-05 G_eff=2.78775603051283e-08
Rh20n3f1 tap3n h20p 35876.6391769524
* h20 input 4 w=+0.269987692172837 w+  bank=n alpha=1 R=123462.418101617 G_phys=8.09963076518511e-06 G_eff=8.09963076518511e-06
Rh20p4n1 in4 h20p 122963.608911249
* h20 input 5 w=+0.140155013181344 w+  bank=n alpha=1 R=237831.901811489 G_phys=4.20465039544031e-06 G_eff=4.20465039544031e-06
Rh20p5n1 in5 h20p 237489.508452217
* h20 input 6 w=+0.15481044132605 w+  bank=n alpha=1 R=215317.087451028 G_phys=4.6443132397815e-06 G_eff=4.6443132397815e-06
Rh20p6n1 in6 h20p 216355.169676441
* h20 input 7 w=-0.803119096824844 w-  bank=n alpha=1 R=41504.8446302892 G_phys=2.40935729047453e-05 G_eff=2.40935729047453e-05
Rh20n7n1 in7n h20p 41632.417754144
* h20 input 8 w=+0.12095822380885 w+  bank=n alpha=1 R=275577.238849092 G_phys=3.62874671426549e-06 G_eff=3.62874671426549e-06
Rh20p8n1 in8 h20p 276453.681172951
* h20 input 9 w=+0.307944073046154 w+  bank=n alpha=1 R=108244.763419549 G_phys=9.23832219138461e-06 G_eff=9.23832219138461e-06
Rh20p9n1 in9 h20p 108557.855102743
* h20 input 10 w=+0.100067069291622 w+  bank=n alpha=1 R=333109.918870425 G_phys=3.00201207874865e-06 G_eff=3.00201207874865e-06
Rh20p10n1 in10 h20p 334516.869405438
* h20 input 11 w=+0.376050768766317 w+  bank=n alpha=1 R=88640.513733525 G_phys=1.12815230629895e-05 G_eff=1.12815230629895e-05
Rh20p11n1 in11 h20p 89062.0940489022
* h20 input 12 w=-0.859853426992325 w-  bank=n alpha=1 R=38766.2970070722 G_phys=2.57956028097698e-05 G_eff=2.57956028097698e-05
Rh20n12n1 in12n h20p 38743.439703316
* h20 input 13 w=+0.0677970111280841 w+  bank=n alpha=1 R=491663.758898737 G_phys=2.03391033384252e-06 G_eff=2.03391033384252e-06
Rh20p13n1 in13 h20p 493312.923099553
* h20 input 14 w=-0.43012675419833 w-  bank=n alpha=1 R=77496.5356327578 G_phys=1.29038026259499e-05 G_eff=1.29038026259499e-05
Rh20n14n1 in14n h20p 77830.8003911819
* h20 input 15 w=-0.0800571778528839 w-  bank=n alpha=1 R=416369.078043045 G_phys=2.40171533558652e-06 G_eff=2.40171533558652e-06
Rh20n15n1 in15n h20p 416234.514305622
* h20 input 16 w=-0.127529601563162 w-  bank=n alpha=1 R=261377.224775726 G_phys=3.82588804689485e-06 G_eff=3.82588804689485e-06
Rh20n16n1 in16n h20p 261335.501288552
* h20 bias w+  bank=f alpha=0.001 R=1236.06584989005 G_phys=0.000809018386915995 G_eff=8.09018386915995e-07
Rh20bpf1 tapref h20p 1241.98681865793
* single-copy I-to-V: 0 V sum h20p, I dump onto R_IV=33333.3333333333
Vh20p h20p 0 DC 0
Bh20iv 0 h20lin I = i(Vh20p)
Rh20iv h20lin 0 33461.2465938308
* direct bounded ReLU, no output buffer: y=max(0, min(15, v(h20lin)))
Bh20relu h20y 0 V = max(0, min(15, v(h20lin)))

* h21 input 1 w=-0.00681344895090886 w-  bank=f alpha=0.001 R=4892.28488736045 G_phys=0.000204403468527266 G_eff=2.04403468527266e-07
Rh21n1f1 tap1n h21p 4880.81355864785
* h21 input 2 w=+0.17215275761211 w+  bank=n alpha=1 R=193626.484964238 G_phys=5.1645827283633e-06 G_eff=5.1645827283633e-06
Rh21p2n1 in2 h21p 194061.353937602
* h21 input 3 w=-0.241244992284912 w-  bank=n alpha=1 R=138172.12542993 G_phys=7.23734976854735e-06 G_eff=7.23734976854735e-06
Rh21n3n1 in3n h21p 138618.125260759
* h21 input 4 w=-0.253516997925259 w-  bank=n alpha=1 R=131483.622818698 G_phys=7.60550993775776e-06 G_eff=7.60550993775776e-06
Rh21n4n1 in4n h21p 132012.950874498
* h21 input 5 w=+0.732528033504134 w+  bank=n alpha=1 R=45504.515607245 G_phys=2.1975841005124e-05 G_eff=2.1975841005124e-05
Rh21p5n1 in5 h21p 45672.0930400349
* h21 input 6 w=-0.335745026911547 w-  bank=n alpha=1 R=99281.6889648676 G_phys=1.00723508073464e-05 G_eff=1.00723508073464e-05
Rh21n6n1 in6n h21p 99738.7511854974
* h21 input 7 w=-0.133397447206163 w-  bank=n alpha=1 R=249879.844265815 G_phys=4.00192341618489e-06 G_eff=4.00192341618489e-06
Rh21n7n1 in7n h21p 249137.075854177
* h21 input 8 w=-0.602502751086194 w-  bank=n alpha=1 R=55324.7819586548 G_phys=1.80750825325858e-05 G_eff=1.80750825325858e-05
Rh21n8n1 in8n h21p 55390.6011790036
* h21 input 9 w=-0.464313715662176 w-  bank=n alpha=1 R=71790.5420601142 G_phys=1.39294114698653e-05 G_eff=1.39294114698653e-05
Rh21n9n1 in9n h21p 72126.9353567532
* h21 input 10 w=+0.0220606443883595 w+  bank=f alpha=0.001 R=1510.98638582479 G_phys=0.000661819331650786 G_eff=6.61819331650786e-07
Rh21p10f1 tap10 h21p 1517.97635511747
* h21 input 11 w=+0.293613135845564 w+  bank=n alpha=1 R=113528.072364127 G_phys=8.80839407536691e-06 G_eff=8.80839407536691e-06
Rh21p11n1 in11 h21p 113859.17399038
* h21 input 12 w=+0.585788543436 w+  bank=n alpha=1 R=56903.3548143728 G_phys=1.757365630308e-05 G_eff=1.757365630308e-05
Rh21p12n1 in12 h21p 57039.3611382263
* h21 input 13 w=-0.255400978522459 w-  bank=n alpha=1 R=130513.726009089 G_phys=7.66202935567376e-06 G_eff=7.66202935567376e-06
Rh21n13n1 in13n h21p 130367.266446555
* h21 input 14 w=+0.15251581562556 w+  bank=n alpha=1 R=218556.568685111 G_phys=4.57547446876679e-06 G_eff=4.57547446876679e-06
Rh21p14n1 in14 h21p 218055.580106325
* h21 input 15 w=-0.610279514665944 w-  bank=n alpha=1 R=54619.7808254787 G_phys=1.83083854399783e-05 G_eff=1.83083854399783e-05
Rh21n15n1 in15n h21p 54637.123760553
* h21 input 16 w=+0.0580238118020399 w+  bank=n alpha=1 R=574476.793200985 G_phys=1.7407143540612e-06 G_eff=1.7407143540612e-06
Rh21p16n1 in16 h21p 572812.889503117
* h21 bias w-  bank=f alpha=0.001 R=5534.66769609038 G_phys=0.00018067932076688 G_eff=1.8067932076688e-07
Rh21bnf1 taprefn h21p 5552.06451857867
* single-copy I-to-V: 0 V sum h21p, I dump onto R_IV=33333.3333333333
Vh21p h21p 0 DC 0
Bh21iv 0 h21lin I = i(Vh21p)
Rh21iv h21lin 0 33167.6357443739
* direct bounded ReLU, no output buffer: y=max(0, min(15, v(h21lin)))
Bh21relu h21y 0 V = max(0, min(15, v(h21lin)))

* h22 input 1 w=+0.733134048211177 w+  bank=n alpha=1 R=45466.901195853 G_phys=2.19940214463353e-05 G_eff=2.19940214463353e-05
Rh22p1n1 in1 h22p 45321.1428498188
* h22 input 2 w=-0.468945077984231 w-  bank=n alpha=1 R=71081.5293693183 G_phys=1.40683523395269e-05 G_eff=1.40683523395269e-05
Rh22n2n1 in2n h22p 70982.4825331934
* h22 input 3 w=+0.0425168801269381 w+  bank=n alpha=1 R=784002.335867861 G_phys=1.27550640380814e-06 G_eff=1.27550640380814e-06
Rh22p3n1 in3 h22p 782802.275447005
* h22 input 4 w=-0.440513463519883 w-  bank=n alpha=1 R=75669.2725506874 G_phys=1.32154039055965e-05 G_eff=1.32154039055965e-05
Rh22n4n1 in4n h22p 75964.260039009
* h22 input 5 w=+0.139436850403416 w+  bank=n alpha=1 R=239056.843559604 G_phys=4.18310551210248e-06 G_eff=4.18310551210248e-06
Rh22p5n1 in5 h22p 239201.832316882
* h22 input 6 w=-0.216633688080034 w-  bank=n alpha=1 R=153869.574158838 G_phys=6.49901064240101e-06 G_eff=6.49901064240101e-06
Rh22n6n1 in6n h22p 153867.389396291
* h22 input 7 w=+0.3413541130964 w+  bank=n alpha=1 R=97650.305224006 G_phys=1.0240623392892e-05 G_eff=1.0240623392892e-05
Rh22p7n1 in7 h22p 97624.5452530757
* h22 input 8 w=+0.375494249585175 w+  bank=n alpha=1 R=88771.88763918 G_phys=1.12648274875552e-05 G_eff=1.12648274875552e-05
Rh22p8n1 in8 h22p 89000.0494185615
* h22 input 9 w=-0.0598723775607 w-  bank=n alpha=1 R=556739.763667131 G_phys=1.796171326821e-06 G_eff=1.796171326821e-06
Rh22n9n1 in9n h22p 554436.790155905
* h22 input 10 w=-0.886177024526985 w-  bank=n alpha=1 R=37614.7568835083 G_phys=2.65853107358095e-05 G_eff=2.65853107358095e-05
Rh22n10n1 in10n h22p 37496.9745196385
* h22 input 11 w=-0.158397755226926 w-  bank=n alpha=1 R=210440.692707917 G_phys=4.75193265680777e-06 G_eff=4.75193265680777e-06
Rh22n11n1 in11n h22p 210102.434930707
* h22 input 12 w=+0.00642379373490928 w+  bank=f alpha=0.001 R=5189.04166430307 G_phys=0.000192713812047279 G_eff=1.92713812047279e-07
Rh22p12f1 tap12 h22p 5206.0428604323
* h22 input 13 w=+0.483338726494796 w+  bank=n alpha=1 R=68964.7477144421 G_phys=1.45001617948439e-05 G_eff=1.45001617948439e-05
Rh22p13n1 in13 h22p 69196.8809128733
* h22 input 14 w=+0.995892890290009 w+  bank=n alpha=1 R=33470.8015875347 G_phys=2.98767867087003e-05 G_eff=2.98767867087003e-05
Rh22p14n1 in14 h22p 33615.7864476022
* h22 input 15 w=-0.0635579626600016 w-  bank=n alpha=1 R=524455.661230796 G_phys=1.90673887980005e-06 G_eff=1.90673887980005e-06
Rh22n15n1 in15n h22p 523993.532122937
* h22 input 16 w=+0.143429643183018 w+  bank=n alpha=1 R=232401.981860887 G_phys=4.30288929549054e-06 G_eff=4.30288929549054e-06
Rh22p16n1 in16 h22p 232634.259421118
* h22 bias w+  bank=f alpha=0.001 R=8748.48537925215 G_phys=0.000114305500512305 G_eff=1.14305500512305e-07
Rh22bpf1 tapref h22p 8777.9578321089
* single-copy I-to-V: 0 V sum h22p, I dump onto R_IV=33333.3333333333
Vh22p h22p 0 DC 0
Bh22iv 0 h22lin I = i(Vh22p)
Rh22iv h22lin 0 33323.2829283016
* direct bounded ReLU, no output buffer: y=max(0, min(15, v(h22lin)))
Bh22relu h22y 0 V = max(0, min(15, v(h22lin)))

* h23 input 1 w=-0.311855168471888 w-  bank=n alpha=1 R=106887.224273592 G_phys=9.35565505415663e-06 G_eff=9.35565505415663e-06
Rh23n1n1 in1n h23p 107128.872477462
* h23 input 2 w=-0.519305850985266 w-  bank=n alpha=1 R=64188.2491215741 G_phys=1.5579175529558e-05 G_eff=1.5579175529558e-05
Rh23n2n1 in2n h23p 64245.0856362598
* h23 input 3 w=+0.0590711076347425 w+  bank=n alpha=1 R=564291.659121157 G_phys=1.77213322904228e-06 G_eff=1.77213322904228e-06
Rh23p3n1 in3 h23p 566198.444152757
* h23 input 4 w=-0.153433475387477 w-  bank=n alpha=1 R=217249.418675776 G_phys=4.60300426162431e-06 G_eff=4.60300426162431e-06
Rh23n4n1 in4n h23p 216982.334241307
* h23 input 5 w=+0.565735693190981 w+  bank=n alpha=1 R=58920.3292889647 G_phys=1.69720707957294e-05 G_eff=1.69720707957294e-05
Rh23p5n1 in5 h23p 59158.0486231571
* h23 input 6 w=-0.371646754353268 w-  bank=n alpha=1 R=89690.90391046 G_phys=1.1149402630598e-05 G_eff=1.1149402630598e-05
Rh23n6n1 in6n h23p 89273.101099054
* h23 input 7 w=-0.111660278324499 w-  bank=n alpha=1 R=298524.540987283 G_phys=3.34980834973497e-06 G_eff=3.34980834973497e-06
Rh23n7n1 in7n h23p 299480.90986723
* h23 input 8 w=+0.496809212320021 w+  bank=n alpha=1 R=67094.8374279775 G_phys=1.49042763696006e-05 G_eff=1.49042763696006e-05
Rh23p8n1 in8 h23p 67004.5345402537
* h23 input 9 w=-0.177241184436762 w-  bank=n alpha=1 R=188067.65165365 G_phys=5.31723553310286e-06 G_eff=5.31723553310286e-06
Rh23n9n1 in9n h23p 188567.247190595
* h23 input 10 w=-0.405292848695184 w-  bank=n alpha=1 R=82245.0567303322 G_phys=1.21587854608555e-05 G_eff=1.21587854608555e-05
Rh23n10n1 in10n h23p 82624.0178167232
* h23 input 11 w=-0.16052467280172 w-  bank=n alpha=1 R=207652.398547522 G_phys=4.81574018405159e-06 G_eff=4.81574018405159e-06
Rh23n11n1 in11n h23p 208474.490286761
* h23 input 12 w=+0.846508036935069 w+  bank=n alpha=1 R=39377.4564196963 G_phys=2.53952411080521e-05 G_eff=2.53952411080521e-05
Rh23p12n1 in12 h23p 39251.5412081868
* h23 input 13 w=-0.0538311215013525 w-  bank=n alpha=1 R=619220.488142641 G_phys=1.61493364504058e-06 G_eff=1.61493364504058e-06
Rh23n13n1 in13n h23p 619677.341820292
* h23 input 14 w=+0.31071243911676 w+  bank=n alpha=1 R=107280.331061375 G_phys=9.3213731735028e-06 G_eff=9.3213731735028e-06
Rh23p14n1 in14 h23p 106814.879452384
* h23 input 15 w=+0.331311012578656 w+  bank=n alpha=1 R=100610.399497118 G_phys=9.93933037735967e-06 G_eff=9.93933037735967e-06
Rh23p15n1 in15 h23p 100393.031842431
* h23 input 16 w=-0.486368816876819 w-  bank=n alpha=1 R=68535.0955420638 G_phys=1.45910645063046e-05 G_eff=1.45910645063046e-05
Rh23n16n1 in16n h23p 68408.4905152014
* h23 bias w-  bank=n alpha=1 R=642782.148246781 G_phys=1.55573704516771e-06 G_eff=1.55573704516771e-06
Rh23bnn1 vrefn h23p 641361.875471521
* single-copy I-to-V: 0 V sum h23p, I dump onto R_IV=33333.3333333333
Vh23p h23p 0 DC 0
Bh23iv 0 h23lin I = i(Vh23p)
Rh23iv h23lin 0 33178.0682824738
* direct bounded ReLU, no output buffer: y=max(0, min(15, v(h23lin)))
Bh23relu h23y 0 V = max(0, min(15, v(h23lin)))

* h24 input 1 w=+0.61389120350986 w+  bank=n alpha=1 R=54298.4378058415 G_phys=1.84167361052958e-05 G_eff=1.84167361052958e-05
Rh24p1n1 in1 h24p 54404.8593806057
* h24 input 2 w=-0.0429199313830527 w-  bank=n alpha=1 R=776639.949300928 G_phys=1.28759794149158e-06 G_eff=1.28759794149158e-06
Rh24n2n1 in2n h24p 773220.726693948
* h24 input 3 w=-0.014915873427812 w-  bank=f alpha=0.001 R=2234.75571140073 G_phys=0.000447476202834361 G_eff=4.47476202834361e-07
Rh24n3f1 tap3n h24p 2228.83443519552
* h24 input 4 w=-0.169036355792668 w-  bank=n alpha=1 R=197196.237324345 G_phys=5.07109067378003e-06 G_eff=5.07109067378003e-06
Rh24n4n1 in4n h24p 196851.896904698
* h24 input 5 w=-0.510336523880732 w-  bank=n alpha=1 R=65316.378063357 G_phys=1.5310095716422e-05 G_eff=1.5310095716422e-05
Rh24n5n1 in5n h24p 65154.5004856448
* h24 input 6 w=-0.303361656916169 w-  bank=n alpha=1 R=109879.849919678 G_phys=9.10084970748506e-06 G_eff=9.10084970748506e-06
Rh24n6n1 in6n h24p 109811.168628978
* h24 input 7 w=-0.0292327970624363 w-  bank=f alpha=0.001 R=1140.27177290422 G_phys=0.000876983911873088 G_eff=8.76983911873088e-07
Rh24n7f1 tap7n h24p 1138.22220891268
* h24 input 8 w=-0.329334996951297 w-  bank=n alpha=1 R=101214.063618823 G_phys=9.88004990853891e-06 G_eff=9.88004990853891e-06
Rh24n8n1 in8n h24p 101255.070965641
* h24 input 9 w=+0.0109599477370603 w+  bank=f alpha=0.001 R=3041.37703326988 G_phys=0.000328798432111809 G_eff=3.28798432111809e-07
Rh24p9f1 tap9 h24p 3042.49472173886
* h24 input 10 w=+0.0571459019805778 w+  bank=n alpha=1 R=583302.252271078 G_phys=1.71437705941734e-06 G_eff=1.71437705941734e-06
Rh24p10n1 in10 h24p 580958.783383849
* h24 input 11 w=+0.243568584743939 w+  bank=n alpha=1 R=136853.992760915 G_phys=7.30705754231816e-06 G_eff=7.30705754231816e-06
Rh24p11n1 in11 h24p 137398.956321159
* h24 input 12 w=-0.323004255102081 w-  bank=n alpha=1 R=103197.814910515 G_phys=9.69012765306243e-06 G_eff=9.69012765306243e-06
Rh24n12n1 in12n h24p 102703.906234706
* h24 input 13 w=+0.243938800887145 w+  bank=n alpha=1 R=136646.294939994 G_phys=7.31816402661434e-06 G_eff=7.31816402661434e-06
Rh24p13n1 in13 h24p 136199.899214419
* h24 input 14 w=+0.0840399613598874 w+  bank=n alpha=1 R=396636.704657547 G_phys=2.52119884079662e-06 G_eff=2.52119884079662e-06
Rh24p14n1 in14 h24p 396993.631032685
* h24 input 15 w=-0.352451854106752 w-  bank=n alpha=1 R=94575.5652720646 G_phys=1.05735556232026e-05 G_eff=1.05735556232026e-05
Rh24n15n1 in15n h24p 94718.5828123423
* h24 input 16 w=+0.406056698737055 w+  bank=n alpha=1 R=82090.3421542089 G_phys=1.21817009621116e-05 G_eff=1.21817009621116e-05
Rh24p16n1 in16 h24p 81753.640107643
* h24 bias w+  bank=f alpha=0.001 R=1792.9894089827 G_phys=0.000557727778530147 G_eff=5.57727778530147e-07
Rh24bpf1 tapref h24p 1795.49396643997
* single-copy I-to-V: 0 V sum h24p, I dump onto R_IV=33333.3333333333
Vh24p h24p 0 DC 0
Bh24iv 0 h24lin I = i(Vh24p)
Rh24iv h24lin 0 33358.5552246626
* direct bounded ReLU, no output buffer: y=max(0, min(15, v(h24lin)))
Bh24relu h24y 0 V = max(0, min(15, v(h24lin)))

* h25 input 1 w=-0.507226781565224 w-  bank=n alpha=1 R=65716.824396519 G_phys=1.52168034469567e-05 G_eff=1.52168034469567e-05
Rh25n1n1 in1n h25p 65483.4524808053
* h25 input 2 w=-0.323616844242374 w-  bank=n alpha=1 R=103002.467042068 G_phys=9.70850532727122e-06 G_eff=9.70850532727122e-06
Rh25n2n1 in2n h25p 103316.789518234
* h25 input 3 w=+0.251581142719107 w+  bank=n alpha=1 R=132495.35705683 G_phys=7.5474342815732e-06 G_eff=7.5474342815732e-06
Rh25p3n1 in3 h25p 132614.691004615
* h25 input 4 w=+0.0279414599016099 w+  bank=f alpha=0.001 R=1192.97035483149 G_phys=0.000838243797048297 G_eff=8.38243797048297e-07
Rh25p4f1 tap4 h25p 1188.3033308773
* h25 input 5 w=+0.310516223746861 w+  bank=n alpha=1 R=107348.121560654 G_phys=9.31548671240582e-06 G_eff=9.31548671240582e-06
Rh25p5n1 in5 h25p 107704.029779932
* h25 input 6 w=-0.583310440311788 w-  bank=n alpha=1 R=57145.0998125736 G_phys=1.74993132093536e-05 G_eff=1.74993132093536e-05
Rh25n6n1 in6n h25p 57351.1038346937
* h25 input 7 w=-0.128366308561082 w-  bank=n alpha=1 R=259673.536670037 G_phys=3.85098925683245e-06 G_eff=3.85098925683245e-06
Rh25n7n1 in7n h25p 259804.269387158
* h25 input 8 w=-0.237966635841971 w-  bank=n alpha=1 R=140075.658990571 G_phys=7.13899907525912e-06 G_eff=7.13899907525912e-06
Rh25n8n1 in8n h25p 140202.477842021
* h25 input 9 w=+0.869293927250567 w+  bank=n alpha=1 R=38345.2964393311 G_phys=2.6078817817517e-05 G_eff=2.6078817817517e-05
Rh25p9n1 in9 h25p 38392.6645301811
* h25 input 10 w=-0.700407093798758 w-  bank=n alpha=1 R=47591.3702594662 G_phys=2.10122128139627e-05 G_eff=2.10122128139627e-05
Rh25n10n1 in10n h25p 47370.8039410659
* h25 input 11 w=+0.176416664646434 w+  bank=n alpha=1 R=188946.624742841 G_phys=5.29249993939301e-06 G_eff=5.29249993939301e-06
Rh25p11n1 in11 h25p 188318.50356537
* h25 input 12 w=+0.165054591787149 w+  bank=n alpha=1 R=201953.383861743 G_phys=4.95163775361447e-06 G_eff=4.95163775361447e-06
Rh25p12n1 in12 h25p 202448.974129962
* h25 input 13 w=+0.414882742059982 w+  bank=n alpha=1 R=80343.9862738715 G_phys=1.24464822617995e-05 G_eff=1.24464822617995e-05
Rh25p13n1 in13 h25p 80710.0923408755
* h25 input 14 w=-0.441614461314228 w-  bank=n alpha=1 R=75480.619982721 G_phys=1.32484338394269e-05 G_eff=1.32484338394269e-05
Rh25n14n1 in14n h25p 75176.3083655984
* h25 input 15 w=+0.152726206779301 w+  bank=n alpha=1 R=218255.491550983 G_phys=4.58178620337902e-06 G_eff=4.58178620337902e-06
Rh25p15n1 in15 h25p 218154.439428109
* h25 input 16 w=-0.0538945970745783 w-  bank=n alpha=1 R=618491.187292992 G_phys=1.61683791223735e-06 G_eff=1.61683791223735e-06
Rh25n16n1 in16n h25p 620500.883281688
* h25 bias w+  bank=n alpha=1 R=396065.019631007 G_phys=2.52483796961329e-06 G_eff=2.52483796961329e-06
Rh25bpn1 vref h25p 394699.583419723
* single-copy I-to-V: 0 V sum h25p, I dump onto R_IV=33333.3333333333
Vh25p h25p 0 DC 0
Bh25iv 0 h25lin I = i(Vh25p)
Rh25iv h25lin 0 33299.6032977239
* direct bounded ReLU, no output buffer: y=max(0, min(15, v(h25lin)))
Bh25relu h25y 0 V = max(0, min(15, v(h25lin)))

* h26 input 1 w=-0.733410608571861 w-  bank=n alpha=1 R=45449.7561717056 G_phys=2.20023182571558e-05 G_eff=2.20023182571558e-05
Rh26n1n1 in1n h26p 45392.0175878773
* h26 input 2 w=+0.207000343516658 w+  bank=n alpha=1 R=161030.328583251 G_phys=6.21001030549975e-06 G_eff=6.21001030549975e-06
Rh26p2n1 in2 h26p 161579.669052775
* h26 input 3 w=-0.0671817515718929 w-  bank=n alpha=1 R=496166.482019488 G_phys=2.01545254715679e-06 G_eff=2.01545254715679e-06
Rh26n3n1 in3n h26p 494148.583399451
* h26 input 4 w=+0.312724326896377 w+  bank=n alpha=1 R=106590.151345592 G_phys=9.38172980689131e-06 G_eff=9.38172980689131e-06
Rh26p4n1 in4 h26p 107060.027882325
* h26 input 5 w=+0.0982363551813243 w+  bank=n alpha=1 R=339317.692231219 G_phys=2.94709065543973e-06 G_eff=2.94709065543973e-06
Rh26p5n1 in5 h26p 340141.136583757
* h26 input 6 w=+0.0433697195878843 w+  bank=n alpha=1 R=768585.401291025 G_phys=1.30109158763653e-06 G_eff=1.30109158763653e-06
Rh26p6n1 in6 h26p 771160.997311829
* h26 input 7 w=-0.253243820471769 w-  bank=n alpha=1 R=131625.45593901 G_phys=7.59731461415306e-06 G_eff=7.59731461415306e-06
Rh26n7n1 in7n h26p 131768.002198598
* h26 input 8 w=+0.388367135047654 w+  bank=n alpha=1 R=85829.4390158508 G_phys=1.16510140514296e-05 G_eff=1.16510140514296e-05
Rh26p8n1 in8 h26p 86115.410780025
* h26 input 9 w=+0.190562655499984 w+  bank=n alpha=1 R=174920.596304013 G_phys=5.71687966499952e-06 G_eff=5.71687966499952e-06
Rh26p9n1 in9 h26p 174305.833937799
* h26 input 10 w=-0.282938574156096 w-  bank=n alpha=1 R=117811.201363245 G_phys=8.48815722468287e-06 G_eff=8.48815722468287e-06
Rh26n10n1 in10n h26p 117951.582518254
* h26 input 11 w=+0.123317846030254 w+  bank=n alpha=1 R=270304.21310761 G_phys=3.69953538090763e-06 G_eff=3.69953538090763e-06
Rh26p11n1 in11 h26p 270313.489442957
* h26 input 12 w=-0.494646699470857 w-  bank=n alpha=1 R=67388.1648639146 G_phys=1.48394009841257e-05 G_eff=1.48394009841257e-05
Rh26n12n1 in12n h26p 67449.3655466127
* h26 input 13 w=-0.136127092468903 w-  bank=n alpha=1 R=244869.208096457 G_phys=4.08381277406708e-06 G_eff=4.08381277406708e-06
Rh26n13n1 in13n h26p 245986.047085201
* h26 input 14 w=+0.481522107274068 w+  bank=n alpha=1 R=69224.928263493 G_phys=1.4445663218222e-05 G_eff=1.4445663218222e-05
Rh26p14n1 in14 h26p 69232.721742927
* h26 input 15 w=+0.0644124429905188 w+  bank=n alpha=1 R=517498.355686336 G_phys=1.93237328971556e-06 G_eff=1.93237328971556e-06
Rh26p15n1 in15 h26p 519020.404298307
* h26 input 16 w=+0.0297993400818282 w+  bank=f alpha=0.001 R=1118.5930037981 G_phys=0.000893980202454845 G_eff=8.93980202454845e-07
Rh26p16f1 tap16 h26p 1117.29619995484
* h26 bias w-  bank=f alpha=0.001 R=2150.60895252505 G_phys=0.000464984579751652 G_eff=4.64984579751652e-07
Rh26bnf1 taprefn h26p 2146.439559124
* single-copy I-to-V: 0 V sum h26p, I dump onto R_IV=33333.3333333333
Vh26p h26p 0 DC 0
Bh26iv 0 h26lin I = i(Vh26p)
Rh26iv h26lin 0 33171.1558785013
* direct bounded ReLU, no output buffer: y=max(0, min(15, v(h26lin)))
Bh26relu h26y 0 V = max(0, min(15, v(h26lin)))

* h27 input 1 w=-0.473232380174693 w-  bank=n alpha=1 R=70437.5582267393 G_phys=1.41969714052408e-05 G_eff=1.41969714052408e-05
Rh27n1n1 in1n h27p 70227.2399828887
* h27 input 2 w=+0.0192680774504759 w+  bank=f alpha=0.001 R=1729.97713025645 G_phys=0.000578042323514278 G_eff=5.78042323514278e-07
Rh27p2f1 tap2 h27p 1734.74960638247
* h27 input 3 w=-0.33925202928177 w-  bank=n alpha=1 R=98255.3690361212 G_phys=1.01775608784531e-05 G_eff=1.01775608784531e-05
Rh27n3n1 in3n h27p 98259.7055349488
* h27 input 4 w=+0.300608725256371 w+  bank=n alpha=1 R=110886.113850838 G_phys=9.01826175769113e-06 G_eff=9.01826175769113e-06
Rh27p4n1 in4 h27p 110896.314073298
* h27 input 5 w=-0.265937781386581 w-  bank=n alpha=1 R=125342.60141427 G_phys=7.97813344159742e-06 G_eff=7.97813344159742e-06
Rh27n5n1 in5n h27p 125914.614317619
* h27 input 6 w=-0.0714924370091341 w-  bank=n alpha=1 R=466249.784282421 G_phys=2.14477311027402e-06 G_eff=2.14477311027402e-06
Rh27n6n1 in6n h27p 467416.562825911
* h27 input 7 w=+0.32365049129675 w+  bank=n alpha=1 R=102991.758794429 G_phys=9.7095147389025e-06 G_eff=9.7095147389025e-06
Rh27p7n1 in7 h27p 103135.067642756
* h27 input 8 w=+0.264468500812474 w+  bank=n alpha=1 R=126038.954472574 G_phys=7.93405502437422e-06 G_eff=7.93405502437422e-06
Rh27p8n1 in8 h27p 126551.691629263
* h27 input 9 w=-0.251852607935664 w-  bank=n alpha=1 R=132352.543841231 G_phys=7.55557823806993e-06 G_eff=7.55557823806993e-06
Rh27n9n1 in9n h27p 132272.875559947
* h27 input 10 w=-0.0922567674902895 w-  bank=n alpha=1 R=361310.440850226 G_phys=2.76770302470868e-06 G_eff=2.76770302470868e-06
Rh27n10n1 in10n h27p 359787.790064342
* h27 input 11 w=-0.519972660308657 w-  bank=n alpha=1 R=64105.9345573026 G_phys=1.55991798092597e-05 G_eff=1.55991798092597e-05
Rh27n11n1 in11n h27p 64048.55303937
* h27 input 12 w=+0.109096005067641 w+  bank=n alpha=1 R=305541.282768935 G_phys=3.27288015202924e-06 G_eff=3.27288015202924e-06
Rh27p12n1 in12 h27p 305978.475912839
* h27 input 13 w=+0.0733868764952063 w+  bank=n alpha=1 R=454213.817582367 G_phys=2.20160629485619e-06 G_eff=2.20160629485619e-06
Rh27p13n1 in13 h27p 453801.695064351
* h27 input 14 w=-0.779894486957924 w-  bank=n alpha=1 R=42740.8244201779 G_phys=2.33968346087377e-05 G_eff=2.33968346087377e-05
Rh27n14n1 in14n h27p 42605.1905724329
* h27 input 15 w=+0.520337169546291 w+  bank=n alpha=1 R=64061.0267423301 G_phys=1.56101150863887e-05 G_eff=1.56101150863887e-05
Rh27p15n1 in15 h27p 64129.998714176
* h27 input 16 w=+0.00922691889455085 w+  bank=f alpha=0.001 R=3612.61800545565 G_phys=0.000276807566836526 G_eff=2.76807566836526e-07
Rh27p16f1 tap16 h27p 3600.79323536354
* h27 bias w+  bank=f alpha=0.001 R=2714.58121636714 G_phys=0.000368380947297011 G_eff=3.68380947297011e-07
Rh27bpf1 tapref h27p 2719.14281298588
* single-copy I-to-V: 0 V sum h27p, I dump onto R_IV=33333.3333333333
Vh27p h27p 0 DC 0
Bh27iv 0 h27lin I = i(Vh27p)
Rh27iv h27lin 0 33330.8751694803
* direct bounded ReLU, no output buffer: y=max(0, min(15, v(h27lin)))
Bh27relu h27y 0 V = max(0, min(15, v(h27lin)))

* h28 input 1 w=+0.0928477001370985 w+  bank=n alpha=1 R=359010.86708786 G_phys=2.78543100411296e-06 G_eff=2.78543100411296e-06
Rh28p1n1 in1 h28p 357527.768662109
* h28 input 2 w=+0.628866123797832 w+  bank=n alpha=1 R=53005.4523083984 G_phys=1.8865983713935e-05 G_eff=1.8865983713935e-05
Rh28p2n1 in2 h28p 52742.1886587256
* h28 input 3 w=-0.429442295580587 w-  bank=n alpha=1 R=77620.0520451022 G_phys=1.28832688674176e-05 G_eff=1.28832688674176e-05
Rh28n3n1 in3n h28p 77941.4204836764
* h28 input 4 w=+0.0390774584408687 w+  bank=n alpha=1 R=853006.686291349 G_phys=1.17232375322606e-06 G_eff=1.17232375322606e-06
Rh28p4n1 in4 h28p 853361.102734231
* h28 input 5 w=-0.500231352741198 w-  bank=n alpha=1 R=66635.8339009967 G_phys=1.50069405822359e-05 G_eff=1.50069405822359e-05
Rh28n5n1 in5n h28p 66592.5691403354
* h28 input 6 w=-0.374880121408735 w-  bank=n alpha=1 R=88917.3136416848 G_phys=1.1246403642262e-05 G_eff=1.1246403642262e-05
Rh28n6n1 in6n h28p 88812.2995719478
* h28 input 7 w=-0.575469641796179 w-  bank=n alpha=1 R=57923.7042449224 G_phys=1.72640892538854e-05 G_eff=1.72640892538854e-05
Rh28n7n1 in7n h28p 58049.1142619888
* h28 input 8 w=+0.475130253886277 w+  bank=n alpha=1 R=70156.2004538479 G_phys=1.42539076165883e-05 G_eff=1.42539076165883e-05
Rh28p8n1 in8 h28p 69837.4678808373
* h28 input 9 w=-0.381841652824232 w-  bank=n alpha=1 R=87296.221056002 G_phys=1.1455249584727e-05 G_eff=1.1455249584727e-05
Rh28n9n1 in9n h28p 87148.5632763832
* h28 input 10 w=+0.758567082707225 w+  bank=n alpha=1 R=43942.4990791469 G_phys=2.27570124812167e-05 G_eff=2.27570124812167e-05
Rh28p10n1 in10 h28p 43761.3731688562
* h28 input 11 w=-0.0530277840915393 w-  bank=n alpha=1 R=628601.287125096 G_phys=1.59083352274618e-06 G_eff=1.59083352274618e-06
Rh28n11n1 in11n h28p 625881.397247446
* h28 input 12 w=+0.0401492881024246 w+  bank=n alpha=1 R=830234.729151284 G_phys=1.20447864307274e-06 G_eff=1.20447864307274e-06
Rh28p12n1 in12 h28p 831017.001629238
* h28 input 13 w=-0.344979802042177 w-  bank=n alpha=1 R=96624.0143220269 G_phys=1.03493940612653e-05 G_eff=1.03493940612653e-05
Rh28n13n1 in13n h28p 96476.0214333122
* h28 input 14 w=+0.139059200435423 w+  bank=n alpha=1 R=239706.062086937 G_phys=4.1717760130627e-06 G_eff=4.1717760130627e-06
Rh28p14n1 in14 h28p 238798.339588653
* h28 input 15 w=-0.317012120275182 w-  bank=n alpha=1 R=105148.450804967 G_phys=9.51036360825546e-06 G_eff=9.51036360825546e-06
Rh28n15n1 in15n h28p 105454.888158965
* h28 input 16 w=-0.398313118116402 w-  bank=n alpha=1 R=83686.2554037001 G_phys=1.1949393543492e-05 G_eff=1.1949393543492e-05
Rh28n16n1 in16n h28p 83765.6624270776
* h28 bias w-  bank=n alpha=1 R=393235.409243175 G_phys=2.54300598698528e-06 G_eff=2.54300598698528e-06
Rh28bnn1 vrefn h28p 395011.561879434
* single-copy I-to-V: 0 V sum h28p, I dump onto R_IV=33333.3333333333
Vh28p h28p 0 DC 0
Bh28iv 0 h28lin I = i(Vh28p)
Rh28iv h28lin 0 33477.6058179759
* direct bounded ReLU, no output buffer: y=max(0, min(15, v(h28lin)))
Bh28relu h28y 0 V = max(0, min(15, v(h28lin)))

* h29 input 1 w=+0.125932002984804 w+  bank=n alpha=1 R=264693.108529018 G_phys=3.77796008954411e-06 G_eff=3.77796008954411e-06
Rh29p1n1 in1 h29p 263985.17108966
* h29 input 2 w=-0.650061827874195 w-  bank=n alpha=1 R=51277.1738072033 G_phys=1.95018548362258e-05 G_eff=1.95018548362258e-05
Rh29n2n1 in2n h29p 51516.351054456
* h29 input 3 w=-0.0394473233812264 w-  bank=n alpha=1 R=845008.747772155 G_phys=1.18341970143679e-06 G_eff=1.18341970143679e-06
Rh29n3n1 in3n h29p 843901.746961015
* h29 input 4 w=-0.231823015010513 w-  bank=n alpha=1 R=143787.85183094 G_phys=6.9546904503154e-06 G_eff=6.9546904503154e-06
Rh29n4n1 in4n h29p 143818.012075941
* h29 input 5 w=+0.19053303604273 w+  bank=n alpha=1 R=174947.788717637 G_phys=5.71599108128189e-06 G_eff=5.71599108128189e-06
Rh29p5n1 in5 h29p 175292.512170368
* h29 input 6 w=+0.447719174196915 w+  bank=n alpha=1 R=74451.4312864178 G_phys=1.34315752259074e-05 G_eff=1.34315752259074e-05
Rh29p6n1 in6 h29p 74735.7058178203
* h29 input 7 w=+0.0126486175371352 w+  bank=f alpha=0.001 R=2635.33411738237 G_phys=0.000379458526114055 G_eff=3.79458526114055e-07
Rh29p7f1 tap7 h29p 2648.00080880495
* h29 input 8 w=+0.108364236263017 w+  bank=n alpha=1 R=307604.561088107 G_phys=3.25092708789052e-06 G_eff=3.25092708789052e-06
Rh29p8n1 in8 h29p 308823.858142311
* h29 input 9 w=+0.430118110319429 w+  bank=n alpha=1 R=77498.0930437414 G_phys=1.29035433095829e-05 G_eff=1.29035433095829e-05
Rh29p9n1 in9 h29p 77568.4548125378
* h29 input 10 w=+0.849664650654267 w+  bank=n alpha=1 R=39231.1640924048 G_phys=2.5489939519628e-05 G_eff=2.5489939519628e-05
Rh29p10n1 in10 h29p 39168.2883962034
* h29 input 11 w=+0.430581993177771 w+  bank=n alpha=1 R=77414.6013104902 G_phys=1.29174597953331e-05 G_eff=1.29174597953331e-05
Rh29p11n1 in11 h29p 77388.3952848055
* h29 input 12 w=-0.974573192285427 w-  bank=n alpha=1 R=34203.006605553 G_phys=2.92371957685628e-05 G_eff=2.92371957685628e-05
Rh29n12n1 in12n h29p 34156.9782962795
* h29 input 13 w=+0.16029064712382 w+  bank=n alpha=1 R=207955.572776396 G_phys=4.80871941371461e-06 G_eff=4.80871941371461e-06
Rh29p13n1 in13 h29p 207474.625782087
* h29 input 14 w=+0.466636118473806 w+  bank=n alpha=1 R=71433.2474784727 G_phys=1.39990835542142e-05 G_eff=1.39990835542142e-05
Rh29p14n1 in14 h29p 71731.9270463966
* h29 input 15 w=-0.0331745755104183 w-  bank=f alpha=0.001 R=1004.78552688233 G_phys=0.000995237265312548 G_eff=9.95237265312548e-07
Rh29n15f1 tap15n h29p 1009.42408546762
* h29 input 16 w=-0.589046477086867 w-  bank=n alpha=1 R=56588.6303202822 G_phys=1.7671394312606e-05 G_eff=1.7671394312606e-05
Rh29n16n1 in16n h29p 56597.0695993278
* h29 bias w-  bank=n alpha=1 R=500623.285959049 G_phys=1.99750996017752e-06 G_eff=1.99750996017752e-06
Rh29bnn1 vrefn h29p 501925.364396553
* single-copy I-to-V: 0 V sum h29p, I dump onto R_IV=33333.3333333333
Vh29p h29p 0 DC 0
Bh29iv 0 h29lin I = i(Vh29p)
Rh29iv h29lin 0 33179.4671922373
* direct bounded ReLU, no output buffer: y=max(0, min(15, v(h29lin)))
Bh29relu h29y 0 V = max(0, min(15, v(h29lin)))

* h30 input 1 w=-0.507901838841989 w-  bank=n alpha=1 R=65629.4795256756 G_phys=1.52370551652597e-05 G_eff=1.52370551652597e-05
Rh30n1n1 in1n h30p 65348.5936041272
* h30 input 2 w=-0.0392944483392576 w-  bank=n alpha=1 R=848296.254105474 G_phys=1.17883345017773e-06 G_eff=1.17883345017773e-06
Rh30n2n1 in2n h30p 845444.997561349
* h30 input 3 w=+0.205776196534446 w+  bank=n alpha=1 R=161988.285791615 G_phys=6.17328589603337e-06 G_eff=6.17328589603337e-06
Rh30p3n1 in3 h30p 162716.731297156
* h30 input 4 w=+0.172383143604269 w+  bank=n alpha=1 R=193367.707749053 G_phys=5.17149430812806e-06 G_eff=5.17149430812806e-06
Rh30p4n1 in4 h30p 194082.910716001
* h30 input 5 w=-0.0737740397875715 w-  bank=n alpha=1 R=451830.121128177 G_phys=2.21322119362714e-06 G_eff=2.21322119362714e-06
Rh30n5n1 in5n h30p 451932.486341461
* h30 input 6 w=-0.113337981854853 w-  bank=n alpha=1 R=294105.583916448 G_phys=3.40013945564559e-06 G_eff=3.40013945564559e-06
Rh30n6n1 in6n h30p 293316.546335425
* h30 input 7 w=-0.199472534274412 w-  bank=n alpha=1 R=167107.383753781 G_phys=5.98417602823235e-06 G_eff=5.98417602823235e-06
Rh30n7n1 in7n h30p 167219.054670357
* h30 input 8 w=+0.667476408484971 w+  bank=n alpha=1 R=49939.3430383448 G_phys=2.00242922545491e-05 G_eff=2.00242922545491e-05
Rh30p8n1 in8 h30p 49818.7225791159
* h30 input 9 w=+0.0327305955718174 w+  bank=f alpha=0.001 R=1018.41511744549 G_phys=0.000981917867154523 G_eff=9.81917867154523e-07
Rh30p9f1 tap9 h30p 1020.40834619731
* h30 input 10 w=-0.112124407230259 w-  bank=n alpha=1 R=297288.825481859 G_phys=3.36373221690776e-06 G_eff=3.36373221690776e-06
Rh30n10n1 in10n h30p 297903.274880762
* h30 input 11 w=+0.283868618501327 w+  bank=n alpha=1 R=117425.214204076 G_phys=8.51605855503981e-06 G_eff=8.51605855503981e-06
Rh30p11n1 in11 h30p 117828.863826071
* h30 input 12 w=-0.058671072800694 w-  bank=n alpha=1 R=568139.148342606 G_phys=1.76013218402082e-06 G_eff=1.76013218402082e-06
Rh30n12n1 in12n h30p 567649.161319801
* h30 input 13 w=-0.679698898194489 w-  bank=n alpha=1 R=49041.323182777 G_phys=2.03909669458347e-05 G_eff=2.03909669458347e-05
Rh30n13n1 in13n h30p 49045.6533428928
* h30 input 14 w=+0.213421552049108 w+  bank=n alpha=1 R=156185.413390975 G_phys=6.40264656147323e-06 G_eff=6.40264656147323e-06
Rh30p14n1 in14 h30p 156316.938345767
* h30 input 15 w=+0.353043376484901 w+  bank=n alpha=1 R=94417.1043944198 G_phys=1.0591301294547e-05 G_eff=1.0591301294547e-05
Rh30p15n1 in15 h30p 94618.13516981
* h30 input 16 w=-0.0402310971621178 w-  bank=n alpha=1 R=828546.464915216 G_phys=1.20693291486354e-06 G_eff=1.20693291486354e-06
Rh30n16n1 in16n h30p 826587.504540722
* h30 bias w+  bank=f alpha=0.001 R=1174.50422834716 G_phys=0.000851423073552715 G_eff=8.51423073552714e-07
Rh30bpf1 tapref h30p 1170.06788737694
* single-copy I-to-V: 0 V sum h30p, I dump onto R_IV=33333.3333333333
Vh30p h30p 0 DC 0
Bh30iv 0 h30lin I = i(Vh30p)
Rh30iv h30lin 0 33375.7963462504
* direct bounded ReLU, no output buffer: y=max(0, min(15, v(h30lin)))
Bh30relu h30y 0 V = max(0, min(15, v(h30lin)))

* h31 input 1 w=+0.786523739677983 w+  bank=n alpha=1 R=42380.5813502598 G_phys=2.35957121903395e-05 G_eff=2.35957121903395e-05
Rh31p1n1 in1 h31p 42450.4849208493
* h31 input 2 w=+0.575951127580127 w+  bank=n alpha=1 R=57875.2809693839 G_phys=1.72785338274038e-05 G_eff=1.72785338274038e-05
Rh31p2n1 in2 h31p 57925.1649248454
* h31 input 3 w=+0.131568206508636 w+  bank=n alpha=1 R=253354.014756941 G_phys=3.94704619525908e-06 G_eff=3.94704619525908e-06
Rh31p3n1 in3 h31p 252910.899819187
* h31 input 4 w=+0.217046331869883 w+  bank=n alpha=1 R=153577.040653773 G_phys=6.51138995609649e-06 G_eff=6.51138995609649e-06
Rh31p4n1 in4 h31p 154307.874695718
* h31 input 5 w=+0.0670548023806797 w+  bank=n alpha=1 R=497105.832093803 G_phys=2.01164407142039e-06 G_eff=2.01164407142039e-06
Rh31p5n1 in5 h31p 497612.305780659
* h31 input 6 w=-0.0924541633789126 w-  bank=n alpha=1 R=360539.018634786 G_phys=2.77362490136738e-06 G_eff=2.77362490136738e-06
Rh31n6n1 in6n h31p 359669.253697869
* h31 input 7 w=+0.532768880755568 w+  bank=n alpha=1 R=62566.2168669842 G_phys=1.59830664226671e-05 G_eff=1.59830664226671e-05
Rh31p7n1 in7 h31p 62720.6113674103
* h31 input 8 w=-0.213038536483163 w-  bank=n alpha=1 R=156466.214439883 G_phys=6.39115609449489e-06 G_eff=6.39115609449489e-06
Rh31n8n1 in8n h31p 156847.295948443
* h31 input 9 w=+0.217996086164886 w+  bank=n alpha=1 R=152907.943989971 G_phys=6.53988258494657e-06 G_eff=6.53988258494657e-06
Rh31p9n1 in9 h31p 153492.631225408
* h31 input 10 w=-0.173189336412784 w-  bank=n alpha=1 R=192467.58503587 G_phys=5.19568009238351e-06 G_eff=5.19568009238351e-06
Rh31n10n1 in10n h31p 191740.0384189
* h31 input 11 w=+0.227561810267943 w+  bank=n alpha=1 R=146480.348763639 G_phys=6.8268543080383e-06 G_eff=6.8268543080383e-06
Rh31p11n1 in11 h31p 146748.475057068
* h31 input 12 w=+0.400647928830177 w+  bank=n alpha=1 R=83198.5664587384 G_phys=1.20194378649053e-05 G_eff=1.20194378649053e-05
Rh31p12n1 in12 h31p 83174.1487927791
* h31 input 13 w=+0.0924404555732517 w+  bank=n alpha=1 R=360592.482226781 G_phys=2.77321366719755e-06 G_eff=2.77321366719755e-06
Rh31p13n1 in13 h31p 359102.646551024
* h31 input 14 w=+0.340918137300815 w+  bank=n alpha=1 R=97775.1832074605 G_phys=1.02275441190244e-05 G_eff=1.02275441190244e-05
Rh31p14n1 in14 h31p 97410.3293965409
* h31 input 15 w=+0.631456773568415 w+  bank=n alpha=1 R=52787.9891840638 G_phys=1.89437032070525e-05 G_eff=1.89437032070525e-05
Rh31p15n1 in15 h31p 52620.3284399523
* h31 input 16 w=+0.19173700817347 w+  bank=n alpha=1 R=173849.240951834 G_phys=5.75211024520409e-06 G_eff=5.75211024520409e-06
Rh31p16n1 in16 h31p 174515.960384869
* h31 bias w-  bank=n alpha=1 R=620531.31238591 G_phys=1.61152222303666e-06 G_eff=1.61152222303666e-06
Rh31bnn1 vrefn h31p 619319.753107847
* single-copy I-to-V: 0 V sum h31p, I dump onto R_IV=33333.3333333333
Vh31p h31p 0 DC 0
Bh31iv 0 h31lin I = i(Vh31p)
Rh31iv h31lin 0 33487.3214340759
* direct bounded ReLU, no output buffer: y=max(0, min(15, v(h31lin)))
Bh31relu h31y 0 V = max(0, min(15, v(h31lin)))

* h32 input 1 w=+0.018363806586789 w+  bank=f alpha=0.001 R=1815.16469234181 G_phys=0.000550914197603669 G_eff=5.50914197603669e-07
Rh32p1f1 tap1 h32p 1812.39289043378
* h32 input 2 w=+0.274234487929714 w+  bank=n alpha=1 R=121550.478880237 G_phys=8.22703463789143e-06 G_eff=8.22703463789143e-06
Rh32p2n1 in2 h32p 121137.820766843
* h32 input 3 w=+0.286642259390481 w+  bank=n alpha=1 R=116288.970803585 G_phys=8.59926778171444e-06 G_eff=8.59926778171444e-06
Rh32p3n1 in3 h32p 116612.121172918
* h32 input 4 w=-0.106012181190002 w-  bank=n alpha=1 R=314429.275571559 G_phys=3.18036543570007e-06 G_eff=3.18036543570007e-06
Rh32n4n1 in4n h32p 315875.690169423
* h32 input 5 w=-0.539184466126997 w-  bank=n alpha=1 R=61821.7612476287 G_phys=1.61755339838099e-05 G_eff=1.61755339838099e-05
Rh32n5n1 in5n h32p 61533.8692545276
* h32 input 6 w=-0.141969883388357 w-  bank=n alpha=1 R=234791.580705539 G_phys=4.25909650165071e-06 G_eff=4.25909650165071e-06
Rh32n6n1 in6n h32p 233631.885656692
* h32 input 7 w=-0.343812430494534 w-  bank=n alpha=1 R=96952.0889206571 G_phys=1.0314372914836e-05 G_eff=1.0314372914836e-05
Rh32n7n1 in7n h32p 97136.7908909216
* h32 input 8 w=-0.197072814561277 w-  bank=n alpha=1 R=169142.219882229 G_phys=5.91218443683832e-06 G_eff=5.91218443683832e-06
Rh32n8n1 in8n h32p 168296.853845416
* h32 input 9 w=-0.180430465047897 w-  bank=n alpha=1 R=184743.376482927 G_phys=5.41291395143692e-06 G_eff=5.41291395143692e-06
Rh32n9n1 in9n h32p 184882.212236106
* h32 input 10 w=+0.113268490856906 w+  bank=n alpha=1 R=294286.019714378 G_phys=3.39805472570718e-06 G_eff=3.39805472570718e-06
Rh32p10n1 in10 h32p 293145.22996966
* h32 input 11 w=+0.0737822862098911 w+  bank=n alpha=1 R=451779.621446112 G_phys=2.21346858629673e-06 G_eff=2.21346858629673e-06
Rh32p11n1 in11 h32p 449873.094368232
* h32 input 12 w=+0.131260687318804 w+  bank=n alpha=1 R=253947.575730529 G_phys=3.93782061956414e-06 G_eff=3.93782061956414e-06
Rh32p12n1 in12 h32p 253250.030981821
* h32 input 13 w=-0.105796213840622 w-  bank=n alpha=1 R=315071.136511074 G_phys=3.17388641521865e-06 G_eff=3.17388641521865e-06
Rh32n13n1 in13n h32p 313581.716179374
* h32 input 14 w=-0.365435123738796 w-  bank=n alpha=1 R=91215.4611529876 G_phys=1.09630537121639e-05 G_eff=1.09630537121639e-05
Rh32n14n1 in14n h32p 91217.9448203566
* h32 input 15 w=-0.0205558893905 w-  bank=f alpha=0.001 R=1621.59528591055 G_phys=0.000616676681714999 G_eff=6.16676681714999e-07
Rh32n15f1 tap15n h32p 1613.86602122088
* h32 input 16 w=-0.212152037098157 w-  bank=n alpha=1 R=157120.024814614 G_phys=6.36456111294471e-06 G_eff=6.36456111294471e-06
Rh32n16n1 in16n h32p 157776.442650254
* h32 bias w+  bank=f alpha=0.001 R=4134.96891231251 G_phys=0.000241839786756884 G_eff=2.41839786756884e-07
Rh32bpf1 tapref h32p 4132.3527404087
* single-copy I-to-V: 0 V sum h32p, I dump onto R_IV=33333.3333333333
Vh32p h32p 0 DC 0
Bh32iv 0 h32lin I = i(Vh32p)
Rh32iv h32lin 0 33261.1968812962
* direct bounded ReLU, no output buffer: y=max(0, min(15, v(h32lin)))
Bh32relu h32y 0 V = max(0, min(15, v(h32lin)))

* passive invert h1y -> h1yn: R2/R1=1.0000200002 closed-loop -1 at A=100000
Rinvh1ia h1y invh1m 9958.68221281769
Rinvh1ib h1yn invh1m 9963.93814739982
Einvh1amp h1yn 0 0 invh1m 100000
* load-compensated divider h1y->htap1: G_load=6.00022240247825e-05 Ra=942450.852798063 Rb=1000 target beta=0.001 (no tap buffer)
Rdivh1a h1y htap1 940279.269087564
Rdivh1b htap1 0 998.436646500122
* load-compensated divider h1yn->htap1n: G_load=0.000717504633896169 Ra=581657.819306003 Rb=1000 target beta=0.001 (no tap buffer)
Rdivh1na h1yn htap1n 581406.356399938
Rdivh1nb htap1n 0 1004.57565557185
* passive invert h2y -> h2yn: R2/R1=1.0000200002 closed-loop -1 at A=100000
Rinvh2ia h2y invh2m 9993.41325163955
Rinvh2ib h2yn invh2m 10015.1687963333
Einvh2amp h2yn 0 0 invh2m 100000
* load-compensated divider h2y->htap2: G_load=0.00034407671071968 Ra=743261.148736882 Rb=1000 target beta=0.001 (no tap buffer)
Rdivh2a h2y htap2 743601.813233312
Rdivh2b htap2 0 996.673006626171
* load-compensated divider h2yn->htap2n: G_load=0.000712380497940648 Ra=583398.375069923 Rb=1000 target beta=0.001 (no tap buffer)
Rdivh2na h2yn htap2n 581753.90154952
Rdivh2nb htap2n 0 1003.02454350518
* passive invert h3y -> h3yn: R2/R1=1.0000200002 closed-loop -1 at A=100000
Rinvh3ia h3y invh3m 10048.0674194273
Rinvh3ib h3yn invh3m 9985.72996253124
Einvh3amp h3yn 0 0 invh3m 100000
* load-compensated divider h3y->htap3: G_load=0.000928920570217644 Ra=517906.240114014 Rb=1000 target beta=0.001 (no tap buffer)
Rdivh3a h3y htap3 515365.890354874
Rdivh3b htap3 0 1000.27204386107
* passive invert h4y -> h4yn: R2/R1=1.0000200002 closed-loop -1 at A=100000
Rinvh4ia h4y invh4m 10014.2069873003
Rinvh4ib h4yn invh4m 9951.56372382206
Einvh4amp h4yn 0 0 invh4m 100000
* load-compensated divider h4y->htap4: G_load=0.000814282747184905 Ra=550630.821766937 Rb=1000 target beta=0.001 (no tap buffer)
Rdivh4a h4y htap4 550121.180597562
Rdivh4b htap4 0 995.81795221019
* load-compensated divider h4yn->htap4n: G_load=0.0014954055609593 Ra=400335.727237843 Rb=1000 target beta=0.001 (no tap buffer)
Rdivh4na h4yn htap4n 402281.526845869
Rdivh4nb htap4n 0 997.635132184749
* passive invert h5y -> h5yn: R2/R1=1.0000200002 closed-loop -1 at A=100000
Rinvh5ia h5y invh5m 10046.0630996342
Rinvh5ib h5yn invh5m 10007.6252309123
Einvh5amp h5yn 0 0 invh5m 100000
* load-compensated divider h5y->htap5: G_load=0.00063839892598525 Ra=609741.610639333 Rb=1000 target beta=0.001 (no tap buffer)
Rdivh5a h5y htap5 609481.099069462
Rdivh5b htap5 0 1001.04545489228
* passive invert h6y -> h6yn: R2/R1=1.0000200002 closed-loop -1 at A=100000
Rinvh6ia h6y invh6m 9972.29878617928
Rinvh6ib h6yn invh6m 9994.67061136875
Einvh6amp h6yn 0 0 invh6m 100000
* load-compensated divider h6y->htap6: G_load=0.00101622287932375 Ra=495480.93628174 Rb=1000 target beta=0.001 (no tap buffer)
Rdivh6a h6y htap6 495451.201165143
Rdivh6b htap6 0 1004.59860989654
* load-compensated divider h6yn->htap6n: G_load=0.000176838972885357 Ra=848884.191480051 Rb=1000 target beta=0.001 (no tap buffer)
Rdivh6na h6yn htap6n 853033.880567772
Rdivh6nb htap6n 0 1003.03909234309
* passive invert h7y -> h7yn: R2/R1=1.0000200002 closed-loop -1 at A=100000
Rinvh7ia h7y invh7m 10044.0565766314
Rinvh7ib h7yn invh7m 10028.5932354047
Einvh7amp h7yn 0 0 invh7m 100000
* load-compensated divider h7yn->htap7n: G_load=0.000978460874628438 Ra=504937.961023675 Rb=1000 target beta=0.001 (no tap buffer)
Rdivh7na h7yn htap7n 503915.480316525
Rdivh7nb htap7n 0 995.304940757062
* passive invert h8y -> h8yn: R2/R1=1.0000200002 closed-loop -1 at A=100000
Rinvh8ia h8y invh8m 10046.3072647246
Rinvh8ib h8yn invh8m 10050.1249308913
Einvh8amp h8yn 0 0 invh8m 100000
* load-compensated divider h8y->htap8: G_load=0.00121560414490552 Ra=450892.819593727 Rb=1000 target beta=0.001 (no tap buffer)
Rdivh8a h8y htap8 452969.744092296
Rdivh8b htap8 0 997.210210545727
* load-compensated divider h8yn->htap8n: G_load=0.000501432225011038 Ra=665364.698691381 Rb=1000 target beta=0.001 (no tap buffer)
Rdivh8na h8yn htap8n 662071.607682415
Rdivh8nb htap8n 0 999.897806332944
* passive invert h9y -> h9yn: R2/R1=1.0000200002 closed-loop -1 at A=100000
Rinvh9ia h9y invh9m 9977.13063203976
Rinvh9ib h9yn invh9m 9984.96438493717
Einvh9amp h9yn 0 0 invh9m 100000
* load-compensated divider h9yn->htap9n: G_load=0.00094144317858438 Ra=514565.664872268 Rb=1000 target beta=0.001 (no tap buffer)
Rdivh9na h9yn htap9n 514290.735915971
Rdivh9nb htap9n 0 1001.07750758345
* passive invert h10y -> h10yn: R2/R1=1.0000200002 closed-loop -1 at A=100000
Rinvh10ia h10y invh10m 10008.6718181274
Rinvh10ib h10yn invh10m 10029.8680593199
Einvh10amp h10yn 0 0 invh10m 100000
* passive invert h11y -> h11yn: R2/R1=1.0000200002 closed-loop -1 at A=100000
Rinvh11ia h11y invh11m 10044.0262562979
Rinvh11ib h11yn invh11m 10042.5489329032
Einvh11amp h11yn 0 0 invh11m 100000
* load-compensated divider h11y->htap11: G_load=0.000646362512497387 Ra=606792.241937412 Rb=1000 target beta=0.001 (no tap buffer)
Rdivh11a h11y htap11 607585.462841097
Rdivh11b htap11 0 998.942147403752
* load-compensated divider h11yn->htap11n: G_load=0.000344332712001725 Ra=743119.609514284 Rb=1000 target beta=0.001 (no tap buffer)
Rdivh11na h11yn htap11n 741017.338458974
Rdivh11nb htap11n 0 1004.63616806212
* passive invert h12y -> h12yn: R2/R1=1.0000200002 closed-loop -1 at A=100000
Rinvh12ia h12y invh12m 9969.87163895568
Rinvh12ib h12yn invh12m 9961.1873207827
Einvh12amp h12yn 0 0 invh12m 100000
* load-compensated divider h12yn->htap12n: G_load=0.0014576014431314 Ra=406493.901927036 Rb=1000 target beta=0.001 (no tap buffer)
Rdivh12na h12yn htap12n 405281.17115404
Rdivh12nb htap12n 0 995.099926830841
* passive invert h13y -> h13yn: R2/R1=1.0000200002 closed-loop -1 at A=100000
Rinvh13ia h13y invh13m 10016.482120915
Rinvh13ib h13yn invh13m 9979.61410944061
Einvh13amp h13yn 0 0 invh13m 100000
* load-compensated divider h13yn->htap13n: G_load=0.000608857399561785 Ra=620937.567414057 Rb=1000 target beta=0.001 (no tap buffer)
Rdivh13na h13yn htap13n 618880.067108449
Rdivh13nb htap13n 0 1001.4387890143
* passive invert h14y -> h14yn: R2/R1=1.0000200002 closed-loop -1 at A=100000
Rinvh14ia h14y invh14m 10001.378037254
Rinvh14ib h14yn invh14m 9983.6540369434
Einvh14amp h14yn 0 0 invh14m 100000
* load-compensated divider h14y->htap14: G_load=0.000230447960623581 Ra=811899.431727056 Rb=1000 target beta=0.001 (no tap buffer)
Rdivh14a h14y htap14 812710.084539889
Rdivh14b htap14 0 997.921595182178
* load-compensated divider h14yn->htap14n: G_load=0.000644987911304399 Ra=607299.295718131 Rb=1000 target beta=0.001 (no tap buffer)
Rdivh14na h14yn htap14n 607689.954032271
Rdivh14nb htap14n 0 997.327347064337
* passive invert h15y -> h15yn: R2/R1=1.0000200002 closed-loop -1 at A=100000
Rinvh15ia h15y invh15m 10015.9337047814
Rinvh15ib h15yn invh15m 10047.7084677017
Einvh15amp h15yn 0 0 invh15m 100000
* load-compensated divider h15y->htap15: G_load=7.55198625914195e-05 Ra=928853.138604946 Rb=1000 target beta=0.001 (no tap buffer)
Rdivh15a h15y htap15 927936.394830007
Rdivh15b htap15 0 1001.02189887572
* passive invert h16y -> h16yn: R2/R1=1.0000200002 closed-loop -1 at A=100000
Rinvh16ia h16y invh16m 9963.71434542233
Rinvh16ib h16yn invh16m 9960.7084513005
Einvh16amp h16yn 0 0 invh16m 100000
* load-compensated divider h16y->htap16: G_load=0.000453600446759896 Ra=687259.007264885 Rb=1000 target beta=0.001 (no tap buffer)
Rdivh16a h16y htap16 689940.378814896
Rdivh16b htap16 0 999.054821002555
* load-compensated divider h16yn->htap16n: G_load=0.000874717171138128 Ra=532880.380774191 Rb=1000 target beta=0.001 (no tap buffer)
Rdivh16na h16yn htap16n 534607.8979898
Rdivh16nb htap16n 0 1001.24249508849
* passive invert h17y -> h17yn: R2/R1=1.0000200002 closed-loop -1 at A=100000
Rinvh17ia h17y invh17m 10000.9893178268
Rinvh17ib h17yn invh17m 10018.8534271532
Einvh17amp h17yn 0 0 invh17m 100000
* load-compensated divider h17y->htap17: G_load=0.000738531412423623 Ra=574622.921887463 Rb=1000 target beta=0.001 (no tap buffer)
Rdivh17a h17y htap17 574329.301535137
Rdivh17b htap17 0 1000.43445354662
* load-compensated divider h17yn->htap17n: G_load=0.000805385822001192 Ra=553344.325531842 Rb=1000 target beta=0.001 (no tap buffer)
Rdivh17na h17yn htap17n 554055.111575328
Rdivh17nb htap17n 0 1002.92984273231
* passive invert h18y -> h18yn: R2/R1=1.0000200002 closed-loop -1 at A=100000
Rinvh18ia h18y invh18m 9951.71564310073
Rinvh18ib h18yn invh18m 10041.9168483864
Einvh18amp h18yn 0 0 invh18m 100000
* passive invert h19y -> h19yn: R2/R1=1.0000200002 closed-loop -1 at A=100000
Rinvh19ia h19y invh19m 9976.08289638889
Rinvh19ib h19yn invh19m 10003.7247955036
Einvh19amp h19yn 0 0 invh19m 100000
* passive invert h20y -> h20yn: R2/R1=1.0000200002 closed-loop -1 at A=100000
Rinvh20ia h20y invh20m 9966.16558540296
Rinvh20ib h20yn invh20m 10001.9027390674
Einvh20amp h20yn 0 0 invh20m 100000
* load-compensated divider h20y->htap20: G_load=0.00028049585678463 Ra=780166.522762927 Rb=1000 target beta=0.001 (no tap buffer)
Rdivh20a h20y htap20 776572.74315892
Rdivh20b htap20 0 1003.0311924341
* load-compensated divider h20yn->htap20n: G_load=0.0016896004824873 Ra=371430.629383342 Rb=1000 target beta=0.001 (no tap buffer)
Rdivh20na h20yn htap20n 371390.400499582
Rdivh20nb htap20n 0 1002.69956839993
* passive invert h21y -> h21yn: R2/R1=1.0000200002 closed-loop -1 at A=100000
Rinvh21ia h21y invh21m 10031.8149254546
Rinvh21ib h21yn invh21m 10034.865263963
Einvh21amp h21yn 0 0 invh21m 100000
* load-compensated divider h21yn->htap21n: G_load=0.000996893144360737 Ra=500277.144433689 Rb=1000 target beta=0.001 (no tap buffer)
Rdivh21na h21yn htap21n 498625.307541082
Rdivh21nb htap21n 0 1000.49749349561
* passive invert h22y -> h22yn: R2/R1=1.0000200002 closed-loop -1 at A=100000
Rinvh22ia h22y invh22m 9994.91386200627
Rinvh22ib h22yn invh22m 10033.3397178014
Einvh22amp h22yn 0 0 invh22m 100000
* load-compensated divider h22y->htap22: G_load=0.000238269487966002 Ra=806771.070198113 Rb=1000 target beta=0.001 (no tap buffer)
Rdivh22a h22y htap22 804702.661579419
Rdivh22b htap22 0 999.715189924364
* passive invert h23y -> h23yn: R2/R1=1.0000200002 closed-loop -1 at A=100000
Rinvh23ia h23y invh23m 10023.5823163637
Rinvh23ib h23yn invh23m 10010.9387396249
Einvh23amp h23yn 0 0 invh23m 100000
* load-compensated divider h23y->htap23: G_load=0.000186102491889634 Ra=842254.364046101 Rb=1000 target beta=0.001 (no tap buffer)
Rdivh23a h23y htap23 838423.155669441
Rdivh23b htap23 0 1000.43748498711
* passive invert h24y -> h24yn: R2/R1=1.0000200002 closed-loop -1 at A=100000
Rinvh24ia h24y invh24m 10021.7211638067
Rinvh24ib h24yn invh24m 10015.4221180687
Einvh24amp h24yn 0 0 invh24m 100000
* load-compensated divider h24y->htap24: G_load=0.000321063215271205 Ra=756209.0810279 Rb=1000 target beta=0.001 (no tap buffer)
Rdivh24a h24y htap24 756114.300990696
Rdivh24b htap24 0 996.277137637394
* load-compensated divider h24yn->htap24n: G_load=0.00179208295517046 Ra=357797.392140525 Rb=1000 target beta=0.001 (no tap buffer)
Rdivh24na h24yn htap24n 359206.566054639
Rdivh24nb htap24n 0 997.026645429694
* passive invert h25y -> h25yn: R2/R1=1.0000200002 closed-loop -1 at A=100000
Rinvh25ia h25y invh25m 9994.86550896445
Rinvh25ib h25yn invh25m 9989.05146079486
Einvh25amp h25yn 0 0 invh25m 100000
* load-compensated divider h25yn->htap25n: G_load=0.00043215997093136 Ra=697547.774184983 Rb=1000 target beta=0.001 (no tap buffer)
Rdivh25na h25yn htap25n 698879.828468748
Rdivh25nb htap25n 0 1002.6999807475
* passive invert h26y -> h26yn: R2/R1=1.0000200002 closed-loop -1 at A=100000
Rinvh26ia h26y invh26m 10014.8502283016
Rinvh26ib h26yn invh26m 9999.64044016318
Einvh26amp h26yn 0 0 invh26m 100000
* load-compensated divider h26y->htap26: G_load=0.000228692257589393 Ra=813059.571124804 Rb=1000 target beta=0.001 (no tap buffer)
Rdivh26a h26y htap26 815660.423960222
Rdivh26b htap26 0 1003.26660679686
* passive invert h27y -> h27yn: R2/R1=1.0000200002 closed-loop -1 at A=100000
Rinvh27ia h27y invh27m 10016.7288376469
Rinvh27ib h27yn invh27m 9950.96312987199
Einvh27amp h27yn 0 0 invh27m 100000
* passive invert h28y -> h28yn: R2/R1=1.0000200002 closed-loop -1 at A=100000
Rinvh28ia h28y invh28m 9977.73685696417
Rinvh28ib h28yn invh28m 10041.6037294767
Einvh28amp h28yn 0 0 invh28m 100000
* load-compensated divider h28yn->htap28n: G_load=0.000369491999393624 Ra=729467.569319376 Rb=1000 target beta=0.001 (no tap buffer)
Rdivh28na h28yn htap28n 732505.598240857
Rdivh28nb htap28n 0 1003.03310199537
* passive invert h29y -> h29yn: R2/R1=1.0000200002 closed-loop -1 at A=100000
Rinvh29ia h29y invh29m 10019.134768819
Rinvh29ib h29yn invh29m 10048.6841041354
Einvh29amp h29yn 0 0 invh29m 100000
* load-compensated divider h29y->htap29: G_load=0.00122218503343532 Ra=449557.523324521 Rb=1000 target beta=0.001 (no tap buffer)
Rdivh29a h29y htap29 448492.626983273
Rdivh29b htap29 0 1004.64420849784
* load-compensated divider h29yn->htap29n: G_load=0.000860568019222978 Ra=536932.802068268 Rb=1000 target beta=0.001 (no tap buffer)
Rdivh29na h29yn htap29n 536923.917885338
Rdivh29nb htap29n 0 1004.96785386084
* passive invert h30y -> h30yn: R2/R1=1.0000200002 closed-loop -1 at A=100000
Rinvh30ia h30y invh30m 9992.48215527779
Rinvh30ib h30yn invh30m 9983.1014738936
Einvh30amp h30yn 0 0 invh30m 100000
* load-compensated divider h30yn->htap30n: G_load=0.000487976394847741 Ra=671381.618323471 Rb=1000 target beta=0.001 (no tap buffer)
Rdivh30na h30yn htap30n 669916.321391893
Rdivh30nb htap30n 0 1001.05079850024
* passive invert h31y -> h31yn: R2/R1=1.0000200002 closed-loop -1 at A=100000
Rinvh31ia h31y invh31m 9988.59597307536
Rinvh31ib h31yn invh31m 9954.24439787925
Einvh31amp h31yn 0 0 invh31m 100000
* passive invert h32y -> h32yn: R2/R1=1.0000200002 closed-loop -1 at A=100000
Rinvh32ia h32y invh32m 10014.8516480275
Rinvh32ib h32yn invh32m 10029.906230933
Einvh32amp h32yn 0 0 invh32m 100000
* load-compensated divider h32y->htap32: G_load=9.22574297882182e-05 Ra=914619.550991473 Rb=1000 target beta=0.001 (no tap buffer)
Rdivh32a h32y htap32 917931.37883953
Rdivh32b htap32 0 996.461914001742

* o1 input 1 w=+0.115109951768787 w+  bank=n alpha=1 R=289578.206064126 G_phys=3.4532985530636e-06 G_eff=3.4532985530636e-06
Ro1p1n1 h1y o1p 288521.778359354
* o1 input 2 w=+0.416557305918275 w+  bank=n alpha=1 R=80021.0027762017 G_phys=1.24967191775482e-05 G_eff=1.24967191775482e-05
Ro1p2n1 h2y o1p 79753.4664976506
* o1 input 3 w=+0.460762298204741 w+  bank=n alpha=1 R=72343.8820042555 G_phys=1.38228689461422e-05 G_eff=1.38228689461422e-05
Ro1p3n1 h3y o1p 72053.2341551968
* o1 input 4 w=+0.128235529120638 w+  bank=n alpha=1 R=259938.361559493 G_phys=3.84706587361914e-06 G_eff=3.84706587361914e-06
Ro1p4n1 h4y o1p 259971.555545867
* o1 input 5 w=+0.25946188501651 w+  bank=n alpha=1 R=128471.021210735 G_phys=7.78385655049531e-06 G_eff=7.78385655049531e-06
Ro1p5n1 h5y o1p 128838.014348441
* o1 input 6 w=+0.0121141451968155 w+  bank=f alpha=0.001 R=2751.60424378073 G_phys=0.000363424355904464 G_eff=3.63424355904464e-07
Ro1p6f1 htap6 o1p 2763.95149380701
* o1 input 7 w=-0.240253536162518 w-  bank=n alpha=1 R=138742.321406604 G_phys=7.20760608487554e-06 G_eff=7.20760608487554e-06
Ro1n7n1 h7yn o1p 139211.861466852
* o1 input 8 w=+0.187475674056081 w+  bank=n alpha=1 R=177800.845369208 G_phys=5.62427022168244e-06 G_eff=5.62427022168244e-06
Ro1p8n1 h8y o1p 177709.880348832
* o1 input 9 w=-0.249792136720497 w-  bank=n alpha=1 R=133444.28600101 G_phys=7.4937641016149e-06 G_eff=7.4937641016149e-06
Ro1n9n1 h9yn o1p 134019.908101079
* o1 input 10 w=-0.0478130377197742 w-  bank=n alpha=1 R=697159.915433434 G_phys=1.43439113159322e-06 G_eff=1.43439113159322e-06
Ro1n10n1 h10yn o1p 697398.5348527
* o1 input 11 w=+0.103135444855694 w+  bank=n alpha=1 R=323199.588463238 G_phys=3.09406334567083e-06 G_eff=3.09406334567083e-06
Ro1p11n1 h11y o1p 324224.028086117
* o1 input 12 w=-0.0209153710838255 w-  bank=f alpha=0.001 R=1593.72421362923 G_phys=0.000627461132514765 G_eff=6.27461132514765e-07
Ro1n12f1 htap12n o1p 1593.8142434989
* o1 input 13 w=-0.0177641479719743 w-  bank=f alpha=0.001 R=1876.43862153827 G_phys=0.00053292443915923 G_eff=5.3292443915923e-07
Ro1n13f1 htap13n o1p 1869.96724424012
* o1 input 14 w=-0.162077236015947 w-  bank=n alpha=1 R=205663.263717389 G_phys=4.86231708047842e-06 G_eff=4.86231708047842e-06
Ro1n14n1 h14yn o1p 204932.431563304
* o1 input 15 w=+0.156787201998635 w+  bank=n alpha=1 R=212602.386600556 G_phys=4.70361605995906e-06 G_eff=4.70361605995906e-06
Ro1p15n1 h15y o1p 211743.704401511
* o1 input 16 w=-0.00694237968883333 w-  bank=f alpha=0.001 R=4801.42758353441 G_phys=0.000208271390665 G_eff=2.08271390665e-07
Ro1n16f1 htap16n o1p 4815.66663249692
* o1 input 17 w=+0.263424706628807 w+  bank=n alpha=1 R=126538.37128612 G_phys=7.90274119886422e-06 G_eff=7.90274119886422e-06
Ro1p17n1 h17y o1p 126755.581854124
* o1 input 18 w=+0.403807796552332 w+  bank=n alpha=1 R=82547.5229005725 G_phys=1.211423389657e-05 G_eff=1.211423389657e-05
Ro1p18n1 h18y o1p 82303.1300193033
* o1 input 19 w=+0.415931315874452 w+  bank=n alpha=1 R=80141.4369659891 G_phys=1.24779394762336e-05 G_eff=1.24779394762336e-05
Ro1p19n1 h19y o1p 80136.6662860121
* o1 input 20 w=+0.0719298844689274 w+  bank=n alpha=1 R=463414.248186827 G_phys=2.15789653406782e-06 G_eff=2.15789653406782e-06
Ro1p20n1 h20y o1p 464671.17128529
* o1 input 21 w=-0.387164693396724 w-  bank=n alpha=1 R=86096.0048833198 G_phys=1.16149408019017e-05 G_eff=1.16149408019017e-05
Ro1n21n1 h21yn o1p 86485.899851335
* o1 input 22 w=+0.13881898843949 w+  bank=n alpha=1 R=240120.848797735 G_phys=4.1645696531847e-06 G_eff=4.1645696531847e-06
Ro1p22n1 h22y o1p 241268.463669787
* o1 input 23 w=-0.118143194098524 w-  bank=n alpha=1 R=282143.491952108 G_phys=3.54429582295573e-06 G_eff=3.54429582295573e-06
Ro1n23n1 h23yn o1p 281556.280527232
* o1 input 24 w=-0.494956544406075 w-  bank=n alpha=1 R=67345.9795815646 G_phys=1.48486963321823e-05 G_eff=1.48486963321823e-05
Ro1n24n1 h24yn o1p 67412.1568843425
* o1 input 25 w=-0.0137314432186455 w-  bank=f alpha=0.001 R=2427.51856469617 G_phys=0.000411943296559366 G_eff=4.11943296559366e-07
Ro1n25f1 htap25n o1p 2424.03698865218
* o1 input 26 w=+0.00762307525297978 w+  bank=f alpha=0.001 R=4372.68847901032 G_phys=0.000228692257589393 G_eff=2.28692257589393e-07
Ro1p26f1 htap26 o1p 4353.59645492453
* o1 input 27 w=+0.187160704798257 w+  bank=n alpha=1 R=178100.063094247 G_phys=5.6148211439477e-06 G_eff=5.6148211439477e-06
Ro1p27n1 h27y o1p 178579.729516261
* o1 input 28 w=+0.0939442280900053 w+  bank=n alpha=1 R=354820.450505992 G_phys=2.81832684270016e-06 G_eff=2.81832684270016e-06
Ro1p28n1 h28y o1p 354457.143939337
* o1 input 29 w=+0.0315398664392492 w+  bank=f alpha=0.001 R=1056.86349045069 G_phys=0.000946195993177476 G_eff=9.46195993177476e-07
Ro1p29f1 htap29 o1p 1060.17502052703
* o1 input 30 w=+0.183835448783735 w+  bank=n alpha=1 R=181321.576191471 G_phys=5.51506346351205e-06 G_eff=5.51506346351205e-06
Ro1p30n1 h30y o1p 181442.973702107
* o1 input 31 w=-0.236627512253244 w-  bank=n alpha=1 R=140868.375853351 G_phys=7.09882536759733e-06 G_eff=7.09882536759733e-06
Ro1n31n1 h31yn o1p 140351.11985635
* o1 input 32 w=-0.230869865069063 w-  bank=n alpha=1 R=144381.482283805 G_phys=6.92609595207188e-06 G_eff=6.92609595207188e-06
Ro1n32n1 h32yn o1p 143792.80299057
* o1 bias w-  bank=n alpha=1 R=411699.330459582 G_phys=2.42895707137462e-06 G_eff=2.42895707137462e-06
Ro1bnn1 vrefn o1p 413573.853513909
* single-copy I-to-V: 0 V sum o1p, I dump onto R_IV=33333.3333333333
Vo1p o1p 0 DC 0
Bo1iv 0 o1lin I = i(Vo1p)
Ro1iv o1lin 0 33393.0770317229

* o2 input 1 w=-0.195521390350609 w-  bank=n alpha=1 R=170484.330505015 G_phys=5.86564171051827e-06 G_eff=5.86564171051827e-06
Ro2n1n1 h1yn o2p 170012.214329698
* o2 input 2 w=+0.386445174905558 w+  bank=n alpha=1 R=86256.3061926689 G_phys=1.15933552471668e-05 G_eff=1.15933552471668e-05
Ro2p2n1 h2y o2p 86293.9968336025
* o2 input 3 w=+0.296294588630229 w+  bank=n alpha=1 R=112500.648383197 G_phys=8.88883765890688e-06 G_eff=8.88883765890688e-06
Ro2p3n1 h3y o2p 112186.007255234
* o2 input 4 w=-0.299308681857295 w-  bank=n alpha=1 R=111367.746256108 G_phys=8.97926045571886e-06 G_eff=8.97926045571886e-06
Ro2n4n1 h4yn o2p 111048.639531758
* o2 input 5 w=+0.732671792857329 w+  bank=n alpha=1 R=45495.5870531571 G_phys=2.19801537857199e-05 G_eff=2.19801537857199e-05
Ro2p5n1 h5y o2p 45389.9309627449
* o2 input 6 w=+0.124925987288217 w+  bank=n alpha=1 R=266824.65399637 G_phys=3.7477796186465e-06 G_eff=3.7477796186465e-06
Ro2p6n1 h6y o2p 267706.262902805
* o2 input 7 w=-0.0857938493267301 w-  bank=n alpha=1 R=388528.240601368 G_phys=2.5738154798019e-06 G_eff=2.5738154798019e-06
Ro2n7n1 h7yn o2p 388643.262653024
* o2 input 8 w=-0.0609936542707342 w-  bank=n alpha=1 R=546504.939438057 G_phys=1.82980962812202e-06 G_eff=1.82980962812202e-06
Ro2n8n1 h8yn o2p 548134.666608297
* o2 input 9 w=+0.256981204903229 w+  bank=n alpha=1 R=129711.172246568 G_phys=7.70943614709688e-06 G_eff=7.70943614709688e-06
Ro2p9n1 h9y o2p 129968.666786183
* o2 input 10 w=+0.073638013162671 w+  bank=n alpha=1 R=452664.756987643 G_phys=2.20914039488013e-06 G_eff=2.20914039488013e-06
Ro2p10n1 h10y o2p 453194.40768611
* o2 input 11 w=-0.149208279345328 w-  bank=n alpha=1 R=223401.365390634 G_phys=4.47624838035983e-06 G_eff=4.47624838035983e-06
Ro2n11n1 h11yn o2p 223179.967884936
* o2 input 12 w=-0.475362564845884 w-  bank=n alpha=1 R=70121.9149306388 G_phys=1.42608769453765e-05 G_eff=1.42608769453765e-05
Ro2n12n1 h12yn o2p 70265.9844622279
* o2 input 13 w=-0.0533811781970356 w-  bank=n alpha=1 R=624439.820535554 G_phys=1.60143534591107e-06 G_eff=1.60143534591107e-06
Ro2n13n1 h13yn o2p 626346.954960811
* o2 input 14 w=+0.279456004632752 w+  bank=n alpha=1 R=119279.359830319 G_phys=8.38368013898257e-06 G_eff=8.38368013898257e-06
Ro2p14n1 h14y o2p 119828.628987538
* o2 input 15 w=-0.0744870090943736 w-  bank=n alpha=1 R=447505.326614748 G_phys=2.23461027283121e-06 G_eff=2.23461027283121e-06
Ro2n15n1 h15yn o2p 447466.136961104
* o2 input 16 w=-0.0222148593491043 w-  bank=f alpha=0.001 R=1500.49715865869 G_phys=0.000666445780473128 G_eff=6.66445780473128e-07
Ro2n16f1 htap16n o2p 1507.31368522633
* o2 input 17 w=+0.0088751960388594 w+  bank=f alpha=0.001 R=3755.78558348297 G_phys=0.000266255881165782 G_eff=2.66255881165782e-07
Ro2p17f1 htap17 o2p 3738.27719466689
* o2 input 18 w=-0.194172060066752 w-  bank=n alpha=1 R=171669.051262443 G_phys=5.82516180200256e-06 G_eff=5.82516180200256e-06
Ro2n18n1 h18yn o2p 171295.5264931
* o2 input 19 w=+0.341327626188232 w+  bank=n alpha=1 R=97657.8828546125 G_phys=1.0239828785647e-05 G_eff=1.0239828785647e-05
Ro2p19n1 h19y o2p 98107.5308193743
* o2 input 20 w=-0.0323870183321868 w-  bank=f alpha=0.001 R=1029.21896024637 G_phys=0.000971610549965604 G_eff=9.71610549965604e-07
Ro2n20f1 htap20n o2p 1031.50623983691
* o2 input 21 w=-0.0999542141187652 w-  bank=n alpha=1 R=333486.022847689 G_phys=2.99862642356296e-06 G_eff=2.99862642356296e-06
Ro2n21n1 h21yn o2p 333187.593547073
* o2 input 22 w=+0.693789300406694 w+  bank=n alpha=1 R=48045.3263170729 G_phys=2.08136790122008e-05 G_eff=2.08136790122008e-05
Ro2p22n1 h22y o2p 47811.1852209447
* o2 input 23 w=+0.0972685864670828 w+  bank=n alpha=1 R=342693.715864925 G_phys=2.91805759401248e-06 G_eff=2.91805759401248e-06
Ro2p23n1 h23y o2p 342066.382391118
* o2 input 24 w=-0.0293783170287994 w-  bank=f alpha=0.001 R=1134.6236512002 G_phys=0.000881349510863982 G_eff=8.81349510863982e-07
Ro2n24f1 htap24n o2p 1136.37914162814
* o2 input 25 w=+0.0497492024826392 w+  bank=n alpha=1 R=670027.491294269 G_phys=1.49247607447918e-06 G_eff=1.49247607447918e-06
Ro2p25n1 h25y o2p 672833.680949461
* o2 input 26 w=-0.466063512962686 w-  bank=n alpha=1 R=71521.0103477937 G_phys=1.39819053888806e-05 G_eff=1.39819053888806e-05
Ro2n26n1 h26yn o2p 71750.2497479409
* o2 input 27 w=+0.194887582685885 w+  bank=n alpha=1 R=171038.774630702 G_phys=5.84662748057655e-06 G_eff=5.84662748057655e-06
Ro2p27n1 h27y o2p 171674.567425191
* o2 input 28 w=+0.209047565197081 w+  bank=n alpha=1 R=159453.344036359 G_phys=6.27142695591242e-06 G_eff=6.27142695591242e-06
Ro2p28n1 h28y o2p 159928.352807323
* o2 input 29 w=+0.00919963467526149 w+  bank=f alpha=0.001 R=3623.33228546229 G_phys=0.000275989040257845 G_eff=2.75989040257845e-07
Ro2p29f1 htap29 o2p 3610.5660638754
* o2 input 30 w=-0.379437042796868 w-  bank=n alpha=1 R=87849.4442388387 G_phys=1.13831112839061e-05 G_eff=1.13831112839061e-05
Ro2n30n1 h30yn o2p 87829.992084115
* o2 input 31 w=-0.216631724491884 w-  bank=n alpha=1 R=153870.96885979 G_phys=6.49895173475653e-06 G_eff=6.49895173475653e-06
Ro2n31n1 h31yn o2p 154127.602038875
* o2 input 32 w=+0.139103822260271 w+  bank=n alpha=1 R=239629.169002738 G_phys=4.17311466780814e-06 G_eff=4.17311466780814e-06
Ro2p32n1 h32y o2p 239344.967328097
* o2 bias w+  bank=f alpha=0.001 R=1034.77721072674 G_phys=0.000966391595827364 G_eff=9.66391595827364e-07
Ro2bpf1 tapref o2p 1038.12993961751
* single-copy I-to-V: 0 V sum o2p, I dump onto R_IV=33333.3333333333
Vo2p o2p 0 DC 0
Bo2iv 0 o2lin I = i(Vo2p)
Ro2iv o2lin 0 33226.1211608335

* o3 input 1 w=-0.100595944434035 w-  bank=n alpha=1 R=331358.620080271 G_phys=3.01787833302104e-06 G_eff=3.01787833302104e-06
Ro3n1n1 h1yn o3p 331409.210562653
* o3 input 2 w=-0.265315115107159 w-  bank=n alpha=1 R=125636.767132058 G_phys=7.95945345321476e-06 G_eff=7.95945345321476e-06
Ro3n2n1 h2yn o3p 126257.327166718
* o3 input 3 w=-0.0591677372187977 w-  bank=n alpha=1 R=563370.088162562 G_phys=1.77503211656393e-06 G_eff=1.77503211656393e-06
Ro3n3n1 h3yn o3p 563653.052466122
* o3 input 4 w=-0.0695954531730398 w-  bank=n alpha=1 R=478958.492452868 G_phys=2.08786359519119e-06 G_eff=2.08786359519119e-06
Ro3n4n1 h4yn o3p 479662.722948452
* o3 input 5 w=-0.284313347850547 w-  bank=n alpha=1 R=117241.53503639 G_phys=8.52940043551641e-06 G_eff=8.52940043551641e-06
Ro3n5n1 h5yn o3p 117588.533145519
* o3 input 6 w=+0.314440272159438 w+  bank=n alpha=1 R=106008.473737841 G_phys=9.43320816478313e-06 G_eff=9.43320816478313e-06
Ro3p6n1 h6y o3p 106298.220632283
* o3 input 7 w=-0.349535009995164 w-  bank=n alpha=1 R=95364.7914519193 G_phys=1.04860502998549e-05 G_eff=1.04860502998549e-05
Ro3n7n1 h7yn o3p 95111.241956721
* o3 input 8 w=-0.295696300813859 w-  bank=n alpha=1 R=112728.273034152 G_phys=8.87088902441576e-06 G_eff=8.87088902441576e-06
Ro3n8n1 h8yn o3p 112277.038642174
* o3 input 9 w=-0.735854867565559 w-  bank=n alpha=1 R=45298.7875769723 G_phys=2.20756460269668e-05 G_eff=2.20756460269668e-05
Ro3n9n1 h9yn o3p 45514.094638161
* o3 input 10 w=-0.0859238760568894 w-  bank=n alpha=1 R=387940.289277262 G_phys=2.57771628170668e-06 G_eff=2.57771628170668e-06
Ro3n10n1 h10yn o3p 386377.64250424
* o3 input 11 w=-0.105996934570411 w-  bank=n alpha=1 R=314474.503139436 G_phys=3.17990803711233e-06 G_eff=3.17990803711233e-06
Ro3n11n1 h11yn o3p 315892.890944041
* o3 input 12 w=-0.193541479603888 w-  bank=n alpha=1 R=172228.36883109 G_phys=5.80624438811663e-06 G_eff=5.80624438811663e-06
Ro3n12n1 h12yn o3p 172825.424355129
* o3 input 13 w=-0.351950930756974 w-  bank=n alpha=1 R=94710.172414206 G_phys=1.05585279227092e-05 G_eff=1.05585279227092e-05
Ro3n13n1 h13yn o3p 94255.9247196199
* o3 input 14 w=+0.0402342325324318 w+  bank=n alpha=1 R=828481.898007229 G_phys=1.20702697597296e-06 G_eff=1.20702697597296e-06
Ro3p14n1 h14y o3p 831636.410073207
* o3 input 15 w=+0.188158881095559 w+  bank=n alpha=1 R=177155.248475381 G_phys=5.64476643286676e-06 G_eff=5.64476643286676e-06
Ro3p15n1 h15y o3p 177259.545937064
* o3 input 16 w=+0.204693314484602 w+  bank=n alpha=1 R=162845.246886853 G_phys=6.14079943453807e-06 G_eff=6.14079943453807e-06
Ro3p16n1 h16y o3p 162286.463591409
* o3 input 17 w=+0.153640089266272 w+  bank=n alpha=1 R=216957.263514496 G_phys=4.60920267798816e-06 G_eff=4.60920267798816e-06
Ro3p17n1 h17y o3p 217232.167895595
* o3 input 18 w=+0.463153650429953 w+  bank=n alpha=1 R=71970.3564948468 G_phys=1.38946095128986e-05 G_eff=1.38946095128986e-05
Ro3p18n1 h18y o3p 71870.5927716323
* o3 input 19 w=-0.0426705918571366 w-  bank=n alpha=1 R=781178.134227318 G_phys=1.2801177557141e-06 G_eff=1.2801177557141e-06
Ro3n19n1 h19yn o3p 782321.240968927
* o3 input 20 w=+0.210331327799834 w+  bank=n alpha=1 R=158480.116500076 G_phys=6.30993983399502e-06 G_eff=6.30993983399502e-06
Ro3p20n1 h20y o3p 158265.385514251
* o3 input 21 w=-0.0625815721904128 w-  bank=n alpha=1 R=532638.157953466 G_phys=1.87744716571238e-06 G_eff=1.87744716571238e-06
Ro3n21n1 h21yn o3p 532451.297611
* o3 input 22 w=+0.238697201684848 w+  bank=n alpha=1 R=139646.938037185 G_phys=7.16091605054544e-06 G_eff=7.16091605054544e-06
Ro3p22n1 h22y o3p 139725.638508316
* o3 input 23 w=-0.0558624260671465 w-  bank=n alpha=1 R=596704.004463873 G_phys=1.67587278201439e-06 G_eff=1.67587278201439e-06
Ro3n23n1 h23yn o3p 598372.288715431
* o3 input 24 w=+0.439236044835332 w+  bank=n alpha=1 R=75889.3395140872 G_phys=1.317708134506e-05 G_eff=1.317708134506e-05
Ro3p24n1 h24y o3p 75676.328013677
* o3 input 25 w=+0.113742741787302 w+  bank=n alpha=1 R=293058.992684265 G_phys=3.41228225361907e-06 G_eff=3.41228225361907e-06
Ro3p25n1 h25y o3p 292916.647015609
* o3 input 26 w=-0.433617266896606 w-  bank=n alpha=1 R=76872.7075190056 G_phys=1.30085180068982e-05 G_eff=1.30085180068982e-05
Ro3n26n1 h26yn o3p 76700.0800718884
* o3 input 27 w=+0.230315174630548 w+  bank=n alpha=1 R=144729.210252012 G_phys=6.90945523891643e-06 G_eff=6.90945523891643e-06
Ro3p27n1 h27y o3p 144840.052452882
* o3 input 28 w=-0.12398109066818 w-  bank=n alpha=1 R=268858.203728388 G_phys=3.71943272004541e-06 G_eff=3.71943272004541e-06
Ro3n28n1 h28yn o3p 268154.914687733
* o3 input 29 w=-0.26178305647614 w-  bank=n alpha=1 R=127331.897572108 G_phys=7.85349169428421e-06 G_eff=7.85349169428421e-06
Ro3n29n1 h29yn o3p 127937.490688124
* o3 input 30 w=-0.44647126763401 w-  bank=n alpha=1 R=74659.5262668906 G_phys=1.33941380290203e-05 G_eff=1.33941380290203e-05
Ro3n30n1 h30yn o3p 74310.4672231583
* o3 input 31 w=-0.53039390006668 w-  bank=n alpha=1 R=62846.3738537392 G_phys=1.59118170020004e-05 G_eff=1.59118170020004e-05
Ro3n31n1 h31yn o3p 63155.0881746303
* o3 input 32 w=+0.288818654520262 w+  bank=n alpha=1 R=115412.674394946 G_phys=8.66455963560785e-06 G_eff=8.66455963560785e-06
Ro3p32n1 h32y o3p 115230.337866423
* o3 bias w+  bank=n alpha=1 R=524928.575339756 G_phys=1.90502107711084e-06 G_eff=1.90502107711084e-06
Ro3bpn1 vref o3p 526247.082655791
* single-copy I-to-V: 0 V sum o3p, I dump onto R_IV=33333.3333333333
Vo3p o3p 0 DC 0
Bo3iv 0 o3lin I = i(Vo3p)
Ro3iv o3lin 0 33195.9780429112

* o4 input 1 w=+0.274757256178841 w+  bank=n alpha=1 R=121319.210261863 G_phys=8.24271768536522e-06 G_eff=8.24271768536522e-06
Ro4p1n1 h1y o4p 120907.06887925
* o4 input 2 w=-0.133159767354893 w-  bank=n alpha=1 R=250325.860396666 G_phys=3.99479302064678e-06 G_eff=3.99479302064678e-06
Ro4n2n1 h2yn o4p 249436.471058942
* o4 input 3 w=-0.106623598682841 w-  bank=n alpha=1 R=312626.226699453 G_phys=3.19870796048523e-06 G_eff=3.19870796048523e-06
Ro4n3n1 h3yn o4p 314138.849059908
* o4 input 4 w=+0.10049322803724 w+  bank=n alpha=1 R=331697.309205562 G_phys=3.01479684111719e-06 G_eff=3.01479684111719e-06
Ro4p4n1 h4y o4p 333045.936253582
* o4 input 5 w=-0.195742340683107 w-  bank=n alpha=1 R=170291.890947078 G_phys=5.87227022049321e-06 G_eff=5.87227022049321e-06
Ro4n5n1 h5yn o4p 169967.130704604
* o4 input 6 w=-0.202179592890339 w-  bank=n alpha=1 R=164869.920137851 G_phys=6.06538778671016e-06 G_eff=6.06538778671016e-06
Ro4n6n1 h6yn o4p 164285.026652033
* o4 input 7 w=-0.112561544712497 w-  bank=n alpha=1 R=296134.291853162 G_phys=3.37684634137491e-06 G_eff=3.37684634137491e-06
Ro4n7n1 h7yn o4p 295882.931935674
* o4 input 8 w=+0.0264861793940817 w+  bank=f alpha=0.001 R=1258.5179930021 G_phys=0.000794585381822452 G_eff=7.94585381822452e-07
Ro4p8f1 htap8 o4p 1255.09172750306
* o4 input 9 w=-0.0974936293293829 w-  bank=n alpha=1 R=341902.681873874 G_phys=2.92480887988149e-06 G_eff=2.92480887988149e-06
Ro4n9n1 h9yn o4p 342385.335501132
* o4 input 10 w=-0.296895349286464 w-  bank=n alpha=1 R=112273.006005127 G_phys=8.90686047859392e-06 G_eff=8.90686047859392e-06
Ro4n10n1 h10yn o4p 111835.685338512
* o4 input 11 w=-0.580818210763829 w-  bank=n alpha=1 R=57390.303395441 G_phys=1.74245463229149e-05 G_eff=1.74245463229149e-05
Ro4n11n1 h11yn o4p 57399.4400727446
* o4 input 12 w=-0.276549005245937 w-  bank=n alpha=1 R=120533.188335607 G_phys=8.29647015737811e-06 G_eff=8.29647015737811e-06
Ro4n12n1 h12yn o4p 120844.723665314
* o4 input 13 w=-0.164579538023522 w-  bank=n alpha=1 R=202536.316079398 G_phys=4.93738614070565e-06 G_eff=4.93738614070565e-06
Ro4n13n1 h13yn o4p 202680.180923602
* o4 input 14 w=-0.00939321676538441 w-  bank=f alpha=0.001 R=3548.66007736267 G_phys=0.000281796502961532 G_eff=2.81796502961532e-07
Ro4n14f1 htap14n o4p 3540.45241822526
* o4 input 15 w=-0.0690593814994067 w-  bank=n alpha=1 R=482676.395438319 G_phys=2.0717814449822e-06 G_eff=2.0717814449822e-06
Ro4n15n1 h15yn o4p 482924.636380455
* o4 input 16 w=-0.272869230842632 w-  bank=n alpha=1 R=122158.637052623 G_phys=8.18607692527895e-06 G_eff=8.18607692527895e-06
Ro4n16n1 h16yn o4p 122714.532798136
* o4 input 17 w=+0.168866320874711 w+  bank=n alpha=1 R=197394.798208843 G_phys=5.06598962624132e-06 G_eff=5.06598962624132e-06
Ro4p17n1 h17y o4p 196861.129233137
* o4 input 18 w=-0.0339148293163791 w-  bank=n alpha=1 R=982854.226461786 G_phys=1.01744487949137e-06 G_eff=1.01744487949137e-06
Ro4n18n1 h18yn o4p 980459.809791142
* o4 input 19 w=-0.0805852645818897 w-  bank=n alpha=1 R=413640.552106898 G_phys=2.41755793745669e-06 G_eff=2.41755793745669e-06
Ro4n19n1 h19yn o4p 414196.955131801
* o4 input 20 w=+0.0499049155841609 w+  bank=n alpha=1 R=667936.874417093 G_phys=1.49714746752483e-06 G_eff=1.49714746752483e-06
Ro4p20n1 h20y o4p 670321.72268663
* o4 input 21 w=+0.0630428027700635 w+  bank=n alpha=1 R=528741.29747864 G_phys=1.8912840831019e-06 G_eff=1.8912840831019e-06
Ro4p21n1 h21y o4p 530418.716299309
* o4 input 22 w=+0.077534797791833 w+  bank=n alpha=1 R=429914.493655189 G_phys=2.32604393375499e-06 G_eff=2.32604393375499e-06
Ro4p22n1 h22y o4p 429886.368654977
* o4 input 23 w=+0.0744829629231984 w+  bank=n alpha=1 R=447529.636645958 G_phys=2.23448888769595e-06 G_eff=2.23448888769595e-06
Ro4p23n1 h23y o4p 447560.155512821
* o4 input 24 w=-0.00836970221956497 w-  bank=f alpha=0.001 R=3982.61879083506 G_phys=0.000251091066586949 G_eff=2.51091066586949e-07
Ro4n24f1 htap24n o4p 3994.53769050346
* o4 input 25 w=-0.0959555339157937 w-  bank=n alpha=1 R=347383.126048626 G_phys=2.87866601747381e-06 G_eff=2.87866601747381e-06
Ro4n25n1 h25yn o4p 345650.739197344
* o4 input 26 w=-0.27047998771669 w-  bank=n alpha=1 R=123237.706474047 G_phys=8.1143996315007e-06 G_eff=8.1143996315007e-06
Ro4n26n1 h26yn o4p 123446.722608124
* o4 input 27 w=-0.0478904255869687 w-  bank=n alpha=1 R=696033.349563792 G_phys=1.43671276760906e-06 G_eff=1.43671276760906e-06
Ro4n27n1 h27yn o4p 695155.866146996
* o4 input 28 w=-0.311644423649809 w-  bank=n alpha=1 R=106959.505140351 G_phys=9.34933270949427e-06 G_eff=9.34933270949427e-06
Ro4n28n1 h28yn o4p 106474.586848229
* o4 input 29 w=-0.0286856006407659 w-  bank=f alpha=0.001 R=1162.02319591532 G_phys=0.000860568019222978 G_eff=8.60568019222978e-07
Ro4n29f1 htap29n o4p 1158.35619209343
* o4 input 30 w=-0.016265879828258 w-  bank=f alpha=0.001 R=2049.27945400314 G_phys=0.000487976394847741 G_eff=4.87976394847741e-07
Ro4n30f1 htap30n o4p 2048.16752869004
* o4 input 31 w=-0.119685509607977 w-  bank=n alpha=1 R=278507.677683913 G_phys=3.59056528823931e-06 G_eff=3.59056528823931e-06
Ro4n31n1 h31yn o4p 278434.015038366
* o4 input 32 w=-0.0356690164245122 w-  bank=n alpha=1 R=934517.872223306 G_phys=1.07007049273537e-06 G_eff=1.07007049273537e-06
Ro4n32n1 h32yn o4p 938867.542366527
* o4 bias w+  bank=n alpha=1 R=496540.049452281 G_phys=2.01393623959048e-06 G_eff=2.01393623959048e-06
Ro4bpn1 vref o4p 497753.659350401
* single-copy I-to-V: 0 V sum o4p, I dump onto R_IV=33333.3333333333
Vo4p o4p 0 DC 0
Bo4iv 0 o4lin I = i(Vo4p)
Ro4iv o4lin 0 33237.2259327096

* o5 input 1 w=+0.0860510418468527 w+  bank=n alpha=1 R=387366.99309995 G_phys=2.58153125540558e-06 G_eff=2.58153125540558e-06
Ro5p1n1 h1y o5p 387548.507405371
* o5 input 2 w=-0.140209371980717 w-  bank=n alpha=1 R=237739.695017803 G_phys=4.20628115942151e-06 G_eff=4.20628115942151e-06
Ro5n2n1 h2yn o5p 237785.29816497
* o5 input 3 w=-0.298670153474102 w-  bank=n alpha=1 R=111605.839906008 G_phys=8.96010460422305e-06 G_eff=8.96010460422305e-06
Ro5n3n1 h3yn o5p 112043.166730593
* o5 input 4 w=+0.194023589749981 w+  bank=n alpha=1 R=171800.415487038 G_phys=5.82070769249943e-06 G_eff=5.82070769249943e-06
Ro5p4n1 h4y o5p 171182.386594416
* o5 input 5 w=+0.104223096266613 w+  bank=n alpha=1 R=319826.74212694 G_phys=3.1266928879984e-06 G_eff=3.1266928879984e-06
Ro5p5n1 h5y o5p 320500.513764817
* o5 input 6 w=+0.179601423642336 w+  bank=n alpha=1 R=185596.153178131 G_phys=5.38804270927008e-06 G_eff=5.38804270927008e-06
Ro5p6n1 h6y o5p 185672.854908945
* o5 input 7 w=-0.15816414054373 w-  bank=n alpha=1 R=210751.521923626 G_phys=4.74492421631189e-06 G_eff=4.74492421631189e-06
Ro5n7n1 h7yn o5p 211418.164325707
* o5 input 8 w=-0.249576912278698 w-  bank=n alpha=1 R=133559.362638923 G_phys=7.48730736836095e-06 G_eff=7.48730736836095e-06
Ro5n8n1 h8yn o5p 134020.667513243
* o5 input 9 w=-0.031381439286146 w-  bank=f alpha=0.001 R=1062.19899697364 G_phys=0.00094144317858438 G_eff=9.41443178584379e-07
Ro5n9f1 htap9n o5p 1064.72812309337
* o5 input 10 w=+0.375618440651073 w+  bank=n alpha=1 R=88742.5369094113 G_phys=1.12685532195322e-05 G_eff=1.12685532195322e-05
Ro5p10n1 h10y o5p 88612.4195886822
* o5 input 11 w=+0.0953608962368974 w+  bank=n alpha=1 R=349549.287482848 G_phys=2.86082688710692e-06 G_eff=2.86082688710692e-06
Ro5p11n1 h11y o5p 349455.651035339
* o5 input 12 w=+0.235920649298708 w+  bank=n alpha=1 R=141290.44419138 G_phys=7.07761947896125e-06 G_eff=7.07761947896125e-06
Ro5p12n1 h12y o5p 141688.037748356
* o5 input 13 w=-0.0940916695355706 w-  bank=n alpha=1 R=354264.447616502 G_phys=2.82275008606712e-06 G_eff=2.82275008606712e-06
Ro5n13n1 h13yn o5p 354318.288500966
* o5 input 14 w=+0.00295126144933853 w+  bank=f alpha=0.001 R=11294.6053426762 G_phys=8.85378434801559e-05 G_eff=8.85378434801559e-08
Ro5p14f1 htap14 o5p 11331.2348773939
* o5 input 15 w=+0.529616924207031 w+  bank=n alpha=1 R=62938.572786815 G_phys=1.58885077262109e-05 G_eff=1.58885077262109e-05
Ro5p15n1 h15y o5p 63245.4358047125
* o5 input 16 w=+0.319042125899952 w+  bank=n alpha=1 R=104479.410796637 G_phys=9.57126377699856e-06 G_eff=9.57126377699856e-06
Ro5p16n1 h16y o5p 104703.940283314
* o5 input 17 w=-0.466616152697173 w-  bank=n alpha=1 R=71436.3039956017 G_phys=1.39984845809152e-05 G_eff=1.39984845809152e-05
Ro5n17n1 h17yn o5p 71137.8851086494
* o5 input 18 w=-0.243973793531226 w-  bank=n alpha=1 R=136626.696051546 G_phys=7.31921380593677e-06 G_eff=7.31921380593677e-06
Ro5n18n1 h18yn o5p 136510.898046875
* o5 input 19 w=-0.167620412829882 w-  bank=n alpha=1 R=198862.01668745 G_phys=5.02861238489647e-06 G_eff=5.02861238489647e-06
Ro5n19n1 h19yn o5p 199668.974494233
* o5 input 20 w=+0.191248887162316 w+  bank=n alpha=1 R=174292.953166534 G_phys=5.73746661486949e-06 G_eff=5.73746661486949e-06
Ro5p20n1 h20y o5p 174959.804083884
* o5 input 21 w=+0.174220054558956 w+  bank=n alpha=1 R=191328.91111599 G_phys=5.22660163676868e-06 G_eff=5.22660163676868e-06
Ro5p21n1 h21y o5p 191522.89051196
* o5 input 22 w=-0.14737880105185 w-  bank=n alpha=1 R=226174.545426015 G_phys=4.4213640315555e-06 G_eff=4.4213640315555e-06
Ro5n22n1 h22yn o5p 226942.609902765
* o5 input 23 w=-0.261133636281725 w-  bank=n alpha=1 R=127648.562659203 G_phys=7.83400908845174e-06 G_eff=7.83400908845174e-06
Ro5n23n1 h23yn o5p 128182.900109825
* o5 input 24 w=+0.130521837388059 w+  bank=n alpha=1 R=255385.106434174 G_phys=3.91565512164177e-06 G_eff=3.91565512164177e-06
Ro5p24n1 h24y o5p 255364.826174185
* o5 input 25 w=-0.326372621774105 w-  bank=n alpha=1 R=102132.749837101 G_phys=9.79117865322314e-06 G_eff=9.79117865322314e-06
Ro5n25n1 h25yn o5p 101962.202063217
* o5 input 26 w=+0.16696553546102 w+  bank=n alpha=1 R=199641.99941799 G_phys=5.00896606383059e-06 G_eff=5.00896606383059e-06
Ro5p26n1 h26y o5p 199968.833333892
* o5 input 27 w=-0.105618085709112 w-  bank=n alpha=1 R=315602.513618153 G_phys=3.16854257127337e-06 G_eff=3.16854257127337e-06
Ro5n27n1 h27yn o5p 315023.359957836
* o5 input 28 w=+0.0630335864648206 w+  bank=n alpha=1 R=528818.606124163 G_phys=1.89100759394462e-06 G_eff=1.89100759394462e-06
Ro5p28n1 h28y o5p 529046.286206173
* o5 input 29 w=+0.231531157265063 w+  bank=n alpha=1 R=143969.104318744 G_phys=6.94593471795189e-06 G_eff=6.94593471795189e-06
Ro5p29n1 h29y o5p 143534.062207397
* o5 input 30 w=-0.0894419530377066 w-  bank=n alpha=1 R=372681.188203491 G_phys=2.6832585911312e-06 G_eff=2.6832585911312e-06
Ro5n30n1 h30yn o5p 373165.746237972
* o5 input 31 w=+0.216486138811528 w+  bank=n alpha=1 R=153974.446199316 G_phys=6.49458416434585e-06 G_eff=6.49458416434585e-06
Ro5p31n1 h31y o5p 154636.74654058
* o5 input 32 w=-0.32037829849107 w-  bank=n alpha=1 R=104043.668033472 G_phys=9.6113489547321e-06 G_eff=9.6113489547321e-06
Ro5n32n1 h32yn o5p 104151.285248808
* o5 bias w+  bank=f alpha=0.001 R=14493.185792249 G_phys=6.89979425044561e-05 G_eff=6.89979425044561e-08
Ro5bpf1 tapref o5p 14490.8158259264
* single-copy I-to-V: 0 V sum o5p, I dump onto R_IV=33333.3333333333
Vo5p o5p 0 DC 0
Bo5iv 0 o5lin I = i(Vo5p)
Ro5iv o5lin 0 33497.6001831505

* o6 input 1 w=+0.177051530119574 w+  bank=n alpha=1 R=188269.106236028 G_phys=5.31154590358722e-06 G_eff=5.31154590358722e-06
Ro6p1n1 h1y o6p 188704.948281592
* o6 input 2 w=+0.301592495922723 w+  bank=n alpha=1 R=110524.412191855 G_phys=9.04777487768168e-06 G_eff=9.04777487768168e-06
Ro6p2n1 h2y o6p 110712.536356194
* o6 input 3 w=+0.171870982949934 w+  bank=n alpha=1 R=193943.92678282 G_phys=5.15612948849803e-06 G_eff=5.15612948849803e-06
Ro6p3n1 h3y o6p 193238.42071888
* o6 input 4 w=-0.3405205591368 w-  bank=n alpha=1 R=97889.3415946205 G_phys=1.0215616774104e-05 G_eff=1.0215616774104e-05
Ro6n4n1 h4yn o6p 98057.1856984382
* o6 input 5 w=-0.19025500833844 w-  bank=n alpha=1 R=175203.447333368 G_phys=5.70765025015321e-06 G_eff=5.70765025015321e-06
Ro6n5n1 h5yn o6p 174791.89509628
* o6 input 6 w=+0.141724280050197 w+  bank=n alpha=1 R=235198.466497956 G_phys=4.25172840150592e-06 G_eff=4.25172840150592e-06
Ro6p6n1 h6y o6p 234539.388702738
* o6 input 7 w=-0.0326153624876146 w-  bank=f alpha=0.001 R=1022.01327199694 G_phys=0.000978460874628438 G_eff=9.78460874628438e-07
Ro6n7f1 htap7n o6p 1024.51954773124
* o6 input 8 w=+0.106637930601 w+  bank=n alpha=1 R=312584.210378712 G_phys=3.19913791802999e-06 G_eff=3.19913791802999e-06
Ro6p8n1 h8y o6p 313562.357736425
* o6 input 9 w=+0.167194950685368 w+  bank=n alpha=1 R=199368.062233296 G_phys=5.01584852056104e-06 G_eff=5.01584852056104e-06
Ro6p9n1 h9y o6p 198916.873337425
* o6 input 10 w=-0.113695758135469 w-  bank=n alpha=1 R=293180.096425556 G_phys=3.41087274406406e-06 G_eff=3.41087274406406e-06
Ro6n10n1 h10yn o6p 294162.794977192
* o6 input 11 w=+0.174899957381211 w+  bank=n alpha=1 R=190585.142686343 G_phys=5.24699872143633e-06 G_eff=5.24699872143633e-06
Ro6p11n1 h11y o6p 190622.992187616
* o6 input 12 w=-0.244360694504916 w-  bank=n alpha=1 R=136410.372383611 G_phys=7.33082083514748e-06 G_eff=7.33082083514748e-06
Ro6n12n1 h12yn o6p 136951.33377584
* o6 input 13 w=+0.255772583539878 w+  bank=n alpha=1 R=130324.106172764 G_phys=7.67317750619635e-06 G_eff=7.67317750619635e-06
Ro6p13n1 h13y o6p 130424.105564859
* o6 input 14 w=+0.139949769298614 w+  bank=n alpha=1 R=238180.695119327 G_phys=4.19849307895843e-06 G_eff=4.19849307895843e-06
Ro6p14n1 h14y o6p 237763.656045097
* o6 input 15 w=-0.401168375335584 w-  bank=n alpha=1 R=83090.6307244419 G_phys=1.20350512600675e-05 G_eff=1.20350512600675e-05
Ro6n15n1 h15yn o6p 83253.7589313024
* o6 input 16 w=+0.405832076822582 w+  bank=n alpha=1 R=82135.777916603 G_phys=1.21749623046775e-05 G_eff=1.21749623046775e-05
Ro6p16n1 h16y o6p 82139.9383984437
* o6 input 17 w=-0.113061682974004 w-  bank=n alpha=1 R=294824.315864798 G_phys=3.39185048922012e-06 G_eff=3.39185048922012e-06
Ro6n17n1 h17yn o6p 296192.09127142
* o6 input 18 w=-0.197513353657142 w-  bank=n alpha=1 R=168764.960526141 G_phys=5.92540060971425e-06 G_eff=5.92540060971425e-06
Ro6n18n1 h18yn o6p 169428.493680635
* o6 input 19 w=-0.228990652840289 w-  bank=n alpha=1 R=145566.349193222 G_phys=6.86971958520868e-06 G_eff=6.86971958520868e-06
Ro6n19n1 h19yn o6p 145079.246790473
* o6 input 20 w=-0.216778558754084 w-  bank=n alpha=1 R=153766.744852045 G_phys=6.50335676262251e-06 G_eff=6.50335676262251e-06
Ro6n20n1 h20yn o6p 153304.862364203
* o6 input 21 w=-0.139531541535413 w-  bank=n alpha=1 R=238894.610971336 G_phys=4.18594624606239e-06 G_eff=4.18594624606239e-06
Ro6n21n1 h21yn o6p 239413.992452684
* o6 input 22 w=-0.394983843934915 w-  bank=n alpha=1 R=84391.6373927081 G_phys=1.18495153180474e-05 G_eff=1.18495153180474e-05
Ro6n22n1 h22yn o6p 84653.1032776803
* o6 input 23 w=-0.193849822273603 w-  bank=n alpha=1 R=171954.41781879 G_phys=5.81549466820809e-06 G_eff=5.81549466820809e-06
Ro6n23n1 h23yn o6p 172737.506761207
* o6 input 24 w=-0.0741873589980665 w-  bank=n alpha=1 R=449312.844984846 G_phys=2.22562076994199e-06 G_eff=2.22562076994199e-06
Ro6n24n1 h24yn o6p 449264.895032658
* o6 input 25 w=-0.172655508406202 w-  bank=n alpha=1 R=193062.669364194 G_phys=5.17966525218605e-06 G_eff=5.17966525218605e-06
Ro6n25n1 h25yn o6p 193816.15199784
* o6 input 26 w=+0.0670699610875517 w+  bank=n alpha=1 R=496993.479537295 G_phys=2.01209883262655e-06 G_eff=2.01209883262655e-06
Ro6p26n1 h26y o6p 497538.904062267
* o6 input 27 w=+0.25363855276468 w+  bank=n alpha=1 R=131420.610037384 G_phys=7.60915658294039e-06 G_eff=7.60915658294039e-06
Ro6p27n1 h27y o6p 131805.41498555
* o6 input 28 w=-0.179185579156039 w-  bank=n alpha=1 R=186026.874988115 G_phys=5.37556737468116e-06 G_eff=5.37556737468116e-06
Ro6n28n1 h28yn o6p 185155.440448347
* o6 input 29 w=-0.129923130427228 w-  bank=n alpha=1 R=256561.962629155 G_phys=3.89769391281685e-06 G_eff=3.89769391281685e-06
Ro6n29n1 h29yn o6p 257625.632652282
* o6 input 30 w=-0.169171092451912 w-  bank=n alpha=1 R=197039.179981701 G_phys=5.07513277355737e-06 G_eff=5.07513277355737e-06
Ro6n30n1 h30yn o6p 196458.366396669
* o6 input 31 w=+0.218686712022964 w+  bank=n alpha=1 R=152425.051458238 G_phys=6.56060136068893e-06 G_eff=6.56060136068893e-06
Ro6p31n1 h31y o6p 151782.208567692
* o6 input 32 w=+0.133370937368681 w+  bank=n alpha=1 R=249929.512313385 G_phys=4.00112812106042e-06 G_eff=4.00112812106042e-06
Ro6p32n1 h32y o6p 250965.594884929
* o6 bias w+  bank=n alpha=1 R=514207.987696552 G_phys=1.94473836254393e-06 G_eff=1.94473836254393e-06
Ro6bpn1 vref o6p 515256.527292212
* single-copy I-to-V: 0 V sum o6p, I dump onto R_IV=33333.3333333333
Vo6p o6p 0 DC 0
Bo6iv 0 o6lin I = i(Vo6p)
Ro6iv o6lin 0 33310.4418657601

* o7 input 1 w=+0.130193574665561 w+  bank=n alpha=1 R=256029.020010853 G_phys=3.90580723996683e-06 G_eff=3.90580723996683e-06
Ro7p1n1 h1y o7p 254805.45384945
* o7 input 2 w=+0.394190134763453 w+  bank=n alpha=1 R=84561.5615249634 G_phys=1.18257040429036e-05 G_eff=1.18257040429036e-05
Ro7p2n1 h2y o7p 84873.5051368392
* o7 input 3 w=+0.206617853142924 w+  bank=n alpha=1 R=161328.427463021 G_phys=6.19853559428773e-06 G_eff=6.19853559428773e-06
Ro7p3n1 h3y o7p 161985.95831025
* o7 input 4 w=-0.378033462280536 w-  bank=n alpha=1 R=88175.6158098959 G_phys=1.13410038684161e-05 G_eff=1.13410038684161e-05
Ro7n4n1 h4yn o7p 88242.1364992014
* o7 input 5 w=-0.580108461232067 w-  bank=n alpha=1 R=57460.5191286783 G_phys=1.7403253836962e-05 G_eff=1.7403253836962e-05
Ro7n5n1 h5yn o7p 57676.9226055895
* o7 input 6 w=+0.107934080055711 w+  bank=n alpha=1 R=308830.476121427 G_phys=3.23802240167132e-06 G_eff=3.23802240167132e-06
Ro7p6n1 h6y o7p 308154.505150974
* o7 input 7 w=+0.101501144533757 w+  bank=n alpha=1 R=328403.521816913 G_phys=3.04503433601271e-06 G_eff=3.04503433601271e-06
Ro7p7n1 h7y o7p 330009.861878693
* o7 input 8 w=+0.0692471666647439 w+  bank=n alpha=1 R=481367.468718463 G_phys=2.07741499994232e-06 G_eff=2.07741499994232e-06
Ro7p8n1 h8y o7p 480374.196358829
* o7 input 9 w=-0.335430638558454 w-  bank=n alpha=1 R=99374.7424999297 G_phys=1.00629191567536e-05 G_eff=1.00629191567536e-05
Ro7n9n1 h9yn o7p 99791.7979734785
* o7 input 10 w=+0.101094797691112 w+  bank=n alpha=1 R=329723.527764315 G_phys=3.03284393073337e-06 G_eff=3.03284393073337e-06
Ro7p10n1 h10y o7p 329989.477679419
* o7 input 11 w=-0.148243371766924 w-  bank=n alpha=1 R=224855.472025703 G_phys=4.44730115300771e-06 G_eff=4.44730115300771e-06
Ro7n11n1 h11yn o7p 225699.516359585
* o7 input 12 w=-0.334713947003149 w-  bank=n alpha=1 R=99587.5243077928 G_phys=1.00414184100945e-05 G_eff=1.00414184100945e-05
Ro7n12n1 h12yn o7p 99384.9287735848
* o7 input 13 w=-0.322800486422993 w-  bank=n alpha=1 R=103262.958809962 G_phys=9.68401459268979e-06 G_eff=9.68401459268979e-06
Ro7n13n1 h13yn o7p 103699.014863767
* o7 input 14 w=-0.104357857187523 w-  bank=n alpha=1 R=319413.73876081 G_phys=3.13073571562568e-06 G_eff=3.13073571562568e-06
Ro7n14n1 h14yn o7p 318494.556306377
* o7 input 15 w=+0.182195051802482 w+  bank=n alpha=1 R=182954.108816688 G_phys=5.46585155407446e-06 G_eff=5.46585155407446e-06
Ro7p15n1 h15y o7p 183216.832785424
* o7 input 16 w=+0.0146234127477982 w+  bank=f alpha=0.001 R=2279.44966802309 G_phys=0.000438702382433947 G_eff=4.38702382433947e-07
Ro7p16f1 htap16 o7p 2286.28111391153
* o7 input 17 w=-0.0268461940667064 w-  bank=f alpha=0.001 R=1241.64092871071 G_phys=0.000805385822001192 G_eff=8.05385822001192e-07
Ro7n17f1 htap17n o7p 1242.52715036733
* o7 input 18 w=+0.263886686193095 w+  bank=n alpha=1 R=126316.843847674 G_phys=7.91660058579284e-06 G_eff=7.91660058579284e-06
Ro7p18n1 h18y o7p 125723.115464151
* o7 input 19 w=+0.184182739421503 w+  bank=n alpha=1 R=180979.680495738 G_phys=5.52548218264508e-06 G_eff=5.52548218264508e-06
Ro7p19n1 h19y o7p 180147.283487488
* o7 input 20 w=-0.16994338127458 w-  bank=n alpha=1 R=196143.757311009 G_phys=5.09830143823739e-06 G_eff=5.09830143823739e-06
Ro7n20n1 h20yn o7p 196978.182768102
* o7 input 21 w=-0.17515931490212 w-  bank=n alpha=1 R=190302.94421944 G_phys=5.25477944706359e-06 G_eff=5.25477944706359e-06
Ro7n21n1 h21yn o7p 189678.874210748
* o7 input 22 w=+0.170460541565249 w+  bank=n alpha=1 R=195548.67670401 G_phys=5.11381624695746e-06 G_eff=5.11381624695746e-06
Ro7p22n1 h22y o7p 195511.025390764
* o7 input 23 w=-0.342102206419994 w-  bank=n alpha=1 R=97436.7680412165 G_phys=1.02630661925998e-05 G_eff=1.02630661925998e-05
Ro7n23n1 h23yn o7p 97475.068665654
* o7 input 24 w=-0.0940891241579366 w-  bank=n alpha=1 R=354274.031474461 G_phys=2.8226737247381e-06 G_eff=2.8226737247381e-06
Ro7n24n1 h24yn o7p 353649.815195177
* o7 input 25 w=-0.147263798833488 w-  bank=n alpha=1 R=226351.171145758 G_phys=4.41791396500465e-06 G_eff=4.41791396500465e-06
Ro7n25n1 h25yn o7p 226288.460786381
* o7 input 26 w=-0.0975787524659246 w-  bank=n alpha=1 R=341604.421976738 G_phys=2.92736257397774e-06 G_eff=2.92736257397774e-06
Ro7n26n1 h26yn o7p 341595.302484395
* o7 input 27 w=-0.201262065009158 w-  bank=n alpha=1 R=165621.540908947 G_phys=6.03786195027474e-06 G_eff=6.03786195027474e-06
Ro7n27n1 h27yn o7p 166403.092003373
* o7 input 28 w=-0.060609790215781 w-  bank=n alpha=1 R=549966.155874506 G_phys=1.81829370647343e-06 G_eff=1.81829370647343e-06
Ro7n28n1 h28yn o7p 548843.030618301
* o7 input 29 w=-0.355920486311588 w-  bank=n alpha=1 R=93653.8766811862 G_phys=1.06776145893477e-05 G_eff=1.06776145893477e-05
Ro7n29n1 h29yn o7p 93211.5578989175
* o7 input 30 w=+0.0702967455487947 w+  bank=n alpha=1 R=474180.320484337 G_phys=2.10890236646384e-06 G_eff=2.10890236646384e-06
Ro7p30n1 h30y o7p 473475.071480346
* o7 input 31 w=+0.188674793501044 w+  bank=n alpha=1 R=176670.835116874 G_phys=5.66024380503133e-06 G_eff=5.66024380503133e-06
Ro7p31n1 h31y o7p 176109.927164157
* o7 input 32 w=-0.221533996080022 w-  bank=n alpha=1 R=150465.995843332 G_phys=6.64601988240065e-06 G_eff=6.64601988240065e-06
Ro7n32n1 h32yn o7p 149921.560880513
* o7 bias w+  bank=n alpha=1 R=694833.256669366 G_phys=1.43919421012378e-06 G_eff=1.43919421012378e-06
Ro7bpn1 vref o7p 695289.603182466
* single-copy I-to-V: 0 V sum o7p, I dump onto R_IV=33333.3333333333
Vo7p o7p 0 DC 0
Bo7iv 0 o7lin I = i(Vo7p)
Ro7iv o7lin 0 33346.050695274

* o8 input 1 w=-0.264579445854062 w-  bank=n alpha=1 R=125986.103061534 G_phys=7.93738337562187e-06 G_eff=7.93738337562187e-06
Ro8n1n1 h1yn o8p 126429.526303422
* o8 input 2 w=-0.461651647659873 w-  bank=n alpha=1 R=72204.5150327114 G_phys=1.38495494297962e-05 G_eff=1.38495494297962e-05
Ro8n2n1 h2yn o8p 72553.1834788282
* o8 input 3 w=-0.248506615035073 w-  bank=n alpha=1 R=134134.591663199 G_phys=7.45519845105219e-06 G_eff=7.45519845105219e-06
Ro8n3n1 h3yn o8p 134399.442304172
* o8 input 4 w=-0.0596907059046396 w-  bank=n alpha=1 R=558434.22905043 G_phys=1.79072117713919e-06 G_eff=1.79072117713919e-06
Ro8n4n1 h4yn o8p 558157.986582386
* o8 input 5 w=-0.142952779428107 w-  bank=n alpha=1 R=233177.231437442 G_phys=4.28858338284322e-06 G_eff=4.28858338284322e-06
Ro8n5n1 h5yn o8p 233947.462104737
* o8 input 6 w=+0.230947580946818 w+  bank=n alpha=1 R=144332.896654195 G_phys=6.92842742840454e-06 G_eff=6.92842742840454e-06
Ro8p6n1 h6y o8p 143952.305434513
* o8 input 7 w=+0.224542704495923 w+  bank=n alpha=1 R=148449.861277673 G_phys=6.7362811348777e-06 G_eff=6.7362811348777e-06
Ro8p7n1 h7y o8p 148333.104700441
* o8 input 8 w=-0.0814289785611842 w-  bank=n alpha=1 R=409354.678424307 G_phys=2.44286935683553e-06 G_eff=2.44286935683553e-06
Ro8n8n1 h8yn o8p 407744.82062834
* o8 input 9 w=+0.151871407153412 w+  bank=n alpha=1 R=219483.93024147 G_phys=4.55614221460235e-06 G_eff=4.55614221460235e-06
Ro8p9n1 h9y o8p 219332.00838735
* o8 input 10 w=-0.0439376442611886 w-  bank=n alpha=1 R=758650.899333209 G_phys=1.31812932783566e-06 G_eff=1.31812932783566e-06
Ro8n10n1 h10yn o8p 759684.658265146
* o8 input 11 w=-0.0114777570667242 w-  bank=f alpha=0.001 R=2904.16787352748 G_phys=0.000344332712001725 G_eff=3.44332712001725e-07
Ro8n11f1 htap11n o8p 2905.76733687142
* o8 input 12 w=-0.184091969163629 w-  bank=n alpha=1 R=181068.91617692 G_phys=5.52275907490888e-06 G_eff=5.52275907490888e-06
Ro8n12n1 h12yn o8p 181192.227045737
* o8 input 13 w=+0.167375709493599 w+  bank=n alpha=1 R=199152.753014069 G_phys=5.02127128480798e-06 G_eff=5.02127128480798e-06
Ro8p13n1 h13y o8p 200064.484123594
* o8 input 14 w=+0.639794426458427 w+  bank=n alpha=1 R=52100.068326399 G_phys=1.91938327937528e-05 G_eff=1.91938327937528e-05
Ro8p14n1 h14y o8p 52107.3031611925
* o8 input 15 w=+0.00251732875304732 w+  bank=f alpha=0.001 R=13241.5495167177 G_phys=7.55198625914195e-05 G_eff=7.55198625914195e-08
Ro8p15f1 htap15 o8p 13257.9090089659
* o8 input 16 w=+0.510552134317183 w+  bank=n alpha=1 R=65288.7944106113 G_phys=1.53165640295155e-05 G_eff=1.53165640295155e-05
Ro8p16n1 h16y o8p 65273.2875896694
* o8 input 17 w=-0.402994248540282 w-  bank=n alpha=1 R=82714.166403299 G_phys=1.20898274562085e-05 G_eff=1.20898274562085e-05
Ro8n17n1 h17yn o8p 82800.2485168153
* o8 input 18 w=+0.141582671709231 w+  bank=n alpha=1 R=235433.707606466 G_phys=4.24748015127692e-06 G_eff=4.24748015127692e-06
Ro8p18n1 h18y o8p 234756.869360361
* o8 input 19 w=+0.181760587882604 w+  bank=n alpha=1 R=183391.425620073 G_phys=5.45281763647812e-06 G_eff=5.45281763647812e-06
Ro8p19n1 h19y o8p 183061.225270563
* o8 input 20 w=+0.465247625040388 w+  bank=n alpha=1 R=71646.4341552301 G_phys=1.39574287512116e-05 G_eff=1.39574287512116e-05
Ro8p20n1 h20y o8p 71991.2777990465
* o8 input 21 w=-0.129997678502292 w-  bank=n alpha=1 R=256414.835382969 G_phys=3.89993035506876e-06 G_eff=3.89993035506876e-06
Ro8n21n1 h21yn o8p 256676.873706147
* o8 input 22 w=+0.727771195072513 w+  bank=n alpha=1 R=45801.9409932982 G_phys=2.18331358521754e-05 G_eff=2.18331358521754e-05
Ro8p22n1 h22y o8p 46008.4563742468
* o8 input 23 w=+0.0590279674258587 w+  bank=n alpha=1 R=564704.068036922 G_phys=1.77083902277576e-06 G_eff=1.77083902277576e-06
Ro8p23n1 h23y o8p 563721.089682815
* o8 input 24 w=-0.0219880792573176 w-  bank=f alpha=0.001 R=1515.97294803456 G_phys=0.000659642377719527 G_eff=6.59642377719527e-07
Ro8n24f1 htap24n o8p 1508.99477770902
* o8 input 25 w=-0.000673889145733125 w-  bank=f alpha=0.001 R=49464.1196469635 G_phys=2.02166743719938e-05 G_eff=2.02166743719938e-08
Ro8n25f1 htap25n o8p 49479.8102681562
* o8 input 26 w=-0.0895992045192751 w-  bank=n alpha=1 R=372027.112430027 G_phys=2.68797613557825e-06 G_eff=2.68797613557825e-06
Ro8n26n1 h26yn o8p 373512.334873119
* o8 input 27 w=-0.161030155307918 w-  bank=n alpha=1 R=207000.56625788 G_phys=4.83090465923753e-06 G_eff=4.83090465923753e-06
Ro8n27n1 h27yn o8p 206973.288903188
* o8 input 28 w=-0.0515875057732319 w-  bank=n alpha=1 R=646151.288644577 G_phys=1.54762517319696e-06 G_eff=1.54762517319696e-06
Ro8n28n1 h28yn o8p 648043.510880227
* o8 input 29 w=-0.167333727666792 w-  bank=n alpha=1 R=199202.71781496 G_phys=5.02001183000377e-06 G_eff=5.02001183000377e-06
Ro8n29n1 h29yn o8p 200062.784469845
* o8 input 30 w=+0.117154510339097 w+  bank=n alpha=1 R=284524.541452582 G_phys=3.5146353101729e-06 G_eff=3.5146353101729e-06
Ro8p30n1 h30y o8p 284345.466373823
* o8 input 31 w=-0.114263857072683 w-  bank=n alpha=1 R=291722.458766031 G_phys=3.42791571218049e-06 G_eff=3.42791571218049e-06
Ro8n31n1 h31yn o8p 291124.477325316
* o8 input 32 w=+0.185068242761295 w+  bank=n alpha=1 R=180113.739861503 G_phys=5.55204728283885e-06 G_eff=5.55204728283885e-06
Ro8p32n1 h32y o8p 179950.808835406
* o8 bias w+  bank=n alpha=1 R=473927.47001289 G_phys=2.11002751111431e-06 G_eff=2.11002751111431e-06
Ro8bpn1 vref o8p 472486.303792187
* single-copy I-to-V: 0 V sum o8p, I dump onto R_IV=33333.3333333333
Vo8p o8p 0 DC 0
Bo8iv 0 o8lin I = i(Vo8p)
Ro8iv o8lin 0 33422.2556646898

* o9 input 1 w=-0.342788496026982 w-  bank=n alpha=1 R=97241.6919461309 G_phys=1.02836548808095e-05 G_eff=1.02836548808095e-05
Ro9n1n1 h1yn o9p 96765.2123442163
* o9 input 2 w=+0.117901804588507 w+  bank=n alpha=1 R=282721.146208671 G_phys=3.5370541376552e-06 G_eff=3.5370541376552e-06
Ro9p2n1 h2y o9p 282482.564854992
* o9 input 3 w=-0.555835720214104 w-  bank=n alpha=1 R=59969.7574680763 G_phys=1.66750716064231e-05 G_eff=1.66750716064231e-05
Ro9n3n1 h3yn o9p 60080.1744606312
* o9 input 4 w=+0.355136587925528 w+  bank=n alpha=1 R=93860.6003060526 G_phys=1.06540976377658e-05 G_eff=1.06540976377658e-05
Ro9p4n1 h4y o9p 93414.6220990096
* o9 input 5 w=+0.236432436172994 w+  bank=n alpha=1 R=140984.603774686 G_phys=7.09297308518982e-06 G_eff=7.09297308518982e-06
Ro9p5n1 h5y o9p 141339.96773178
* o9 input 6 w=-0.00589463242951189 w-  bank=f alpha=0.001 R=5654.86206848924 G_phys=0.000176838972885357 G_eff=1.76838972885357e-07
Ro9n6f1 htap6n o9p 5665.46258112144
* o9 input 7 w=-0.175810166557473 w-  bank=n alpha=1 R=189598.440101794 G_phys=5.27430499672418e-06 G_eff=5.27430499672418e-06
Ro9n7n1 h7yn o9p 190271.503822131
* o9 input 8 w=+0.162552656301944 w+  bank=n alpha=1 R=205061.757166343 G_phys=4.87657968905832e-06 G_eff=4.87657968905832e-06
Ro9p8n1 h8y o9p 204616.78262693
* o9 input 9 w=-0.443497798175432 w-  bank=n alpha=1 R=75160.0875370025 G_phys=1.3304933945263e-05 G_eff=1.3304933945263e-05
Ro9n9n1 h9yn o9p 75108.113967907
* o9 input 10 w=+0.114863161009978 w+  bank=n alpha=1 R=290200.383136224 G_phys=3.44589483029933e-06 G_eff=3.44589483029933e-06
Ro9p10n1 h10y o9p 290733.916363579
* o9 input 11 w=-0.051706338551111 w-  bank=n alpha=1 R=644666.287874624 G_phys=1.55119015653333e-06 G_eff=1.55119015653333e-06
Ro9n11n1 h11yn o9p 647158.898399827
* o9 input 12 w=-0.247913853258797 w-  bank=n alpha=1 R=134455.307338298 G_phys=7.43741559776392e-06 G_eff=7.43741559776392e-06
Ro9n12n1 h12yn o9p 134648.244977557
* o9 input 13 w=+0.0720916431840902 w+  bank=n alpha=1 R=462374.442599605 G_phys=2.16274929552271e-06 G_eff=2.16274929552271e-06
Ro9p13n1 h13y o9p 464218.589683554
* o9 input 14 w=+0.00473033723811417 w+  bank=f alpha=0.001 R=7046.71393505597 G_phys=0.000141910117143425 G_eff=1.41910117143425e-07
Ro9p14f1 htap14 o9p 7051.12307779029
* o9 input 15 w=-0.290577914446662 w-  bank=n alpha=1 R=114713.925856371 G_phys=8.71733743339986e-06 G_eff=8.71733743339986e-06
Ro9n15n1 h15yn o9p 114753.445696078
* o9 input 16 w=-0.0531648681945055 w-  bank=n alpha=1 R=626980.456556052 G_phys=1.59494604583516e-06 G_eff=1.59494604583516e-06
Ro9n16n1 h16yn o9p 625784.844392045
* o9 input 17 w=+0.0157425177085947 w+  bank=f alpha=0.001 R=2117.40802521917 G_phys=0.000472275531257841 G_eff=4.72275531257841e-07
Ro9p17f1 htap17 o9p 2118.32895823648
* o9 input 18 w=-0.104777957691913 w-  bank=n alpha=1 R=318133.06985183 G_phys=3.14333873075738e-06 G_eff=3.14333873075738e-06
Ro9n18n1 h18yn o9p 318520.269846501
* o9 input 19 w=-0.368259428743895 w-  bank=n alpha=1 R=90515.8992046201 G_phys=1.10477828623168e-05 G_eff=1.10477828623168e-05
Ro9n19n1 h19yn o9p 90766.8539742052
* o9 input 20 w=+0.100989358745228 w+  bank=n alpha=1 R=330067.778897631 G_phys=3.02968076235683e-06 G_eff=3.02968076235683e-06
Ro9p20n1 h20y o9p 330962.099731795
* o9 input 21 w=+0.084258883556939 w+  bank=n alpha=1 R=395606.15956664 G_phys=2.52776650670817e-06 G_eff=2.52776650670817e-06
Ro9p21n1 h21y o9p 394896.321503484
* o9 input 22 w=+0.093068688723566 w+  bank=n alpha=1 R=358158.40741391 G_phys=2.79206066170698e-06 G_eff=2.79206066170698e-06
Ro9p22n1 h22y o9p 357927.603039136
* o9 input 23 w=+0.153137872499505 w+  bank=n alpha=1 R=217668.776438311 G_phys=4.59413617498515e-06 G_eff=4.59413617498515e-06
Ro9p23n1 h23y o9p 217976.312406046
* o9 input 24 w=+0.0107021071757068 w+  bank=f alpha=0.001 R=3114.65142201137 G_phys=0.000321063215271205 G_eff=3.21063215271205e-07
Ro9p24f1 htap24 o9p 3118.11998449483
* o9 input 25 w=+0.151859492007221 w+  bank=n alpha=1 R=219501.151312611 G_phys=4.55578476021664e-06 G_eff=4.55578476021664e-06
Ro9p25n1 h25y o9p 219634.022121991
* o9 input 26 w=-0.0745603298060184 w-  bank=n alpha=1 R=447065.261380358 G_phys=2.23680989418055e-06 G_eff=2.23680989418055e-06
Ro9n26n1 h26yn o9p 446327.926120327
* o9 input 27 w=+0.475223780202243 w+  bank=n alpha=1 R=70142.3933775947 G_phys=1.42567134060673e-05 G_eff=1.42567134060673e-05
Ro9p27n1 h27y o9p 69893.2683588165
* o9 input 28 w=+0.715956917954612 w+  bank=n alpha=1 R=46557.736223238 G_phys=2.14787075386384e-05 G_eff=2.14787075386384e-05
Ro9p28n1 h28y o9p 46658.9411620806
* o9 input 29 w=-0.520384445309866 w-  bank=n alpha=1 R=64055.2069412544 G_phys=1.5611533359296e-05 G_eff=1.5611533359296e-05
Ro9n29n1 h29yn o9p 63976.0029417389
* o9 input 30 w=+0.217731604854565 w+  bank=n alpha=1 R=153093.683186685 G_phys=6.53194814563695e-06 G_eff=6.53194814563695e-06
Ro9p30n1 h30y o9p 153289.045935606
* o9 input 31 w=-0.123913004875871 w-  bank=n alpha=1 R=269005.931756111 G_phys=3.71739014627614e-06 G_eff=3.71739014627614e-06
Ro9n31n1 h31yn o9p 269730.346491594
* o9 input 32 w=+0.0869405958454977 w+  bank=n alpha=1 R=383403.552841644 G_phys=2.60821787536493e-06 G_eff=2.60821787536493e-06
Ro9p32n1 h32y o9p 383966.016240287
* o9 bias w-  bank=f alpha=0.001 R=4242.12569305226 G_phys=0.000235730874650366 G_eff=2.35730874650366e-07
Ro9bnf1 taprefn o9p 4260.28520843495
* single-copy I-to-V: 0 V sum o9p, I dump onto R_IV=33333.3333333333
Vo9p o9p 0 DC 0
Bo9iv 0 o9lin I = i(Vo9p)
Ro9iv o9lin 0 33247.5371098512

* o10 input 1 w=-0.0381763956958746 w-  bank=n alpha=1 R=873139.874148344 G_phys=1.14529187087624e-06 G_eff=1.14529187087624e-06
Ro10n1n1 h1yn o10p 871929.220539816
* o10 input 2 w=+0.410781186996451 w+  bank=n alpha=1 R=81146.2023785947 G_phys=1.23234356098935e-05 G_eff=1.23234356098935e-05
Ro10p2n1 h2y o10p 81374.6190544514
* o10 input 3 w=+0.475033421735393 w+  bank=n alpha=1 R=70170.5012913827 G_phys=1.42510026520618e-05 G_eff=1.42510026520618e-05
Ro10p3n1 h3y o10p 70035.594390679
* o10 input 4 w=+0.0271427582394968 w+  bank=f alpha=0.001 R=1228.07465030685 G_phys=0.000814282747184905 G_eff=8.14282747184905e-07
Ro10p4f1 htap4 o10p 1223.20770085386
* o10 input 5 w=+0.0212799641995083 w+  bank=f alpha=0.001 R=1566.41867537087 G_phys=0.00063839892598525 G_eff=6.3839892598525e-07
Ro10p5f1 htap5 o10p 1566.74760811473
* o10 input 6 w=+0.0201273268189427 w+  bank=f alpha=0.001 R=1656.12322158758 G_phys=0.00060381980456828 G_eff=6.0381980456828e-07
Ro10p6f1 htap6 o10p 1663.24268148637
* o10 input 7 w=-0.036291550108304 w-  bank=n alpha=1 R=918487.450490747 G_phys=1.08874650324912e-06 G_eff=1.08874650324912e-06
Ro10n7n1 h7yn o10p 921823.737120029
* o10 input 8 w=+0.0509688710938526 w+  bank=n alpha=1 R=653993.949992621 G_phys=1.52906613281558e-06 G_eff=1.52906613281558e-06
Ro10p8n1 h8y o10p 653384.909067793
* o10 input 9 w=-0.135969386219015 w-  bank=n alpha=1 R=245153.223532546 G_phys=4.07908158657046e-06 G_eff=4.07908158657046e-06
Ro10n9n1 h9yn o10p 244323.121274344
* o10 input 10 w=+0.542965243347564 w+  bank=n alpha=1 R=61391.2837731971 G_phys=1.62889573004269e-05 G_eff=1.62889573004269e-05
Ro10p10n1 h10y o10p 61216.7375099864
* o10 input 11 w=+0.200790198383509 w+  bank=n alpha=1 R=166010.759497666 G_phys=6.02370595150528e-06 G_eff=6.02370595150528e-06
Ro10p11n1 h11y o10p 165653.849970069
* o10 input 12 w=-0.0602452386161185 w-  bank=n alpha=1 R=553294.071017507 G_phys=1.80735715848356e-06 G_eff=1.80735715848356e-06
Ro10n12n1 h12yn o10p 555265.486312569
* o10 input 13 w=-0.18784742953156 w-  bank=n alpha=1 R=177448.972373258 G_phys=5.6354228859468e-06 G_eff=5.6354228859468e-06
Ro10n13n1 h13yn o10p 178286.201448027
* o10 input 14 w=-0.0121063802780956 w-  bank=f alpha=0.001 R=2753.36909692523 G_phys=0.000363191408342867 G_eff=3.63191408342867e-07
Ro10n14f1 htap14n o10p 2761.53571903121
* o10 input 15 w=+0.162912924713055 w+  bank=n alpha=1 R=204608.280110646 G_phys=4.88738774139165e-06 G_eff=4.88738774139165e-06
Ro10p15n1 h15y o10p 204270.887207594
* o10 input 16 w=+0.000496602144198326 w+  bank=f alpha=0.001 R=67122.8139522916 G_phys=1.48980643259498e-05 G_eff=1.48980643259498e-08
Ro10p16f1 htap16 o10p 67323.4008920045
* o10 input 17 w=+0.150471984074884 w+  bank=n alpha=1 R=221525.179841748 G_phys=4.51415952224652e-06 G_eff=4.51415952224652e-06
Ro10p17n1 h17y o10p 220811.494686907
* o10 input 18 w=-0.0993574349593851 w-  bank=n alpha=1 R=335489.068804556 G_phys=2.98072304878155e-06 G_eff=2.98072304878155e-06
Ro10n18n1 h18yn o10p 334462.021964894
* o10 input 19 w=-0.0430450321763909 w-  bank=n alpha=1 R=774382.818364248 G_phys=1.29135096529173e-06 G_eff=1.29135096529173e-06
Ro10n19n1 h19yn o10p 771589.042485398
* o10 input 20 w=-0.498578232263262 w-  bank=n alpha=1 R=66856.7762816658 G_phys=1.49573469678979e-05 G_eff=1.49573469678979e-05
Ro10n20n1 h20yn o10p 66693.0002419346
* o10 input 21 w=-0.135185117923925 w-  bank=n alpha=1 R=246575.465149141 G_phys=4.05555353771776e-06 G_eff=4.05555353771776e-06
Ro10n21n1 h21yn o10p 246235.100894633
* o10 input 22 w=+0.00794231626553338 w+  bank=f alpha=0.001 R=4196.92848016985 G_phys=0.000238269487966002 G_eff=2.38269487966002e-07
Ro10p22f1 htap22 o10p 4201.53194372274
* o10 input 23 w=-0.411689837989046 w-  bank=n alpha=1 R=80967.1025550556 G_phys=1.23506951396714e-05 G_eff=1.23506951396714e-05
Ro10n23n1 h23yn o10p 81335.0139078103
* o10 input 24 w=+0.321047972853849 w+  bank=n alpha=1 R=103826.643217921 G_phys=9.63143918561547e-06 G_eff=9.63143918561547e-06
Ro10p24n1 h24y o10p 103556.900914121
* o10 input 25 w=-0.130972309748016 w-  bank=n alpha=1 R=254506.722813891 G_phys=3.92916929244047e-06 G_eff=3.92916929244047e-06
Ro10n25n1 h25yn o10p 255658.035784413
* o10 input 26 w=+0.0365278526067883 w+  bank=n alpha=1 R=912545.659120916 G_phys=1.09583557820365e-06 G_eff=1.09583557820365e-06
Ro10p26n1 h26y o10p 914421.846178379
* o10 input 27 w=-0.205674584301975 w-  bank=n alpha=1 R=162068.315083563 G_phys=6.17023752905924e-06 G_eff=6.17023752905924e-06
Ro10n27n1 h27yn o10p 161694.727285645
* o10 input 28 w=-0.0123163999797875 w-  bank=f alpha=0.001 R=2706.41854665624 G_phys=0.000369491999393624 G_eff=3.69491999393624e-07
Ro10n28f1 htap28n o10p 2693.15860782272
* o10 input 29 w=-0.120487475126756 w-  bank=n alpha=1 R=276653.928537102 G_phys=3.61462425380267e-06 G_eff=3.61462425380267e-06
Ro10n29n1 h29yn o10p 276204.234488139
* o10 input 30 w=-0.421650115672696 w-  bank=n alpha=1 R=79054.486396034 G_phys=1.26495034701809e-05 G_eff=1.26495034701809e-05
Ro10n30n1 h30yn o10p 79033.2302605677
* o10 input 31 w=+0.15176529701113 w+  bank=n alpha=1 R=219637.387398838 G_phys=4.55295891033391e-06 G_eff=4.55295891033391e-06
Ro10p31n1 h31y o10p 218971.675289997
* o10 input 32 w=+0.00307524765960727 w+  bank=f alpha=0.001 R=10839.2354122107 G_phys=9.22574297882182e-05 G_eff=9.22574297882182e-08
Ro10p32f1 htap32 o10p 10850.8368731887
* o10 bias w-  bank=f alpha=0.001 R=1066.20335663783 G_phys=0.000937907383028131 G_eff=9.37907383028131e-07
Ro10bnf1 taprefn o10p 1071.40517058416
* single-copy I-to-V: 0 V sum o10p, I dump onto R_IV=33333.3333333333
Vo10p o10p 0 DC 0
Bo10iv 0 o10lin I = i(Vo10p)
Ro10iv o10lin 0 33189.266281629

* o11 input 1 w=-0.160102279955593 w-  bank=n alpha=1 R=208200.241386812 G_phys=4.80306839866778e-06 G_eff=4.80306839866778e-06
Ro11n1n1 h1yn o11p 208376.29084093
* o11 input 2 w=+0.011469223690656 w+  bank=f alpha=0.001 R=2906.32864371544 G_phys=0.00034407671071968 G_eff=3.4407671071968e-07
Ro11p2f1 htap2 o11p 2893.40045724732
* o11 input 3 w=+0.0176041755498141 w+  bank=f alpha=0.001 R=1893.49016879608 G_phys=0.000528125266494424 G_eff=5.28125266494424e-07
Ro11p3f1 htap3 o11p 1890.95134092114
* o11 input 4 w=-0.0193710750418404 w-  bank=f alpha=0.001 R=1720.77870027013 G_phys=0.000581132251255212 G_eff=5.81132251255212e-07
Ro11n4f1 htap4n o11p 1721.6105143992
* o11 input 5 w=+0.112602634979867 w+  bank=n alpha=1 R=296026.228331984 G_phys=3.37807904939602e-06 G_eff=3.37807904939602e-06
Ro11p5n1 h5y o11p 295646.920184195
* o11 input 6 w=+0.00163262396170036 w+  bank=f alpha=0.001 R=20417.0305687643 G_phys=4.89787188510109e-05 G_eff=4.89787188510109e-08
Ro11p6f1 htap6 o11p 20322.2705866514
* o11 input 7 w=-0.0344149127536822 w-  bank=n alpha=1 R=968572.361984759 G_phys=1.03244738261047e-06 G_eff=1.03244738261047e-06
Ro11n7n1 h7yn o11p 964419.382936947
* o11 input 8 w=+0.0140339587694358 w+  bank=f alpha=0.001 R=2375.19105485255 G_phys=0.000421018763083073 G_eff=4.21018763083073e-07
Ro11p8f1 htap8 o11p 2370.04246465637
* o11 input 9 w=+0.200472625000294 w+  bank=n alpha=1 R=166273.741032146 G_phys=6.01417875000882e-06 G_eff=6.01417875000882e-06
Ro11p9n1 h9y o11p 166447.777448435
* o11 input 10 w=+0.127220756971711 w+  bank=n alpha=1 R=262011.751280064 G_phys=3.81662270915132e-06 G_eff=3.81662270915132e-06
Ro11p10n1 h10y o11p 261109.224187341
* o11 input 11 w=-0.215899699488286 w-  bank=n alpha=1 R=154392.680547209 G_phys=6.47699098464857e-06 G_eff=6.47699098464857e-06
Ro11n11n1 h11yn o11p 153816.35176267
* o11 input 12 w=-0.0276713436872213 w-  bank=f alpha=0.001 R=1204.61563811687 G_phys=0.000830140310616638 G_eff=8.30140310616639e-07
Ro11n12f1 htap12n o11p 1207.34168231293
* o11 input 13 w=+0.188664634231365 w+  bank=n alpha=1 R=176680.34854087 G_phys=5.65993902694096e-06 G_eff=5.65993902694096e-06
Ro11p13n1 h13y o11p 177387.474425622
* o11 input 14 w=-0.119078372545684 w-  bank=n alpha=1 R=279927.686453265 G_phys=3.57235117637052e-06 G_eff=3.57235117637052e-06
Ro11n14n1 h14yn o11p 280449.897976322
* o11 input 15 w=+0.15422975355602 w+  bank=n alpha=1 R=216127.774082359 G_phys=4.6268926066806e-06 G_eff=4.6268926066806e-06
Ro11p15n1 h15y o11p 216289.503504468
* o11 input 16 w=-0.104607206722078 w-  bank=n alpha=1 R=318652.360366468 G_phys=3.13821620166235e-06 G_eff=3.13821620166235e-06
Ro11n16n1 h16yn o11p 317821.816329628
* o11 input 17 w=+0.106639727219858 w+  bank=n alpha=1 R=312578.944098482 G_phys=3.19919181659573e-06 G_eff=3.19919181659573e-06
Ro11p17n1 h17y o11p 313427.974155891
* o11 input 18 w=+0.310905721051453 w+  bank=n alpha=1 R=107213.637692492 G_phys=9.32717163154358e-06 G_eff=9.32717163154358e-06
Ro11p18n1 h18y o11p 107740.884702803
* o11 input 19 w=+0.210141672521531 w+  bank=n alpha=1 R=158623.146629415 G_phys=6.30425017564592e-06 G_eff=6.30425017564592e-06
Ro11p19n1 h19y o11p 158106.609410306
* o11 input 20 w=+0.009349861892821 w+  bank=f alpha=0.001 R=3565.11504826903 G_phys=0.00028049585678463 G_eff=2.8049585678463e-07
Ro11p20f1 htap20 o11p 3571.34590763899
* o11 input 21 w=-0.148461029214851 w-  bank=n alpha=1 R=224525.81333714 G_phys=4.45383087644554e-06 G_eff=4.45383087644554e-06
Ro11n21n1 h21yn o11p 224598.954272714
* o11 input 22 w=-0.118671866129314 w-  bank=n alpha=1 R=280886.56916384 G_phys=3.56015598387941e-06 G_eff=3.56015598387941e-06
Ro11n22n1 h22yn o11p 280457.389014343
* o11 input 23 w=-0.109207143921327 w-  bank=n alpha=1 R=305230.336921427 G_phys=3.2762143176398e-06 G_eff=3.2762143176398e-06
Ro11n23n1 h23yn o11p 304871.666533327
* o11 input 24 w=-0.0902417819363344 w-  bank=n alpha=1 R=369378.048816124 G_phys=2.70725345809003e-06 G_eff=2.70725345809003e-06
Ro11n24n1 h24yn o11p 369482.64177785
* o11 input 25 w=+0.314745464583241 w+  bank=n alpha=1 R=105905.68279505 G_phys=9.44236393749723e-06 G_eff=9.44236393749723e-06
Ro11p25n1 h25y o11p 106290.794979164
* o11 input 26 w=+0.0956381358816812 w+  bank=n alpha=1 R=348536.000059346 G_phys=2.86914407645044e-06 G_eff=2.86914407645044e-06
Ro11p26n1 h26y o11p 348770.91739214
* o11 input 27 w=-0.150311342322866 w-  bank=n alpha=1 R=221761.929726726 G_phys=4.50934026968598e-06 G_eff=4.50934026968598e-06
Ro11n27n1 h27yn o11p 222058.527346869
* o11 input 28 w=-0.0832874521070705 w-  bank=n alpha=1 R=400220.351205864 G_phys=2.49862356321211e-06 G_eff=2.49862356321211e-06
Ro11n28n1 h28yn o11p 401411.298211979
* o11 input 29 w=+0.0404370827831914 w+  bank=n alpha=1 R=824325.86722574 G_phys=1.21311248349574e-06 G_eff=1.21311248349574e-06
Ro11p29n1 h29y o11p 822144.545871265
* o11 input 30 w=-0.0722629324126473 w-  bank=n alpha=1 R=461278.448305807 G_phys=2.16788797237942e-06 G_eff=2.16788797237942e-06
Ro11n30n1 h30yn o11p 460706.857536815
* o11 input 31 w=-0.0830409064130833 w-  bank=n alpha=1 R=401408.592140338 G_phys=2.4912271923925e-06 G_eff=2.4912271923925e-06
Ro11n31n1 h31yn o11p 400201.441511521
* o11 input 32 w=-0.390143512242536 w-  bank=n alpha=1 R=85438.6457479045 G_phys=1.17043053672761e-05 G_eff=1.17043053672761e-05
Ro11n32n1 h32yn o11p 85048.3379706484
* o11 bias w-  bank=f alpha=0.001 R=23104.9891990359 G_phys=4.32806954110901e-05 G_eff=4.32806954110902e-08
Ro11bnf1 taprefn o11p 23157.112961746
* single-copy I-to-V: 0 V sum o11p, I dump onto R_IV=33333.3333333333
Vo11p o11p 0 DC 0
Bo11iv 0 o11lin I = i(Vo11p)
Ro11iv o11lin 0 33295.4330071013

* o12 input 1 w=-0.0568819810826339 w-  bank=n alpha=1 R=586008.656852319 G_phys=1.70645943247902e-06 G_eff=1.70645943247902e-06
Ro12n1n1 h1yn o12p 583836.108112801
* o12 input 2 w=-0.116449760348513 w-  bank=n alpha=1 R=286246.47430422 G_phys=3.4934928104554e-06 G_eff=3.4934928104554e-06
Ro12n2n1 h2yn o12p 286118.752941164
* o12 input 3 w=-0.394245634375715 w-  bank=n alpha=1 R=84549.6574391152 G_phys=1.18273690312714e-05 G_eff=1.18273690312714e-05
Ro12n3n1 h3yn o12p 84737.0542395098
* o12 input 4 w=-0.0304757769901363 w-  bank=f alpha=0.001 R=1093.76483966666 G_phys=0.000914273309704088 G_eff=9.14273309704088e-07
Ro12n4f1 htap4n o12p 1096.14348792058
* o12 input 5 w=-0.225077356892672 w-  bank=n alpha=1 R=148097.231074329 G_phys=6.75232070678017e-06 G_eff=6.75232070678017e-06
Ro12n5n1 h5yn o12p 147370.522986418
* o12 input 6 w=-0.48876360312342 w-  bank=n alpha=1 R=68199.2953655269 G_phys=1.46629080937026e-05 G_eff=1.46629080937026e-05
Ro12n6n1 h6yn o12p 68426.2767176375
* o12 input 7 w=+0.269859073889073 w+  bank=n alpha=1 R=123521.261868093 G_phys=8.09577221667219e-06 G_eff=8.09577221667219e-06
Ro12p7n1 h7y o12p 123467.201783993
* o12 input 8 w=-0.0167144075003679 w-  bank=f alpha=0.001 R=1994.28746323192 G_phys=0.000501432225011038 G_eff=5.01432225011038e-07
Ro12n8f1 htap8n o12p 1992.98248278937
* o12 input 9 w=-0.271168635938693 w-  bank=n alpha=1 R=122924.737287352 G_phys=8.13505907816079e-06 G_eff=8.13505907816079e-06
Ro12n9n1 h9yn o12p 122918.031599368
* o12 input 10 w=-0.229866523415109 w-  bank=n alpha=1 R=145011.691298509 G_phys=6.89599570245327e-06 G_eff=6.89599570245327e-06
Ro12n10n1 h10yn o12p 144619.647334259
* o12 input 11 w=+0.111794037161303 w+  bank=n alpha=1 R=298167.363660355 G_phys=3.35382111483908e-06 G_eff=3.35382111483908e-06
Ro12p11n1 h11y o12p 297112.461820158
* o12 input 12 w=-0.187970289472281 w-  bank=n alpha=1 R=177332.989308658 G_phys=5.63910868416843e-06 G_eff=5.63910868416843e-06
Ro12n12n1 h12yn o12p 177080.101233541
* o12 input 13 w=+0.219867348390274 w+  bank=n alpha=1 R=151606.564491628 G_phys=6.59602045170821e-06 G_eff=6.59602045170821e-06
Ro12p13n1 h13y o12p 151059.967962673
* o12 input 14 w=-0.127058880326711 w-  bank=n alpha=1 R=262345.561739739 G_phys=3.81176640980134e-06 G_eff=3.81176640980134e-06
Ro12n14n1 h14yn o12p 263436.276286816
* o12 input 15 w=+0.40629100094033 w+  bank=n alpha=1 R=82043.0018291959 G_phys=1.21887300282099e-05 G_eff=1.21887300282099e-05
Ro12p15n1 h15y o12p 82445.4830445344
* o12 input 16 w=-0.479164967789437 w-  bank=n alpha=1 R=69565.4640344684 G_phys=1.43749490336831e-05 G_eff=1.43749490336831e-05
Ro12n16n1 h16yn o12p 69600.4558827338
* o12 input 17 w=-0.142691971348636 w-  bank=n alpha=1 R=233603.425744892 G_phys=4.28075914045907e-06 G_eff=4.28075914045907e-06
Ro12n17n1 h17yn o12p 234360.552121496
* o12 input 18 w=+0.0750962927559542 w+  bank=n alpha=1 R=443874.552391808 G_phys=2.25288878267863e-06 G_eff=2.25288878267863e-06
Ro12p18n1 h18y o12p 443768.811403975
* o12 input 19 w=-0.0357891000093011 w-  bank=n alpha=1 R=931382.273504235 G_phys=1.07367300027903e-06 G_eff=1.07367300027903e-06
Ro12n19n1 h19yn o12p 927177.189043179
* o12 input 20 w=-0.274882313904053 w-  bank=n alpha=1 R=121264.016079871 G_phys=8.24646941712159e-06 G_eff=8.24646941712159e-06
Ro12n20n1 h20yn o12p 120768.601503683
* o12 input 21 w=+0.0723735016816067 w+  bank=n alpha=1 R=460573.726002328 G_phys=2.1712050504482e-06 G_eff=2.1712050504482e-06
Ro12p21n1 h21y o12p 458586.284154455
* o12 input 22 w=-0.42830678611073 w-  bank=n alpha=1 R=77825.8351589968 G_phys=1.28492035833219e-05 G_eff=1.28492035833219e-05
Ro12n22n1 h22yn o12p 77857.0552457839
* o12 input 23 w=-0.495732058756383 w-  bank=n alpha=1 R=67240.6247377966 G_phys=1.48719617626915e-05 G_eff=1.48719617626915e-05
Ro12n23n1 h23yn o12p 66911.3323407909
* o12 input 24 w=-0.0511653226482421 w-  bank=n alpha=1 R=651482.910847599 G_phys=1.53495967944726e-06 G_eff=1.53495967944726e-06
Ro12n24n1 h24yn o12p 651918.748051301
* o12 input 25 w=+0.0558940521557335 w+  bank=n alpha=1 R=596366.376165735 G_phys=1.676821564672e-06 G_eff=1.676821564672e-06
Ro12p25n1 h25y o12p 596468.761438805
* o12 input 26 w=+0.307817092263132 w+  bank=n alpha=1 R=108289.416576123 G_phys=9.23451276789396e-06 G_eff=9.23451276789396e-06
Ro12p26n1 h26y o12p 108488.881311538
* o12 input 27 w=-0.124284155438311 w-  bank=n alpha=1 R=268202.597634244 G_phys=3.72852466314934e-06 G_eff=3.72852466314934e-06
Ro12n27n1 h27yn o12p 266998.240547826
* o12 input 28 w=+0.511620988407946 w+  bank=n alpha=1 R=65152.3961850343 G_phys=1.53486296522384e-05 G_eff=1.53486296522384e-05
Ro12p28n1 h28y o12p 64953.9204530021
* o12 input 29 w=-0.110998740438628 w-  bank=n alpha=1 R=300303.70796652 G_phys=3.32996221315884e-06 G_eff=3.32996221315884e-06
Ro12n29n1 h29yn o12p 299036.535143711
* o12 input 30 w=+0.0696620617055659 w+  bank=n alpha=1 R=478500.528368227 G_phys=2.08986185116698e-06 G_eff=2.08986185116698e-06
Ro12p30n1 h30y o12p 478157.089733382
* o12 input 31 w=+0.219973071991933 w+  bank=n alpha=1 R=151533.699245496 G_phys=6.59919215975798e-06 G_eff=6.59919215975798e-06
Ro12p31n1 h31y o12p 152221.825265839
* o12 input 32 w=+0.138023444689957 w+  bank=n alpha=1 R=241504.864685924 G_phys=4.14070334069872e-06 G_eff=4.14070334069872e-06
Ro12p32n1 h32y o12p 240665.353134165
* o12 bias w+  bank=f alpha=0.001 R=5330.66503610944 G_phys=0.000187593854280111 G_eff=1.87593854280111e-07
Ro12bpf1 tapref o12p 5311.98245578064
* single-copy I-to-V: 0 V sum o12p, I dump onto R_IV=33333.3333333333
Vo12p o12p 0 DC 0
Bo12iv 0 o12lin I = i(Vo12p)
Ro12iv o12lin 0 33227.7143595626

* o13 input 1 w=+0.00200007413415942 w+  bank=f alpha=0.001 R=16666.0489049035 G_phys=6.00022240247825e-05 G_eff=6.00022240247825e-08
Ro13p1f1 htap1 o13p 16735.5312573142
* o13 input 2 w=-0.0237460165980216 w-  bank=f alpha=0.001 R=1403.74421098108 G_phys=0.000712380497940648 G_eff=7.12380497940648e-07
Ro13n2f1 htap2n o13p 1407.03883294909
* o13 input 3 w=-0.481641955158027 w-  bank=n alpha=1 R=69207.7028929023 G_phys=1.44492586547408e-05 G_eff=1.44492586547408e-05
Ro13n3n1 h3yn o13p 69275.5408282494
* o13 input 4 w=-0.401500412219866 w-  bank=n alpha=1 R=83021.9155916573 G_phys=1.2045012366596e-05 G_eff=1.2045012366596e-05
Ro13n4n1 h4yn o13p 83123.3515839126
* o13 input 5 w=-0.324731283585407 w-  bank=n alpha=1 R=102648.974762441 G_phys=9.7419385075622e-06 G_eff=9.7419385075622e-06
Ro13n5n1 h5yn o13p 102162.711411795
* o13 input 6 w=+0.0791891194793975 w+  bank=n alpha=1 R=420933.248815901 G_phys=2.37567358438193e-06 G_eff=2.37567358438193e-06
Ro13p6n1 h6y o13p 421961.070116961
* o13 input 7 w=+0.286949833874567 w+  bank=n alpha=1 R=116164.323509956 G_phys=8.60849501623701e-06 G_eff=8.60849501623701e-06
Ro13p7n1 h7y o13p 115967.040242782
* o13 input 8 w=-0.153846131933853 w-  bank=n alpha=1 R=216666.697526495 G_phys=4.61538395801558e-06 G_eff=4.61538395801558e-06
Ro13n8n1 h8yn o13p 215608.907252756
* o13 input 9 w=-0.0455077430770376 w-  bank=n alpha=1 R=732476.081639671 G_phys=1.36523229231113e-06 G_eff=1.36523229231113e-06
Ro13n9n1 h9yn o13p 731617.624959511
* o13 input 10 w=+0.122909253832841 w+  bank=n alpha=1 R=271202.796322133 G_phys=3.68727761498523e-06 G_eff=3.68727761498523e-06
Ro13p10n1 h10y o13p 269951.832005437
* o13 input 11 w=+0.0797228425783465 w+  bank=n alpha=1 R=418115.213347736 G_phys=2.3916852773504e-06 G_eff=2.3916852773504e-06
Ro13p11n1 h11y o13p 417109.302827698
* o13 input 12 w=-0.0916703213430956 w-  bank=n alpha=1 R=363621.866324394 G_phys=2.75010964029287e-06 G_eff=2.75010964029287e-06
Ro13n12n1 h12yn o13p 364980.632930008
* o13 input 13 w=-0.00253109868008519 w-  bank=f alpha=0.001 R=13169.5115625486 G_phys=7.59329604025557e-05 G_eff=7.59329604025556e-08
Ro13n13f1 htap13n o13p 13117.3360426929
* o13 input 14 w=+0.523873822520012 w+  bank=n alpha=1 R=63628.5530988905 G_phys=1.57162146756004e-05 G_eff=1.57162146756004e-05
Ro13p14n1 h14y o13p 63311.6343708554
* o13 input 15 w=+0.0718975606852002 w+  bank=n alpha=1 R=463622.590469816 G_phys=2.15692682055601e-06 G_eff=2.15692682055601e-06
Ro13p15n1 h15y o13p 465327.980065736
* o13 input 16 w=+0.212010526629755 w+  bank=n alpha=1 R=157224.897570982 G_phys=6.36031579889266e-06 G_eff=6.36031579889266e-06
Ro13p16n1 h16y o13p 157394.899096365
* o13 input 17 w=+0.50252589011925 w+  bank=n alpha=1 R=66331.5741312817 G_phys=1.50757767035775e-05 G_eff=1.50757767035775e-05
Ro13p17n1 h17y o13p 66201.0872647908
* o13 input 18 w=-0.0631368164337741 w-  bank=n alpha=1 R=527953.97703173 G_phys=1.89410449301322e-06 G_eff=1.89410449301322e-06
Ro13n18n1 h18yn o13p 528115.16241809
* o13 input 19 w=+0.124615759492256 w+  bank=n alpha=1 R=267488.907254983 G_phys=3.73847278476769e-06 G_eff=3.73847278476769e-06
Ro13p19n1 h19y o13p 267748.749940206
* o13 input 20 w=-0.0825374863137293 w-  bank=n alpha=1 R=403856.899719863 G_phys=2.47612458941188e-06 G_eff=2.47612458941188e-06
Ro13n20n1 h20yn o13p 403464.471376415
* o13 input 21 w=-0.0332297714786912 w-  bank=f alpha=0.001 R=1003.11653827377 G_phys=0.000996893144360737 G_eff=9.96893144360737e-07
Ro13n21f1 htap21n o13p 1002.45937340099
* o13 input 22 w=+0.217350752944783 w+  bank=n alpha=1 R=153361.940925972 G_phys=6.5205225883435e-06 G_eff=6.5205225883435e-06
Ro13p22n1 h22y o13p 152713.824959735
* o13 input 23 w=+0.00620341639632115 w+  bank=f alpha=0.001 R=5373.38318174179 G_phys=0.000186102491889634 G_eff=1.86102491889634e-07
Ro13p23f1 htap23 o13p 5393.03444460567
* o13 input 24 w=-0.56329887647671 w-  bank=n alpha=1 R=59175.2171455139 G_phys=1.68989662943013e-05 G_eff=1.68989662943013e-05
Ro13n24n1 h24yn o13p 59458.6802203871
* o13 input 25 w=+0.121217122487375 w+  bank=n alpha=1 R=274988.653824918 G_phys=3.63651367462124e-06 G_eff=3.63651367462124e-06
Ro13p25n1 h25y o13p 273954.845629923
* o13 input 26 w=-0.0619389520134905 w-  bank=n alpha=1 R=538164.309368251 G_phys=1.85816856040471e-06 G_eff=1.85816856040471e-06
Ro13n26n1 h26yn o13p 537169.926047916
* o13 input 27 w=-0.148385692307615 w-  bank=n alpha=1 R=224639.807349019 G_phys=4.45157076922844e-06 G_eff=4.45157076922844e-06
Ro13n27n1 h27yn o13p 225068.330226733
* o13 input 28 w=+0.0960859107643036 w+  bank=n alpha=1 R=346911.769563169 G_phys=2.88257732292911e-06 G_eff=2.88257732292911e-06
Ro13p28n1 h28y o13p 345356.810945942
* o13 input 29 w=-0.0967464729103534 w-  bank=n alpha=1 R=344543.137652372 G_phys=2.9023941873106e-06 G_eff=2.9023941873106e-06
Ro13n29n1 h29yn o13p 345029.011041801
* o13 input 30 w=+0.0502110731232858 w+  bank=n alpha=1 R=663864.188910847 G_phys=1.50633219369857e-06 G_eff=1.50633219369857e-06
Ro13p30n1 h30y o13p 661838.810274169
* o13 input 31 w=+0.0717291842082243 w+  bank=n alpha=1 R=464710.894195719 G_phys=2.15187552624673e-06 G_eff=2.15187552624673e-06
Ro13p31n1 h31y o13p 465981.298594519
* o13 input 32 w=+0.117218732023777 w+  bank=n alpha=1 R=284368.656424059 G_phys=3.51656196071332e-06 G_eff=3.51656196071332e-06
Ro13p32n1 h32y o13p 283404.22148138
* o13 bias w+  bank=f alpha=0.001 R=7028.1846436546 G_phys=0.000142284252719918 G_eff=1.42284252719918e-07
Ro13bpf1 tapref o13p 7011.27802995391
* single-copy I-to-V: 0 V sum o13p, I dump onto R_IV=33333.3333333333
Vo13p o13p 0 DC 0
Bo13iv 0 o13lin I = i(Vo13p)
Ro13iv o13lin 0 33174.5253377489

* o14 input 1 w=-0.25477230027339 w-  bank=n alpha=1 R=130835.782765882 G_phys=7.64316900820172e-06 G_eff=7.64316900820172e-06
Ro14n1n1 h1yn o14p 130694.003659534
* o14 input 2 w=+0.102637632071701 w+  bank=n alpha=1 R=324767.170291372 G_phys=3.07912896215104e-06 G_eff=3.07912896215104e-06
Ro14p2n1 h2y o14p 325931.509744601
* o14 input 3 w=+0.107208211835011 w+  bank=n alpha=1 R=310921.456134648 G_phys=3.21624635505032e-06 G_eff=3.21624635505032e-06
Ro14p3n1 h3y o14p 310084.068361842
* o14 input 4 w=-0.361346054145307 w-  bank=n alpha=1 R=92247.6749114552 G_phys=1.08403816243592e-05 G_eff=1.08403816243592e-05
Ro14n4n1 h4yn o14p 92200.2400787582
* o14 input 5 w=+0.0565127294479513 w+  bank=n alpha=1 R=589837.611082537 G_phys=1.69538188343854e-06 G_eff=1.69538188343854e-06
Ro14p5n1 h5y o14p 589395.130328166
* o14 input 6 w=-0.166023137794918 w-  bank=n alpha=1 R=200775.22793545 G_phys=4.98069413384754e-06 G_eff=4.98069413384754e-06
Ro14n6n1 h6yn o14p 200260.570031854
* o14 input 7 w=+0.0533068959488943 w+  bank=n alpha=1 R=625309.96674971 G_phys=1.59920687846683e-06 G_eff=1.59920687846683e-06
Ro14p7n1 h7y o14p 627527.03623405
* o14 input 8 w=-0.334728977765226 w-  bank=n alpha=1 R=99583.0524022118 G_phys=1.00418693329568e-05 G_eff=1.00418693329568e-05
Ro14n8n1 h8yn o14p 99385.6961268288
* o14 input 9 w=-0.184424571200296 w-  bank=n alpha=1 R=180742.365924394 G_phys=5.53273713600887e-06 G_eff=5.53273713600887e-06
Ro14n9n1 h9yn o14p 180359.726757399
* o14 input 10 w=+0.263838736865495 w+  bank=n alpha=1 R=126339.800324039 G_phys=7.91516210596486e-06 G_eff=7.91516210596486e-06
Ro14p10n1 h10y o14p 126546.537925624
* o14 input 11 w=+0.0215454170832462 w+  bank=f alpha=0.001 R=1547.11942704759 G_phys=0.000646362512497387 G_eff=6.46362512497387e-07
Ro14p11f1 htap11 o14p 1541.54193755951
* o14 input 12 w=-0.0509620245346412 w-  bank=n alpha=1 R=654081.811657133 G_phys=1.52886073603923e-06 G_eff=1.52886073603923e-06
Ro14n12n1 h12yn o14p 652899.798603373
* o14 input 13 w=-0.289718223355261 w-  bank=n alpha=1 R=115054.320530121 G_phys=8.69154670065782e-06 G_eff=8.69154670065782e-06
Ro14n13n1 h13yn o14p 114500.00718626
* o14 input 14 w=+0.114352462647064 w+  bank=n alpha=1 R=291496.41871914 G_phys=3.43057387941191e-06 G_eff=3.43057387941191e-06
Ro14p14n1 h14y o14p 290158.861395073
* o14 input 15 w=-0.172686817087866 w-  bank=n alpha=1 R=193027.666474232 G_phys=5.18060451263599e-06 G_eff=5.18060451263599e-06
Ro14n15n1 h15yn o14p 193471.385812395
* o14 input 16 w=-0.0880371911025684 w-  bank=n alpha=1 R=378627.860746921 G_phys=2.64111573307705e-06 G_eff=2.64111573307705e-06
Ro14n16n1 h16yn o14p 377745.849366467
* o14 input 17 w=-0.0970577820037651 w-  bank=n alpha=1 R=343438.028823286 G_phys=2.91173346011295e-06 G_eff=2.91173346011295e-06
Ro14n17n1 h17yn o14p 342581.749173901
* o14 input 18 w=+0.279065168461303 w+  bank=n alpha=1 R=119446.412883145 G_phys=8.3719550538391e-06 G_eff=8.3719550538391e-06
Ro14p18n1 h18y o14p 119492.214749227
* o14 input 19 w=+0.12574844379754 w+  bank=n alpha=1 R=265079.489866303 G_phys=3.7724533139262e-06 G_eff=3.7724533139262e-06
Ro14p19n1 h19y o14p 263848.790550669
* o14 input 20 w=+0.196093228285189 w+  bank=n alpha=1 R=169987.172044793 G_phys=5.88279684855566e-06 G_eff=5.88279684855566e-06
Ro14p20n1 h20y o14p 170550.390019791
* o14 input 21 w=+0.0606582432664274 w+  bank=n alpha=1 R=549526.849746115 G_phys=1.81974729799282e-06 G_eff=1.81974729799282e-06
Ro14p21n1 h21y o14p 551265.323514628
* o14 input 22 w=+0.471542863591523 w+  bank=n alpha=1 R=70689.9327867011 G_phys=1.41462859077457e-05 G_eff=1.41462859077457e-05
Ro14p22n1 h22y o14p 70360.0599163855
* o14 input 23 w=+0.132895212526076 w+  bank=n alpha=1 R=250824.184707127 G_phys=3.98685637578228e-06 G_eff=3.98685637578228e-06
Ro14p23n1 h23y o14p 250688.189808787
* o14 input 24 w=-0.150700282102261 w-  bank=n alpha=1 R=221189.588156937 G_phys=4.52100846306782e-06 G_eff=4.52100846306782e-06
Ro14n24n1 h24yn o14p 221401.441612345
* o14 input 25 w=-0.172018927572569 w-  bank=n alpha=1 R=193777.125597247 G_phys=5.16056782717707e-06 G_eff=5.16056782717707e-06
Ro14n25n1 h25yn o14p 194621.155680726
* o14 input 26 w=-0.144277203051731 w-  bank=n alpha=1 R=231036.730878278 G_phys=4.32831609155192e-06 G_eff=4.32831609155192e-06
Ro14n26n1 h26yn o14p 230026.175345648
* o14 input 27 w=-0.0456897569368309 w-  bank=n alpha=1 R=729558.12348529 G_phys=1.37069270810493e-06 G_eff=1.37069270810493e-06
Ro14n27n1 h27yn o14p 733146.410643289
* o14 input 28 w=-0.269930966859316 w-  bank=n alpha=1 R=123488.363418141 G_phys=8.09792900577949e-06 G_eff=8.09792900577949e-06
Ro14n28n1 h28yn o14p 123023.855078262
* o14 input 29 w=-0.380176315173873 w-  bank=n alpha=1 R=87678.6164811146 G_phys=1.14052894552162e-05 G_eff=1.14052894552162e-05
Ro14n29n1 h29yn o14p 87974.7523176549
* o14 input 30 w=+0.211443520189348 w+  bank=n alpha=1 R=157646.511482042 G_phys=6.34330560568043e-06 G_eff=6.34330560568043e-06
Ro14p30n1 h30y o14p 157887.197183992
* o14 input 31 w=+0.0784944631218348 w+  bank=n alpha=1 R=424658.402741034 G_phys=2.35483389365504e-06 G_eff=2.35483389365504e-06
Ro14p31n1 h31y o14p 424720.212464272
* o14 input 32 w=+0.0843025902123393 w+  bank=n alpha=1 R=395401.057658776 G_phys=2.52907770637018e-06 G_eff=2.52907770637018e-06
Ro14p32n1 h32y o14p 395597.648470099
* o14 bias w-  bank=f alpha=0.001 R=2670.46157164376 G_phys=0.00037446709985213 G_eff=3.74467099852129e-07
Ro14bnf1 taprefn o14p 2664.20136446933
* single-copy I-to-V: 0 V sum o14p, I dump onto R_IV=33333.3333333333
Vo14p o14p 0 DC 0
Bo14iv 0 o14lin I = i(Vo14p)
Ro14iv o14lin 0 33355.7004573685

* o15 input 1 w=-0.113449668897813 w-  bank=n alpha=1 R=293816.047743229 G_phys=3.40349006693439e-06 G_eff=3.40349006693439e-06
Ro15n1n1 h1yn o15p 293588.483913326
* o15 input 2 w=-0.169978823552936 w-  bank=n alpha=1 R=196102.85938326 G_phys=5.09936470658807e-06 G_eff=5.09936470658807e-06
Ro15n2n1 h2yn o15p 196306.3867664
* o15 input 3 w=+0.0133598434574407 w+  bank=f alpha=0.001 R=2495.03921505672 G_phys=0.00040079530372322 G_eff=4.0079530372322e-07
Ro15p3f1 htap3 o15p 2498.94430213413
* o15 input 4 w=-0.169966115485037 w-  bank=n alpha=1 R=196117.52164959 G_phys=5.0989834645511e-06 G_eff=5.0989834645511e-06
Ro15n4n1 h4yn o15p 195573.546247116
* o15 input 5 w=-0.0418903282162887 w-  bank=n alpha=1 R=795728.626455878 G_phys=1.25670984648866e-06 G_eff=1.25670984648866e-06
Ro15n5n1 h5yn o15p 794223.392443219
* o15 input 6 w=-0.324291927905124 w-  bank=n alpha=1 R=102788.045168628 G_phys=9.72875783715372e-06 G_eff=9.72875783715372e-06
Ro15n6n1 h6yn o15p 102507.400281645
* o15 input 7 w=+0.558916704640692 w+  bank=n alpha=1 R=59639.1788911769 G_phys=1.67675011392208e-05 G_eff=1.67675011392208e-05
Ro15p7n1 h7y o15p 59533.3009547287
* o15 input 8 w=-0.047599242693459 w-  bank=n alpha=1 R=700291.253539501 G_phys=1.42797728080377e-06 G_eff=1.42797728080377e-06
Ro15n8n1 h8yn o15p 702708.983827942
* o15 input 9 w=-0.103084990895521 w-  bank=n alpha=1 R=323357.775402217 G_phys=3.09254972686562e-06 G_eff=3.09254972686562e-06
Ro15n9n1 h9yn o15p 322992.592467355
* o15 input 10 w=-0.115049291784761 w-  bank=n alpha=1 R=289730.886789766 G_phys=3.45147875354283e-06 G_eff=3.45147875354283e-06
Ro15n10n1 h10yn o15p 289188.813531829
* o15 input 11 w=+0.0920546297717411 w+  bank=n alpha=1 R=362103.822653861 G_phys=2.76163889315223e-06 G_eff=2.76163889315223e-06
Ro15p11n1 h11y o15p 362595.721104143
* o15 input 12 w=+0.0505985364133342 w+  bank=n alpha=1 R=658780.583316418 G_phys=1.51795609240003e-06 G_eff=1.51795609240003e-06
Ro15p12n1 h12y o15p 660916.939936161
* o15 input 13 w=-0.145296396139138 w-  bank=n alpha=1 R=229416.105416771 G_phys=4.35889188417414e-06 G_eff=4.35889188417414e-06
Ro15n13n1 h13yn o15p 229184.246472792
* o15 input 14 w=-0.379881852318272 w-  bank=n alpha=1 R=87746.579969306 G_phys=1.13964555695482e-05 G_eff=1.13964555695482e-05
Ro15n14n1 h14yn o15p 87887.1406146414
* o15 input 15 w=+0.223112491519187 w+  bank=n alpha=1 R=149401.466078231 G_phys=6.69337474557561e-06 G_eff=6.69337474557561e-06
Ro15p15n1 h15y o15p 148676.522613527
* o15 input 16 w=-0.14757878301826 w-  bank=n alpha=1 R=225868.059429714 G_phys=4.42736349054781e-06 G_eff=4.42736349054781e-06
Ro15n16n1 h16yn o15p 224742.990198701
* o15 input 17 w=+0.173921977011029 w+  bank=n alpha=1 R=191656.821674811 G_phys=5.21765931033087e-06 G_eff=5.21765931033087e-06
Ro15p17n1 h17y o15p 192576.238641577
* o15 input 18 w=+0.133725887369399 w+  bank=n alpha=1 R=249266.121833648 G_phys=4.01177662108198e-06 G_eff=4.01177662108198e-06
Ro15p18n1 h18y o15p 249310.370176726
* o15 input 19 w=+0.209560948195519 w+  bank=n alpha=1 R=159062.714787077 G_phys=6.28682844586558e-06 G_eff=6.28682844586558e-06
Ro15p19n1 h19y o15p 158407.543052337
* o15 input 20 w=-0.0239329977507233 w-  bank=f alpha=0.001 R=1392.7771890726 G_phys=0.000717989932521699 G_eff=7.179899325217e-07
Ro15n20f1 htap20n o15p 1399.07306059921
* o15 input 21 w=+0.196041920231295 w+  bank=n alpha=1 R=170031.661054972 G_phys=5.88125760693885e-06 G_eff=5.88125760693885e-06
Ro15p21n1 h21y o15p 169211.04081312
* o15 input 22 w=-0.0995510863910355 w-  bank=n alpha=1 R=334836.459769011 G_phys=2.98653259173107e-06 G_eff=2.98653259173107e-06
Ro15n22n1 h22yn o15p 333983.302481368
* o15 input 23 w=+0.102107365264583 w+  bank=n alpha=1 R=326453.760186243 G_phys=3.06322095793749e-06 G_eff=3.06322095793749e-06
Ro15p23n1 h23y o15p 328080.948362555
* o15 input 24 w=-0.21795159550845 w-  bank=n alpha=1 R=152939.157226958 G_phys=6.53854786525351e-06 G_eff=6.53854786525351e-06
Ro15n24n1 h24yn o15p 153651.71224948
* o15 input 25 w=+0.202525001628457 w+  bank=n alpha=1 R=164588.732577744 G_phys=6.07575004885372e-06 G_eff=6.07575004885372e-06
Ro15p25n1 h25y o15p 165251.580258608
* o15 input 26 w=-0.281017181998367 w-  bank=n alpha=1 R=118616.709114701 G_phys=8.43051545995101e-06 G_eff=8.43051545995101e-06
Ro15n26n1 h26yn o15p 118135.457588563
* o15 input 27 w=+0.141610254018665 w+  bank=n alpha=1 R=235387.850719764 G_phys=4.24830762055994e-06 G_eff=4.24830762055994e-06
Ro15p27n1 h27y o15p 234641.253355638
* o15 input 28 w=+0.444984802739648 w+  bank=n alpha=1 R=74908.9252669063 G_phys=1.33495440821894e-05 G_eff=1.33495440821894e-05
Ro15p28n1 h28y o15p 74873.7642628114
* o15 input 29 w=-0.120073433142323 w-  bank=n alpha=1 R=277607.897608986 G_phys=3.60220299426968e-06 G_eff=3.60220299426968e-06
Ro15n29n1 h29yn o15p 277248.647633017
* o15 input 30 w=-0.0538706707421541 w-  bank=n alpha=1 R=618765.886411172 G_phys=1.61612012226462e-06 G_eff=1.61612012226462e-06
Ro15n30n1 h30yn o15p 617265.25617647
* o15 input 31 w=+0.148090323839994 w+  bank=n alpha=1 R=225087.854959036 G_phys=4.44270971519983e-06 G_eff=4.44270971519983e-06
Ro15p31n1 h31y o15p 224864.430296273
* o15 input 32 w=-0.347735979661958 w-  bank=n alpha=1 R=95858.1662033862 G_phys=1.04320793898588e-05 G_eff=1.04320793898588e-05
Ro15n32n1 h32yn o15p 96172.7405361815
* o15 bias w+  bank=n alpha=1 R=468672.189169108 G_phys=2.13368751786374e-06 G_eff=2.13368751786374e-06
Ro15bpn1 vref o15p 466574.59699052
* single-copy I-to-V: 0 V sum o15p, I dump onto R_IV=33333.3333333333
Vo15p o15p 0 DC 0
Bo15iv 0 o15lin I = i(Vo15p)
Ro15iv o15lin 0 33494.5869843719

* o16 input 1 w=-0.0239168211298723 w-  bank=f alpha=0.001 R=1393.71922181162 G_phys=0.000717504633896169 G_eff=7.17504633896169e-07
Ro16n1f1 htap1n o16p 1395.35449516137
* o16 input 2 w=-0.455843018824687 w-  bank=n alpha=1 R=73124.5888535874 G_phys=1.36752905647406e-05 G_eff=1.36752905647406e-05
Ro16n2n1 h2yn o16p 73147.6254372646
* o16 input 3 w=-0.360558107273835 w-  bank=n alpha=1 R=92449.2686778431 G_phys=1.0816743218215e-05 G_eff=1.0816743218215e-05
Ro16n3n1 h3yn o16p 92362.6441283528
* o16 input 4 w=+0.281324980833712 w+  bank=n alpha=1 R=118486.930078336 G_phys=8.43974942501135e-06 G_eff=8.43974942501135e-06
Ro16p4n1 h4y o16p 117968.960470684
* o16 input 5 w=-0.0789059543438914 w-  bank=n alpha=1 R=422443.827091407 G_phys=2.36717863031674e-06 G_eff=2.36717863031674e-06
Ro16n5n1 h5yn o16p 423689.677955114
* o16 input 6 w=+0.0459206910877794 w+  bank=n alpha=1 R=725889.191641633 G_phys=1.37762073263338e-06 G_eff=1.37762073263338e-06
Ro16p6n1 h6y o16p 723732.593655436
* o16 input 7 w=-0.348093944852844 w-  bank=n alpha=1 R=95759.5896918717 G_phys=1.04428183455853e-05 G_eff=1.04428183455853e-05
Ro16n7n1 h7yn o16p 95724.6668448455
* o16 input 8 w=-0.0796710739452782 w-  bank=n alpha=1 R=418386.896055 G_phys=2.39013221835835e-06 G_eff=2.39013221835835e-06
Ro16n8n1 h8yn o16p 420443.5362558
* o16 input 9 w=-0.173339228342165 w-  bank=n alpha=1 R=192301.15220967 G_phys=5.20017685026494e-06 G_eff=5.20017685026494e-06
Ro16n9n1 h9yn o16p 192513.73398862
* o16 input 10 w=+0.194262181446587 w+  bank=n alpha=1 R=171589.411202501 G_phys=5.82786544339762e-06 G_eff=5.82786544339762e-06
Ro16p10n1 h10y o16p 171501.809642026
* o16 input 11 w=+0.155708231075043 w+  bank=n alpha=1 R=214075.602190025 G_phys=4.67124693225129e-06 G_eff=4.67124693225129e-06
Ro16p11n1 h11y o16p 214510.877867466
* o16 input 12 w=+0.124882648574468 w+  bank=n alpha=1 R=266917.251626487 G_phys=3.74647945723404e-06 G_eff=3.74647945723404e-06
Ro16p12n1 h12y o16p 268196.119427413
* o16 input 13 w=+0.270423516346849 w+  bank=n alpha=1 R=123263.441669694 G_phys=8.11270549040547e-06 G_eff=8.11270549040547e-06
Ro16p13n1 h13y o16p 123399.791748065
* o16 input 14 w=-0.22936067173287 w-  bank=n alpha=1 R=145331.512510374 G_phys=6.88082015198609e-06 G_eff=6.88082015198609e-06
Ro16n14n1 h14yn o16p 145311.137487901
* o16 input 15 w=+0.0349795005301705 w+  bank=n alpha=1 R=952939.087983336 G_phys=1.04938501590512e-06 G_eff=1.04938501590512e-06
Ro16p15n1 h15y o16p 951915.704823348
* o16 input 16 w=+0.104322324768401 w+  bank=n alpha=1 R=319522.531800691 G_phys=3.12966974305203e-06 G_eff=3.12966974305203e-06
Ro16p16n1 h16y o16p 320239.29499302
* o16 input 17 w=-0.351176137449102 w-  bank=n alpha=1 R=94919.129686494 G_phys=1.05352841234731e-05 G_eff=1.05352841234731e-05
Ro16n17n1 h17yn o16p 95316.1894640604
* o16 input 18 w=+0.119462358831177 w+  bank=n alpha=1 R=279027.918580107 G_phys=3.58387076493532e-06 G_eff=3.58387076493532e-06
Ro16p18n1 h18y o16p 277756.59402811
* o16 input 19 w=+0.230688311648174 w+  bank=n alpha=1 R=144495.111586626 G_phys=6.92064934944523e-06 G_eff=6.92064934944523e-06
Ro16p19n1 h19y o16p 144576.564590636
* o16 input 20 w=-0.0614748986253126 w-  bank=n alpha=1 R=542226.731214294 G_phys=1.84424695875938e-06 G_eff=1.84424695875938e-06
Ro16n20n1 h20yn o16p 544571.71047136
* o16 input 21 w=+0.36727529530057 w+  bank=n alpha=1 R=90758.4413104999 G_phys=1.10182588590171e-05 G_eff=1.10182588590171e-05
Ro16p21n1 h21y o16p 90469.038209129
* o16 input 22 w=+0.579638140801163 w+  bank=n alpha=1 R=57507.1427964708 G_phys=1.73891442240349e-05 G_eff=1.73891442240349e-05
Ro16p22n1 h22y o16p 57575.5217854501
* o16 input 23 w=-0.0387096142803063 w-  bank=n alpha=1 R=861112.515664923 G_phys=1.16128842840919e-06 G_eff=1.16128842840919e-06
Ro16n23n1 h23yn o16p 857134.893994605
* o16 input 24 w=+0.0384174368738491 w+  bank=n alpha=1 R=867661.563232072 G_phys=1.15252310621547e-06 G_eff=1.15252310621547e-06
Ro16p24n1 h24y o16p 868508.75520015
* o16 input 25 w=+0.201641208818347 w+  bank=n alpha=1 R=165310.12449624 G_phys=6.04923626455041e-06 G_eff=6.04923626455041e-06
Ro16p25n1 h25y o16p 165513.379368645
* o16 input 26 w=-0.606109769372092 w-  bank=n alpha=1 R=54995.5387913735 G_phys=1.81832930811628e-05 G_eff=1.81832930811628e-05
Ro16n26n1 h26yn o16p 54946.1656698396
* o16 input 27 w=-0.101484914332963 w-  bank=n alpha=1 R=328456.04248105 G_phys=3.04454742998888e-06 G_eff=3.04454742998888e-06
Ro16n27n1 h27yn o16p 326843.214860732
* o16 input 28 w=+0.04265872854179 w+  bank=n alpha=1 R=781395.378455286 G_phys=1.2797618562537e-06 G_eff=1.2797618562537e-06
Ro16p28n1 h28y o16p 780996.782458872
* o16 input 29 w=+0.0889131834636398 w+  bank=n alpha=1 R=374897.535267812 G_phys=2.66739550390919e-06 G_eff=2.66739550390919e-06
Ro16p29n1 h29y o16p 375863.142175937
* o16 input 30 w=+0.0420485970959956 w+  bank=n alpha=1 R=792733.54250641 G_phys=1.26145791287987e-06 G_eff=1.26145791287987e-06
Ro16p30n1 h30y o16p 789297.83316582
* o16 input 31 w=-0.332324220948992 w-  bank=n alpha=1 R=100303.652975236 G_phys=9.96972662846976e-06 G_eff=9.96972662846976e-06
Ro16n31n1 h31yn o16p 100704.143267976
* o16 input 32 w=+0.137132637809711 w+  bank=n alpha=1 R=243073.668425948 G_phys=4.11397913429134e-06 G_eff=4.11397913429134e-06
Ro16p32n1 h32y o16p 243207.198932591
* o16 bias w+  bank=n alpha=1 R=811464.21158382 G_phys=1.23234023845389e-06 G_eff=1.23234023845389e-06
Ro16bpn1 vref o16p 811487.941712337
* single-copy I-to-V: 0 V sum o16p, I dump onto R_IV=33333.3333333333
Vo16p o16p 0 DC 0
Bo16iv 0 o16lin I = i(Vo16p)
Ro16iv o16lin 0 33380.7022498861
.control
set numdgt=15
alter Vin1 DC 0.632568504068692
alter Vin2 DC 0.130751912471634
alter Vin3 DC 0.498395519129232
alter Vin4 DC 0.508991138596361
alter Vin5 DC 0.741696432510955
alter Vin6 DC -0.174816274310903
alter Vin7 DC -0.711636899513491
alter Vin8 DC -0.992297390491566
alter Vin9 DC 0.124859661764151
alter Vin10 DC 0.927115220977617
alter Vin11 DC 0.757625693253616
alter Vin12 DC -0.349962125380286
alter Vin13 DC 0.772046924490164
alter Vin14 DC 0.809792344935797
alter Vin15 DC 0.311400434804866
alter Vin16 DC 0.38369938347353
op
print v(o1lin)
print v(o2lin)
print v(o3lin)
print v(o4lin)
print v(o5lin)
print v(o6lin)
print v(o7lin)
print v(o8lin)
print v(o9lin)
print v(o10lin)
print v(o11lin)
print v(o12lin)
print v(o13lin)
print v(o14lin)
print v(o15lin)
print v(o16lin)
alter Vin1 DC -0.974788209071848
alter Vin2 DC -0.200637826852555
alter Vin3 DC 0.823173051424639
alter Vin4 DC 0.925543502570132
alter Vin5 DC -0.235735032734585
alter Vin6 DC -0.141680228154392
alter Vin7 DC -0.886626844533918
alter Vin8 DC 0.40575230866322
alter Vin9 DC -0.9068934262577
alter Vin10 DC -0.71518146061856
alter Vin11 DC 0.507768822660382
alter Vin12 DC -0.423033389400712
alter Vin13 DC -0.189634986503447
alter Vin14 DC -0.729894999162038
alter Vin15 DC -0.822420852539174
alter Vin16 DC 0.729238013944139
op
print v(o1lin)
print v(o2lin)
print v(o3lin)
print v(o4lin)
print v(o5lin)
print v(o6lin)
print v(o7lin)
print v(o8lin)
print v(o9lin)
print v(o10lin)
print v(o11lin)
print v(o12lin)
print v(o13lin)
print v(o14lin)
print v(o15lin)
print v(o16lin)
alter Vin1 DC 0.847734806115268
alter Vin2 DC -0.795676825133873
alter Vin3 DC -0.576906573311323
alter Vin4 DC 0.808070915111557
alter Vin5 DC -0.272832325997157
alter Vin6 DC 0.984764551383679
alter Vin7 DC 0.873557149180198
alter Vin8 DC -0.395997821263188
alter Vin9 DC -0.91476403063532
alter Vin10 DC -0.814982443313317
alter Vin11 DC 0.386244963375333
alter Vin12 DC 0.97673536509706
alter Vin13 DC 0.859516677956838
alter Vin14 DC -0.48344879964576
alter Vin15 DC -0.389119391902879
alter Vin16 DC -0.0777429346880354
op
print v(o1lin)
print v(o2lin)
print v(o3lin)
print v(o4lin)
print v(o5lin)
print v(o6lin)
print v(o7lin)
print v(o8lin)
print v(o9lin)
print v(o10lin)
print v(o11lin)
print v(o12lin)
print v(o13lin)
print v(o14lin)
print v(o15lin)
print v(o16lin)
alter Vin1 DC -0.634763869503377
alter Vin2 DC 0.66136408923338
alter Vin3 DC -0.0583013778475243
alter Vin4 DC 0.720990552465887
alter Vin5 DC 0.260016013717853
alter Vin6 DC 0.577414589397466
alter Vin7 DC 0.854892175873237
alter Vin8 DC -0.100267864923785
alter Vin9 DC -0.2976521369567
alter Vin10 DC 0.530570623968421
alter Vin11 DC 0.0982353459122769
alter Vin12 DC -0.228498741708201
alter Vin13 DC -0.423704441504684
alter Vin14 DC -0.324453707550555
alter Vin15 DC 0.963733756086886
alter Vin16 DC 0.888564654599973
op
print v(o1lin)
print v(o2lin)
print v(o3lin)
print v(o4lin)
print v(o5lin)
print v(o6lin)
print v(o7lin)
print v(o8lin)
print v(o9lin)
print v(o10lin)
print v(o11lin)
print v(o12lin)
print v(o13lin)
print v(o14lin)
print v(o15lin)
print v(o16lin)
alter Vin1 DC 0.399419993562847
alter Vin2 DC 0.822754861286246
alter Vin3 DC -0.217979993499255
alter Vin4 DC -0.524840716208239
alter Vin5 DC -0.343585224682448
alter Vin6 DC 0.597298680392867
alter Vin7 DC 0.745769924406716
alter Vin8 DC -0.31122778594332
alter Vin9 DC -0.551408564506993
alter Vin10 DC 0.508813890470598
alter Vin11 DC 0.967095039058534
alter Vin12 DC 0.436711939252078
alter Vin13 DC -0.637944426107168
alter Vin14 DC -0.610126039852947
alter Vin15 DC -0.0266004623343832
alter Vin16 DC 0.865503835859949
op
print v(o1lin)
print v(o2lin)
print v(o3lin)
print v(o4lin)
print v(o5lin)
print v(o6lin)
print v(o7lin)
print v(o8lin)
print v(o9lin)
print v(o10lin)
print v(o11lin)
print v(o12lin)
print v(o13lin)
print v(o14lin)
print v(o15lin)
print v(o16lin)
alter Vin1 DC -0.39950651162754
alter Vin2 DC 0.845146280157393
alter Vin3 DC -0.293453062060104
alter Vin4 DC -0.935486140839395
alter Vin5 DC -0.0810356399901349
alter Vin6 DC -0.902253265490345
alter Vin7 DC -0.555846545167458
alter Vin8 DC 0.760951343886015
alter Vin9 DC 0.759556104325771
alter Vin10 DC -0.949711300869059
alter Vin11 DC 0.0303569257790743
alter Vin12 DC -0.0286488050711204
alter Vin13 DC -0.578375740619194
alter Vin14 DC 0.906957053187536
alter Vin15 DC -0.073548295446664
alter Vin16 DC 0.0683418880828401
op
print v(o1lin)
print v(o2lin)
print v(o3lin)
print v(o4lin)
print v(o5lin)
print v(o6lin)
print v(o7lin)
print v(o8lin)
print v(o9lin)
print v(o10lin)
print v(o11lin)
print v(o12lin)
print v(o13lin)
print v(o14lin)
print v(o15lin)
print v(o16lin)
alter Vin1 DC -0.269700131318679
alter Vin2 DC -0.0587851098186172
alter Vin3 DC -0.93859148153159
alter Vin4 DC 0.37397748574996
alter Vin5 DC -0.640198473614279
alter Vin6 DC 0.28300439655269
alter Vin7 DC 0.495573806278234
alter Vin8 DC 0.4844036398211
alter Vin9 DC 0.865719664227782
alter Vin10 DC -0.637807257193159
alter Vin11 DC 0.140608503083495
alter Vin12 DC -0.793259398029265
alter Vin13 DC 0.803362583110163
alter Vin14 DC 0.644880503300019
alter Vin15 DC 0.80511980776248
alter Vin16 DC 0.00183769605351314
op
print v(o1lin)
print v(o2lin)
print v(o3lin)
print v(o4lin)
print v(o5lin)
print v(o6lin)
print v(o7lin)
print v(o8lin)
print v(o9lin)
print v(o10lin)
print v(o11lin)
print v(o12lin)
print v(o13lin)
print v(o14lin)
print v(o15lin)
print v(o16lin)
alter Vin1 DC -0.681053369759573
alter Vin2 DC 0.971345998932643
alter Vin3 DC 0.0228486000093842
alter Vin4 DC -0.68100585488642
alter Vin5 DC 0.935892877213541
alter Vin6 DC 0.408157507560112
alter Vin7 DC 0.0488412507809939
alter Vin8 DC 0.828266383636528
alter Vin9 DC 0.784246855742534
alter Vin10 DC 0.207324880526272
alter Vin11 DC 0.218839873002423
alter Vin12 DC -0.64711694724826
alter Vin13 DC -0.45152559776989
alter Vin14 DC -0.16638824613438
alter Vin15 DC 0.56955443939986
alter Vin16 DC -0.894236938055073
op
print v(o1lin)
print v(o2lin)
print v(o3lin)
print v(o4lin)
print v(o5lin)
print v(o6lin)
print v(o7lin)
print v(o8lin)
print v(o9lin)
print v(o10lin)
print v(o11lin)
print v(o12lin)
print v(o13lin)
print v(o14lin)
print v(o15lin)
print v(o16lin)
alter Vin1 DC -0.924906884178613
alter Vin2 DC 0.267791334016869
alter Vin3 DC 0.386698050737095
alter Vin4 DC -0.375678093248884
alter Vin5 DC -0.481472424709471
alter Vin6 DC -0.590426934613701
alter Vin7 DC 0.274930056654101
alter Vin8 DC -0.495416670165966
alter Vin9 DC 0.662447960935986
alter Vin10 DC -0.39828366695253
alter Vin11 DC -0.435305893543825
alter Vin12 DC -0.673137852956615
alter Vin13 DC 0.399291241842683
alter Vin14 DC -0.135245929167714
alter Vin15 DC 0.191750308509824
alter Vin16 DC -0.317239774769057
op
print v(o1lin)
print v(o2lin)
print v(o3lin)
print v(o4lin)
print v(o5lin)
print v(o6lin)
print v(o7lin)
print v(o8lin)
print v(o9lin)
print v(o10lin)
print v(o11lin)
print v(o12lin)
print v(o13lin)
print v(o14lin)
print v(o15lin)
print v(o16lin)
alter Vin1 DC 0.691315307576891
alter Vin2 DC -0.966597973272848
alter Vin3 DC 0.337819856228323
alter Vin4 DC 0.445958641593821
alter Vin5 DC 0.28794565803369
alter Vin6 DC -0.437558044466196
alter Vin7 DC 0.335767271835964
alter Vin8 DC 0.741106323711654
alter Vin9 DC -0.498474688285342
alter Vin10 DC -0.937258343994007
alter Vin11 DC 0.628549591207388
alter Vin12 DC 0.0809865794436
alter Vin13 DC -0.792347081447127
alter Vin14 DC 0.290895831462678
alter Vin15 DC 0.917514644221665
alter Vin16 DC -0.636405891470935
op
print v(o1lin)
print v(o2lin)
print v(o3lin)
print v(o4lin)
print v(o5lin)
print v(o6lin)
print v(o7lin)
print v(o8lin)
print v(o9lin)
print v(o10lin)
print v(o11lin)
print v(o12lin)
print v(o13lin)
print v(o14lin)
print v(o15lin)
print v(o16lin)
alter Vin1 DC -0.436056235334991
alter Vin2 DC 0.359995773967924
alter Vin3 DC -0.862040082296962
alter Vin4 DC -0.613020281079166
alter Vin5 DC -0.682661118108276
alter Vin6 DC 0.0327240219234706
alter Vin7 DC -0.254762451719826
alter Vin8 DC -0.628386977446209
alter Vin9 DC -0.435404154442101
alter Vin10 DC -0.560268250029906
alter Vin11 DC -0.34004922102946
alter Vin12 DC 0.828462300998657
alter Vin13 DC -0.258762364783062
alter Vin14 DC 0.0615557520793739
alter Vin15 DC -0.749003484831865
alter Vin16 DC -0.461728905661948
op
print v(o1lin)
print v(o2lin)
print v(o3lin)
print v(o4lin)
print v(o5lin)
print v(o6lin)
print v(o7lin)
print v(o8lin)
print v(o9lin)
print v(o10lin)
print v(o11lin)
print v(o12lin)
print v(o13lin)
print v(o14lin)
print v(o15lin)
print v(o16lin)
alter Vin1 DC 0.402941317710264
alter Vin2 DC 0.676235321348749
alter Vin3 DC 0.422742637816617
alter Vin4 DC 0.294030371745866
alter Vin5 DC -0.638561187867718
alter Vin6 DC -0.0501402124484349
alter Vin7 DC -0.126876472940439
alter Vin8 DC 0.249620810954959
alter Vin9 DC 0.800022887685632
alter Vin10 DC -0.267525733933315
alter Vin11 DC -0.0493799961815793
alter Vin12 DC 0.412930540027973
alter Vin13 DC 0.168971578589697
alter Vin14 DC 0.402529908662486
alter Vin15 DC 0.590508734712441
alter Vin16 DC -0.809797572982249
op
print v(o1lin)
print v(o2lin)
print v(o3lin)
print v(o4lin)
print v(o5lin)
print v(o6lin)
print v(o7lin)
print v(o8lin)
print v(o9lin)
print v(o10lin)
print v(o11lin)
print v(o12lin)
print v(o13lin)
print v(o14lin)
print v(o15lin)
print v(o16lin)
alter Vin1 DC -0.720940644465072
alter Vin2 DC 0.811090286911281
alter Vin3 DC 0.0887704649024641
alter Vin4 DC -0.703881870777446
alter Vin5 DC 0.792271352370679
alter Vin6 DC -0.611577475657032
alter Vin7 DC 0.630598962593579
alter Vin8 DC -0.909175170042211
alter Vin9 DC 0.45028681887581
alter Vin10 DC -0.610646509410917
alter Vin11 DC 0.942769230832138
alter Vin12 DC 0.253399891858326
alter Vin13 DC 0.239806152599995
alter Vin14 DC -0.424323687911083
alter Vin15 DC -0.132402036224528
alter Vin16 DC 0.499567887714755
op
print v(o1lin)
print v(o2lin)
print v(o3lin)
print v(o4lin)
print v(o5lin)
print v(o6lin)
print v(o7lin)
print v(o8lin)
print v(o9lin)
print v(o10lin)
print v(o11lin)
print v(o12lin)
print v(o13lin)
print v(o14lin)
print v(o15lin)
print v(o16lin)
alter Vin1 DC -0.553601012740836
alter Vin2 DC -0.0853827874775894
alter Vin3 DC 0.472526855220367
alter Vin4 DC 0.983320104826496
alter Vin5 DC -0.32589641106305
alter Vin6 DC 0.620602426134993
alter Vin7 DC -0.529649272081957
alter Vin8 DC -0.400401658684954
alter Vin9 DC 0.506127142109278
alter Vin10 DC -0.0613843649963521
alter Vin11 DC 0.194508563247131
alter Vin12 DC -0.0888973979013215
alter Vin13 DC 0.304485213029303
alter Vin14 DC 0.571192626328441
alter Vin15 DC 0.39987631868635
alter Vin16 DC 0.458594801121468
op
print v(o1lin)
print v(o2lin)
print v(o3lin)
print v(o4lin)
print v(o5lin)
print v(o6lin)
print v(o7lin)
print v(o8lin)
print v(o9lin)
print v(o10lin)
print v(o11lin)
print v(o12lin)
print v(o13lin)
print v(o14lin)
print v(o15lin)
print v(o16lin)
alter Vin1 DC 0.941921702845139
alter Vin2 DC -0.797590224953611
alter Vin3 DC -0.353544884625478
alter Vin4 DC -0.223679714692619
alter Vin5 DC 0.934853237163932
alter Vin6 DC 0.813220120283511
alter Vin7 DC 0.620477689684263
alter Vin8 DC -0.971969304466214
alter Vin9 DC -0.591538023713506
alter Vin10 DC 0.157162778762541
alter Vin11 DC -0.00954942079742005
alter Vin12 DC -0.766378178791702
alter Vin13 DC 0.781165514171662
alter Vin14 DC -0.870653903905813
alter Vin15 DC -0.855576259711061
alter Vin16 DC 0.576744547964966
op
print v(o1lin)
print v(o2lin)
print v(o3lin)
print v(o4lin)
print v(o5lin)
print v(o6lin)
print v(o7lin)
print v(o8lin)
print v(o9lin)
print v(o10lin)
print v(o11lin)
print v(o12lin)
print v(o13lin)
print v(o14lin)
print v(o15lin)
print v(o16lin)
alter Vin1 DC 0.0847980140064368
alter Vin2 DC -0.546436186199117
alter Vin3 DC 0.157551439199196
alter Vin4 DC -0.675094911660673
alter Vin5 DC 0.251984062858915
alter Vin6 DC 0.533034777990185
alter Vin7 DC -0.636309229712619
alter Vin8 DC 0.205266715162125
alter Vin9 DC 0.355151588504783
alter Vin10 DC -0.763079400779309
alter Vin11 DC 0.279208117784239
alter Vin12 DC -0.046053502725351
alter Vin13 DC -0.0674199792200116
alter Vin14 DC -0.0988424326224195
alter Vin15 DC 0.341224431366531
alter Vin16 DC -0.128234288046615
op
print v(o1lin)
print v(o2lin)
print v(o3lin)
print v(o4lin)
print v(o5lin)
print v(o6lin)
print v(o7lin)
print v(o8lin)
print v(o9lin)
print v(o10lin)
print v(o11lin)
print v(o12lin)
print v(o13lin)
print v(o14lin)
print v(o15lin)
print v(o16lin)
alter Vin1 DC -0.595380417251091
alter Vin2 DC -0.170465926726426
alter Vin3 DC -0.165712373937593
alter Vin4 DC 0.484522499674577
alter Vin5 DC 0.78085882899596
alter Vin6 DC -0.00693757328167033
alter Vin7 DC -0.498016397952294
alter Vin8 DC -0.76057897931883
alter Vin9 DC -0.343082475402419
alter Vin10 DC 0.0125577265451373
alter Vin11 DC 0.60192661275731
alter Vin12 DC -0.0810399461010238
alter Vin13 DC 0.308396489131115
alter Vin14 DC -0.555444513107257
alter Vin15 DC -0.388314730894595
alter Vin16 DC 0.923801824090698
op
print v(o1lin)
print v(o2lin)
print v(o3lin)
print v(o4lin)
print v(o5lin)
print v(o6lin)
print v(o7lin)
print v(o8lin)
print v(o9lin)
print v(o10lin)
print v(o11lin)
print v(o12lin)
print v(o13lin)
print v(o14lin)
print v(o15lin)
print v(o16lin)
alter Vin1 DC -0.344075298305219
alter Vin2 DC -0.299983052907286
alter Vin3 DC -0.203058505077156
alter Vin4 DC 0.435239788418766
alter Vin5 DC 0.363815756954568
alter Vin6 DC 0.837980352083505
alter Vin7 DC -0.538527300440037
alter Vin8 DC -0.938627722316779
alter Vin9 DC 0.4922043173456
alter Vin10 DC 0.207737109101553
alter Vin11 DC 0.020741026962491
alter Vin12 DC 0.25637018547913
alter Vin13 DC -0.83211091299048
alter Vin14 DC 0.766421841791898
alter Vin15 DC -0.927411256783522
alter Vin16 DC 0.369430588094565
op
print v(o1lin)
print v(o2lin)
print v(o3lin)
print v(o4lin)
print v(o5lin)
print v(o6lin)
print v(o7lin)
print v(o8lin)
print v(o9lin)
print v(o10lin)
print v(o11lin)
print v(o12lin)
print v(o13lin)
print v(o14lin)
print v(o15lin)
print v(o16lin)
alter Vin1 DC 0.627063489212866
alter Vin2 DC -0.582648694346974
alter Vin3 DC -0.765786006835309
alter Vin4 DC 0.102836606226475
alter Vin5 DC -0.66611661718385
alter Vin6 DC 0.412069103904774
alter Vin7 DC -0.320626602803983
alter Vin8 DC 0.664935939224919
alter Vin9 DC -0.907582410736682
alter Vin10 DC 0.138301736499832
alter Vin11 DC -0.124043342050667
alter Vin12 DC -0.444462469724564
alter Vin13 DC 0.993018090945098
alter Vin14 DC 0.384970115288437
alter Vin15 DC 0.988144749211259
alter Vin16 DC 0.83719280846034
op
print v(o1lin)
print v(o2lin)
print v(o3lin)
print v(o4lin)
print v(o5lin)
print v(o6lin)
print v(o7lin)
print v(o8lin)
print v(o9lin)
print v(o10lin)
print v(o11lin)
print v(o12lin)
print v(o13lin)
print v(o14lin)
print v(o15lin)
print v(o16lin)
alter Vin1 DC -0.45182957480955
alter Vin2 DC -0.662024952982424
alter Vin3 DC -0.229489946519203
alter Vin4 DC 0.68091685978688
alter Vin5 DC -0.524794188274996
alter Vin6 DC -0.775298122631856
alter Vin7 DC 0.477695002661498
alter Vin8 DC 0.318249373784927
alter Vin9 DC 0.0674353216224022
alter Vin10 DC -0.757574746285693
alter Vin11 DC 0.194480016220294
alter Vin12 DC -0.986058532734065
alter Vin13 DC -0.858099129281211
alter Vin14 DC 0.875413943263164
alter Vin15 DC -0.355937045022594
alter Vin16 DC -0.909269999495478
op
print v(o1lin)
print v(o2lin)
print v(o3lin)
print v(o4lin)
print v(o5lin)
print v(o6lin)
print v(o7lin)
print v(o8lin)
print v(o9lin)
print v(o10lin)
print v(o11lin)
print v(o12lin)
print v(o13lin)
print v(o14lin)
print v(o15lin)
print v(o16lin)
alter Vin1 DC -0.166134124041978
alter Vin2 DC 0.326271636139386
alter Vin3 DC 0.0377865575229868
alter Vin4 DC 0.642967168503026
alter Vin5 DC -0.0313452796975957
alter Vin6 DC -0.898196834887308
alter Vin7 DC -0.0223210703281855
alter Vin8 DC 0.0240743286141054
alter Vin9 DC -0.32939698929494
alter Vin10 DC 0.156138339259947
alter Vin11 DC 0.998037514156259
alter Vin12 DC 0.996329734012833
alter Vin13 DC -0.792547573290175
alter Vin14 DC 0.272037484511549
alter Vin15 DC 0.144597423090336
alter Vin16 DC 0.648759180262861
op
print v(o1lin)
print v(o2lin)
print v(o3lin)
print v(o4lin)
print v(o5lin)
print v(o6lin)
print v(o7lin)
print v(o8lin)
print v(o9lin)
print v(o10lin)
print v(o11lin)
print v(o12lin)
print v(o13lin)
print v(o14lin)
print v(o15lin)
print v(o16lin)
alter Vin1 DC 0.513767503102245
alter Vin2 DC -0.993130673228192
alter Vin3 DC -0.741368455463561
alter Vin4 DC -0.673172294979255
alter Vin5 DC 0.53329038934038
alter Vin6 DC 0.273011112722964
alter Vin7 DC -0.22429483417346
alter Vin8 DC -0.904486174889755
alter Vin9 DC -0.0476389722976311
alter Vin10 DC 0.0830713748633647
alter Vin11 DC -0.0631237690576123
alter Vin12 DC -0.387190151349574
alter Vin13 DC 0.490599598157352
alter Vin14 DC -0.431150162403273
alter Vin15 DC -0.494227353798093
alter Vin16 DC 0.199587837072336
op
print v(o1lin)
print v(o2lin)
print v(o3lin)
print v(o4lin)
print v(o5lin)
print v(o6lin)
print v(o7lin)
print v(o8lin)
print v(o9lin)
print v(o10lin)
print v(o11lin)
print v(o12lin)
print v(o13lin)
print v(o14lin)
print v(o15lin)
print v(o16lin)
alter Vin1 DC -0.527641643915313
alter Vin2 DC -0.760469900825891
alter Vin3 DC -0.971812928614647
alter Vin4 DC -0.462029484155251
alter Vin5 DC -0.0990347067926469
alter Vin6 DC -0.431709782876269
alter Vin7 DC 0.582115295594787
alter Vin8 DC 0.490760521778589
alter Vin9 DC -0.597773697850127
alter Vin10 DC -0.146377118439857
alter Vin11 DC 0.77673031103089
alter Vin12 DC -0.958686104499727
alter Vin13 DC -0.651792165711311
alter Vin14 DC -0.771428363238295
alter Vin15 DC -0.274616062196005
alter Vin16 DC 0.797804290304925
op
print v(o1lin)
print v(o2lin)
print v(o3lin)
print v(o4lin)
print v(o5lin)
print v(o6lin)
print v(o7lin)
print v(o8lin)
print v(o9lin)
print v(o10lin)
print v(o11lin)
print v(o12lin)
print v(o13lin)
print v(o14lin)
print v(o15lin)
print v(o16lin)
alter Vin1 DC -0.0660406839746723
alter Vin2 DC -0.199767810717373
alter Vin3 DC 0.433496899757818
alter Vin4 DC 0.179118988466795
alter Vin5 DC -0.213841522026575
alter Vin6 DC 0.556646137550105
alter Vin7 DC -0.700676048926627
alter Vin8 DC -0.447891404812417
alter Vin9 DC -0.03646969314408
alter Vin10 DC 0.356038664374622
alter Vin11 DC -0.898261479878571
alter Vin12 DC -0.522238075094493
alter Vin13 DC 0.470385125738646
alter Vin14 DC -0.934570154871633
alter Vin15 DC -0.215637621907727
alter Vin16 DC -0.839313330640211
op
print v(o1lin)
print v(o2lin)
print v(o3lin)
print v(o4lin)
print v(o5lin)
print v(o6lin)
print v(o7lin)
print v(o8lin)
print v(o9lin)
print v(o10lin)
print v(o11lin)
print v(o12lin)
print v(o13lin)
print v(o14lin)
print v(o15lin)
print v(o16lin)
alter Vin1 DC 0.944694975466901
alter Vin2 DC 0.557429746816729
alter Vin3 DC 0.0879434025868335
alter Vin4 DC -0.971277715280804
alter Vin5 DC 0.469272183979264
alter Vin6 DC 0.0553351732696565
alter Vin7 DC 0.319789179040026
alter Vin8 DC 0.105605881218313
alter Vin9 DC -0.808751474487991
alter Vin10 DC 0.345207050357025
alter Vin11 DC 0.887488099386043
alter Vin12 DC -0.946434379958131
alter Vin13 DC -0.756800857731664
alter Vin14 DC 0.584597058025779
alter Vin15 DC -0.172504938226507
alter Vin16 DC 0.057467887193803
op
print v(o1lin)
print v(o2lin)
print v(o3lin)
print v(o4lin)
print v(o5lin)
print v(o6lin)
print v(o7lin)
print v(o8lin)
print v(o9lin)
print v(o10lin)
print v(o11lin)
print v(o12lin)
print v(o13lin)
print v(o14lin)
print v(o15lin)
print v(o16lin)
alter Vin1 DC 0.268139611364692
alter Vin2 DC -0.0761352932592003
alter Vin3 DC 0.257679787771012
alter Vin4 DC 0.647151913043588
alter Vin5 DC 0.688559040420576
alter Vin6 DC 0.195725091292368
alter Vin7 DC -0.650874124907297
alter Vin8 DC 0.757864910663943
alter Vin9 DC -0.801870229804984
alter Vin10 DC 0.0650107507341318
alter Vin11 DC 0.76839506437409
alter Vin12 DC 0.626485114847845
alter Vin13 DC -0.916744432608743
alter Vin14 DC -0.0381884442222795
alter Vin15 DC -0.39538459366548
alter Vin16 DC -0.53577973836249
op
print v(o1lin)
print v(o2lin)
print v(o3lin)
print v(o4lin)
print v(o5lin)
print v(o6lin)
print v(o7lin)
print v(o8lin)
print v(o9lin)
print v(o10lin)
print v(o11lin)
print v(o12lin)
print v(o13lin)
print v(o14lin)
print v(o15lin)
print v(o16lin)
alter Vin1 DC -0.399980891864974
alter Vin2 DC -0.311058824105357
alter Vin3 DC -0.121767102063513
alter Vin4 DC -0.1825017503415
alter Vin5 DC -0.384605419902336
alter Vin6 DC 0.330631581125283
alter Vin7 DC -0.386290416681561
alter Vin8 DC -0.384489741601594
alter Vin9 DC 0.461619066894131
alter Vin10 DC 0.340745152205258
alter Vin11 DC 0.0704341709189509
alter Vin12 DC -0.729253158394329
alter Vin13 DC -0.938300926484224
alter Vin14 DC -0.138387864413021
alter Vin15 DC -0.774754191520238
alter Vin16 DC -0.06472577537549
op
print v(o1lin)
print v(o2lin)
print v(o3lin)
print v(o4lin)
print v(o5lin)
print v(o6lin)
print v(o7lin)
print v(o8lin)
print v(o9lin)
print v(o10lin)
print v(o11lin)
print v(o12lin)
print v(o13lin)
print v(o14lin)
print v(o15lin)
print v(o16lin)
alter Vin1 DC 0.829033111352976
alter Vin2 DC 0.280583414286498
alter Vin3 DC -0.120742403743087
alter Vin4 DC 0.0243484731867412
alter Vin5 DC 0.814584378326768
alter Vin6 DC 0.126953925080522
alter Vin7 DC -0.480745642214154
alter Vin8 DC 0.58301448926957
alter Vin9 DC -0.81340983633115
alter Vin10 DC -0.0371270227098195
alter Vin11 DC 0.20534777858118
alter Vin12 DC 0.195891870031178
alter Vin13 DC 0.970242611575792
alter Vin14 DC -0.260742875944806
alter Vin15 DC -0.707389032009879
alter Vin16 DC -0.834880031964718
op
print v(o1lin)
print v(o2lin)
print v(o3lin)
print v(o4lin)
print v(o5lin)
print v(o6lin)
print v(o7lin)
print v(o8lin)
print v(o9lin)
print v(o10lin)
print v(o11lin)
print v(o12lin)
print v(o13lin)
print v(o14lin)
print v(o15lin)
print v(o16lin)
alter Vin1 DC 0.857714478615315
alter Vin2 DC -0.977990911511488
alter Vin3 DC 0.522120406530206
alter Vin4 DC -0.818687889680604
alter Vin5 DC -0.375725178244296
alter Vin6 DC 0.0646773078474716
alter Vin7 DC -0.0696743243817957
alter Vin8 DC -0.260504274511249
alter Vin9 DC 0.991412947690472
alter Vin10 DC -0.736994622705201
alter Vin11 DC -0.989748939020532
alter Vin12 DC 0.745774856471066
alter Vin13 DC 0.801402815326226
alter Vin14 DC -0.709499539722716
alter Vin15 DC 0.652792790844334
alter Vin16 DC 0.832995677945966
op
print v(o1lin)
print v(o2lin)
print v(o3lin)
print v(o4lin)
print v(o5lin)
print v(o6lin)
print v(o7lin)
print v(o8lin)
print v(o9lin)
print v(o10lin)
print v(o11lin)
print v(o12lin)
print v(o13lin)
print v(o14lin)
print v(o15lin)
print v(o16lin)
alter Vin1 DC 0.578295068169871
alter Vin2 DC -0.645738590777075
alter Vin3 DC -0.438695216585002
alter Vin4 DC 0.354791332621486
alter Vin5 DC 0.572376875240838
alter Vin6 DC 0.283557785900749
alter Vin7 DC 0.801480336715229
alter Vin8 DC 0.837498240545797
alter Vin9 DC -0.162628392977149
alter Vin10 DC 0.0188708173241798
alter Vin11 DC 0.732770034383577
alter Vin12 DC 0.829886941830955
alter Vin13 DC -0.215883555562326
alter Vin14 DC 0.778511642633058
alter Vin15 DC 0.726117246545339
alter Vin16 DC -0.836770051577228
op
print v(o1lin)
print v(o2lin)
print v(o3lin)
print v(o4lin)
print v(o5lin)
print v(o6lin)
print v(o7lin)
print v(o8lin)
print v(o9lin)
print v(o10lin)
print v(o11lin)
print v(o12lin)
print v(o13lin)
print v(o14lin)
print v(o15lin)
print v(o16lin)
alter Vin1 DC 0.512666764012534
alter Vin2 DC -0.91042789183315
alter Vin3 DC -0.674618340260172
alter Vin4 DC 0.77595275679209
alter Vin5 DC 0.541729157541262
alter Vin6 DC 0.434965717552227
alter Vin7 DC 0.812555641142557
alter Vin8 DC -0.696450119180847
alter Vin9 DC 0.349416262802516
alter Vin10 DC 0.238837808121401
alter Vin11 DC -0.606665588660031
alter Vin12 DC 0.394312915601357
alter Vin13 DC -0.299226531600345
alter Vin14 DC -0.590822138784816
alter Vin15 DC -0.900583331081588
alter Vin16 DC 0.969002954577666
op
print v(o1lin)
print v(o2lin)
print v(o3lin)
print v(o4lin)
print v(o5lin)
print v(o6lin)
print v(o7lin)
print v(o8lin)
print v(o9lin)
print v(o10lin)
print v(o11lin)
print v(o12lin)
print v(o13lin)
print v(o14lin)
print v(o15lin)
print v(o16lin)
alter Vin1 DC 0.996964849631111
alter Vin2 DC -0.382670628895657
alter Vin3 DC -0.589629194051136
alter Vin4 DC -0.257488018342011
alter Vin5 DC -0.0225875667849409
alter Vin6 DC 0.316086952435916
alter Vin7 DC 0.923082372784055
alter Vin8 DC 0.0720344794803358
alter Vin9 DC -0.570888117083981
alter Vin10 DC 0.636196022229113
alter Vin11 DC -0.59824376349448
alter Vin12 DC 0.724608074730714
alter Vin13 DC -0.224915642937104
alter Vin14 DC 0.262010847512565
alter Vin15 DC -0.401587833404117
alter Vin16 DC 0.438103800930035
op
print v(o1lin)
print v(o2lin)
print v(o3lin)
print v(o4lin)
print v(o5lin)
print v(o6lin)
print v(o7lin)
print v(o8lin)
print v(o9lin)
print v(o10lin)
print v(o11lin)
print v(o12lin)
print v(o13lin)
print v(o14lin)
print v(o15lin)
print v(o16lin)
alter Vin1 DC 0.146388210996796
alter Vin2 DC 0.851378176855976
alter Vin3 DC -0.545296719530172
alter Vin4 DC 0.936320371011729
alter Vin5 DC -0.659971945152452
alter Vin6 DC 0.637939687045485
alter Vin7 DC 0.775987953987478
alter Vin8 DC -0.7151329644111
alter Vin9 DC -0.403349246529835
alter Vin10 DC -0.818560699155668
alter Vin11 DC 0.66658468821056
alter Vin12 DC 0.229852048443837
alter Vin13 DC 0.152309271507268
alter Vin14 DC -0.0441514852931166
alter Vin15 DC 0.0779565043300003
alter Vin16 DC -0.122549087436726
op
print v(o1lin)
print v(o2lin)
print v(o3lin)
print v(o4lin)
print v(o5lin)
print v(o6lin)
print v(o7lin)
print v(o8lin)
print v(o9lin)
print v(o10lin)
print v(o11lin)
print v(o12lin)
print v(o13lin)
print v(o14lin)
print v(o15lin)
print v(o16lin)
alter Vin1 DC -0.926439381972823
alter Vin2 DC -0.615234894251263
alter Vin3 DC -0.0340238055806736
alter Vin4 DC 0.109946635985621
alter Vin5 DC -0.227895739326049
alter Vin6 DC 0.455407156960182
alter Vin7 DC 0.400984605846592
alter Vin8 DC -0.461739950266764
alter Vin9 DC 0.962599087089418
alter Vin10 DC 0.712808562717367
alter Vin11 DC 0.514105913709235
alter Vin12 DC 0.33339311864586
alter Vin13 DC 0.983543769948446
alter Vin14 DC 0.536587909150327
alter Vin15 DC 0.0318213121438755
alter Vin16 DC 0.666927443816752
op
print v(o1lin)
print v(o2lin)
print v(o3lin)
print v(o4lin)
print v(o5lin)
print v(o6lin)
print v(o7lin)
print v(o8lin)
print v(o9lin)
print v(o10lin)
print v(o11lin)
print v(o12lin)
print v(o13lin)
print v(o14lin)
print v(o15lin)
print v(o16lin)
alter Vin1 DC -0.322834862686127
alter Vin2 DC -0.584062888919473
alter Vin3 DC -0.720596149709497
alter Vin4 DC -0.678155702025423
alter Vin5 DC -0.50355911783956
alter Vin6 DC 0.493391744831513
alter Vin7 DC 0.77110097674651
alter Vin8 DC 0.35657120941032
alter Vin9 DC -0.299379898988419
alter Vin10 DC 0.913130383361827
alter Vin11 DC 0.047342951298037
alter Vin12 DC -0.309370616770426
alter Vin13 DC 0.192831131458793
alter Vin14 DC 0.116497038265849
alter Vin15 DC 0.128520413216278
alter Vin16 DC 0.177999850779134
op
print v(o1lin)
print v(o2lin)
print v(o3lin)
print v(o4lin)
print v(o5lin)
print v(o6lin)
print v(o7lin)
print v(o8lin)
print v(o9lin)
print v(o10lin)
print v(o11lin)
print v(o12lin)
print v(o13lin)
print v(o14lin)
print v(o15lin)
print v(o16lin)
alter Vin1 DC -0.727341455542907
alter Vin2 DC 0.529599033013268
alter Vin3 DC 0.521024787135614
alter Vin4 DC -0.866776027386548
alter Vin5 DC 0.776840732388895
alter Vin6 DC -0.717793598737009
alter Vin7 DC -0.591867360923596
alter Vin8 DC -0.0815920521485731
alter Vin9 DC -0.0328119134751146
alter Vin10 DC 0.509073071940425
alter Vin11 DC -0.546284331957509
alter Vin12 DC 0.481384262792588
alter Vin13 DC -0.859595413394354
alter Vin14 DC -0.291234569240053
alter Vin15 DC -0.870152250182007
alter Vin16 DC -0.435785443442337
op
print v(o1lin)
print v(o2lin)
print v(o3lin)
print v(o4lin)
print v(o5lin)
print v(o6lin)
print v(o7lin)
print v(o8lin)
print v(o9lin)
print v(o10lin)
print v(o11lin)
print v(o12lin)
print v(o13lin)
print v(o14lin)
print v(o15lin)
print v(o16lin)
alter Vin1 DC 0.308674565966459
alter Vin2 DC 0.476522030460678
alter Vin3 DC 0.176116940403099
alter Vin4 DC -0.269696616647023
alter Vin5 DC -0.835425825203222
alter Vin6 DC -0.257374488996112
alter Vin7 DC 0.861825960245245
alter Vin8 DC -0.757200981805819
alter Vin9 DC 0.219570221593069
alter Vin10 DC -0.737313772662746
alter Vin11 DC 0.916532670163939
alter Vin12 DC -0.326724749976099
alter Vin13 DC -0.258958621423432
alter Vin14 DC 0.110523904762884
alter Vin15 DC -0.262524879020353
alter Vin16 DC 0.595305764490593
op
print v(o1lin)
print v(o2lin)
print v(o3lin)
print v(o4lin)
print v(o5lin)
print v(o6lin)
print v(o7lin)
print v(o8lin)
print v(o9lin)
print v(o10lin)
print v(o11lin)
print v(o12lin)
print v(o13lin)
print v(o14lin)
print v(o15lin)
print v(o16lin)
alter Vin1 DC -0.121565718815817
alter Vin2 DC 0.85026137362778
alter Vin3 DC -0.725882120507907
alter Vin4 DC 0.0407127903627837
alter Vin5 DC 0.486714139870312
alter Vin6 DC -0.174725929659921
alter Vin7 DC 0.197358954375944
alter Vin8 DC 0.807395499014515
alter Vin9 DC 0.843354973338086
alter Vin10 DC 0.282953221647761
alter Vin11 DC -0.999304235886526
alter Vin12 DC -0.950389802844308
alter Vin13 DC 0.771638055757985
alter Vin14 DC -0.140350408284357
alter Vin15 DC 0.438700172314504
alter Vin16 DC 0.766208145137089
op
print v(o1lin)
print v(o2lin)
print v(o3lin)
print v(o4lin)
print v(o5lin)
print v(o6lin)
print v(o7lin)
print v(o8lin)
print v(o9lin)
print v(o10lin)
print v(o11lin)
print v(o12lin)
print v(o13lin)
print v(o14lin)
print v(o15lin)
print v(o16lin)
alter Vin1 DC 0.524565147427742
alter Vin2 DC -0.228728707561463
alter Vin3 DC 0.622966092889961
alter Vin4 DC 0.442099278822348
alter Vin5 DC -0.68185971324033
alter Vin6 DC -0.657022993439861
alter Vin7 DC 0.606146642396182
alter Vin8 DC -0.234310724429887
alter Vin9 DC 0.330684414271566
alter Vin10 DC 0.118943468091141
alter Vin11 DC -0.905603957323895
alter Vin12 DC -0.647082133976604
alter Vin13 DC -0.988277487148225
alter Vin14 DC -0.0351159487862691
alter Vin15 DC 0.0357885445778272
alter Vin16 DC -0.573737602016074
op
print v(o1lin)
print v(o2lin)
print v(o3lin)
print v(o4lin)
print v(o5lin)
print v(o6lin)
print v(o7lin)
print v(o8lin)
print v(o9lin)
print v(o10lin)
print v(o11lin)
print v(o12lin)
print v(o13lin)
print v(o14lin)
print v(o15lin)
print v(o16lin)
alter Vin1 DC 0.420805696758339
alter Vin2 DC -0.616530557983683
alter Vin3 DC 0.364821943112122
alter Vin4 DC -0.395523393484615
alter Vin5 DC -0.679355100506025
alter Vin6 DC -0.65784113684798
alter Vin7 DC 0.438381846487236
alter Vin8 DC -0.85021400464495
alter Vin9 DC -0.420415477822893
alter Vin10 DC 0.0361561564656332
alter Vin11 DC -0.815551896898906
alter Vin12 DC -0.241219421510256
alter Vin13 DC -0.0373494349822094
alter Vin14 DC -0.135841212962577
alter Vin15 DC 0.57727959838417
alter Vin16 DC -0.210802787968692
op
print v(o1lin)
print v(o2lin)
print v(o3lin)
print v(o4lin)
print v(o5lin)
print v(o6lin)
print v(o7lin)
print v(o8lin)
print v(o9lin)
print v(o10lin)
print v(o11lin)
print v(o12lin)
print v(o13lin)
print v(o14lin)
print v(o15lin)
print v(o16lin)
.endc

.end
