* Physical AI - Experiment 17 architecture C: current-mode ReLU then TIA
* Hidden: I_y = max(0, I_sum) in SPICE, then TIA. Output: feedback TIA. Current-domain ReLU is a B-source.
* Frozen Experiment 9 network A. Weights were not edited.
* Behavioral circuit analysis. Not transistor-level or PCB power.
* A_tia=100000 A_inv=100000 rail=15 vos=0.001 rout=100 Ileak=1e-08 clip=False linear=False
* shape: 2 -> 4 -> 1

Vin1 in1 0 DC 0
* passive invert in1 -> in1n: R2/R1=1.0000200002 closed-loop -1 at A=100000
Rinv1ia in1 inv1m 9990.05107083323
Rinv1ib in1n inv1m 10045.6555378019
Einv1amp in1n 0 0 inv1m 100000
Vin2 in2 0 DC 0
Vref vref 0 DC 1
* passive invert vref -> vrefn: R2/R1=1.0000200002 closed-loop -1 at A=100000
Rinvrefia vref invrefm 10027.7031786718
Rinvrefib vrefn invrefm 10025.7522464751
Einvrefamp vrefn 0 0 invrefm 100000
* load-compensated divider vref->tapref: G_load=0.000523133389485774 Ra=655884.774699393 Rb=1000 target beta=0.001 (no tap buffer)
Rdivrefa vref tapref 657790.637143785
Rdivrefb tapref 0 1004.67211668901
* load-compensated divider vrefn->taprefn: G_load=0.00166093129089326 Ra=375432.46735418 Rb=1000 target beta=0.001 (no tap buffer)
Rdivrefna vrefn taprefn 375742.064985429
Rdivrefnb taprefn 0 1001.88712544197

* h1 input 1 w=+0.683760795348816 w+  bank=n alpha=1 R=48749.9920441162 G_phys=2.05128238604645e-05 G_eff=2.05128238604645e-05
Rh1p1n1 in1 h1p 48974.6195823288
* h1 input 2 w=+0.309366783045794 w+  bank=n alpha=1 R=107746.969487669 G_phys=9.28100349137382e-06 G_eff=9.28100349137382e-06
Rh1p2n1 in2 h1p 107721.140305531
* h1 bias w-  bank=f alpha=0.001 R=1253.18954325804 G_phys=0.000797963887729386 G_eff=7.97963887729385e-07
Rh1bnf1 taprefn h1p 1254.30802002337
* current-mode ReLU + TIA h1: I_y=max(0, i(Vh1p)), then feedback TIA Rf=33333.3333333333
Vh1p h1p 0 DC 0
Bh1crelu h1ir 0 I = max(0, i(Vh1p))
* feedback TIA h1: Rf=33333.3333333333 A=100000 V(h1lin) = -I(h1ir)*Rf*A/(A+1)  (uncompensated)
Bh1tia h1drv 0 V = -(100100) * (v(h1ir) - (0.001))
Rh1ro h1drv h1lin 99.9674020365516
Rh1f h1lin h1ir 33362.6980101269
Bh1leak 0 h1ir I = 1e-08
Bh1relu h1y 0 V = max(0, min(15, v(h1lin)))

* h2 input 1 w=-0.884821731731664 w-  bank=n alpha=1 R=37672.3718890781 G_phys=2.65446519519499e-05 G_eff=2.65446519519499e-05
Rh2n1n1 in1n h2p 37500.0537883721
* h2 input 2 w=+0.782653240240456 w+  bank=n alpha=1 R=42590.1684417639 G_phys=2.34795972072137e-05 G_eff=2.34795972072137e-05
Rh2p2n1 in2 h2p 42751.9755912796
* h2 bias w+  bank=f alpha=0.001 R=560963.988396833 G_phys=1.78264562553806e-06 G_eff=1.78264562553806e-09
Rh2bpf1 tapref h2p 558554.8354202
* current-mode ReLU + TIA h2: I_y=max(0, i(Vh2p)), then feedback TIA Rf=33333.3333333333
Vh2p h2p 0 DC 0
Bh2crelu h2ir 0 I = max(0, i(Vh2p))
* feedback TIA h2: Rf=33333.3333333333 A=100000 V(h2lin) = -I(h2ir)*Rf*A/(A+1)  (uncompensated)
Bh2tia h2drv 0 V = -(100100) * (v(h2ir) - (0.001))
Rh2ro h2drv h2lin 100.211942666791
Rh2f h2lin h2ir 33200.8880315315
Bh2leak 0 h2ir I = 1e-08
Bh2relu h2y 0 V = max(0, min(15, v(h2lin)))

* h3 input 1 w=+0.80723931339229 w+  bank=n alpha=1 R=41293.0004526854 G_phys=2.42171794017687e-05 G_eff=2.42171794017687e-05
Rh3p1n1 in1 h3p 41494.6766163014
* h3 input 2 w=+1.71882311343666 w+  bank=n alpha=1 R=19393.1144355429 G_phys=5.15646934030999e-05 G_eff=5.15646934030999e-05
Rh3p2n1 in2 h3p 19472.8963780754
* h3 bias w+  bank=f alpha=0.001 R=1918.09451080035 G_phys=0.000521350743860236 G_eff=5.21350743860236e-07
Rh3bpf1 tapref h3p 1923.41670809501
* current-mode ReLU + TIA h3: I_y=max(0, i(Vh3p)), then feedback TIA Rf=33333.3333333333
Vh3p h3p 0 DC 0
Bh3crelu h3ir 0 I = max(0, i(Vh3p))
* feedback TIA h3: Rf=33333.3333333333 A=100000 V(h3lin) = -I(h3ir)*Rf*A/(A+1)  (uncompensated)
Bh3tia h3drv 0 V = -(100100) * (v(h3ir) - (0.001))
Rh3ro h3drv h3lin 99.9174448445821
Rh3f h3lin h3ir 33412.7110546358
Bh3leak 0 h3ir I = 1e-08
Bh3relu h3y 0 V = max(0, min(15, v(h3lin)))

* h4 input 1 w=-2.16286246457598 w-  bank=n alpha=1 R=15411.6749813161 G_phys=6.48858739372794e-05 G_eff=6.48858739372794e-05
Rh4n1n1 in1n h4p 15425.8325538707
* h4 input 2 w=+0.726967919426763 w+  bank=n alpha=1 R=45852.5506319697 G_phys=2.18090375828029e-05 G_eff=2.18090375828029e-05
Rh4p2n1 in2 h4p 45629.2896867935
* h4 bias w-  bank=f alpha=0.001 R=1810.10591973139 G_phys=0.000552453858693748 G_eff=5.52453858693748e-07
Rh4bnf1 taprefn h4p 1810.45759431869
* current-mode ReLU + TIA h4: I_y=max(0, i(Vh4p)), then feedback TIA Rf=33333.3333333333
Vh4p h4p 0 DC 0
Bh4crelu h4ir 0 I = max(0, i(Vh4p))
* feedback TIA h4: Rf=33333.3333333333 A=100000 V(h4lin) = -I(h4ir)*Rf*A/(A+1)  (uncompensated)
Bh4tia h4drv 0 V = -(100100) * (v(h4ir) - (0.001))
Rh4ro h4drv h4lin 100.394794828516
Rh4f h4lin h4ir 33214.51029595
Bh4leak 0 h4ir I = 1e-08
Bh4relu h4y 0 V = max(0, min(15, v(h4lin)))

* passive invert h1y -> h1yn: R2/R1=1.0000200002 closed-loop -1 at A=100000
Rinvh1ia h1y invh1m 9967.00734076627
Rinvh1ib h1yn invh1m 10009.7354024107
Einvh1amp h1yn 0 0 invh1m 100000
* passive invert h2y -> h2yn: R2/R1=1.0000200002 closed-loop -1 at A=100000
Rinvh2ia h2y invh2m 9973.3519096036
Rinvh2ib h2yn invh2m 10034.7971038041
Einvh2amp h2yn 0 0 invh2m 100000
* passive invert h3y -> h3yn: R2/R1=1.0000200002 closed-loop -1 at A=100000
Rinvh3ia h3y invh3m 10045.7880309395
Rinvh3ib h3yn invh3m 10018.4886220994
Einvh3amp h3yn 0 0 invh3m 100000
* passive invert h4y -> h4yn: R2/R1=1.0000200002 closed-loop -1 at A=100000
Rinvh4ia h4y invh4m 10016.6537721142
Rinvh4ib h4yn invh4m 9956.70728848959
Einvh4amp h4yn 0 0 invh4m 100000

* o1 input 1 w=+0.601889648539537 w+  bank=n alpha=1 R=55381.137413171 G_phys=1.80566894561861e-05 G_eff=1.80566894561861e-05
Ro1p1n1 h1yn o1p 55111.9802382968
* o1 input 2 w=+0.347315954504283 w+  bank=n alpha=1 R=95974.0918925228 G_phys=1.04194786351285e-05 G_eff=1.04194786351285e-05
Ro1p2n1 h2yn o1p 95747.8657887313
* o1 input 3 w=+0.876922607606196 w+  bank=n alpha=1 R=38011.716249768 G_phys=2.63076782281859e-05 G_eff=2.63076782281859e-05
Ro1p3n1 h3yn o1p 37834.2983681213
* o1 input 4 w=+0.929527796434486 w+  bank=n alpha=1 R=35860.5019249499 G_phys=2.78858338930346e-05 G_eff=2.78858338930346e-05
Ro1p4n1 h4yn o1p 35721.8636180625
* o1 bias w+  bank=f alpha=0.001 R=3220.47143452777 G_phys=0.000310513544470123 G_eff=3.10513544470123e-07
Ro1bpf1 taprefn o1p 3218.65783696448
* feedback TIA o1: Rf=33333.3333333333 A=100000 V(o1lin) = -I(o1p)*Rf*A/(A+1)  (uncompensated)
Bo1tia o1drv 0 V = -(100100) * (v(o1p) - (0.001))
Ro1ro o1drv o1lin 99.6267455988001
Ro1f o1lin o1p 33192.6024954043
Bo1leak 0 o1p I = 1e-08
.control
set numdgt=15
alter Vin1 DC 0.493925116004925
alter Vin2 DC -0.229327488703493
op
print v(o1lin)
alter Vin1 DC 0.756362988797612
alter Vin2 DC -0.494123288285482
op
print v(o1lin)
alter Vin1 DC 0.0208576432382299
alter Vin2 DC -0.495193882470016
op
print v(o1lin)
alter Vin1 DC 0.717231911298878
alter Vin2 DC 0.919247862966533
op
print v(o1lin)
alter Vin1 DC 0.852839488541252
alter Vin2 DC 0.47489664581968
op
print v(o1lin)
alter Vin1 DC -0.990229498917874
alter Vin2 DC 0.3730423647707
op
print v(o1lin)
alter Vin1 DC -0.492000998637298
alter Vin2 DC -0.617166440669081
op
print v(o1lin)
alter Vin1 DC 0.47509604615893
alter Vin2 DC 0.376734693114416
op
print v(o1lin)
.endc

.end
