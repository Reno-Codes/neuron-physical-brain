* Physical AI - Experiment 16 architecture I: current-mode invert-and-sum, unbuffered compensated dividers
* Passive inverting amplifiers (R ratio) create -Vin. One 0 V summing node per neuron. One current dump onto physical R_IV. Fine taps load-compensated, no isolation buffer. No dual CCCS.
* Frozen Experiment 9 network A. Weights were not edited.
* Behavioral circuit analysis. Not transistor-level or PCB power.
* invert A=100000 R_INV=10000 Ileak=1e-08 rail=15 linear=False vos=0.001
* shape: 2 -> 4 -> 1

Vin1 in1 0 DC 0
* passive invert in1 -> in1n: R2/R1=1.0000200002 closed-loop -1 at A=100000
Rinv1ia in1 inv1m 9950.48796694684
Rinv1ib in1n inv1m 10003.9331008321
Einv1amp in1n 0 0 inv1m 100100
Vin2 in2 0 DC 0
Vref vref 0 DC 1
* passive invert vref -> vrefn: R2/R1=1.0000200002 closed-loop -1 at A=100000
Rinvrefia vref invrefm 10009.9322344132
Rinvrefib vrefn invrefm 10006.4769194738
Einvrefamp vrefn 0 0 invrefm 100100
* load-compensated divider vref->tapref: G_load=0.000833646933955897 Ra=544815.897488381 Rb=1000 target beta=0.001 (no tap buffer)
Rdivrefa vref tapref 546286.917802314
Rdivrefb tapref 0 1004.86244343458
* load-compensated divider vrefn->taprefn: G_load=0.00135041774642313 Ra=425030.827613635 Rb=1000 target beta=0.001 (no tap buffer)
Rdivrefna vrefn taprefn 424026.339093278
Rdivrefnb taprefn 0 996.242830629859

* h1 input 1 w=+0.683760795348816 w+  bank=n alpha=1 R=48749.9920441162 G_phys=2.05128238604645e-05 G_eff=2.05128238604645e-05
Rh1p1n1 in1 h1p 48575.9079486811
* h1 input 2 w=+0.309366783045794 w+  bank=n alpha=1 R=107746.969487669 G_phys=9.28100349137382e-06 G_eff=9.28100349137382e-06
Rh1p2n1 in2 h1p 108130.330803131
* h1 bias w-  bank=f alpha=0.001 R=1253.18954325804 G_phys=0.000797963887729386 G_eff=7.97963887729385e-07
Rh1bnf1 taprefn h1p 1252.97020458269
* single-copy I-to-V: 0 V sum h1p, I dump onto R_IV=33333.3333333333
Vh1p h1p 0 DC 0
Bh1iv 0 h1lin I = (1.001)*(i(Vh1p) + (0.001)/33333.3333333333)
Rh1iv h1lin 0 33413.5948659925
Bh1leak 0 h1lin I = 1e-08
* direct bounded ReLU, no output buffer: y=max(0, min(15, v(h1lin)))
Bh1relu h1y 0 V = max(0, min(15, v(h1lin)))

* h2 input 1 w=-0.884821731731664 w-  bank=n alpha=1 R=37672.3718890781 G_phys=2.65446519519499e-05 G_eff=2.65446519519499e-05
Rh2n1n1 in1n h2p 37839.3078486089
* h2 input 2 w=+0.782653240240456 w+  bank=n alpha=1 R=42590.1684417639 G_phys=2.34795972072137e-05 G_eff=2.34795972072137e-05
Rh2p2n1 in2 h2p 42755.9773672046
* h2 bias w+  bank=f alpha=0.001 R=560963.988396833 G_phys=1.78264562553806e-06 G_eff=1.78264562553806e-09
Rh2bpf1 tapref h2p 558655.319995989
* single-copy I-to-V: 0 V sum h2p, I dump onto R_IV=33333.3333333333
Vh2p h2p 0 DC 0
Bh2iv 0 h2lin I = (1.001)*(i(Vh2p) + (0.001)/33333.3333333333)
Rh2iv h2lin 0 33231.8876078707
Bh2leak 0 h2lin I = 1e-08
* direct bounded ReLU, no output buffer: y=max(0, min(15, v(h2lin)))
Bh2relu h2y 0 V = max(0, min(15, v(h2lin)))

* h3 input 1 w=+0.80723931339229 w+  bank=n alpha=1 R=41293.0004526854 G_phys=2.42171794017687e-05 G_eff=2.42171794017687e-05
Rh3p1n1 in1 h3p 41328.5939265393
* h3 input 2 w=+1.71882311343666 w+  bank=n alpha=1 R=19393.1144355429 G_phys=5.15646934030999e-05 G_eff=5.15646934030999e-05
Rh3p2n1 in2 h3p 19426.0887139691
* h3 bias w+  bank=f alpha=0.001 R=1918.09451080035 G_phys=0.000521350743860236 G_eff=5.21350743860236e-07
Rh3bpf1 tapref h3p 1915.03887107451
* single-copy I-to-V: 0 V sum h3p, I dump onto R_IV=33333.3333333333
Vh3p h3p 0 DC 0
Bh3iv 0 h3lin I = (1.001)*(i(Vh3p) + (0.001)/33333.3333333333)
Rh3iv h3lin 0 33479.0693927859
Bh3leak 0 h3lin I = 1e-08
* direct bounded ReLU, no output buffer: y=max(0, min(15, v(h3lin)))
Bh3relu h3y 0 V = max(0, min(15, v(h3lin)))

* h4 input 1 w=-2.16286246457598 w-  bank=n alpha=1 R=15411.6749813161 G_phys=6.48858739372794e-05 G_eff=6.48858739372794e-05
Rh4n1n1 in1n h4p 15427.6291872907
* h4 input 2 w=+0.726967919426763 w+  bank=n alpha=1 R=45852.5506319697 G_phys=2.18090375828029e-05 G_eff=2.18090375828029e-05
Rh4p2n1 in2 h4p 45673.8811219074
* h4 bias w-  bank=f alpha=0.001 R=1810.10591973139 G_phys=0.000552453858693748 G_eff=5.52453858693748e-07
Rh4bnf1 taprefn h4p 1801.20089858424
* single-copy I-to-V: 0 V sum h4p, I dump onto R_IV=33333.3333333333
Vh4p h4p 0 DC 0
Bh4iv 0 h4lin I = (1.001)*(i(Vh4p) + (0.001)/33333.3333333333)
Rh4iv h4lin 0 33429.8430214523
Bh4leak 0 h4lin I = 1e-08
* direct bounded ReLU, no output buffer: y=max(0, min(15, v(h4lin)))
Bh4relu h4y 0 V = max(0, min(15, v(h4lin)))

* o1 input 1 w=+0.601889648539537 w+  bank=n alpha=1 R=55381.137413171 G_phys=1.80566894561861e-05 G_eff=1.80566894561861e-05
Ro1p1n1 h1y o1p 55525.7653374024
* o1 input 2 w=+0.347315954504283 w+  bank=n alpha=1 R=95974.0918925228 G_phys=1.04194786351285e-05 G_eff=1.04194786351285e-05
Ro1p2n1 h2y o1p 95520.261635821
* o1 input 3 w=+0.876922607606196 w+  bank=n alpha=1 R=38011.716249768 G_phys=2.63076782281859e-05 G_eff=2.63076782281859e-05
Ro1p3n1 h3y o1p 38155.1463940561
* o1 input 4 w=+0.929527796434486 w+  bank=n alpha=1 R=35860.5019249499 G_phys=2.78858338930346e-05 G_eff=2.78858338930346e-05
Ro1p4n1 h4y o1p 35889.4059704546
* o1 bias w+  bank=f alpha=0.001 R=3220.47143452777 G_phys=0.000310513544470123 G_eff=3.10513544470123e-07
Ro1bpf1 tapref o1p 3207.53340185484
* single-copy I-to-V: 0 V sum o1p, I dump onto R_IV=33333.3333333333
Vo1p o1p 0 DC 0
Bo1iv 0 o1lin I = (1.001)*(i(Vo1p) + (0.001)/33333.3333333333)
Ro1iv o1lin 0 33307.1479526317
Bo1leak 0 o1lin I = 1e-08
.control
set numdgt=15
alter Vin1 DC 0.495350281909392
alter Vin2 DC -0.227940221493937
op
print v(o1lin)
alter Vin1 DC 0.756707999100166
alter Vin2 DC -0.495567307300757
op
print v(o1lin)
alter Vin1 DC 0.0206795790043307
alter Vin2 DC -0.498911751644256
op
print v(o1lin)
alter Vin1 DC 0.718687831971548
alter Vin2 DC 0.920131159148118
op
print v(o1lin)
alter Vin1 DC 0.85392305414411
alter Vin2 DC 0.474918029196124
op
print v(o1lin)
alter Vin1 DC -0.989160191940506
alter Vin2 DC 0.373922891182639
op
print v(o1lin)
alter Vin1 DC -0.49337400733901
alter Vin2 DC -0.617156722465176
op
print v(o1lin)
alter Vin1 DC 0.476820481250052
alter Vin2 DC 0.377821567064159
op
print v(o1lin)
.endc

.end
