* Physical AI - Experiment 9: scaling network E 8->16->8
* Frozen random weights (seed 9). Weights were not edited.
* Matter Compiler v1 mapping: G=1e-05 quant=exact range=unconstrained
* Hidden: precision ReLU. Output: linear.
* Signed weights: G+/G- paths, I_diff = I+ - I- by KCL in SPICE.
* Bias: 1 V reference through G_SCALE*|b| onto the + or - path.
* G_SCALE = 1e-05
* shape: 8 -> 16 -> 8

Vin1 in1 0 DC 0
Vin2 in2 0 DC 0
Vin3 in3 0 DC 0
Vin4 in4 0 DC 0
Vin5 in5 0 DC 0
Vin6 in6 0 DC 0
Vin7 in7 0 DC 0
Vin8 in8 0 DC 0
Vref vref 0 DC 1

* --- neuron h1 ---
* h1 input 1 w=-1.15775360181108 w-  G = 1.15775360181108e-05 S  R = 86374.1644539649 Ohm
Rh1n1 in1 h1n 86374.1644539649
* h1 input 2 w=+1.33295717717371 w+  G = 1.33295717717371e-05 S  R = 75021.1647549187 Ohm
Rh1p2 in2 h1p 75021.1647549187
* h1 input 3 w=-0.472069475452146 w-  G = 4.72069475452146e-06 S  R = 211833.226251751 Ohm
Rh1n3 in3 h1n 211833.226251751
* h1 input 4 w=+0.00858773366067369 w+  G = 8.58773366067369e-08 S  R = 11644515.7653102 Ohm
Rh1p4 in4 h1p 11644515.7653102
* h1 input 5 w=+0.864252101496725 w+  G = 8.64252101496725e-06 S  R = 115706.979279331 Ohm
Rh1p5 in5 h1p 115706.979279331
* h1 input 6 w=+0.101098579945752 w+  G = 1.01098579945752e-06 S  R = 989133.576887617 Ohm
Rh1p6 in6 h1p 989133.576887617
* h1 input 7 w=-0.610548331137994 w-  G = 6.10548331137994e-06 S  R = 163787.197343757 Ohm
Rh1n7 in7 h1n 163787.197343757
* h1 input 8 w=-0.524673317455484 w-  G = 5.24673317455484e-06 S  R = 190594.788553326 Ohm
Rh1n8 in8 h1n 190594.788553326
* h1 bias=+0.0343429027136924 b+  G = 3.43429027136924e-07 S  R = 2911809.78013633 Ohm
Rh1bp vref h1p 2911809.78013633
Vh1p h1p 0 DC 0
Vh1n h1n 0 DC 0
Fh1p 0 h1d Vh1p 1
Fh1n h1d 0 Vh1n 1
Vh1d h1d 0 DC 0
Hh1 h1lin 0 Vh1d 100000
Bh1 h1amp 0 V = max(-15, min(15, 100000 * v(h1lin, h1y)))
Dh1 h1amp h1y Dsi
RLh1 h1y 0 10000
Eh1 h1buf 0 h1y 0 1

* --- neuron h2 ---
* h2 input 1 w=-0.213495803442125 w-  G = 2.13495803442125e-06 S  R = 468393.281683911 Ohm
Rh2n1 in1 h2n 468393.281683911
* h2 input 2 w=+0.460530174119438 w+  G = 4.60530174119438e-06 S  R = 217141.03791615 Ohm
Rh2p2 in2 h2p 217141.03791615
* h2 input 3 w=+0.175161524405965 w+  G = 1.75161524405965e-06 S  R = 570901.631160927 Ohm
Rh2p3 in3 h2p 570901.631160927
* h2 input 4 w=-0.910622971664039 w-  G = 9.10622971664039e-06 S  R = 109814.932317448 Ohm
Rh2n4 in4 h2n 109814.932317448
* h2 input 5 w=-0.305972983997477 w-  G = 3.05972983997477e-06 S  R = 326826.240322004 Ohm
Rh2n5 in5 h2n 326826.240322004
* h2 input 6 w=-0.0632588960719376 w-  G = 6.32588960719376e-07 S  R = 1580805.32872848 Ohm
Rh2n6 in6 h2n 1580805.32872848
* h2 input 7 w=-0.195040964050645 w-  G = 1.95040964050645e-06 S  R = 512712.806187904 Ohm
Rh2n7 in7 h2n 512712.806187904
* h2 input 8 w=-0.184394816232662 w-  G = 1.84394816232662e-06 S  R = 542314.594537321 Ohm
Rh2n8 in8 h2n 542314.594537321
* h2 bias=+0.0243157353777825 b+  G = 2.43157353777825e-07 S  R = 4112563.26186914 Ohm
Rh2bp vref h2p 4112563.26186914
Vh2p h2p 0 DC 0
Vh2n h2n 0 DC 0
Fh2p 0 h2d Vh2p 1
Fh2n h2d 0 Vh2n 1
Vh2d h2d 0 DC 0
Hh2 h2lin 0 Vh2d 100000
Bh2 h2amp 0 V = max(-15, min(15, 100000 * v(h2lin, h2y)))
Dh2 h2amp h2y Dsi
RLh2 h2y 0 10000
Eh2 h2buf 0 h2y 0 1

* --- neuron h3 ---
* h3 input 1 w=+0.379568761344245 w+  G = 3.79568761344245e-06 S  R = 263456.875760401 Ohm
Rh3p1 in1 h3p 263456.875760401
* h3 input 2 w=+0.0773585426215326 w+  G = 7.73585426215326e-07 S  R = 1292682.05696736 Ohm
Rh3p2 in2 h3p 1292682.05696736
* h3 input 3 w=-0.600104141373273 w-  G = 6.00104141373273e-06 S  R = 166637.743527583 Ohm
Rh3n3 in3 h3n 166637.743527583
* h3 input 4 w=-0.231691767700986 w-  G = 2.31691767700986e-06 S  R = 431607.911633082 Ohm
Rh3n4 in4 h3n 431607.911633082
* h3 input 5 w=-0.0827919976432861 w-  G = 8.27919976432861e-07 S  R = 1207846.20309387 Ohm
Rh3n5 in5 h3n 1207846.20309387
* h3 input 6 w=+0.904695104812246 w+  G = 9.04695104812246e-06 S  R = 110534.476718268 Ohm
Rh3p6 in6 h3p 110534.476718268
* h3 input 7 w=-1.05499227901329 w-  G = 1.05499227901329e-05 S  R = 94787.4235568127 Ohm
Rh3n7 in7 h3n 94787.4235568127
* h3 input 8 w=-0.576454528398348 w-  G = 5.76454528398348e-06 S  R = 173474.220556208 Ohm
Rh3n8 in8 h3n 173474.220556208
* h3 bias=-0.0174741293276786 b-  G = 1.74741293276786e-07 S  R = 5722745.78748839 Ohm
Rh3bn vref h3n 5722745.78748839
Vh3p h3p 0 DC 0
Vh3n h3n 0 DC 0
Fh3p 0 h3d Vh3p 1
Fh3n h3d 0 Vh3n 1
Vh3d h3d 0 DC 0
Hh3 h3lin 0 Vh3d 100000
Bh3 h3amp 0 V = max(-15, min(15, 100000 * v(h3lin, h3y)))
Dh3 h3amp h3y Dsi
RLh3 h3y 0 10000
Eh3 h3buf 0 h3y 0 1

* --- neuron h4 ---
* h4 input 1 w=+0.674696319995144 w+  G = 6.74696319995144e-06 S  R = 148214.829452041 Ohm
Rh4p1 in1 h4p 148214.829452041
* h4 input 2 w=-0.292514978622093 w-  G = 2.92514978622093e-06 S  R = 341862.835438566 Ohm
Rh4n2 in2 h4n 341862.835438566
* h4 input 3 w=-0.625056327852211 w-  G = 6.25056327852211e-06 S  R = 159985.581369307 Ohm
Rh4n3 in3 h4n 159985.581369307
* h4 input 4 w=+0.0039120409468376 w+  G = 3.9120409468376e-08 S  R = 25562104.6300238 Ohm
Rh4p4 in4 h4p 25562104.6300238
* h4 input 5 w=-0.19791764912045 w-  G = 1.9791764912045e-06 S  R = 505260.649792487 Ohm
Rh4n5 in5 h4n 505260.649792487
* h4 input 6 w=+0.40162749685132 w+  G = 4.0162749685132e-06 S  R = 248986.936362625 Ohm
Rh4p6 in6 h4p 248986.936362625
* h4 input 7 w=-0.78248651603553 w-  G = 7.8248651603553e-06 S  R = 127797.729354686 Ohm
Rh4n7 in7 h4n 127797.729354686
* h4 input 8 w=-0.699752615330015 w-  G = 6.99752615330015e-06 S  R = 142907.64737312 Ohm
Rh4n8 in8 h4n 142907.64737312
* h4 bias=+0.123379896027472 b+  G = 1.23379896027472e-06 S  R = 810504.816584814 Ohm
Rh4bp vref h4p 810504.816584814
Vh4p h4p 0 DC 0
Vh4n h4n 0 DC 0
Fh4p 0 h4d Vh4p 1
Fh4n h4d 0 Vh4n 1
Vh4d h4d 0 DC 0
Hh4 h4lin 0 Vh4d 100000
Bh4 h4amp 0 V = max(-15, min(15, 100000 * v(h4lin, h4y)))
Dh4 h4amp h4y Dsi
RLh4 h4y 0 10000
Eh4 h4buf 0 h4y 0 1

* --- neuron h5 ---
* h5 input 1 w=+0.0394306967655538 w+  G = 3.94306967655538e-07 S  R = 2536095.17971691 Ohm
Rh5p1 in1 h5p 2536095.17971691
* h5 input 2 w=-0.423772523348551 w-  G = 4.23772523348551e-06 S  R = 235975.657906802 Ohm
Rh5n2 in2 h5n 235975.657906802
* h5 input 3 w=+0.583617678559293 w+  G = 5.83617678559293e-06 S  R = 171345.049462617 Ohm
Rh5p3 in3 h5p 171345.049462617
* h5 input 4 w=-0.110203352834248 w-  G = 1.10203352834248e-06 S  R = 907413.408287182 Ohm
Rh5n4 in4 h5n 907413.408287182
* h5 input 5 w=+0.632871547503374 w+  G = 6.32871547503374e-06 S  R = 158009.947507503 Ohm
Rh5p5 in5 h5p 158009.947507503
* h5 input 6 w=+0.0521222606576311 w+  G = 5.21222606576311e-07 S  R = 1918566.05485432 Ohm
Rh5p6 in6 h5p 1918566.05485432
* h5 input 7 w=-0.824458530457679 w-  G = 8.24458530457679e-06 S  R = 121291.728214016 Ohm
Rh5n7 in7 h5n 121291.728214016
* h5 input 8 w=+0.963607715814347 w+  G = 9.63607715814347e-06 S  R = 103776.670068991 Ohm
Rh5p8 in8 h5p 103776.670068991
* h5 bias=+0.0559803416445191 b+  G = 5.59803416445191e-07 S  R = 1786341.36667136 Ohm
Rh5bp vref h5p 1786341.36667136
Vh5p h5p 0 DC 0
Vh5n h5n 0 DC 0
Fh5p 0 h5d Vh5p 1
Fh5n h5d 0 Vh5n 1
Vh5d h5d 0 DC 0
Hh5 h5lin 0 Vh5d 100000
Bh5 h5amp 0 V = max(-15, min(15, 100000 * v(h5lin, h5y)))
Dh5 h5amp h5y Dsi
RLh5 h5y 0 10000
Eh5 h5buf 0 h5y 0 1

* --- neuron h6 ---
* h6 input 1 w=+0.416989411280743 w+  G = 4.16989411280744e-06 S  R = 239814.242987273 Ohm
Rh6p1 in1 h6p 239814.242987273
* h6 input 2 w=+0.544264851423342 w+  G = 5.44264851423342e-06 S  R = 183734.076779868 Ohm
Rh6p2 in2 h6p 183734.076779868
* h6 input 3 w=-0.19971825048738 w-  G = 1.9971825048738e-06 S  R = 500705.367466249 Ohm
Rh6n3 in3 h6n 500705.367466249
* h6 input 4 w=-0.432701314833321 w-  G = 4.32701314833321e-06 S  R = 231106.300285962 Ohm
Rh6n4 in4 h6n 231106.300285962
* h6 input 5 w=+0.467731029568101 w+  G = 4.67731029568101e-06 S  R = 213798.088384983 Ohm
Rh6p5 in5 h6p 213798.088384983
* h6 input 6 w=+0.950512248779785 w+  G = 9.50512248779785e-06 S  R = 105206.429615583 Ohm
Rh6p6 in6 h6p 105206.429615583
* h6 input 7 w=+0.0535222876830717 w+  G = 5.35222876830717e-07 S  R = 1868380.52573804 Ohm
Rh6p7 in7 h6p 1868380.52573804
* h6 input 8 w=-0.123252827793529 w-  G = 1.23252827793529e-06 S  R = 811340.411333345 Ohm
Rh6n8 in8 h6n 811340.411333345
* h6 bias=-0.0779777481722319 b-  G = 7.79777481722319e-07 S  R = 1282417.12980897 Ohm
Rh6bn vref h6n 1282417.12980897
Vh6p h6p 0 DC 0
Vh6n h6n 0 DC 0
Fh6p 0 h6d Vh6p 1
Fh6n h6d 0 Vh6n 1
Vh6d h6d 0 DC 0
Hh6 h6lin 0 Vh6d 100000
Bh6 h6amp 0 V = max(-15, min(15, 100000 * v(h6lin, h6y)))
Dh6 h6amp h6y Dsi
RLh6 h6y 0 10000
Eh6 h6buf 0 h6y 0 1

* --- neuron h7 ---
* h7 input 1 w=+0.25058523500173 w+  G = 2.5058523500173e-06 S  R = 399065.810877922 Ohm
Rh7p1 in1 h7p 399065.810877922
* h7 input 2 w=-1.66019603055689 w-  G = 1.66019603055689e-05 S  R = 60233.8507980027 Ohm
Rh7n2 in2 h7n 60233.8507980027
* h7 input 3 w=-0.639808541081716 w-  G = 6.39808541081716e-06 S  R = 156296.756887508 Ohm
Rh7n3 in3 h7n 156296.756887508
* h7 input 4 w=-0.511048742862765 w-  G = 5.11048742862765e-06 S  R = 195676.051250661 Ohm
Rh7n4 in4 h7n 195676.051250661
* h7 input 5 w=-0.124644620881647 w-  G = 1.24644620881647e-06 S  R = 802280.911062761 Ohm
Rh7n5 in5 h7n 802280.911062761
* h7 input 6 w=+0.103266483080495 w+  G = 1.03266483080495e-06 S  R = 968368.409739015 Ohm
Rh7p6 in6 h7p 968368.409739015
* h7 input 7 w=-0.468879814070409 w-  G = 4.68879814070409e-06 S  R = 213274.269864353 Ohm
Rh7n7 in7 h7n 213274.269864353
* h7 input 8 w=+0.25965170023636 w+  G = 2.5965170023636e-06 S  R = 385131.312096052 Ohm
Rh7p8 in8 h7p 385131.312096052
* h7 bias=-0.0210229289719939 b-  G = 2.10229289719939e-07 S  R = 4756711.11923638 Ohm
Rh7bn vref h7n 4756711.11923638
Vh7p h7p 0 DC 0
Vh7n h7n 0 DC 0
Fh7p 0 h7d Vh7p 1
Fh7n h7d 0 Vh7n 1
Vh7d h7d 0 DC 0
Hh7 h7lin 0 Vh7d 100000
Bh7 h7amp 0 V = max(-15, min(15, 100000 * v(h7lin, h7y)))
Dh7 h7amp h7y Dsi
RLh7 h7y 0 10000
Eh7 h7buf 0 h7y 0 1

* --- neuron h8 ---
* h8 input 1 w=-0.432622954777499 w-  G = 4.32622954777499e-06 S  R = 231148.160067999 Ohm
Rh8n1 in1 h8n 231148.160067999
* h8 input 2 w=+0.491333921492294 w+  G = 4.91333921492294e-06 S  R = 203527.571831957 Ohm
Rh8p2 in2 h8p 203527.571831957
* h8 input 3 w=+0.302223751714464 w+  G = 3.02223751714464e-06 S  R = 330880.678413649 Ohm
Rh8p3 in3 h8p 330880.678413649
* h8 input 4 w=-0.368253299758198 w-  G = 3.68253299758198e-06 S  R = 271552.217089872 Ohm
Rh8n4 in4 h8n 271552.217089872
* h8 input 5 w=+0.437784814815685 w+  G = 4.37784814815685e-06 S  R = 228422.724168954 Ohm
Rh8p5 in5 h8p 228422.724168954
* h8 input 6 w=+0.174778426441535 w+  G = 1.74778426441535e-06 S  R = 572152.994142277 Ohm
Rh8p6 in6 h8p 572152.994142277
* h8 input 7 w=+0.658960106266846 w+  G = 6.58960106266846e-06 S  R = 151754.254998109 Ohm
Rh8p7 in7 h8p 151754.254998109
* h8 input 8 w=-0.77315082433893 w-  G = 7.7315082433893e-06 S  R = 129340.869662143 Ohm
Rh8n8 in8 h8n 129340.869662143
* h8 bias=+0.0116927467740053 b+  G = 1.16927467740053e-07 S  R = 8552310.41369293 Ohm
Rh8bp vref h8p 8552310.41369293
Vh8p h8p 0 DC 0
Vh8n h8n 0 DC 0
Fh8p 0 h8d Vh8p 1
Fh8n h8d 0 Vh8n 1
Vh8d h8d 0 DC 0
Hh8 h8lin 0 Vh8d 100000
Bh8 h8amp 0 V = max(-15, min(15, 100000 * v(h8lin, h8y)))
Dh8 h8amp h8y Dsi
RLh8 h8y 0 10000
Eh8 h8buf 0 h8y 0 1

* --- neuron h9 ---
* h9 input 1 w=+0.00882395388669549 w+  G = 8.82395388669549e-08 S  R = 11332788.1450941 Ohm
Rh9p1 in1 h9p 11332788.1450941
* h9 input 2 w=-0.703766760215479 w-  G = 7.03766760215479e-06 S  R = 142092.530726205 Ohm
Rh9n2 in2 h9n 142092.530726205
* h9 input 3 w=-0.172622749587978 w-  G = 1.72622749587978e-06 S  R = 579297.921268684 Ohm
Rh9n3 in3 h9n 579297.921268684
* h9 input 4 w=+0.456402435538883 w+  G = 4.56402435538883e-06 S  R = 219104.878092791 Ohm
Rh9p4 in4 h9p 219104.878092791
* h9 input 5 w=-0.532785547423425 w-  G = 5.32785547423425e-06 S  R = 187692.778986976 Ohm
Rh9n5 in5 h9n 187692.778986976
* h9 input 6 w=-0.308561710550926 w-  G = 3.08561710550926e-06 S  R = 324084.280649901 Ohm
Rh9n6 in6 h9n 324084.280649901
* h9 input 7 w=-0.0925775680108823 w-  G = 9.25775680108823e-07 S  R = 1080175.27516218 Ohm
Rh9n7 in7 h9n 1080175.27516218
* h9 input 8 w=+0.4756277096331 w+  G = 4.756277096331e-06 S  R = 210248.47370045 Ohm
Rh9p8 in8 h9p 210248.47370045
* h9 bias=+0.0373559011800317 b+  G = 3.73559011800317e-07 S  R = 2676953.22134148 Ohm
Rh9bp vref h9p 2676953.22134148
Vh9p h9p 0 DC 0
Vh9n h9n 0 DC 0
Fh9p 0 h9d Vh9p 1
Fh9n h9d 0 Vh9n 1
Vh9d h9d 0 DC 0
Hh9 h9lin 0 Vh9d 100000
Bh9 h9amp 0 V = max(-15, min(15, 100000 * v(h9lin, h9y)))
Dh9 h9amp h9y Dsi
RLh9 h9y 0 10000
Eh9 h9buf 0 h9y 0 1

* --- neuron h10 ---
* h10 input 1 w=+0.292877829626092 w+  G = 2.92877829626092e-06 S  R = 341439.296131315 Ohm
Rh10p1 in1 h10p 341439.296131315
* h10 input 2 w=-0.0703367590411641 w-  G = 7.03367590411641e-07 S  R = 1421731.69994193 Ohm
Rh10n2 in2 h10n 1421731.69994193
* h10 input 3 w=+0.165624531699448 w+  G = 1.65624531699448e-06 S  R = 603775.292065223 Ohm
Rh10p3 in3 h10p 603775.292065223
* h10 input 4 w=+0.0139503641552365 w+  G = 1.39503641552365e-07 S  R = 7168271.65851893 Ohm
Rh10p4 in4 h10p 7168271.65851893
* h10 input 5 w=+0.318249695358284 w+  G = 3.18249695358284e-06 S  R = 314218.68255811 Ohm
Rh10p5 in5 h10p 314218.68255811
* h10 input 6 w=-0.0721236731524278 w-  G = 7.21236731524279e-07 S  R = 1386507.30930824 Ohm
Rh10n6 in6 h10n 1386507.30930824
* h10 input 7 w=-0.697379828637934 w-  G = 6.97379828637934e-06 S  R = 143393.880771275 Ohm
Rh10n7 in7 h10n 143393.880771275
* h10 input 8 w=-0.566050836547856 w-  G = 5.66050836547856e-06 S  R = 176662.577887641 Ohm
Rh10n8 in8 h10n 176662.577887641
* h10 bias=-0.0452486270239582 b-  G = 4.52486270239582e-07 S  R = 2210011.80758594 Ohm
Rh10bn vref h10n 2210011.80758594
Vh10p h10p 0 DC 0
Vh10n h10n 0 DC 0
Fh10p 0 h10d Vh10p 1
Fh10n h10d 0 Vh10n 1
Vh10d h10d 0 DC 0
Hh10 h10lin 0 Vh10d 100000
Bh10 h10amp 0 V = max(-15, min(15, 100000 * v(h10lin, h10y)))
Dh10 h10amp h10y Dsi
RLh10 h10y 0 10000
Eh10 h10buf 0 h10y 0 1

* --- neuron h11 ---
* h11 input 1 w=+0.727404151309305 w+  G = 7.27404151309306e-06 S  R = 137475.157132391 Ohm
Rh11p1 in1 h11p 137475.157132391
* h11 input 2 w=-0.267855132453122 w-  G = 2.67855132453122e-06 S  R = 373336.135410814 Ohm
Rh11n2 in2 h11n 373336.135410814
* h11 input 3 w=+0.594902056697111 w+  G = 5.94902056697111e-06 S  R = 168094.897091462 Ohm
Rh11p3 in3 h11p 168094.897091462
* h11 input 4 w=+0.126359818118091 w+  G = 1.26359818118091e-06 S  R = 791390.819402289 Ohm
Rh11p4 in4 h11p 791390.819402289
* h11 input 5 w=-0.188914065054156 w-  G = 1.88914065054156e-06 S  R = 529341.211155098 Ohm
Rh11n5 in5 h11n 529341.211155098
* h11 input 6 w=+0.345175736689339 w+  G = 3.45175736689339e-06 S  R = 289707.500762143 Ohm
Rh11p6 in6 h11p 289707.500762143
* h11 input 7 w=+0.382102442316896 w+  G = 3.82102442316896e-06 S  R = 261709.921019204 Ohm
Rh11p7 in7 h11p 261709.921019204
* h11 input 8 w=+0.233126409922218 w+  G = 2.33126409922218e-06 S  R = 428951.829324549 Ohm
Rh11p8 in8 h11p 428951.829324549
* h11 bias=-0.10967615083553 b-  G = 1.0967615083553e-06 S  R = 911775.251394076 Ohm
Rh11bn vref h11n 911775.251394076
Vh11p h11p 0 DC 0
Vh11n h11n 0 DC 0
Fh11p 0 h11d Vh11p 1
Fh11n h11d 0 Vh11n 1
Vh11d h11d 0 DC 0
Hh11 h11lin 0 Vh11d 100000
Bh11 h11amp 0 V = max(-15, min(15, 100000 * v(h11lin, h11y)))
Dh11 h11amp h11y Dsi
RLh11 h11y 0 10000
Eh11 h11buf 0 h11y 0 1

* --- neuron h12 ---
* h12 input 1 w=-0.356730292305461 w-  G = 3.56730292305461e-06 S  R = 280323.824909077 Ohm
Rh12n1 in1 h12n 280323.824909077
* h12 input 2 w=+0.180827883932526 w+  G = 1.80827883932526e-06 S  R = 553012.056687641 Ohm
Rh12p2 in2 h12p 553012.056687641
* h12 input 3 w=+0.162354647032431 w+  G = 1.62354647032431e-06 S  R = 615935.557298983 Ohm
Rh12p3 in3 h12p 615935.557298983
* h12 input 4 w=-0.731204739454615 w-  G = 7.31204739454615e-06 S  R = 136760.601517144 Ohm
Rh12n4 in4 h12n 136760.601517144
* h12 input 5 w=-0.185748739845231 w-  G = 1.85748739845231e-06 S  R = 538361.66039846 Ohm
Rh12n5 in5 h12n 538361.66039846
* h12 input 6 w=-0.400489841415528 w-  G = 4.00489841415528e-06 S  R = 249694.223570193 Ohm
Rh12n6 in6 h12n 249694.223570193
* h12 input 7 w=-0.327519600015261 w-  G = 3.27519600015261e-06 S  R = 305325.238536382 Ohm
Rh12n7 in7 h12n 305325.238536382
* h12 input 8 w=-0.10234787613188 w-  G = 1.0234787613188e-06 S  R = 977059.845102651 Ohm
Rh12n8 in8 h12n 977059.845102651
* h12 bias=-0.00714423662855672 b-  G = 7.14423662855672e-08 S  R = 13997296.7301059 Ohm
Rh12bn vref h12n 13997296.7301059
Vh12p h12p 0 DC 0
Vh12n h12n 0 DC 0
Fh12p 0 h12d Vh12p 1
Fh12n h12d 0 Vh12n 1
Vh12d h12d 0 DC 0
Hh12 h12lin 0 Vh12d 100000
Bh12 h12amp 0 V = max(-15, min(15, 100000 * v(h12lin, h12y)))
Dh12 h12amp h12y Dsi
RLh12 h12y 0 10000
Eh12 h12buf 0 h12y 0 1

* --- neuron h13 ---
* h13 input 1 w=+0.439082468969843 w+  G = 4.39082468969843e-06 S  R = 227747.648943069 Ohm
Rh13p1 in1 h13p 227747.648943069
* h13 input 2 w=+0.0693190940129033 w+  G = 6.93190940129033e-07 S  R = 1442603.9668289 Ohm
Rh13p2 in2 h13p 1442603.9668289
* h13 input 3 w=+0.372168354249918 w+  G = 3.72168354249918e-06 S  R = 268695.602025443 Ohm
Rh13p3 in3 h13p 268695.602025443
* h13 input 4 w=+0.0285236213138885 w+  G = 2.85236213138885e-07 S  R = 3505866.20469922 Ohm
Rh13p4 in4 h13p 3505866.20469922
* h13 input 5 w=+0.647168116969592 w+  G = 6.47168116969592e-06 S  R = 154519.354983457 Ohm
Rh13p5 in5 h13p 154519.354983457
* h13 input 6 w=-0.325393493223915 w-  G = 3.25393493223915e-06 S  R = 307320.220233126 Ohm
Rh13n6 in6 h13n 307320.220233126
* h13 input 7 w=-0.302653469741904 w-  G = 3.02653469741904e-06 S  R = 330410.882403819 Ohm
Rh13n7 in7 h13n 330410.882403819
* h13 input 8 w=-0.308657998741888 w-  G = 3.08657998741888e-06 S  R = 323983.180113935 Ohm
Rh13n8 in8 h13n 323983.180113935
* h13 bias=+0.0162288070657347 b+  G = 1.62288070657347e-07 S  R = 6161882.36109718 Ohm
Rh13bp vref h13p 6161882.36109718
Vh13p h13p 0 DC 0
Vh13n h13n 0 DC 0
Fh13p 0 h13d Vh13p 1
Fh13n h13d 0 Vh13n 1
Vh13d h13d 0 DC 0
Hh13 h13lin 0 Vh13d 100000
Bh13 h13amp 0 V = max(-15, min(15, 100000 * v(h13lin, h13y)))
Dh13 h13amp h13y Dsi
RLh13 h13y 0 10000
Eh13 h13buf 0 h13y 0 1

* --- neuron h14 ---
* h14 input 1 w=+0.332721649393458 w+  G = 3.32721649393458e-06 S  R = 300551.527627665 Ohm
Rh14p1 in1 h14p 300551.527627665
* h14 input 2 w=+0.112361217853898 w+  G = 1.12361217853898e-06 S  R = 889986.793575244 Ohm
Rh14p2 in2 h14p 889986.793575244
* h14 input 3 w=+0.481341787184925 w+  G = 4.81341787184925e-06 S  R = 207752.583844505 Ohm
Rh14p3 in3 h14p 207752.583844505
* h14 input 4 w=-0.182971752243674 w-  G = 1.82971752243674e-06 S  R = 546532.449811292 Ohm
Rh14n4 in4 h14n 546532.449811292
* h14 input 5 w=-0.320595586023506 w-  G = 3.20595586023506e-06 S  R = 311919.453540661 Ohm
Rh14n5 in5 h14n 311919.453540661
* h14 input 6 w=-0.460262347534122 w-  G = 4.60262347534122e-06 S  R = 217267.392250865 Ohm
Rh14n6 in6 h14n 217267.392250865
* h14 input 7 w=+0.277355733136341 w+  G = 2.77355733136341e-06 S  R = 360547.802164387 Ohm
Rh14p7 in7 h14p 360547.802164387
* h14 input 8 w=+0.00625753457032479 w+  G = 6.25753457032479e-08 S  R = 15980734.7248598 Ohm
Rh14p8 in8 h14p 15980734.7248598
* h14 bias=-0.032583904624722 b-  G = 3.2583904624722e-07 S  R = 3068999.89892949 Ohm
Rh14bn vref h14n 3068999.89892949
Vh14p h14p 0 DC 0
Vh14n h14n 0 DC 0
Fh14p 0 h14d Vh14p 1
Fh14n h14d 0 Vh14n 1
Vh14d h14d 0 DC 0
Hh14 h14lin 0 Vh14d 100000
Bh14 h14amp 0 V = max(-15, min(15, 100000 * v(h14lin, h14y)))
Dh14 h14amp h14y Dsi
RLh14 h14y 0 10000
Eh14 h14buf 0 h14y 0 1

* --- neuron h15 ---
* h15 input 1 w=+0.40565521361642 w+  G = 4.0565521361642e-06 S  R = 246514.765848808 Ohm
Rh15p1 in1 h15p 246514.765848808
* h15 input 2 w=-1.44451770693746 w-  G = 1.44451770693746e-05 S  R = 69227.2580112646 Ohm
Rh15n2 in2 h15n 69227.2580112646
* h15 input 3 w=+0.134245852521 w+  G = 1.34245852521e-06 S  R = 744901.969946201 Ohm
Rh15p3 in3 h15p 744901.969946201
* h15 input 4 w=+0.235051090101407 w+  G = 2.35051090101407e-06 S  R = 425439.422369228 Ohm
Rh15p4 in4 h15p 425439.422369228
* h15 input 5 w=-0.129970469095356 w-  G = 1.29970469095356e-06 S  R = 769405.548014389 Ohm
Rh15n5 in5 h15n 769405.548014389
* h15 input 6 w=-0.44167234761579 w-  G = 4.4167234761579e-06 S  R = 226412.182106972 Ohm
Rh15n6 in6 h15n 226412.182106972
* h15 input 7 w=+0.31125832265608 w+  G = 3.1125832265608e-06 S  R = 321276.549801669 Ohm
Rh15p7 in7 h15p 321276.549801669
* h15 input 8 w=+0.807283389837115 w+  G = 8.07283389837115e-06 S  R = 123872.237753061 Ohm
Rh15p8 in8 h15p 123872.237753061
* h15 bias=+0.00968494268149175 b+  G = 9.68494268149175e-08 S  R = 10325306.3325923 Ohm
Rh15bp vref h15p 10325306.3325923
Vh15p h15p 0 DC 0
Vh15n h15n 0 DC 0
Fh15p 0 h15d Vh15p 1
Fh15n h15d 0 Vh15n 1
Vh15d h15d 0 DC 0
Hh15 h15lin 0 Vh15d 100000
Bh15 h15amp 0 V = max(-15, min(15, 100000 * v(h15lin, h15y)))
Dh15 h15amp h15y Dsi
RLh15 h15y 0 10000
Eh15 h15buf 0 h15y 0 1

* --- neuron h16 ---
* h16 input 1 w=+0.610389544720461 w+  G = 6.10389544720461e-06 S  R = 163829.804859775 Ohm
Rh16p1 in1 h16p 163829.804859775
* h16 input 2 w=+0.0694241579385955 w+  G = 6.94241579385955e-07 S  R = 1440420.78390707 Ohm
Rh16p2 in2 h16p 1440420.78390707
* h16 input 3 w=-0.388500879390515 w-  G = 3.88500879390515e-06 S  R = 257399.674762336 Ohm
Rh16n3 in3 h16n 257399.674762336
* h16 input 4 w=+0.0160999476690909 w+  G = 1.60999476690909e-07 S  R = 6211200.31290427 Ohm
Rh16p4 in4 h16p 6211200.31290427
* h16 input 5 w=-0.894319028833273 w-  G = 8.94319028833273e-06 S  R = 111816.92078101 Ohm
Rh16n5 in5 h16n 111816.92078101
* h16 input 6 w=-0.0892309717802848 w-  G = 8.92309717802848e-07 S  R = 1120687.11126706 Ohm
Rh16n6 in6 h16n 1120687.11126706
* h16 input 7 w=-0.167076303454311 w-  G = 1.67076303454311e-06 S  R = 598528.923207511 Ohm
Rh16n7 in7 h16n 598528.923207511
* h16 input 8 w=+0.0583579116001486 w+  G = 5.83579116001486e-07 S  R = 1713563.7184067 Ohm
Rh16p8 in8 h16p 1713563.7184067
* h16 bias=+0.0985932029541825 b+  G = 9.85932029541825e-07 S  R = 1014268.70213833 Ohm
Rh16bp vref h16p 1014268.70213833
Vh16p h16p 0 DC 0
Vh16n h16n 0 DC 0
Fh16p 0 h16d Vh16p 1
Fh16n h16d 0 Vh16n 1
Vh16d h16d 0 DC 0
Hh16 h16lin 0 Vh16d 100000
Bh16 h16amp 0 V = max(-15, min(15, 100000 * v(h16lin, h16y)))
Dh16 h16amp h16y Dsi
RLh16 h16y 0 10000
Eh16 h16buf 0 h16y 0 1

* --- neuron o1 ---
* o1 input 1 w=+0.152567568706694 w+  G = 1.52567568706695e-06 S  R = 655447.293600426 Ohm
Ro1p1 h1buf o1p 655447.293600426
* o1 input 2 w=+0.198470248723047 w+  G = 1.98470248723047e-06 S  R = 503853.85539343 Ohm
Ro1p2 h2buf o1p 503853.85539343
* o1 input 3 w=+0.125843864927861 w+  G = 1.25843864927861e-06 S  R = 794635.479904599 Ohm
Ro1p3 h3buf o1p 794635.479904599
* o1 input 4 w=-0.112707257634712 w-  G = 1.12707257634712e-06 S  R = 887254.309071234 Ohm
Ro1n4 h4buf o1n 887254.309071234
* o1 input 5 w=+0.17078431480515 w+  G = 1.7078431480515e-06 S  R = 585533.865414346 Ohm
Ro1p5 h5buf o1p 585533.865414346
* o1 input 6 w=+0.266237628535208 w+  G = 2.66237628535208e-06 S  R = 375604.307137884 Ohm
Ro1p6 h6buf o1p 375604.307137884
* o1 input 7 w=+0.0586439586977422 w+  G = 5.86439586977422e-07 S  R = 1705205.4844287 Ohm
Ro1p7 h7buf o1p 1705205.4844287
* o1 input 8 w=-0.391027992636292 w-  G = 3.91027992636292e-06 S  R = 255736.166932205 Ohm
Ro1n8 h8buf o1n 255736.166932205
* o1 input 9 w=-0.0661342063782924 w-  G = 6.61342063782924e-07 S  R = 1512076.81283711 Ohm
Ro1n9 h9buf o1n 1512076.81283711
* o1 input 10 w=+0.169569484195586 w+  G = 1.69569484195586e-06 S  R = 589728.750278307 Ohm
Ro1p10 h10buf o1p 589728.750278307
* o1 input 11 w=-0.359335364624549 w-  G = 3.59335364624549e-06 S  R = 278291.562269372 Ohm
Ro1n11 h11buf o1n 278291.562269372
* o1 input 12 w=-0.318401063001575 w-  G = 3.18401063001575e-06 S  R = 314069.303215565 Ohm
Ro1n12 h12buf o1n 314069.303215565
* o1 input 13 w=+0.439963564837333 w+  G = 4.39963564837333e-06 S  R = 227291.548646699 Ohm
Ro1p13 h13buf o1p 227291.548646699
* o1 input 14 w=+0.0561691218246175 w+  G = 5.61691218246175e-07 S  R = 1780337.60812996 Ohm
Ro1p14 h14buf o1p 1780337.60812996
* o1 input 15 w=-0.476422795689535 w-  G = 4.76422795689535e-06 S  R = 209897.597060334 Ohm
Ro1n15 h15buf o1n 209897.597060334
* o1 input 16 w=-0.075984281438346 w-  G = 7.5984281438346e-07 S  R = 1316061.66574254 Ohm
Ro1n16 h16buf o1n 1316061.66574254
* o1 bias=-0.115604628203784 b-  G = 1.15604628203784e-06 S  R = 865017.270967073 Ohm
Ro1bn vref o1n 865017.270967073
Vo1p o1p 0 DC 0
Vo1n o1n 0 DC 0
Fo1p 0 o1d Vo1p 1
Fo1n o1d 0 Vo1n 1
Vo1d o1d 0 DC 0
Ho1 o1lin 0 Vo1d 100000

* --- neuron o2 ---
* o2 input 1 w=+0.0527063168377298 w+  G = 5.27063168377298e-07 S  R = 1897305.78799266 Ohm
Ro2p1 h1buf o2p 1897305.78799266
* o2 input 2 w=-0.187034671811497 w-  G = 1.87034671811497e-06 S  R = 534660.226531608 Ohm
Ro2n2 h2buf o2n 534660.226531608
* o2 input 3 w=-0.160187371088008 w-  G = 1.60187371088008e-06 S  R = 624268.937811953 Ohm
Ro2n3 h3buf o2n 624268.937811953
* o2 input 4 w=-0.131787362560029 w-  G = 1.31787362560029e-06 S  R = 758798.097613116 Ohm
Ro2n4 h4buf o2n 758798.097613116
* o2 input 5 w=-0.154896522998126 w-  G = 1.54896522998126e-06 S  R = 645592.283573788 Ohm
Ro2n5 h5buf o2n 645592.283573788
* o2 input 6 w=+0.198188212019818 w+  G = 1.98188212019818e-06 S  R = 504570.877252783 Ohm
Ro2p6 h6buf o2p 504570.877252783
* o2 input 7 w=+0.420527239182312 w+  G = 4.20527239182312e-06 S  R = 237796.724403498 Ohm
Ro2p7 h7buf o2p 237796.724403498
* o2 input 8 w=+0.324620592006622 w+  G = 3.24620592006622e-06 S  R = 308051.930353081 Ohm
Ro2p8 h8buf o2p 308051.930353081
* o2 input 9 w=-0.361684375837218 w-  G = 3.61684375837218e-06 S  R = 276484.157681743 Ohm
Ro2n9 h9buf o2n 276484.157681743
* o2 input 10 w=+0.452890664029133 w+  G = 4.52890664029133e-06 S  R = 220803.845039224 Ohm
Ro2p10 h10buf o2p 220803.845039224
* o2 input 11 w=+0.0606203574330194 w+  G = 6.06203574330194e-07 S  R = 1649610.86068309 Ohm
Ro2p11 h11buf o2p 1649610.86068309
* o2 input 12 w=-0.0898136089242814 w-  G = 8.98136089242814e-07 S  R = 1113417.01104903 Ohm
Ro2n12 h12buf o2n 1113417.01104903
* o2 input 13 w=-0.553902067110154 w-  G = 5.53902067110154e-06 S  R = 180537.329498922 Ohm
Ro2n13 h13buf o2n 180537.329498922
* o2 input 14 w=-0.190984877147874 w-  G = 1.90984877147874e-06 S  R = 523601.666756958 Ohm
Ro2n14 h14buf o2n 523601.666756958
* o2 input 15 w=+0.158029413888863 w+  G = 1.58029413888863e-06 S  R = 632793.589112003 Ohm
Ro2p15 h15buf o2p 632793.589112003
* o2 input 16 w=-0.0395340486529462 w-  G = 3.95340486529463e-07 S  R = 2529465.19284833 Ohm
Ro2n16 h16buf o2n 2529465.19284833
* o2 bias=-0.0700129173356542 b-  G = 7.00129173356542e-07 S  R = 1428307.85811399 Ohm
Ro2bn vref o2n 1428307.85811399
Vo2p o2p 0 DC 0
Vo2n o2n 0 DC 0
Fo2p 0 o2d Vo2p 1
Fo2n o2d 0 Vo2n 1
Vo2d o2d 0 DC 0
Ho2 o2lin 0 Vo2d 100000

* --- neuron o3 ---
* o3 input 1 w=+0.497382607407854 w+  G = 4.97382607407854e-06 S  R = 201052.466472757 Ohm
Ro3p1 h1buf o3p 201052.466472757
* o3 input 2 w=+0.535801570569257 w+  G = 5.35801570569257e-06 S  R = 186636.257698454 Ohm
Ro3p2 h2buf o3p 186636.257698454
* o3 input 3 w=-0.334339460387776 w-  G = 3.34339460387776e-06 S  R = 299097.210613481 Ohm
Ro3n3 h3buf o3n 299097.210613481
* o3 input 4 w=-0.0117893955238855 w-  G = 1.17893955238855e-07 S  R = 8482199.0913273 Ohm
Ro3n4 h4buf o3n 8482199.0913273
* o3 input 5 w=-0.178324934583561 w-  G = 1.78324934583561e-06 S  R = 560774.07365116 Ohm
Ro3n5 h5buf o3n 560774.07365116
* o3 input 6 w=+0.769857201610668 w+  G = 7.69857201610669e-06 S  R = 129894.219071775 Ohm
Ro3p6 h6buf o3p 129894.219071775
* o3 input 7 w=-0.494314902679951 w-  G = 4.94314902679951e-06 S  R = 202300.192565196 Ohm
Ro3n7 h7buf o3n 202300.192565196
* o3 input 8 w=+0.369792890834276 w+  G = 3.69792890834276e-06 S  R = 270421.640000687 Ohm
Ro3p8 h8buf o3p 270421.640000687
* o3 input 9 w=+0.204682399558665 w+  G = 2.04682399558665e-06 S  R = 488561.792394556 Ohm
Ro3p9 h9buf o3p 488561.792394556
* o3 input 10 w=-0.21567626336008 w-  G = 2.1567626336008e-06 S  R = 463657.884470329 Ohm
Ro3n10 h10buf o3n 463657.884470329
* o3 input 11 w=-0.223974534350694 w-  G = 2.23974534350694e-06 S  R = 446479.329848377 Ohm
Ro3n11 h11buf o3n 446479.329848377
* o3 input 12 w=-0.583091052129786 w-  G = 5.83091052129786e-06 S  R = 171499.802020185 Ohm
Ro3n12 h12buf o3n 171499.802020185
* o3 input 13 w=-0.00623301315164361 w-  G = 6.23301315164361e-08 S  R = 16043604.8452153 Ohm
Ro3n13 h13buf o3n 16043604.8452153
* o3 input 14 w=-0.300761338671968 w-  G = 3.00761338671968e-06 S  R = 332489.542843362 Ohm
Ro3n14 h14buf o3n 332489.542843362
* o3 input 15 w=-0.0843829907675772 w-  G = 8.43829907675772e-07 S  R = 1185072.95238489 Ohm
Ro3n15 h15buf o3n 1185072.95238489
* o3 input 16 w=+0.339398993225363 w+  G = 3.39398993225363e-06 S  R = 294638.469754091 Ohm
Ro3p16 h16buf o3p 294638.469754091
* o3 bias=-0.0795449497076742 b-  G = 7.95449497076742e-07 S  R = 1257150.83569099 Ohm
Ro3bn vref o3n 1257150.83569099
Vo3p o3p 0 DC 0
Vo3n o3n 0 DC 0
Fo3p 0 o3d Vo3p 1
Fo3n o3d 0 Vo3n 1
Vo3d o3d 0 DC 0
Ho3 o3lin 0 Vo3d 100000

* --- neuron o4 ---
* o4 input 1 w=-0.327462084226772 w-  G = 3.27462084226772e-06 S  R = 305378.866185767 Ohm
Ro4n1 h1buf o4n 305378.866185767
* o4 input 2 w=-0.0262568622940402 w-  G = 2.62568622940402e-07 S  R = 3808528.18132416 Ohm
Ro4n2 h2buf o4n 3808528.18132416
* o4 input 3 w=+0.154453605104359 w+  G = 1.5445360510436e-06 S  R = 647443.612160643 Ohm
Ro4p3 h3buf o4p 647443.612160643
* o4 input 4 w=+0.128488255591405 w+  G = 1.28488255591405e-06 S  R = 778281.248661371 Ohm
Ro4p4 h4buf o4p 778281.248661371
* o4 input 5 w=+0.0585610981768107 w+  G = 5.85610981768107e-07 S  R = 1707618.25022603 Ohm
Ro4p5 h5buf o4p 1707618.25022603
* o4 input 6 w=+0.208142836423343 w+  G = 2.08142836423343e-06 S  R = 480439.306576034 Ohm
Ro4p6 h6buf o4p 480439.306576034
* o4 input 7 w=+0.216945125191304 w+  G = 2.16945125191304e-06 S  R = 460946.056805006 Ohm
Ro4p7 h7buf o4p 460946.056805006
* o4 input 8 w=-0.0522427558454539 w-  G = 5.22427558454539e-07 S  R = 1914140.98245167 Ohm
Ro4n8 h8buf o4n 1914140.98245167
* o4 input 9 w=-0.0473297589785783 w-  G = 4.73297589785783e-07 S  R = 2112835.60614075 Ohm
Ro4n9 h9buf o4n 2112835.60614075
* o4 input 10 w=+0.702713942079376 w+  G = 7.02713942079376e-06 S  R = 142305.416204058 Ohm
Ro4p10 h10buf o4p 142305.416204058
* o4 input 11 w=-0.265833055394844 w-  G = 2.65833055394844e-06 S  R = 376175.941895071 Ohm
Ro4n11 h11buf o4n 376175.941895071
* o4 input 12 w=+0.592474675537067 w+  G = 5.92474675537067e-06 S  R = 168783.585407008 Ohm
Ro4p12 h12buf o4p 168783.585407008
* o4 input 13 w=-0.00706022029607814 w-  G = 7.06022029607814e-08 S  R = 14163863.9881462 Ohm
Ro4n13 h13buf o4n 14163863.9881462
* o4 input 14 w=+0.264631332898461 w+  G = 2.64631332898461e-06 S  R = 377884.201786377 Ohm
Ro4p14 h14buf o4p 377884.201786377
* o4 input 15 w=+0.189685063134372 w+  G = 1.89685063134372e-06 S  R = 527189.639224047 Ohm
Ro4p15 h15buf o4p 527189.639224047
* o4 input 16 w=+0.151336395626671 w+  G = 1.51336395626671e-06 S  R = 660779.580390485 Ohm
Ro4p16 h16buf o4p 660779.580390485
* o4 bias=-0.0274892269582463 b-  G = 2.74892269582463e-07 S  R = 3637788.72908617 Ohm
Ro4bn vref o4n 3637788.72908617
Vo4p o4p 0 DC 0
Vo4n o4n 0 DC 0
Fo4p 0 o4d Vo4p 1
Fo4n o4d 0 Vo4n 1
Vo4d o4d 0 DC 0
Ho4 o4lin 0 Vo4d 100000

* --- neuron o5 ---
* o5 input 1 w=-0.694863552054671 w-  G = 6.94863552054671e-06 S  R = 143913.146263473 Ohm
Ro5n1 h1buf o5n 143913.146263473
* o5 input 2 w=+0.219447143056421 w+  G = 2.19447143056421e-06 S  R = 455690.598689132 Ohm
Ro5p2 h2buf o5p 455690.598689132
* o5 input 3 w=-0.0358678731252569 w-  G = 3.58678731252569e-07 S  R = 2788010.30802084 Ohm
Ro5n3 h3buf o5n 2788010.30802084
* o5 input 4 w=+0.505029374682183 w+  G = 5.05029374682183e-06 S  R = 198008.284296197 Ohm
Ro5p4 h4buf o5p 198008.284296197
* o5 input 5 w=+0.556285400948618 w+  G = 5.56285400948618e-06 S  R = 179763.840340718 Ohm
Ro5p5 h5buf o5p 179763.840340718
* o5 input 6 w=-0.135044983321689 w-  G = 1.35044983321689e-06 S  R = 740494.000889992 Ohm
Ro5n6 h6buf o5n 740494.000889992
* o5 input 7 w=+0.47614076400193 w+  G = 4.7614076400193e-06 S  R = 210021.925364061 Ohm
Ro5p7 h7buf o5p 210021.925364061
* o5 input 8 w=-0.121444499377643 w-  G = 1.21444499377643e-06 S  R = 823421.4024716 Ohm
Ro5n8 h8buf o5n 823421.4024716
* o5 input 9 w=-0.272966656095316 w-  G = 2.72966656095316e-06 S  R = 366345.111269126 Ohm
Ro5n9 h9buf o5n 366345.111269126
* o5 input 10 w=+0.0522013549896543 w+  G = 5.22013549896543e-07 S  R = 1915659.08624055 Ohm
Ro5p10 h10buf o5p 1915659.08624055
* o5 input 11 w=-0.081219873755529 w-  G = 8.1219873755529e-07 S  R = 1231225.7502517 Ohm
Ro5n11 h11buf o5n 1231225.7502517
* o5 input 12 w=+0.252868868358215 w+  G = 2.52868868358215e-06 S  R = 395461.887614966 Ohm
Ro5p12 h12buf o5p 395461.887614966
* o5 input 13 w=-0.455568839161057 w-  G = 4.55568839161057e-06 S  R = 219505.794523069 Ohm
Ro5n13 h13buf o5n 219505.794523069
* o5 input 14 w=+0.38808867413587 w+  G = 3.8808867413587e-06 S  R = 257673.069750523 Ohm
Ro5p14 h14buf o5p 257673.069750523
* o5 input 15 w=+0.303328916243743 w+  G = 3.03328916243743e-06 S  R = 329675.13034479 Ohm
Ro5p15 h15buf o5p 329675.13034479
* o5 input 16 w=-0.27873075516834 w-  G = 2.7873075516834e-06 S  R = 358769.163953955 Ohm
Ro5n16 h16buf o5n 358769.163953955
* o5 bias=-0.00794496071319509 b-  G = 7.94496071319509e-08 S  R = 12586594.6490986 Ohm
Ro5bn vref o5n 12586594.6490986
Vo5p o5p 0 DC 0
Vo5n o5n 0 DC 0
Fo5p 0 o5d Vo5p 1
Fo5n o5d 0 Vo5n 1
Vo5d o5d 0 DC 0
Ho5 o5lin 0 Vo5d 100000

* --- neuron o6 ---
* o6 input 1 w=+0.45904626175083 w+  G = 4.5904626175083e-06 S  R = 217842.967762321 Ohm
Ro6p1 h1buf o6p 217842.967762321
* o6 input 2 w=+0.0908085794647537 w+  G = 9.08085794647537e-07 S  R = 1101217.53461427 Ohm
Ro6p2 h2buf o6p 1101217.53461427
* o6 input 3 w=+0.560250945806646 w+  G = 5.60250945806646e-06 S  R = 178491.443429909 Ohm
Ro6p3 h3buf o6p 178491.443429909
* o6 input 4 w=+0.325398659272284 w+  G = 3.25398659272284e-06 S  R = 307315.341199126 Ohm
Ro6p4 h4buf o6p 307315.341199126
* o6 input 5 w=-0.845373887857223 w-  G = 8.45373887857223e-06 S  R = 118290.855012651 Ohm
Ro6n5 h5buf o6n 118290.855012651
* o6 input 6 w=-0.148205163963375 w-  G = 1.48205163963375e-06 S  R = 674740.321630844 Ohm
Ro6n6 h6buf o6n 674740.321630844
* o6 input 7 w=+0.269501837898933 w+  G = 2.69501837898933e-06 S  R = 371054.983445053 Ohm
Ro6p7 h7buf o6p 371054.983445053
* o6 input 8 w=+0.248315477406225 w+  G = 2.48315477406225e-06 S  R = 402713.520093666 Ohm
Ro6p8 h8buf o6p 402713.520093666
* o6 input 9 w=-0.19186650619111 w-  G = 1.9186650619111e-06 S  R = 521195.71041959 Ohm
Ro6n9 h9buf o6n 521195.71041959
* o6 input 10 w=+0.695272603906198 w+  G = 6.95272603906198e-06 S  R = 143828.477403219 Ohm
Ro6p10 h10buf o6p 143828.477403219
* o6 input 11 w=+0.513776901712359 w+  G = 5.13776901712359e-06 S  R = 194637.010084945 Ohm
Ro6p11 h11buf o6p 194637.010084945
* o6 input 12 w=-0.195581125563829 w-  G = 1.95581125563829e-06 S  R = 511296.781382743 Ohm
Ro6n12 h12buf o6n 511296.781382743
* o6 input 13 w=-0.426985891611627 w-  G = 4.26985891611627e-06 S  R = 234199.775600447 Ohm
Ro6n13 h13buf o6n 234199.775600447
* o6 input 14 w=-0.567282987929868 w-  G = 5.67282987929868e-06 S  R = 176278.862803414 Ohm
Ro6n14 h14buf o6n 176278.862803414
* o6 input 15 w=+0.365992297925862 w+  G = 3.65992297925862e-06 S  R = 273229.793541329 Ohm
Ro6p15 h15buf o6p 273229.793541329
* o6 input 16 w=-0.330471443267193 w-  G = 3.30471443267193e-06 S  R = 302598.006688124 Ohm
Ro6n16 h16buf o6n 302598.006688124
* o6 bias=+0.0111132032738553 b+  G = 1.11132032738553e-07 S  R = 8998305.66721099 Ohm
Ro6bp vref o6p 8998305.66721099
Vo6p o6p 0 DC 0
Vo6n o6n 0 DC 0
Fo6p 0 o6d Vo6p 1
Fo6n o6d 0 Vo6n 1
Vo6d o6d 0 DC 0
Ho6 o6lin 0 Vo6d 100000

* --- neuron o7 ---
* o7 input 1 w=-0.0332658024207454 w-  G = 3.32658024207454e-07 S  R = 3006090.12027431 Ohm
Ro7n1 h1buf o7n 3006090.12027431
* o7 input 2 w=+0.145758710813814 w+  G = 1.45758710813814e-06 S  R = 686065.343482184 Ohm
Ro7p2 h2buf o7p 686065.343482184
* o7 input 3 w=-0.130657700019485 w-  G = 1.30657700019485e-06 S  R = 765358.643119286 Ohm
Ro7n3 h3buf o7n 765358.643119286
* o7 input 4 w=-0.33866224685449 w-  G = 3.3866224685449e-06 S  R = 295279.444132921 Ohm
Ro7n4 h4buf o7n 295279.444132921
* o7 input 5 w=-0.448715798066713 w-  G = 4.48715798066713e-06 S  R = 222858.210989782 Ohm
Ro7n5 h5buf o7n 222858.210989782
* o7 input 6 w=-0.621841899847368 w-  G = 6.21841899847369e-06 S  R = 160812.579571343 Ohm
Ro7n6 h6buf o7n 160812.579571343
* o7 input 7 w=+0.619590879501709 w+  G = 6.19590879501709e-06 S  R = 161396.823788663 Ohm
Ro7p7 h7buf o7p 161396.823788663
* o7 input 8 w=-0.0160701297837989 w-  G = 1.60701297837989e-07 S  R = 6222725.10212177 Ohm
Ro7n8 h8buf o7n 6222725.10212177
* o7 input 9 w=-0.00995203246284198 w-  G = 9.95203246284198e-08 S  R = 10048198.7346174 Ohm
Ro7n9 h9buf o7n 10048198.7346174
* o7 input 10 w=+0.182194810054795 w+  G = 1.82194810054795e-06 S  R = 548863.054715581 Ohm
Ro7p10 h10buf o7p 548863.054715581
* o7 input 11 w=-0.239756424235478 w-  G = 2.39756424235478e-06 S  R = 417089.97086887 Ohm
Ro7n11 h11buf o7n 417089.97086887
* o7 input 12 w=-0.0160993974759893 w-  G = 1.60993974759893e-07 S  R = 6211412.57920617 Ohm
Ro7n12 h12buf o7n 6211412.57920617
* o7 input 13 w=+0.25833663496509 w+  G = 2.5833663496509e-06 S  R = 387091.826962573 Ohm
Ro7p13 h13buf o7p 387091.826962573
* o7 input 14 w=-0.401990563114474 w-  G = 4.01990563114474e-06 S  R = 248762.0585549 Ohm
Ro7n14 h14buf o7n 248762.0585549
* o7 input 15 w=+0.00644973027409016 w+  G = 6.44973027409016e-08 S  R = 15504524.3367338 Ohm
Ro7p15 h15buf o7p 15504524.3367338
* o7 input 16 w=-0.269031589296092 w-  G = 2.69031589296092e-06 S  R = 371703.561881507 Ohm
Ro7n16 h16buf o7n 371703.561881507
* o7 bias=+0.0420797401619694 b+  G = 4.20797401619694e-07 S  R = 2376440.52969646 Ohm
Ro7bp vref o7p 2376440.52969646
Vo7p o7p 0 DC 0
Vo7n o7n 0 DC 0
Fo7p 0 o7d Vo7p 1
Fo7n o7d 0 Vo7n 1
Vo7d o7d 0 DC 0
Ho7 o7lin 0 Vo7d 100000

* --- neuron o8 ---
* o8 input 1 w=+0.0516194107538671 w+  G = 5.16194107538671e-07 S  R = 1937255.74429399 Ohm
Ro8p1 h1buf o8p 1937255.74429399
* o8 input 2 w=-0.679769094151954 w-  G = 6.79769094151954e-06 S  R = 147108.776877765 Ohm
Ro8n2 h2buf o8n 147108.776877765
* o8 input 3 w=-0.442645111189804 w-  G = 4.42645111189804e-06 S  R = 225914.615279961 Ohm
Ro8n3 h3buf o8n 225914.615279961
* o8 input 4 w=+0.292541192770213 w+  G = 2.92541192770213e-06 S  R = 341832.201656977 Ohm
Ro8p4 h4buf o8p 341832.201656977
* o8 input 5 w=-0.214411517916756 w-  G = 2.14411517916756e-06 S  R = 466392.855064925 Ohm
Ro8n5 h5buf o8n 466392.855064925
* o8 input 6 w=+0.02641483760471 w+  G = 2.641483760471e-07 S  R = 3785751.08037647 Ohm
Ro8p6 h6buf o8p 3785751.08037647
* o8 input 7 w=-0.165807379992927 w-  G = 1.65807379992927e-06 S  R = 603109.463549005 Ohm
Ro8n7 h7buf o8n 603109.463549005
* o8 input 8 w=+0.0471478145146704 w+  G = 4.71478145146704e-07 S  R = 2120989.08569525 Ohm
Ro8p8 h8buf o8p 2120989.08569525
* o8 input 9 w=-0.115460526532582 w-  G = 1.15460526532582e-06 S  R = 866096.864470655 Ohm
Ro8n9 h9buf o8n 866096.864470655
* o8 input 10 w=+0.347489543035249 w+  G = 3.47489543035249e-06 S  R = 287778.443997251 Ohm
Ro8p10 h10buf o8p 287778.443997251
* o8 input 11 w=-0.289608744619325 w-  G = 2.89608744619325e-06 S  R = 345293.441092204 Ohm
Ro8n11 h11buf o8n 345293.441092204
* o8 input 12 w=-0.224060800674934 w-  G = 2.24060800674934e-06 S  R = 446307.429495798 Ohm
Ro8n12 h12buf o8n 446307.429495798
* o8 input 13 w=-0.0251099394619616 w-  G = 2.51099394619616e-07 S  R = 3982486.70218769 Ohm
Ro8n13 h13buf o8n 3982486.70218769
* o8 input 14 w=+0.0180727906900674 w+  G = 1.80727906900674e-07 S  R = 5533179.77920029 Ohm
Ro8p14 h14buf o8p 5533179.77920029
* o8 input 15 w=+0.397743621170271 w+  G = 3.97743621170271e-06 S  R = 251418.236968257 Ohm
Ro8p15 h15buf o8p 251418.236968257
* o8 input 16 w=+0.238942494993685 w+  G = 2.38942494993685e-06 S  R = 418510.738337451 Ohm
Ro8p16 h16buf o8p 418510.738337451
* o8 bias=+0.0779130480692674 b+  G = 7.79130480692674e-07 S  R = 1283482.06722828 Ohm
Ro8bp vref o8p 1283482.06722828
Vo8p o8p 0 DC 0
Vo8n o8n 0 DC 0
Fo8p 0 o8d Vo8p 1
Fo8n o8d 0 Vo8n 1
Vo8d o8d 0 DC 0
Ho8 o8lin 0 Vo8d 100000

.model Dsi D(Is=1e-14 N=1 Rs=1)
.control
set numdgt=15
alter Vin1 DC 0.292066643026527
alter Vin2 DC 0.362824278782178
alter Vin3 DC -0.507121144713447
alter Vin4 DC -0.174383141704869
alter Vin5 DC 0.769929158267543
alter Vin6 DC 0.370858784510567
alter Vin7 DC 0.493170898422606
alter Vin8 DC -0.205625460316851
op
print v(o1lin)
print v(o2lin)
print v(o3lin)
print v(o4lin)
print v(o5lin)
print v(o6lin)
print v(o7lin)
print v(o8lin)
alter Vin1 DC 0.24554017880175
alter Vin2 DC -0.233160923753698
alter Vin3 DC 0.59758403188887
alter Vin4 DC 0.906828140192492
alter Vin5 DC -0.631048792392608
alter Vin6 DC 0.863624389445832
alter Vin7 DC -0.256604626011187
alter Vin8 DC 0.887263938984657
op
print v(o1lin)
print v(o2lin)
print v(o3lin)
print v(o4lin)
print v(o5lin)
print v(o6lin)
print v(o7lin)
print v(o8lin)
alter Vin1 DC -0.904485346238181
alter Vin2 DC -0.427533972031961
alter Vin3 DC -0.814624014450885
alter Vin4 DC -0.587447416961156
alter Vin5 DC -0.604421234962021
alter Vin6 DC -0.449771531064202
alter Vin7 DC -0.609978677911662
alter Vin8 DC 0.222534074931871
op
print v(o1lin)
print v(o2lin)
print v(o3lin)
print v(o4lin)
print v(o5lin)
print v(o6lin)
print v(o7lin)
print v(o8lin)
alter Vin1 DC 0.9516490207919
alter Vin2 DC -0.638986615547767
alter Vin3 DC -0.459300643075119
alter Vin4 DC -0.637124983808852
alter Vin5 DC -0.34536909014708
alter Vin6 DC 0.763676525116783
alter Vin7 DC 0.0247584081758163
alter Vin8 DC -0.446155349870336
op
print v(o1lin)
print v(o2lin)
print v(o3lin)
print v(o4lin)
print v(o5lin)
print v(o6lin)
print v(o7lin)
print v(o8lin)
alter Vin1 DC -0.133127705075713
alter Vin2 DC -0.673014572735916
alter Vin3 DC -0.670682128904316
alter Vin4 DC 0.0235579161045645
alter Vin5 DC 0.74909199820043
alter Vin6 DC 0.311860262384464
alter Vin7 DC -0.478837614159339
alter Vin8 DC 0.623194449641131
op
print v(o1lin)
print v(o2lin)
print v(o3lin)
print v(o4lin)
print v(o5lin)
print v(o6lin)
print v(o7lin)
print v(o8lin)
alter Vin1 DC 0.751895503860844
alter Vin2 DC -0.191822726103574
alter Vin3 DC 0.358253649826237
alter Vin4 DC 0.441424742434942
alter Vin5 DC -0.373934079653724
alter Vin6 DC 0.870152977334431
alter Vin7 DC -0.00288230152986269
alter Vin8 DC -0.532532220309136
op
print v(o1lin)
print v(o2lin)
print v(o3lin)
print v(o4lin)
print v(o5lin)
print v(o6lin)
print v(o7lin)
print v(o8lin)
alter Vin1 DC -0.126174461947244
alter Vin2 DC -0.702682881769009
alter Vin3 DC -0.72685000561842
alter Vin4 DC 0.736941940744483
alter Vin5 DC -0.766087856445693
alter Vin6 DC 0.142332393624092
alter Vin7 DC 0.122672321242906
alter Vin8 DC -0.963420502272634
op
print v(o1lin)
print v(o2lin)
print v(o3lin)
print v(o4lin)
print v(o5lin)
print v(o6lin)
print v(o7lin)
print v(o8lin)
alter Vin1 DC -0.895828772705048
alter Vin2 DC 0.930594837475278
alter Vin3 DC 0.802083736488364
alter Vin4 DC 0.14447318412788
alter Vin5 DC -0.993510939052112
alter Vin6 DC -0.362942286924229
alter Vin7 DC -0.711797456288946
alter Vin8 DC -0.44785119922871
op
print v(o1lin)
print v(o2lin)
print v(o3lin)
print v(o4lin)
print v(o5lin)
print v(o6lin)
print v(o7lin)
print v(o8lin)
alter Vin1 DC -0.886410013578995
alter Vin2 DC -0.293743350476748
alter Vin3 DC -5.43386316855798e-05
alter Vin4 DC -0.448706157437056
alter Vin5 DC 0.423100628298395
alter Vin6 DC 0.433090597599951
alter Vin7 DC 0.297208859400947
alter Vin8 DC -0.636685530568713
op
print v(o1lin)
print v(o2lin)
print v(o3lin)
print v(o4lin)
print v(o5lin)
print v(o6lin)
print v(o7lin)
print v(o8lin)
alter Vin1 DC 0.576360677454351
alter Vin2 DC -0.507087951683394
alter Vin3 DC -0.647645895849739
alter Vin4 DC -0.657545205246403
alter Vin5 DC -0.769033232083184
alter Vin6 DC -0.0671354944827505
alter Vin7 DC -0.400694132669506
alter Vin8 DC 0.136373045528617
op
print v(o1lin)
print v(o2lin)
print v(o3lin)
print v(o4lin)
print v(o5lin)
print v(o6lin)
print v(o7lin)
print v(o8lin)
alter Vin1 DC 0.695751741705376
alter Vin2 DC -0.744146330946501
alter Vin3 DC 0.347745219601844
alter Vin4 DC -0.289278951871078
alter Vin5 DC 0.473622099939047
alter Vin6 DC -0.16030297151441
alter Vin7 DC -0.615767651654969
alter Vin8 DC -0.725028603646585
op
print v(o1lin)
print v(o2lin)
print v(o3lin)
print v(o4lin)
print v(o5lin)
print v(o6lin)
print v(o7lin)
print v(o8lin)
alter Vin1 DC 0.483038136007596
alter Vin2 DC -0.885239720125505
alter Vin3 DC -0.342649495880851
alter Vin4 DC 0.841489719940993
alter Vin5 DC 0.692070026907047
alter Vin6 DC 0.230015811118721
alter Vin7 DC -0.122887636557562
alter Vin8 DC 0.299933492452486
op
print v(o1lin)
print v(o2lin)
print v(o3lin)
print v(o4lin)
print v(o5lin)
print v(o6lin)
print v(o7lin)
print v(o8lin)
alter Vin1 DC -0.917927826642433
alter Vin2 DC -0.25327938084258
alter Vin3 DC -0.873372369384505
alter Vin4 DC 0.656962472821084
alter Vin5 DC 0.924264660234498
alter Vin6 DC 0.500910619027462
alter Vin7 DC 0.717062518481161
alter Vin8 DC -0.131166454527703
op
print v(o1lin)
print v(o2lin)
print v(o3lin)
print v(o4lin)
print v(o5lin)
print v(o6lin)
print v(o7lin)
print v(o8lin)
alter Vin1 DC -0.635584386219876
alter Vin2 DC -0.154978941169398
alter Vin3 DC 0.668331023958396
alter Vin4 DC -0.349181276573311
alter Vin5 DC 0.294683023625949
alter Vin6 DC -0.0913587106439315
alter Vin7 DC -0.964907200176673
alter Vin8 DC 0.401686448787914
op
print v(o1lin)
print v(o2lin)
print v(o3lin)
print v(o4lin)
print v(o5lin)
print v(o6lin)
print v(o7lin)
print v(o8lin)
alter Vin1 DC 0.233276631079323
alter Vin2 DC 0.444844108280645
alter Vin3 DC -0.147850455504622
alter Vin4 DC 0.589379196267813
alter Vin5 DC -0.154612273291213
alter Vin6 DC 0.17771708472659
alter Vin7 DC 0.300291970509642
alter Vin8 DC 0.69704156387471
op
print v(o1lin)
print v(o2lin)
print v(o3lin)
print v(o4lin)
print v(o5lin)
print v(o6lin)
print v(o7lin)
print v(o8lin)
alter Vin1 DC 0.149219670538209
alter Vin2 DC 0.980274272743893
alter Vin3 DC -0.972193975765511
alter Vin4 DC 0.93094415285687
alter Vin5 DC -0.43250148347683
alter Vin6 DC -0.748175816190161
alter Vin7 DC -0.379666643901823
alter Vin8 DC -0.980107666717368
op
print v(o1lin)
print v(o2lin)
print v(o3lin)
print v(o4lin)
print v(o5lin)
print v(o6lin)
print v(o7lin)
print v(o8lin)
alter Vin1 DC 0.609714404549291
alter Vin2 DC -0.933631750995612
alter Vin3 DC -0.140646162062471
alter Vin4 DC -0.905493567038185
alter Vin5 DC -0.503097776186541
alter Vin6 DC -0.105032551318756
alter Vin7 DC -0.0508290041765875
alter Vin8 DC -0.972680375659822
op
print v(o1lin)
print v(o2lin)
print v(o3lin)
print v(o4lin)
print v(o5lin)
print v(o6lin)
print v(o7lin)
print v(o8lin)
alter Vin1 DC 0.589594603559701
alter Vin2 DC 0.827945380681812
alter Vin3 DC 0.575818435284043
alter Vin4 DC -0.245023772010625
alter Vin5 DC 0.234767115717653
alter Vin6 DC 0.141199972286301
alter Vin7 DC -0.284429190112971
alter Vin8 DC 0.482467958436136
op
print v(o1lin)
print v(o2lin)
print v(o3lin)
print v(o4lin)
print v(o5lin)
print v(o6lin)
print v(o7lin)
print v(o8lin)
alter Vin1 DC -0.682365510435796
alter Vin2 DC 0.426909319942684
alter Vin3 DC 0.257728534226715
alter Vin4 DC -0.509748685257793
alter Vin5 DC 0.241687717760015
alter Vin6 DC -0.732656768886782
alter Vin7 DC -0.616310479662379
alter Vin8 DC -0.805788162852981
op
print v(o1lin)
print v(o2lin)
print v(o3lin)
print v(o4lin)
print v(o5lin)
print v(o6lin)
print v(o7lin)
print v(o8lin)
alter Vin1 DC -0.835941611712544
alter Vin2 DC 0.542516525408987
alter Vin3 DC 0.0274187447786809
alter Vin4 DC 0.910156801317074
alter Vin5 DC -0.966158261506138
alter Vin6 DC -0.917606435718897
alter Vin7 DC 0.374545032420849
alter Vin8 DC 0.280101727382577
op
print v(o1lin)
print v(o2lin)
print v(o3lin)
print v(o4lin)
print v(o5lin)
print v(o6lin)
print v(o7lin)
print v(o8lin)
alter Vin1 DC 0.120587715835924
alter Vin2 DC -0.441035070940685
alter Vin3 DC 0.166160907331449
alter Vin4 DC -0.583223516078244
alter Vin5 DC 0.10875546821053
alter Vin6 DC 0.318007573293234
alter Vin7 DC 0.442076110774023
alter Vin8 DC 0.992581692967296
op
print v(o1lin)
print v(o2lin)
print v(o3lin)
print v(o4lin)
print v(o5lin)
print v(o6lin)
print v(o7lin)
print v(o8lin)
alter Vin1 DC -0.617807303574317
alter Vin2 DC -0.203806920625468
alter Vin3 DC 0.196868202867157
alter Vin4 DC 0.393511530335996
alter Vin5 DC 0.998774899734088
alter Vin6 DC -0.0102997254910306
alter Vin7 DC 0.156811946917842
alter Vin8 DC 0.0942232912254948
op
print v(o1lin)
print v(o2lin)
print v(o3lin)
print v(o4lin)
print v(o5lin)
print v(o6lin)
print v(o7lin)
print v(o8lin)
alter Vin1 DC -0.67195695415374
alter Vin2 DC 0.396498087616147
alter Vin3 DC -0.0851691868530999
alter Vin4 DC -0.765069345714001
alter Vin5 DC -0.525780931827023
alter Vin6 DC -0.206010751975036
alter Vin7 DC -0.526246371583909
alter Vin8 DC -0.851811921673297
op
print v(o1lin)
print v(o2lin)
print v(o3lin)
print v(o4lin)
print v(o5lin)
print v(o6lin)
print v(o7lin)
print v(o8lin)
alter Vin1 DC -0.591631670349937
alter Vin2 DC 0.64384466820072
alter Vin3 DC -0.174153727263532
alter Vin4 DC 0.572581978727007
alter Vin5 DC 0.608937700910429
alter Vin6 DC 0.701504189033929
alter Vin7 DC -0.746363674448377
alter Vin8 DC 0.727783951020117
op
print v(o1lin)
print v(o2lin)
print v(o3lin)
print v(o4lin)
print v(o5lin)
print v(o6lin)
print v(o7lin)
print v(o8lin)
alter Vin1 DC 0.787387182877478
alter Vin2 DC -0.188914774477189
alter Vin3 DC -0.895782326562417
alter Vin4 DC -0.92217611431784
alter Vin5 DC 0.517363186549292
alter Vin6 DC -0.940733487584329
alter Vin7 DC -0.37030639047434
alter Vin8 DC -0.799869946482012
op
print v(o1lin)
print v(o2lin)
print v(o3lin)
print v(o4lin)
print v(o5lin)
print v(o6lin)
print v(o7lin)
print v(o8lin)
alter Vin1 DC 0.0196145331133055
alter Vin2 DC -0.87202285953913
alter Vin3 DC -0.145304788903075
alter Vin4 DC 0.318629411327401
alter Vin5 DC -0.88178677013467
alter Vin6 DC 0.210893826160735
alter Vin7 DC -0.225685147453055
alter Vin8 DC -0.103386264664894
op
print v(o1lin)
print v(o2lin)
print v(o3lin)
print v(o4lin)
print v(o5lin)
print v(o6lin)
print v(o7lin)
print v(o8lin)
alter Vin1 DC 0.0645199751922341
alter Vin2 DC -0.568101024830064
alter Vin3 DC 0.230669114004872
alter Vin4 DC 0.29668042647879
alter Vin5 DC 0.474056353216298
alter Vin6 DC -0.174485518334827
alter Vin7 DC -0.751171529462457
alter Vin8 DC -0.664697918094859
op
print v(o1lin)
print v(o2lin)
print v(o3lin)
print v(o4lin)
print v(o5lin)
print v(o6lin)
print v(o7lin)
print v(o8lin)
alter Vin1 DC 0.0275398462670948
alter Vin2 DC 0.646523324758708
alter Vin3 DC -0.815400587604047
alter Vin4 DC -0.406157895051034
alter Vin5 DC -0.149127178077311
alter Vin6 DC 0.950027275626564
alter Vin7 DC -0.942705327604679
alter Vin8 DC 0.462317925319415
op
print v(o1lin)
print v(o2lin)
print v(o3lin)
print v(o4lin)
print v(o5lin)
print v(o6lin)
print v(o7lin)
print v(o8lin)
alter Vin1 DC 0.272045256226076
alter Vin2 DC -0.511627401500185
alter Vin3 DC 0.742022069084732
alter Vin4 DC -0.396318874069422
alter Vin5 DC 0.770809587535823
alter Vin6 DC 0.447135919257908
alter Vin7 DC -0.122734992077934
alter Vin8 DC 0.259548903253485
op
print v(o1lin)
print v(o2lin)
print v(o3lin)
print v(o4lin)
print v(o5lin)
print v(o6lin)
print v(o7lin)
print v(o8lin)
alter Vin1 DC -0.513020707426117
alter Vin2 DC 0.798568947301445
alter Vin3 DC -0.639365933138896
alter Vin4 DC 0.548846623887806
alter Vin5 DC 0.580019564883699
alter Vin6 DC 0.895849960099718
alter Vin7 DC 0.408867375945723
alter Vin8 DC -0.768840503665631
op
print v(o1lin)
print v(o2lin)
print v(o3lin)
print v(o4lin)
print v(o5lin)
print v(o6lin)
print v(o7lin)
print v(o8lin)
alter Vin1 DC 0.101792531157947
alter Vin2 DC -0.300686302247948
alter Vin3 DC -0.960954866473904
alter Vin4 DC 0.13300533747416
alter Vin5 DC 0.623544362690936
alter Vin6 DC -0.0840155101913851
alter Vin7 DC -0.998463047965885
alter Vin8 DC -0.536490968847301
op
print v(o1lin)
print v(o2lin)
print v(o3lin)
print v(o4lin)
print v(o5lin)
print v(o6lin)
print v(o7lin)
print v(o8lin)
alter Vin1 DC -0.149676897504001
alter Vin2 DC 0.910981277332123
alter Vin3 DC 0.362809954870629
alter Vin4 DC 0.544261392794779
alter Vin5 DC 0.233316219882017
alter Vin6 DC 0.584015327979986
alter Vin7 DC 0.545092514997675
alter Vin8 DC -0.526192774465737
op
print v(o1lin)
print v(o2lin)
print v(o3lin)
print v(o4lin)
print v(o5lin)
print v(o6lin)
print v(o7lin)
print v(o8lin)
alter Vin1 DC -0.359305440954763
alter Vin2 DC 0.689972059868187
alter Vin3 DC 0.648160632259179
alter Vin4 DC 0.729221413152189
alter Vin5 DC -0.131413271366549
alter Vin6 DC 0.387687457121906
alter Vin7 DC -0.778484008673441
alter Vin8 DC 0.77528216621976
op
print v(o1lin)
print v(o2lin)
print v(o3lin)
print v(o4lin)
print v(o5lin)
print v(o6lin)
print v(o7lin)
print v(o8lin)
alter Vin1 DC -0.856141542120814
alter Vin2 DC -0.727206050653795
alter Vin3 DC 0.364460811489863
alter Vin4 DC -0.885688858575355
alter Vin5 DC -0.445185567245807
alter Vin6 DC -0.815629980654133
alter Vin7 DC -0.428116439307189
alter Vin8 DC -0.0705436924916261
op
print v(o1lin)
print v(o2lin)
print v(o3lin)
print v(o4lin)
print v(o5lin)
print v(o6lin)
print v(o7lin)
print v(o8lin)
alter Vin1 DC 0.272209404848575
alter Vin2 DC 0.475726390019562
alter Vin3 DC -0.151141379221323
alter Vin4 DC -0.710221894161329
alter Vin5 DC -0.816707586725108
alter Vin6 DC 0.527474805638937
alter Vin7 DC -0.525492594085198
alter Vin8 DC -0.623635343450578
op
print v(o1lin)
print v(o2lin)
print v(o3lin)
print v(o4lin)
print v(o5lin)
print v(o6lin)
print v(o7lin)
print v(o8lin)
alter Vin1 DC 0.411897734955232
alter Vin2 DC 0.271168462032734
alter Vin3 DC 0.698439088591534
alter Vin4 DC 0.111368121529147
alter Vin5 DC -0.0431195877767907
alter Vin6 DC -0.14046139832526
alter Vin7 DC 0.55970981250075
alter Vin8 DC -0.865679844624375
op
print v(o1lin)
print v(o2lin)
print v(o3lin)
print v(o4lin)
print v(o5lin)
print v(o6lin)
print v(o7lin)
print v(o8lin)
alter Vin1 DC -0.126590009869789
alter Vin2 DC 0.13055791782326
alter Vin3 DC -0.455087633441712
alter Vin4 DC -0.831111754272967
alter Vin5 DC 0.739080073701486
alter Vin6 DC 0.691437004180502
alter Vin7 DC -0.105011614471692
alter Vin8 DC -0.666263070151612
op
print v(o1lin)
print v(o2lin)
print v(o3lin)
print v(o4lin)
print v(o5lin)
print v(o6lin)
print v(o7lin)
print v(o8lin)
alter Vin1 DC -0.449077439860748
alter Vin2 DC -0.436317111134445
alter Vin3 DC -0.69657137853183
alter Vin4 DC 0.740802721315162
alter Vin5 DC 0.488530474859895
alter Vin6 DC -0.680172636359617
alter Vin7 DC 0.782056994488354
alter Vin8 DC -0.766668144629732
op
print v(o1lin)
print v(o2lin)
print v(o3lin)
print v(o4lin)
print v(o5lin)
print v(o6lin)
print v(o7lin)
print v(o8lin)
alter Vin1 DC 0.454717565427872
alter Vin2 DC 0.565184999231905
alter Vin3 DC 0.899448194969564
alter Vin4 DC -0.821904437839036
alter Vin5 DC 0.0386188280258311
alter Vin6 DC -0.953632143989347
alter Vin7 DC -0.14855132794345
alter Vin8 DC -0.165680085673336
op
print v(o1lin)
print v(o2lin)
print v(o3lin)
print v(o4lin)
print v(o5lin)
print v(o6lin)
print v(o7lin)
print v(o8lin)
alter Vin1 DC 0.133756392326999
alter Vin2 DC 0.200547055313016
alter Vin3 DC 0.013338234861453
alter Vin4 DC 0.825976082826698
alter Vin5 DC 0.0271074455253626
alter Vin6 DC 0.539369750102621
alter Vin7 DC 0.448495071063004
alter Vin8 DC 0.305613736605886
op
print v(o1lin)
print v(o2lin)
print v(o3lin)
print v(o4lin)
print v(o5lin)
print v(o6lin)
print v(o7lin)
print v(o8lin)
alter Vin1 DC -0.593761862315402
alter Vin2 DC 0.470423669922485
alter Vin3 DC 0.033044318096783
alter Vin4 DC 0.280419961858031
alter Vin5 DC -0.470643310349138
alter Vin6 DC 0.58377884853774
alter Vin7 DC 0.710491859426109
alter Vin8 DC 0.656073466438367
op
print v(o1lin)
print v(o2lin)
print v(o3lin)
print v(o4lin)
print v(o5lin)
print v(o6lin)
print v(o7lin)
print v(o8lin)
alter Vin1 DC 0.637037465604473
alter Vin2 DC 0.257177974202413
alter Vin3 DC 0.609801517211941
alter Vin4 DC -0.00795280218159045
alter Vin5 DC -0.462281281700078
alter Vin6 DC 0.805300653861389
alter Vin7 DC -0.492084205832114
alter Vin8 DC 0.755210474047357
op
print v(o1lin)
print v(o2lin)
print v(o3lin)
print v(o4lin)
print v(o5lin)
print v(o6lin)
print v(o7lin)
print v(o8lin)
alter Vin1 DC -0.55488591638336
alter Vin2 DC 0.121534863519349
alter Vin3 DC -0.0923730972754016
alter Vin4 DC 0.089970267317709
alter Vin5 DC -0.0288858552501396
alter Vin6 DC -0.568934970814338
alter Vin7 DC -0.652108665682275
alter Vin8 DC 0.26367555357758
op
print v(o1lin)
print v(o2lin)
print v(o3lin)
print v(o4lin)
print v(o5lin)
print v(o6lin)
print v(o7lin)
print v(o8lin)
alter Vin1 DC 0.399155467836521
alter Vin2 DC -0.80137921936412
alter Vin3 DC 0.890655767927229
alter Vin4 DC -0.877004004631116
alter Vin5 DC 0.701233272020366
alter Vin6 DC -0.962818538322516
alter Vin7 DC 0.00616138784556486
alter Vin8 DC -0.0581686884954764
op
print v(o1lin)
print v(o2lin)
print v(o3lin)
print v(o4lin)
print v(o5lin)
print v(o6lin)
print v(o7lin)
print v(o8lin)
alter Vin1 DC -0.126012904978764
alter Vin2 DC 0.432748123094634
alter Vin3 DC -0.219887771848478
alter Vin4 DC 0.151275556665791
alter Vin5 DC -0.964546857791375
alter Vin6 DC 0.719245318940972
alter Vin7 DC 0.98640117146032
alter Vin8 DC -0.382143189180336
op
print v(o1lin)
print v(o2lin)
print v(o3lin)
print v(o4lin)
print v(o5lin)
print v(o6lin)
print v(o7lin)
print v(o8lin)
alter Vin1 DC 0.268641874999028
alter Vin2 DC -0.512443007700015
alter Vin3 DC -0.0524938031716489
alter Vin4 DC -0.245460859076648
alter Vin5 DC 0.0111462860842011
alter Vin6 DC 0.600971369965415
alter Vin7 DC -0.0985434270643095
alter Vin8 DC 0.222076733914137
op
print v(o1lin)
print v(o2lin)
print v(o3lin)
print v(o4lin)
print v(o5lin)
print v(o6lin)
print v(o7lin)
print v(o8lin)
alter Vin1 DC -0.752919517994807
alter Vin2 DC 0.28764320679232
alter Vin3 DC -0.659075179377498
alter Vin4 DC -0.585835901044915
alter Vin5 DC -0.169330568302335
alter Vin6 DC 0.297023198385389
alter Vin7 DC -0.538475177381862
alter Vin8 DC -0.931397387364033
op
print v(o1lin)
print v(o2lin)
print v(o3lin)
print v(o4lin)
print v(o5lin)
print v(o6lin)
print v(o7lin)
print v(o8lin)
alter Vin1 DC -0.720770457854014
alter Vin2 DC -0.403312942515066
alter Vin3 DC 0.165775987091576
alter Vin4 DC 0.352510486686998
alter Vin5 DC 0.403691769461902
alter Vin6 DC 0.259228453875241
alter Vin7 DC 0.842187325920168
alter Vin8 DC 0.222303621475045
op
print v(o1lin)
print v(o2lin)
print v(o3lin)
print v(o4lin)
print v(o5lin)
print v(o6lin)
print v(o7lin)
print v(o8lin)
alter Vin1 DC -0.675627124434453
alter Vin2 DC 0.662273902665695
alter Vin3 DC -0.710470376374603
alter Vin4 DC -0.372293517951549
alter Vin5 DC 0.0685603424675043
alter Vin6 DC 0.103011106342232
alter Vin7 DC 0.945272630887952
alter Vin8 DC -0.276810732245984
op
print v(o1lin)
print v(o2lin)
print v(o3lin)
print v(o4lin)
print v(o5lin)
print v(o6lin)
print v(o7lin)
print v(o8lin)
alter Vin1 DC 0.944407360227872
alter Vin2 DC -0.166073420892938
alter Vin3 DC -0.00425005976321335
alter Vin4 DC -0.32084145184742
alter Vin5 DC 0.204511794775159
alter Vin6 DC -0.593532594991577
alter Vin7 DC 0.0216092313863101
alter Vin8 DC -0.145463816859269
op
print v(o1lin)
print v(o2lin)
print v(o3lin)
print v(o4lin)
print v(o5lin)
print v(o6lin)
print v(o7lin)
print v(o8lin)
alter Vin1 DC 0.214832054511103
alter Vin2 DC 0.850374985828614
alter Vin3 DC -0.11816480639449
alter Vin4 DC -0.26224376878421
alter Vin5 DC 0.114361964170003
alter Vin6 DC 0.019221002035295
alter Vin7 DC 0.594702947583303
alter Vin8 DC -0.0341042092087176
op
print v(o1lin)
print v(o2lin)
print v(o3lin)
print v(o4lin)
print v(o5lin)
print v(o6lin)
print v(o7lin)
print v(o8lin)
alter Vin1 DC 0.305063282990849
alter Vin2 DC -0.986094853147567
alter Vin3 DC -0.23074840739552
alter Vin4 DC 0.649645794359179
alter Vin5 DC 0.122612067186631
alter Vin6 DC 0.566780113788777
alter Vin7 DC -0.298415842649093
alter Vin8 DC 0.501759350377662
op
print v(o1lin)
print v(o2lin)
print v(o3lin)
print v(o4lin)
print v(o5lin)
print v(o6lin)
print v(o7lin)
print v(o8lin)
alter Vin1 DC 0.768571709980714
alter Vin2 DC -0.975152295900377
alter Vin3 DC 0.419447035734241
alter Vin4 DC -0.660643842702582
alter Vin5 DC -0.474763907059637
alter Vin6 DC 0.0667464130905706
alter Vin7 DC -0.756201279780879
alter Vin8 DC 0.92300487640956
op
print v(o1lin)
print v(o2lin)
print v(o3lin)
print v(o4lin)
print v(o5lin)
print v(o6lin)
print v(o7lin)
print v(o8lin)
alter Vin1 DC 0.504834322405869
alter Vin2 DC 0.898527391885995
alter Vin3 DC -0.980784114184677
alter Vin4 DC -0.859360317805446
alter Vin5 DC -0.878509557413368
alter Vin6 DC -0.770763113037416
alter Vin7 DC 0.244449333502032
alter Vin8 DC -0.425234668454626
op
print v(o1lin)
print v(o2lin)
print v(o3lin)
print v(o4lin)
print v(o5lin)
print v(o6lin)
print v(o7lin)
print v(o8lin)
alter Vin1 DC 0.743718075171262
alter Vin2 DC -0.300939751856364
alter Vin3 DC -0.25667689414887
alter Vin4 DC -0.506772442583438
alter Vin5 DC 0.890780567456551
alter Vin6 DC 0.89724980365584
alter Vin7 DC 0.039638577133148
alter Vin8 DC -0.758275789622854
op
print v(o1lin)
print v(o2lin)
print v(o3lin)
print v(o4lin)
print v(o5lin)
print v(o6lin)
print v(o7lin)
print v(o8lin)
alter Vin1 DC 0.884802929478638
alter Vin2 DC -0.886373120430302
alter Vin3 DC -0.834010337122986
alter Vin4 DC -0.286322910281529
alter Vin5 DC 0.938835661640086
alter Vin6 DC 0.0863022438731382
alter Vin7 DC 0.866156382848701
alter Vin8 DC 0.821870572297505
op
print v(o1lin)
print v(o2lin)
print v(o3lin)
print v(o4lin)
print v(o5lin)
print v(o6lin)
print v(o7lin)
print v(o8lin)
alter Vin1 DC -0.223003644742757
alter Vin2 DC 0.65588572970158
alter Vin3 DC -0.0853125790281513
alter Vin4 DC 0.947959674244657
alter Vin5 DC -0.641734874206045
alter Vin6 DC 0.605256984621979
alter Vin7 DC -0.495919729511646
alter Vin8 DC 0.393319837656588
op
print v(o1lin)
print v(o2lin)
print v(o3lin)
print v(o4lin)
print v(o5lin)
print v(o6lin)
print v(o7lin)
print v(o8lin)
alter Vin1 DC -0.880621598086048
alter Vin2 DC -0.590721869711439
alter Vin3 DC -0.935315345853632
alter Vin4 DC -0.43291423346305
alter Vin5 DC 0.775205866408331
alter Vin6 DC 0.944690218001333
alter Vin7 DC -0.12076581019415
alter Vin8 DC -0.776222970187939
op
print v(o1lin)
print v(o2lin)
print v(o3lin)
print v(o4lin)
print v(o5lin)
print v(o6lin)
print v(o7lin)
print v(o8lin)
alter Vin1 DC -0.109703784354431
alter Vin2 DC 0.616738017407125
alter Vin3 DC -0.06378624702986
alter Vin4 DC 0.935465636450405
alter Vin5 DC -0.205269357855397
alter Vin6 DC -0.117148389684096
alter Vin7 DC 0.0288520032839388
alter Vin8 DC 0.918014457383641
op
print v(o1lin)
print v(o2lin)
print v(o3lin)
print v(o4lin)
print v(o5lin)
print v(o6lin)
print v(o7lin)
print v(o8lin)
alter Vin1 DC 0.967058259687615
alter Vin2 DC -0.589533366238531
alter Vin3 DC -0.574479669203957
alter Vin4 DC -0.348996068013492
alter Vin5 DC -0.300441550140546
alter Vin6 DC -0.267380165062296
alter Vin7 DC 0.875614791915071
alter Vin8 DC 0.330967377249975
op
print v(o1lin)
print v(o2lin)
print v(o3lin)
print v(o4lin)
print v(o5lin)
print v(o6lin)
print v(o7lin)
print v(o8lin)
alter Vin1 DC -0.753331059504649
alter Vin2 DC -0.259448041474382
alter Vin3 DC -0.80378380712422
alter Vin4 DC 0.667937662528149
alter Vin5 DC -0.710726977381275
alter Vin6 DC -0.876399126661123
alter Vin7 DC 0.491328899484676
alter Vin8 DC -0.430709993435946
op
print v(o1lin)
print v(o2lin)
print v(o3lin)
print v(o4lin)
print v(o5lin)
print v(o6lin)
print v(o7lin)
print v(o8lin)
alter Vin1 DC 0.715489998851547
alter Vin2 DC -0.573143714340036
alter Vin3 DC -0.0559830557903258
alter Vin4 DC 0.648901385908604
alter Vin5 DC -0.133059746358619
alter Vin6 DC -0.961409889206132
alter Vin7 DC 0.425018544291655
alter Vin8 DC -0.691726259809178
op
print v(o1lin)
print v(o2lin)
print v(o3lin)
print v(o4lin)
print v(o5lin)
print v(o6lin)
print v(o7lin)
print v(o8lin)
alter Vin1 DC 0.723016947608895
alter Vin2 DC -0.184470232257393
alter Vin3 DC 0.941094474736244
alter Vin4 DC 0.713505388535356
alter Vin5 DC -0.786728057591885
alter Vin6 DC -0.447607340634308
alter Vin7 DC 0.844001415405583
alter Vin8 DC 0.268749874259759
op
print v(o1lin)
print v(o2lin)
print v(o3lin)
print v(o4lin)
print v(o5lin)
print v(o6lin)
print v(o7lin)
print v(o8lin)
alter Vin1 DC 0.0928336352089341
alter Vin2 DC -0.0295633609741144
alter Vin3 DC 0.0964993425829377
alter Vin4 DC -0.849751996747012
alter Vin5 DC -0.173184547201248
alter Vin6 DC -0.397406627770801
alter Vin7 DC -0.572345494002707
alter Vin8 DC 0.527006793946585
op
print v(o1lin)
print v(o2lin)
print v(o3lin)
print v(o4lin)
print v(o5lin)
print v(o6lin)
print v(o7lin)
print v(o8lin)
alter Vin1 DC -0.363341421103325
alter Vin2 DC 0.963255138880527
alter Vin3 DC 0.736732434995271
alter Vin4 DC 0.414260546839728
alter Vin5 DC 0.461139651159544
alter Vin6 DC -0.552936530816352
alter Vin7 DC -0.620722746626647
alter Vin8 DC 0.801178096416023
op
print v(o1lin)
print v(o2lin)
print v(o3lin)
print v(o4lin)
print v(o5lin)
print v(o6lin)
print v(o7lin)
print v(o8lin)
alter Vin1 DC -0.608982712285187
alter Vin2 DC 0.978350440093152
alter Vin3 DC -0.133415858907505
alter Vin4 DC 0.740996704707666
alter Vin5 DC -0.968845626006452
alter Vin6 DC 0.440741675964764
alter Vin7 DC 0.376096139448323
alter Vin8 DC 0.441154685163441
op
print v(o1lin)
print v(o2lin)
print v(o3lin)
print v(o4lin)
print v(o5lin)
print v(o6lin)
print v(o7lin)
print v(o8lin)
alter Vin1 DC -0.102497670598361
alter Vin2 DC 0.184222962741174
alter Vin3 DC -0.932683687322114
alter Vin4 DC -0.61746594224104
alter Vin5 DC -0.137229851511497
alter Vin6 DC 0.692598756091095
alter Vin7 DC -0.768688574953764
alter Vin8 DC -0.521807357299197
op
print v(o1lin)
print v(o2lin)
print v(o3lin)
print v(o4lin)
print v(o5lin)
print v(o6lin)
print v(o7lin)
print v(o8lin)
alter Vin1 DC -0.36296044579379
alter Vin2 DC 0.910510189199092
alter Vin3 DC -0.553531520682932
alter Vin4 DC 0.382251236476714
alter Vin5 DC -0.88421955317878
alter Vin6 DC -0.91582132921143
alter Vin7 DC -0.599951695544742
alter Vin8 DC 0.685929421262413
op
print v(o1lin)
print v(o2lin)
print v(o3lin)
print v(o4lin)
print v(o5lin)
print v(o6lin)
print v(o7lin)
print v(o8lin)
alter Vin1 DC 0.994351700893435
alter Vin2 DC -0.784956039492465
alter Vin3 DC -0.667540825621632
alter Vin4 DC -0.565979885526799
alter Vin5 DC 0.708321096351053
alter Vin6 DC -0.171733570239699
alter Vin7 DC -0.874585761711283
alter Vin8 DC 0.775003478700682
op
print v(o1lin)
print v(o2lin)
print v(o3lin)
print v(o4lin)
print v(o5lin)
print v(o6lin)
print v(o7lin)
print v(o8lin)
alter Vin1 DC 0.685343571118099
alter Vin2 DC 0.548641130371327
alter Vin3 DC 0.343786443252652
alter Vin4 DC 0.631425433636028
alter Vin5 DC 0.249343580368026
alter Vin6 DC 0.13975445762382
alter Vin7 DC 0.668148036839925
alter Vin8 DC 0.362803099504523
op
print v(o1lin)
print v(o2lin)
print v(o3lin)
print v(o4lin)
print v(o5lin)
print v(o6lin)
print v(o7lin)
print v(o8lin)
alter Vin1 DC -0.300423345218567
alter Vin2 DC -0.970022177379505
alter Vin3 DC 0.881420706997645
alter Vin4 DC 0.722824279089657
alter Vin5 DC 0.289299719498669
alter Vin6 DC -0.455211063527652
alter Vin7 DC 0.689676136202592
alter Vin8 DC 0.34821496085565
op
print v(o1lin)
print v(o2lin)
print v(o3lin)
print v(o4lin)
print v(o5lin)
print v(o6lin)
print v(o7lin)
print v(o8lin)
alter Vin1 DC -0.124649746486052
alter Vin2 DC -0.137608531559948
alter Vin3 DC 0.0962869740254371
alter Vin4 DC -0.377115135130913
alter Vin5 DC -0.363106941723766
alter Vin6 DC -0.0957582860830934
alter Vin7 DC 0.603359087933046
alter Vin8 DC -0.020331322359141
op
print v(o1lin)
print v(o2lin)
print v(o3lin)
print v(o4lin)
print v(o5lin)
print v(o6lin)
print v(o7lin)
print v(o8lin)
alter Vin1 DC -0.86162886227129
alter Vin2 DC -0.513032870828304
alter Vin3 DC -0.347007155878506
alter Vin4 DC -0.228259921577951
alter Vin5 DC -0.091325373488929
alter Vin6 DC 0.898559717386926
alter Vin7 DC -0.233328962125712
alter Vin8 DC -0.0994171520229905
op
print v(o1lin)
print v(o2lin)
print v(o3lin)
print v(o4lin)
print v(o5lin)
print v(o6lin)
print v(o7lin)
print v(o8lin)
alter Vin1 DC 0.188273161278574
alter Vin2 DC -0.00140062601219748
alter Vin3 DC 0.905458254240225
alter Vin4 DC 0.724827956330299
alter Vin5 DC 0.0686092982854971
alter Vin6 DC 0.852619094996975
alter Vin7 DC 0.07288807305788
alter Vin8 DC 0.517628551390212
op
print v(o1lin)
print v(o2lin)
print v(o3lin)
print v(o4lin)
print v(o5lin)
print v(o6lin)
print v(o7lin)
print v(o8lin)
alter Vin1 DC 0.908840595697803
alter Vin2 DC 0.98307154542259
alter Vin3 DC -0.359040197769828
alter Vin4 DC -0.0921049550405506
alter Vin5 DC 0.342782663515992
alter Vin6 DC 0.765085727886263
alter Vin7 DC -0.985672685771185
alter Vin8 DC -0.755165430192914
op
print v(o1lin)
print v(o2lin)
print v(o3lin)
print v(o4lin)
print v(o5lin)
print v(o6lin)
print v(o7lin)
print v(o8lin)
alter Vin1 DC -0.883958051671711
alter Vin2 DC 0.561611999034835
alter Vin3 DC -0.633958116443294
alter Vin4 DC 0.371120632433012
alter Vin5 DC 0.389552340591143
alter Vin6 DC -0.786339763280527
alter Vin7 DC -0.575895448487745
alter Vin8 DC 0.936117807175731
op
print v(o1lin)
print v(o2lin)
print v(o3lin)
print v(o4lin)
print v(o5lin)
print v(o6lin)
print v(o7lin)
print v(o8lin)
alter Vin1 DC 0.556841635643767
alter Vin2 DC 0.592208069208608
alter Vin3 DC 0.501505639496979
alter Vin4 DC -0.969089495839784
alter Vin5 DC 0.934970912696647
alter Vin6 DC 0.464785683756086
alter Vin7 DC 0.31921610206853
alter Vin8 DC -0.910688104073043
op
print v(o1lin)
print v(o2lin)
print v(o3lin)
print v(o4lin)
print v(o5lin)
print v(o6lin)
print v(o7lin)
print v(o8lin)
alter Vin1 DC -0.800765526465067
alter Vin2 DC -0.226978881269668
alter Vin3 DC -0.232453768672959
alter Vin4 DC -0.0579327265927458
alter Vin5 DC 0.995792096858391
alter Vin6 DC 0.396876040981569
alter Vin7 DC 0.230748062838207
alter Vin8 DC 0.496809277748191
op
print v(o1lin)
print v(o2lin)
print v(o3lin)
print v(o4lin)
print v(o5lin)
print v(o6lin)
print v(o7lin)
print v(o8lin)
alter Vin1 DC 0.871576576823178
alter Vin2 DC -0.174545692692201
alter Vin3 DC 0.506589324822514
alter Vin4 DC 0.460811249066947
alter Vin5 DC -0.834738865770672
alter Vin6 DC -0.292036458242669
alter Vin7 DC -0.583927886907676
alter Vin8 DC 0.208604791221493
op
print v(o1lin)
print v(o2lin)
print v(o3lin)
print v(o4lin)
print v(o5lin)
print v(o6lin)
print v(o7lin)
print v(o8lin)
alter Vin1 DC -0.143196243366125
alter Vin2 DC -0.87592393924771
alter Vin3 DC -0.164808299494288
alter Vin4 DC 0.191495536177083
alter Vin5 DC -0.757028581145079
alter Vin6 DC -0.0387517675468791
alter Vin7 DC -0.630151012677438
alter Vin8 DC -0.423454741806106
op
print v(o1lin)
print v(o2lin)
print v(o3lin)
print v(o4lin)
print v(o5lin)
print v(o6lin)
print v(o7lin)
print v(o8lin)
alter Vin1 DC 0.862026432600527
alter Vin2 DC 0.746484056202354
alter Vin3 DC 0.573519069507732
alter Vin4 DC 0.423735659179906
alter Vin5 DC -0.913311215263303
alter Vin6 DC 0.24285226624038
alter Vin7 DC 0.150674752736701
alter Vin8 DC -0.0129662438442235
op
print v(o1lin)
print v(o2lin)
print v(o3lin)
print v(o4lin)
print v(o5lin)
print v(o6lin)
print v(o7lin)
print v(o8lin)
alter Vin1 DC -0.641392561847447
alter Vin2 DC -0.0815328671818023
alter Vin3 DC 0.0611624005195528
alter Vin4 DC -0.41856078555336
alter Vin5 DC 0.135446545275017
alter Vin6 DC 0.140200226266054
alter Vin7 DC 0.00041286652346284
alter Vin8 DC -0.462843193894793
op
print v(o1lin)
print v(o2lin)
print v(o3lin)
print v(o4lin)
print v(o5lin)
print v(o6lin)
print v(o7lin)
print v(o8lin)
alter Vin1 DC -0.452897352306572
alter Vin2 DC -0.176858739709828
alter Vin3 DC -0.37431216847572
alter Vin4 DC -0.215502522039748
alter Vin5 DC 0.478456605991583
alter Vin6 DC 0.98962299150599
alter Vin7 DC -0.103981225055042
alter Vin8 DC -0.976624339711988
op
print v(o1lin)
print v(o2lin)
print v(o3lin)
print v(o4lin)
print v(o5lin)
print v(o6lin)
print v(o7lin)
print v(o8lin)
alter Vin1 DC 0.14682105323094
alter Vin2 DC 0.097111464704261
alter Vin3 DC -0.44636046313809
alter Vin4 DC 0.810653825918775
alter Vin5 DC 0.957649829669894
alter Vin6 DC 0.285495123907136
alter Vin7 DC -0.353718115585669
alter Vin8 DC -0.597743080928746
op
print v(o1lin)
print v(o2lin)
print v(o3lin)
print v(o4lin)
print v(o5lin)
print v(o6lin)
print v(o7lin)
print v(o8lin)
alter Vin1 DC 0.799749572748605
alter Vin2 DC 0.575335281948368
alter Vin3 DC 0.278647353896741
alter Vin4 DC 0.642157690767751
alter Vin5 DC -0.258964539814737
alter Vin6 DC 0.717661717998144
alter Vin7 DC 0.430899603330582
alter Vin8 DC 0.012318362253962
op
print v(o1lin)
print v(o2lin)
print v(o3lin)
print v(o4lin)
print v(o5lin)
print v(o6lin)
print v(o7lin)
print v(o8lin)
alter Vin1 DC -0.307486322320982
alter Vin2 DC -0.319548302378557
alter Vin3 DC 0.211791248068885
alter Vin4 DC 0.845241698241803
alter Vin5 DC -0.463249765334921
alter Vin6 DC 0.0485886812171226
alter Vin7 DC -0.103936753790181
alter Vin8 DC -0.865204327490351
op
print v(o1lin)
print v(o2lin)
print v(o3lin)
print v(o4lin)
print v(o5lin)
print v(o6lin)
print v(o7lin)
print v(o8lin)
alter Vin1 DC 0.062420898729119
alter Vin2 DC -0.0193679787725993
alter Vin3 DC 0.779967365516065
alter Vin4 DC -0.445347890216201
alter Vin5 DC -0.408295953136842
alter Vin6 DC 0.0669734399489457
alter Vin7 DC 0.36460008270435
alter Vin8 DC 0.0413266425605954
op
print v(o1lin)
print v(o2lin)
print v(o3lin)
print v(o4lin)
print v(o5lin)
print v(o6lin)
print v(o7lin)
print v(o8lin)
alter Vin1 DC -0.267146833312764
alter Vin2 DC 0.52715969475383
alter Vin3 DC -0.449549004008985
alter Vin4 DC 0.583336795470641
alter Vin5 DC 0.599911327542717
alter Vin6 DC 0.954624105044853
alter Vin7 DC -0.114253218962592
alter Vin8 DC -0.547193415474915
op
print v(o1lin)
print v(o2lin)
print v(o3lin)
print v(o4lin)
print v(o5lin)
print v(o6lin)
print v(o7lin)
print v(o8lin)
alter Vin1 DC -0.389481210934692
alter Vin2 DC 0.978972373866856
alter Vin3 DC 0.736882694867983
alter Vin4 DC -0.466260111178288
alter Vin5 DC -0.542864676674601
alter Vin6 DC 0.371729430458118
alter Vin7 DC 0.931880498636657
alter Vin8 DC -0.0287985065842913
op
print v(o1lin)
print v(o2lin)
print v(o3lin)
print v(o4lin)
print v(o5lin)
print v(o6lin)
print v(o7lin)
print v(o8lin)
alter Vin1 DC 0.165917759022735
alter Vin2 DC 0.774471459787355
alter Vin3 DC 0.0622867845657151
alter Vin4 DC -0.0699713982283832
alter Vin5 DC -0.229155806056746
alter Vin6 DC 0.177297953774574
alter Vin7 DC -0.945631295111314
alter Vin8 DC -0.794225005416913
op
print v(o1lin)
print v(o2lin)
print v(o3lin)
print v(o4lin)
print v(o5lin)
print v(o6lin)
print v(o7lin)
print v(o8lin)
alter Vin1 DC 0.108446356577655
alter Vin2 DC -0.546004369336922
alter Vin3 DC 0.602347309167057
alter Vin4 DC -0.736715004071992
alter Vin5 DC 0.910011323546865
alter Vin6 DC -0.0530688942350068
alter Vin7 DC -0.738391658819687
alter Vin8 DC -0.454526744419986
op
print v(o1lin)
print v(o2lin)
print v(o3lin)
print v(o4lin)
print v(o5lin)
print v(o6lin)
print v(o7lin)
print v(o8lin)
alter Vin1 DC -0.420039015604011
alter Vin2 DC -0.22649273566142
alter Vin3 DC -0.918769361641439
alter Vin4 DC -0.0871538967396095
alter Vin5 DC 0.263305075470568
alter Vin6 DC -0.21643459780821
alter Vin7 DC 0.754988933880053
alter Vin8 DC 0.623521294707185
op
print v(o1lin)
print v(o2lin)
print v(o3lin)
print v(o4lin)
print v(o5lin)
print v(o6lin)
print v(o7lin)
print v(o8lin)
alter Vin1 DC 0.862957862167934
alter Vin2 DC 0.0726043385717228
alter Vin3 DC 0.549307714997981
alter Vin4 DC 0.328112664599901
alter Vin5 DC 0.293125543226842
alter Vin6 DC 0.398013482962486
alter Vin7 DC -0.203072938645232
alter Vin8 DC 0.0505533171518013
op
print v(o1lin)
print v(o2lin)
print v(o3lin)
print v(o4lin)
print v(o5lin)
print v(o6lin)
print v(o7lin)
print v(o8lin)
alter Vin1 DC 0.863571861528392
alter Vin2 DC -0.924885201067526
alter Vin3 DC -0.131432328807413
alter Vin4 DC -0.783765129484709
alter Vin5 DC 0.230945412015412
alter Vin6 DC -0.926174886660544
alter Vin7 DC 0.206455491325392
alter Vin8 DC -0.998026063532351
op
print v(o1lin)
print v(o2lin)
print v(o3lin)
print v(o4lin)
print v(o5lin)
print v(o6lin)
print v(o7lin)
print v(o8lin)
alter Vin1 DC 0.893812235704942
alter Vin2 DC -0.300700423486417
alter Vin3 DC 0.903959110455478
alter Vin4 DC -0.783904068500062
alter Vin5 DC 0.0979079781699734
alter Vin6 DC 0.169312394860581
alter Vin7 DC -0.749885628897063
alter Vin8 DC 0.959160514661866
op
print v(o1lin)
print v(o2lin)
print v(o3lin)
print v(o4lin)
print v(o5lin)
print v(o6lin)
print v(o7lin)
print v(o8lin)
alter Vin1 DC -0.569899817836385
alter Vin2 DC 0.820536555260425
alter Vin3 DC 0.738712373435252
alter Vin4 DC -0.668859247416257
alter Vin5 DC -0.3868820825104
alter Vin6 DC 0.902458850677468
alter Vin7 DC -0.776335358625364
alter Vin8 DC -0.520857617322994
op
print v(o1lin)
print v(o2lin)
print v(o3lin)
print v(o4lin)
print v(o5lin)
print v(o6lin)
print v(o7lin)
print v(o8lin)
alter Vin1 DC -0.344630606546443
alter Vin2 DC 0.751972254804566
alter Vin3 DC 0.766446553611919
alter Vin4 DC 0.561532623735899
alter Vin5 DC 0.789601565204997
alter Vin6 DC -0.934365760527631
alter Vin7 DC -0.410054160882114
alter Vin8 DC 0.303950378917592
op
print v(o1lin)
print v(o2lin)
print v(o3lin)
print v(o4lin)
print v(o5lin)
print v(o6lin)
print v(o7lin)
print v(o8lin)
alter Vin1 DC -0.895640551816017
alter Vin2 DC 0.34442563707561
alter Vin3 DC 0.623865545104434
alter Vin4 DC 0.492889957367848
alter Vin5 DC 0.781346022963764
alter Vin6 DC -0.523636362853138
alter Vin7 DC 0.948271792776693
alter Vin8 DC -0.993269415639262
op
print v(o1lin)
print v(o2lin)
print v(o3lin)
print v(o4lin)
print v(o5lin)
print v(o6lin)
print v(o7lin)
print v(o8lin)
alter Vin1 DC -0.677723402619157
alter Vin2 DC 0.924287407689962
alter Vin3 DC -0.416907999381625
alter Vin4 DC 0.678229038278689
alter Vin5 DC 0.422078877302989
alter Vin6 DC -0.119989344078895
alter Vin7 DC -0.472826597509565
alter Vin8 DC 0.929475305715469
op
print v(o1lin)
print v(o2lin)
print v(o3lin)
print v(o4lin)
print v(o5lin)
print v(o6lin)
print v(o7lin)
print v(o8lin)
alter Vin1 DC -0.627884035364467
alter Vin2 DC 0.646609460738773
alter Vin3 DC 0.556100641422703
alter Vin4 DC 0.876286949569814
alter Vin5 DC 0.998306592902051
alter Vin6 DC -0.516744215011605
alter Vin7 DC -0.406037152045487
alter Vin8 DC 0.706218774915153
op
print v(o1lin)
print v(o2lin)
print v(o3lin)
print v(o4lin)
print v(o5lin)
print v(o6lin)
print v(o7lin)
print v(o8lin)
.endc

.end
