* Experiment 26 miller_tia open-loop / buffer characterization
* Experiment 26 MOS primitive. Models included, not copied.
.include "C:/ngspice/examples/xspice/see/CMOSOpAmp/modelcard.nmos"
.include "C:/ngspice/examples/xspice/see/CMOSOpAmp/modelcard.pmos"

.subckt NCH D G S B W=1u L=1.4u m=1
MN1 D G S B N1 W={W} L={L} M={m} AS={3*L*W} AD={3*L*W} PS={6*L+W} PD={6*L+W}
.ends NCH

.subckt PCH D G S B W=1u L=1.4u m=1
MP1 D G S B P1 W={W} L={L} M={m} AS={3*L*W} AD={3*L*W} PS={6*L+W} PD={6*L+W}
.ends PCH

* Two-stage Miller CMOS OTA. Topology from ngspice CMOS-OP1, dual supply.
* Bodies to rails. Analog ground is node 0.
.subckt miller_tia inp inn out vdd vss
.param L=1.4u WD=2.8u WT=5.0u WL=2.8u
+ WOP=14.5u WON=17.4u WDI=5.0u
+ MD=2 MT=2 MO=4 CC=2p IBIAS=40u DW=0
Ibias vdd vb {IBIAS}
Xdiode vb vb vss vss NCH W={WDI} L={L} m={MT}
Xtail vs vb vss vss NCH W={WT} L={L} m={MT}
* DW unbalances the pair (explicit geometric mismatch, not a foundry PDF)
Xdp dplus inp vs vss NCH W={WD*(1+DW)} L={L} m={MD}
Xdn dmin inn vs vss NCH W={WD*(1-DW)} L={L} m={MD}
Xlp dplus dplus vdd vdd PCH W={WL} L={L} m={MD}
Xln dmin dplus vdd vdd PCH W={WL} L={L} m={MD}
Xop out dmin vdd vdd PCH W={WOP} L={L} m={MO}
Xon out vb vss vss NCH W={WON} L={L} m={MO}
Cc dmin out {CC}
.ends miller_tia

* 5-transistor OTA used as a slow integrator (capacitive load).
.subckt servo_ota inp inn out vdd vss
.param L=1.4u WD=2.8u WT=5.0u WL=2.8u
+ MD=1 MT=1 IBIAS=2u DW=0
Ibias vdd vb {IBIAS}
Xdiode vb vb vss vss NCH W={WT} L={L} m={MT}
Xtail vs vb vss vss NCH W={WT} L={L} m={MT}
Xdp dplus inp vs vss NCH W={WD*(1+DW)} L={L} m={MD}
Xdn dmin inn vs vss NCH W={WD*(1-DW)} L={L} m={MD}
Xlp dplus dplus vdd vdd PCH W={WL} L={L} m={MD}
Xln out dplus vdd vdd PCH W={WL} L={L} m={MD}
.ends servo_ota

Vdd vdd 0 DC 2.5
Vss vss 0 DC -2.5
.temp 27
Vin inp 0 DC 0 AC 1
Xbuf inp inn out vdd vss miller_tia MD=2 MT=2 MO=4 CC=2e-12 IBIAS=4e-05 DW=0
* unity-gain buffer: inn tied to out
Rfb out inn 1
Cl out 0 1p

.control
set numdgt=15
op
print v(out)
print v(inn)
print i(Vdd)
print i(Vss)
tf v(out) Vin
ac dec 20 1 100Meg
print v(out)
.endc
.end
