* Experiment 54 w10_4s4p tt_mm draw 13 A=1e6 · model AGAUSS
* PDK sky130A open_pdks 1689ac3f2dc763876eaf967227c7dfe831b031ae
* Frozen weights were not edited. SPICE is not Python-corrected.
.lib "C:/dev/pdk/sky130A/libs.tech/ngspice/sky130.lib.spice" tt_mm
.temp 27

* Experiment 22 isolated TIA neuron n1
* frozen n=32 L1=6.7601697 b=0.0322130531942455
* A=1000000 vos=0 Ileak=0 Rout=0 fp=0 invertA=1e+07
* Behavioral TIA. Not transistor-level. Weights were not edited.
* shape: 32 -> 1 (linear Vlin vs z unless ReLU requested)

Vin1 in1 0 DC 0.288635987619693
Vin2 in2 0 DC 0.653552961415873
* passive invert in2 -> in2n: R2/R1=1.0000002 closed-loop -1 at A=1e+07
* PDK sky130_fd_pr__res_xhigh_po Rinv2ia W=10 L=49.614372
* tile Rinv2ia 4s x 4p same W=10 L=49.614372
XRinv2iap0s0 in2 Rinv2iat0s0 0 sky130_fd_pr__res_xhigh_po w=10 l=49.614372
XRinv2iap0s1 Rinv2iat0s0 Rinv2iat0s1 0 sky130_fd_pr__res_xhigh_po w=10 l=49.614372
XRinv2iap0s2 Rinv2iat0s1 Rinv2iat0s2 0 sky130_fd_pr__res_xhigh_po w=10 l=49.614372
XRinv2iap0s3 Rinv2iat0s2 inv2m 0 sky130_fd_pr__res_xhigh_po w=10 l=49.614372
XRinv2iap1s0 in2 Rinv2iat1s0 0 sky130_fd_pr__res_xhigh_po w=10 l=49.614372
XRinv2iap1s1 Rinv2iat1s0 Rinv2iat1s1 0 sky130_fd_pr__res_xhigh_po w=10 l=49.614372
XRinv2iap1s2 Rinv2iat1s1 Rinv2iat1s2 0 sky130_fd_pr__res_xhigh_po w=10 l=49.614372
XRinv2iap1s3 Rinv2iat1s2 inv2m 0 sky130_fd_pr__res_xhigh_po w=10 l=49.614372
XRinv2iap2s0 in2 Rinv2iat2s0 0 sky130_fd_pr__res_xhigh_po w=10 l=49.614372
XRinv2iap2s1 Rinv2iat2s0 Rinv2iat2s1 0 sky130_fd_pr__res_xhigh_po w=10 l=49.614372
XRinv2iap2s2 Rinv2iat2s1 Rinv2iat2s2 0 sky130_fd_pr__res_xhigh_po w=10 l=49.614372
XRinv2iap2s3 Rinv2iat2s2 inv2m 0 sky130_fd_pr__res_xhigh_po w=10 l=49.614372
XRinv2iap3s0 in2 Rinv2iat3s0 0 sky130_fd_pr__res_xhigh_po w=10 l=49.614372
XRinv2iap3s1 Rinv2iat3s0 Rinv2iat3s1 0 sky130_fd_pr__res_xhigh_po w=10 l=49.614372
XRinv2iap3s2 Rinv2iat3s1 Rinv2iat3s2 0 sky130_fd_pr__res_xhigh_po w=10 l=49.614372
XRinv2iap3s3 Rinv2iat3s2 inv2m 0 sky130_fd_pr__res_xhigh_po w=10 l=49.614372
* PDK sky130_fd_pr__res_xhigh_po Rinv2ib W=10 L=49.614382
* tile Rinv2ib 4s x 4p same W=10 L=49.614382
XRinv2ibp0s0 in2n Rinv2ibt0s0 0 sky130_fd_pr__res_xhigh_po w=10 l=49.614382
XRinv2ibp0s1 Rinv2ibt0s0 Rinv2ibt0s1 0 sky130_fd_pr__res_xhigh_po w=10 l=49.614382
XRinv2ibp0s2 Rinv2ibt0s1 Rinv2ibt0s2 0 sky130_fd_pr__res_xhigh_po w=10 l=49.614382
XRinv2ibp0s3 Rinv2ibt0s2 inv2m 0 sky130_fd_pr__res_xhigh_po w=10 l=49.614382
XRinv2ibp1s0 in2n Rinv2ibt1s0 0 sky130_fd_pr__res_xhigh_po w=10 l=49.614382
XRinv2ibp1s1 Rinv2ibt1s0 Rinv2ibt1s1 0 sky130_fd_pr__res_xhigh_po w=10 l=49.614382
XRinv2ibp1s2 Rinv2ibt1s1 Rinv2ibt1s2 0 sky130_fd_pr__res_xhigh_po w=10 l=49.614382
XRinv2ibp1s3 Rinv2ibt1s2 inv2m 0 sky130_fd_pr__res_xhigh_po w=10 l=49.614382
XRinv2ibp2s0 in2n Rinv2ibt2s0 0 sky130_fd_pr__res_xhigh_po w=10 l=49.614382
XRinv2ibp2s1 Rinv2ibt2s0 Rinv2ibt2s1 0 sky130_fd_pr__res_xhigh_po w=10 l=49.614382
XRinv2ibp2s2 Rinv2ibt2s1 Rinv2ibt2s2 0 sky130_fd_pr__res_xhigh_po w=10 l=49.614382
XRinv2ibp2s3 Rinv2ibt2s2 inv2m 0 sky130_fd_pr__res_xhigh_po w=10 l=49.614382
XRinv2ibp3s0 in2n Rinv2ibt3s0 0 sky130_fd_pr__res_xhigh_po w=10 l=49.614382
XRinv2ibp3s1 Rinv2ibt3s0 Rinv2ibt3s1 0 sky130_fd_pr__res_xhigh_po w=10 l=49.614382
XRinv2ibp3s2 Rinv2ibt3s1 Rinv2ibt3s2 0 sky130_fd_pr__res_xhigh_po w=10 l=49.614382
XRinv2ibp3s3 Rinv2ibt3s2 inv2m 0 sky130_fd_pr__res_xhigh_po w=10 l=49.614382
Einv2amp in2n 0 0 inv2m 10000000
Vin3 in3 0 DC 1.14933536319878
* passive invert in3 -> in3n: R2/R1=1.0000002 closed-loop -1 at A=1e+07
* PDK sky130_fd_pr__res_xhigh_po Rinv3ia W=10 L=49.614372
* tile Rinv3ia 4s x 4p same W=10 L=49.614372
XRinv3iap0s0 in3 Rinv3iat0s0 0 sky130_fd_pr__res_xhigh_po w=10 l=49.614372
XRinv3iap0s1 Rinv3iat0s0 Rinv3iat0s1 0 sky130_fd_pr__res_xhigh_po w=10 l=49.614372
XRinv3iap0s2 Rinv3iat0s1 Rinv3iat0s2 0 sky130_fd_pr__res_xhigh_po w=10 l=49.614372
XRinv3iap0s3 Rinv3iat0s2 inv3m 0 sky130_fd_pr__res_xhigh_po w=10 l=49.614372
XRinv3iap1s0 in3 Rinv3iat1s0 0 sky130_fd_pr__res_xhigh_po w=10 l=49.614372
XRinv3iap1s1 Rinv3iat1s0 Rinv3iat1s1 0 sky130_fd_pr__res_xhigh_po w=10 l=49.614372
XRinv3iap1s2 Rinv3iat1s1 Rinv3iat1s2 0 sky130_fd_pr__res_xhigh_po w=10 l=49.614372
XRinv3iap1s3 Rinv3iat1s2 inv3m 0 sky130_fd_pr__res_xhigh_po w=10 l=49.614372
XRinv3iap2s0 in3 Rinv3iat2s0 0 sky130_fd_pr__res_xhigh_po w=10 l=49.614372
XRinv3iap2s1 Rinv3iat2s0 Rinv3iat2s1 0 sky130_fd_pr__res_xhigh_po w=10 l=49.614372
XRinv3iap2s2 Rinv3iat2s1 Rinv3iat2s2 0 sky130_fd_pr__res_xhigh_po w=10 l=49.614372
XRinv3iap2s3 Rinv3iat2s2 inv3m 0 sky130_fd_pr__res_xhigh_po w=10 l=49.614372
XRinv3iap3s0 in3 Rinv3iat3s0 0 sky130_fd_pr__res_xhigh_po w=10 l=49.614372
XRinv3iap3s1 Rinv3iat3s0 Rinv3iat3s1 0 sky130_fd_pr__res_xhigh_po w=10 l=49.614372
XRinv3iap3s2 Rinv3iat3s1 Rinv3iat3s2 0 sky130_fd_pr__res_xhigh_po w=10 l=49.614372
XRinv3iap3s3 Rinv3iat3s2 inv3m 0 sky130_fd_pr__res_xhigh_po w=10 l=49.614372
* PDK sky130_fd_pr__res_xhigh_po Rinv3ib W=10 L=49.614382
* tile Rinv3ib 4s x 4p same W=10 L=49.614382
XRinv3ibp0s0 in3n Rinv3ibt0s0 0 sky130_fd_pr__res_xhigh_po w=10 l=49.614382
XRinv3ibp0s1 Rinv3ibt0s0 Rinv3ibt0s1 0 sky130_fd_pr__res_xhigh_po w=10 l=49.614382
XRinv3ibp0s2 Rinv3ibt0s1 Rinv3ibt0s2 0 sky130_fd_pr__res_xhigh_po w=10 l=49.614382
XRinv3ibp0s3 Rinv3ibt0s2 inv3m 0 sky130_fd_pr__res_xhigh_po w=10 l=49.614382
XRinv3ibp1s0 in3n Rinv3ibt1s0 0 sky130_fd_pr__res_xhigh_po w=10 l=49.614382
XRinv3ibp1s1 Rinv3ibt1s0 Rinv3ibt1s1 0 sky130_fd_pr__res_xhigh_po w=10 l=49.614382
XRinv3ibp1s2 Rinv3ibt1s1 Rinv3ibt1s2 0 sky130_fd_pr__res_xhigh_po w=10 l=49.614382
XRinv3ibp1s3 Rinv3ibt1s2 inv3m 0 sky130_fd_pr__res_xhigh_po w=10 l=49.614382
XRinv3ibp2s0 in3n Rinv3ibt2s0 0 sky130_fd_pr__res_xhigh_po w=10 l=49.614382
XRinv3ibp2s1 Rinv3ibt2s0 Rinv3ibt2s1 0 sky130_fd_pr__res_xhigh_po w=10 l=49.614382
XRinv3ibp2s2 Rinv3ibt2s1 Rinv3ibt2s2 0 sky130_fd_pr__res_xhigh_po w=10 l=49.614382
XRinv3ibp2s3 Rinv3ibt2s2 inv3m 0 sky130_fd_pr__res_xhigh_po w=10 l=49.614382
XRinv3ibp3s0 in3n Rinv3ibt3s0 0 sky130_fd_pr__res_xhigh_po w=10 l=49.614382
XRinv3ibp3s1 Rinv3ibt3s0 Rinv3ibt3s1 0 sky130_fd_pr__res_xhigh_po w=10 l=49.614382
XRinv3ibp3s2 Rinv3ibt3s1 Rinv3ibt3s2 0 sky130_fd_pr__res_xhigh_po w=10 l=49.614382
XRinv3ibp3s3 Rinv3ibt3s2 inv3m 0 sky130_fd_pr__res_xhigh_po w=10 l=49.614382
Einv3amp in3n 0 0 inv3m 10000000
Vin4 in4 0 DC 0
Vin5 in5 0 DC 1.37476380462716
* passive invert in5 -> in5n: R2/R1=1.0000002 closed-loop -1 at A=1e+07
* PDK sky130_fd_pr__res_xhigh_po Rinv5ia W=10 L=49.614372
* tile Rinv5ia 4s x 4p same W=10 L=49.614372
XRinv5iap0s0 in5 Rinv5iat0s0 0 sky130_fd_pr__res_xhigh_po w=10 l=49.614372
XRinv5iap0s1 Rinv5iat0s0 Rinv5iat0s1 0 sky130_fd_pr__res_xhigh_po w=10 l=49.614372
XRinv5iap0s2 Rinv5iat0s1 Rinv5iat0s2 0 sky130_fd_pr__res_xhigh_po w=10 l=49.614372
XRinv5iap0s3 Rinv5iat0s2 inv5m 0 sky130_fd_pr__res_xhigh_po w=10 l=49.614372
XRinv5iap1s0 in5 Rinv5iat1s0 0 sky130_fd_pr__res_xhigh_po w=10 l=49.614372
XRinv5iap1s1 Rinv5iat1s0 Rinv5iat1s1 0 sky130_fd_pr__res_xhigh_po w=10 l=49.614372
XRinv5iap1s2 Rinv5iat1s1 Rinv5iat1s2 0 sky130_fd_pr__res_xhigh_po w=10 l=49.614372
XRinv5iap1s3 Rinv5iat1s2 inv5m 0 sky130_fd_pr__res_xhigh_po w=10 l=49.614372
XRinv5iap2s0 in5 Rinv5iat2s0 0 sky130_fd_pr__res_xhigh_po w=10 l=49.614372
XRinv5iap2s1 Rinv5iat2s0 Rinv5iat2s1 0 sky130_fd_pr__res_xhigh_po w=10 l=49.614372
XRinv5iap2s2 Rinv5iat2s1 Rinv5iat2s2 0 sky130_fd_pr__res_xhigh_po w=10 l=49.614372
XRinv5iap2s3 Rinv5iat2s2 inv5m 0 sky130_fd_pr__res_xhigh_po w=10 l=49.614372
XRinv5iap3s0 in5 Rinv5iat3s0 0 sky130_fd_pr__res_xhigh_po w=10 l=49.614372
XRinv5iap3s1 Rinv5iat3s0 Rinv5iat3s1 0 sky130_fd_pr__res_xhigh_po w=10 l=49.614372
XRinv5iap3s2 Rinv5iat3s1 Rinv5iat3s2 0 sky130_fd_pr__res_xhigh_po w=10 l=49.614372
XRinv5iap3s3 Rinv5iat3s2 inv5m 0 sky130_fd_pr__res_xhigh_po w=10 l=49.614372
* PDK sky130_fd_pr__res_xhigh_po Rinv5ib W=10 L=49.614382
* tile Rinv5ib 4s x 4p same W=10 L=49.614382
XRinv5ibp0s0 in5n Rinv5ibt0s0 0 sky130_fd_pr__res_xhigh_po w=10 l=49.614382
XRinv5ibp0s1 Rinv5ibt0s0 Rinv5ibt0s1 0 sky130_fd_pr__res_xhigh_po w=10 l=49.614382
XRinv5ibp0s2 Rinv5ibt0s1 Rinv5ibt0s2 0 sky130_fd_pr__res_xhigh_po w=10 l=49.614382
XRinv5ibp0s3 Rinv5ibt0s2 inv5m 0 sky130_fd_pr__res_xhigh_po w=10 l=49.614382
XRinv5ibp1s0 in5n Rinv5ibt1s0 0 sky130_fd_pr__res_xhigh_po w=10 l=49.614382
XRinv5ibp1s1 Rinv5ibt1s0 Rinv5ibt1s1 0 sky130_fd_pr__res_xhigh_po w=10 l=49.614382
XRinv5ibp1s2 Rinv5ibt1s1 Rinv5ibt1s2 0 sky130_fd_pr__res_xhigh_po w=10 l=49.614382
XRinv5ibp1s3 Rinv5ibt1s2 inv5m 0 sky130_fd_pr__res_xhigh_po w=10 l=49.614382
XRinv5ibp2s0 in5n Rinv5ibt2s0 0 sky130_fd_pr__res_xhigh_po w=10 l=49.614382
XRinv5ibp2s1 Rinv5ibt2s0 Rinv5ibt2s1 0 sky130_fd_pr__res_xhigh_po w=10 l=49.614382
XRinv5ibp2s2 Rinv5ibt2s1 Rinv5ibt2s2 0 sky130_fd_pr__res_xhigh_po w=10 l=49.614382
XRinv5ibp2s3 Rinv5ibt2s2 inv5m 0 sky130_fd_pr__res_xhigh_po w=10 l=49.614382
XRinv5ibp3s0 in5n Rinv5ibt3s0 0 sky130_fd_pr__res_xhigh_po w=10 l=49.614382
XRinv5ibp3s1 Rinv5ibt3s0 Rinv5ibt3s1 0 sky130_fd_pr__res_xhigh_po w=10 l=49.614382
XRinv5ibp3s2 Rinv5ibt3s1 Rinv5ibt3s2 0 sky130_fd_pr__res_xhigh_po w=10 l=49.614382
XRinv5ibp3s3 Rinv5ibt3s2 inv5m 0 sky130_fd_pr__res_xhigh_po w=10 l=49.614382
Einv5amp in5n 0 0 inv5m 10000000
Vin6 in6 0 DC 1.19986134609244
* passive invert in6 -> in6n: R2/R1=1.0000002 closed-loop -1 at A=1e+07
* PDK sky130_fd_pr__res_xhigh_po Rinv6ia W=10 L=49.614372
* tile Rinv6ia 4s x 4p same W=10 L=49.614372
XRinv6iap0s0 in6 Rinv6iat0s0 0 sky130_fd_pr__res_xhigh_po w=10 l=49.614372
XRinv6iap0s1 Rinv6iat0s0 Rinv6iat0s1 0 sky130_fd_pr__res_xhigh_po w=10 l=49.614372
XRinv6iap0s2 Rinv6iat0s1 Rinv6iat0s2 0 sky130_fd_pr__res_xhigh_po w=10 l=49.614372
XRinv6iap0s3 Rinv6iat0s2 inv6m 0 sky130_fd_pr__res_xhigh_po w=10 l=49.614372
XRinv6iap1s0 in6 Rinv6iat1s0 0 sky130_fd_pr__res_xhigh_po w=10 l=49.614372
XRinv6iap1s1 Rinv6iat1s0 Rinv6iat1s1 0 sky130_fd_pr__res_xhigh_po w=10 l=49.614372
XRinv6iap1s2 Rinv6iat1s1 Rinv6iat1s2 0 sky130_fd_pr__res_xhigh_po w=10 l=49.614372
XRinv6iap1s3 Rinv6iat1s2 inv6m 0 sky130_fd_pr__res_xhigh_po w=10 l=49.614372
XRinv6iap2s0 in6 Rinv6iat2s0 0 sky130_fd_pr__res_xhigh_po w=10 l=49.614372
XRinv6iap2s1 Rinv6iat2s0 Rinv6iat2s1 0 sky130_fd_pr__res_xhigh_po w=10 l=49.614372
XRinv6iap2s2 Rinv6iat2s1 Rinv6iat2s2 0 sky130_fd_pr__res_xhigh_po w=10 l=49.614372
XRinv6iap2s3 Rinv6iat2s2 inv6m 0 sky130_fd_pr__res_xhigh_po w=10 l=49.614372
XRinv6iap3s0 in6 Rinv6iat3s0 0 sky130_fd_pr__res_xhigh_po w=10 l=49.614372
XRinv6iap3s1 Rinv6iat3s0 Rinv6iat3s1 0 sky130_fd_pr__res_xhigh_po w=10 l=49.614372
XRinv6iap3s2 Rinv6iat3s1 Rinv6iat3s2 0 sky130_fd_pr__res_xhigh_po w=10 l=49.614372
XRinv6iap3s3 Rinv6iat3s2 inv6m 0 sky130_fd_pr__res_xhigh_po w=10 l=49.614372
* PDK sky130_fd_pr__res_xhigh_po Rinv6ib W=10 L=49.614382
* tile Rinv6ib 4s x 4p same W=10 L=49.614382
XRinv6ibp0s0 in6n Rinv6ibt0s0 0 sky130_fd_pr__res_xhigh_po w=10 l=49.614382
XRinv6ibp0s1 Rinv6ibt0s0 Rinv6ibt0s1 0 sky130_fd_pr__res_xhigh_po w=10 l=49.614382
XRinv6ibp0s2 Rinv6ibt0s1 Rinv6ibt0s2 0 sky130_fd_pr__res_xhigh_po w=10 l=49.614382
XRinv6ibp0s3 Rinv6ibt0s2 inv6m 0 sky130_fd_pr__res_xhigh_po w=10 l=49.614382
XRinv6ibp1s0 in6n Rinv6ibt1s0 0 sky130_fd_pr__res_xhigh_po w=10 l=49.614382
XRinv6ibp1s1 Rinv6ibt1s0 Rinv6ibt1s1 0 sky130_fd_pr__res_xhigh_po w=10 l=49.614382
XRinv6ibp1s2 Rinv6ibt1s1 Rinv6ibt1s2 0 sky130_fd_pr__res_xhigh_po w=10 l=49.614382
XRinv6ibp1s3 Rinv6ibt1s2 inv6m 0 sky130_fd_pr__res_xhigh_po w=10 l=49.614382
XRinv6ibp2s0 in6n Rinv6ibt2s0 0 sky130_fd_pr__res_xhigh_po w=10 l=49.614382
XRinv6ibp2s1 Rinv6ibt2s0 Rinv6ibt2s1 0 sky130_fd_pr__res_xhigh_po w=10 l=49.614382
XRinv6ibp2s2 Rinv6ibt2s1 Rinv6ibt2s2 0 sky130_fd_pr__res_xhigh_po w=10 l=49.614382
XRinv6ibp2s3 Rinv6ibt2s2 inv6m 0 sky130_fd_pr__res_xhigh_po w=10 l=49.614382
XRinv6ibp3s0 in6n Rinv6ibt3s0 0 sky130_fd_pr__res_xhigh_po w=10 l=49.614382
XRinv6ibp3s1 Rinv6ibt3s0 Rinv6ibt3s1 0 sky130_fd_pr__res_xhigh_po w=10 l=49.614382
XRinv6ibp3s2 Rinv6ibt3s1 Rinv6ibt3s2 0 sky130_fd_pr__res_xhigh_po w=10 l=49.614382
XRinv6ibp3s3 Rinv6ibt3s2 inv6m 0 sky130_fd_pr__res_xhigh_po w=10 l=49.614382
Einv6amp in6n 0 0 inv6m 10000000
Vin7 in7 0 DC 0
Vin8 in8 0 DC 0.317097301363568
Vin9 in9 0 DC 0
* passive invert in9 -> in9n: R2/R1=1.0000002 closed-loop -1 at A=1e+07
* PDK sky130_fd_pr__res_xhigh_po Rinv9ia W=10 L=49.614372
* tile Rinv9ia 4s x 4p same W=10 L=49.614372
XRinv9iap0s0 in9 Rinv9iat0s0 0 sky130_fd_pr__res_xhigh_po w=10 l=49.614372
XRinv9iap0s1 Rinv9iat0s0 Rinv9iat0s1 0 sky130_fd_pr__res_xhigh_po w=10 l=49.614372
XRinv9iap0s2 Rinv9iat0s1 Rinv9iat0s2 0 sky130_fd_pr__res_xhigh_po w=10 l=49.614372
XRinv9iap0s3 Rinv9iat0s2 inv9m 0 sky130_fd_pr__res_xhigh_po w=10 l=49.614372
XRinv9iap1s0 in9 Rinv9iat1s0 0 sky130_fd_pr__res_xhigh_po w=10 l=49.614372
XRinv9iap1s1 Rinv9iat1s0 Rinv9iat1s1 0 sky130_fd_pr__res_xhigh_po w=10 l=49.614372
XRinv9iap1s2 Rinv9iat1s1 Rinv9iat1s2 0 sky130_fd_pr__res_xhigh_po w=10 l=49.614372
XRinv9iap1s3 Rinv9iat1s2 inv9m 0 sky130_fd_pr__res_xhigh_po w=10 l=49.614372
XRinv9iap2s0 in9 Rinv9iat2s0 0 sky130_fd_pr__res_xhigh_po w=10 l=49.614372
XRinv9iap2s1 Rinv9iat2s0 Rinv9iat2s1 0 sky130_fd_pr__res_xhigh_po w=10 l=49.614372
XRinv9iap2s2 Rinv9iat2s1 Rinv9iat2s2 0 sky130_fd_pr__res_xhigh_po w=10 l=49.614372
XRinv9iap2s3 Rinv9iat2s2 inv9m 0 sky130_fd_pr__res_xhigh_po w=10 l=49.614372
XRinv9iap3s0 in9 Rinv9iat3s0 0 sky130_fd_pr__res_xhigh_po w=10 l=49.614372
XRinv9iap3s1 Rinv9iat3s0 Rinv9iat3s1 0 sky130_fd_pr__res_xhigh_po w=10 l=49.614372
XRinv9iap3s2 Rinv9iat3s1 Rinv9iat3s2 0 sky130_fd_pr__res_xhigh_po w=10 l=49.614372
XRinv9iap3s3 Rinv9iat3s2 inv9m 0 sky130_fd_pr__res_xhigh_po w=10 l=49.614372
* PDK sky130_fd_pr__res_xhigh_po Rinv9ib W=10 L=49.614382
* tile Rinv9ib 4s x 4p same W=10 L=49.614382
XRinv9ibp0s0 in9n Rinv9ibt0s0 0 sky130_fd_pr__res_xhigh_po w=10 l=49.614382
XRinv9ibp0s1 Rinv9ibt0s0 Rinv9ibt0s1 0 sky130_fd_pr__res_xhigh_po w=10 l=49.614382
XRinv9ibp0s2 Rinv9ibt0s1 Rinv9ibt0s2 0 sky130_fd_pr__res_xhigh_po w=10 l=49.614382
XRinv9ibp0s3 Rinv9ibt0s2 inv9m 0 sky130_fd_pr__res_xhigh_po w=10 l=49.614382
XRinv9ibp1s0 in9n Rinv9ibt1s0 0 sky130_fd_pr__res_xhigh_po w=10 l=49.614382
XRinv9ibp1s1 Rinv9ibt1s0 Rinv9ibt1s1 0 sky130_fd_pr__res_xhigh_po w=10 l=49.614382
XRinv9ibp1s2 Rinv9ibt1s1 Rinv9ibt1s2 0 sky130_fd_pr__res_xhigh_po w=10 l=49.614382
XRinv9ibp1s3 Rinv9ibt1s2 inv9m 0 sky130_fd_pr__res_xhigh_po w=10 l=49.614382
XRinv9ibp2s0 in9n Rinv9ibt2s0 0 sky130_fd_pr__res_xhigh_po w=10 l=49.614382
XRinv9ibp2s1 Rinv9ibt2s0 Rinv9ibt2s1 0 sky130_fd_pr__res_xhigh_po w=10 l=49.614382
XRinv9ibp2s2 Rinv9ibt2s1 Rinv9ibt2s2 0 sky130_fd_pr__res_xhigh_po w=10 l=49.614382
XRinv9ibp2s3 Rinv9ibt2s2 inv9m 0 sky130_fd_pr__res_xhigh_po w=10 l=49.614382
XRinv9ibp3s0 in9n Rinv9ibt3s0 0 sky130_fd_pr__res_xhigh_po w=10 l=49.614382
XRinv9ibp3s1 Rinv9ibt3s0 Rinv9ibt3s1 0 sky130_fd_pr__res_xhigh_po w=10 l=49.614382
XRinv9ibp3s2 Rinv9ibt3s1 Rinv9ibt3s2 0 sky130_fd_pr__res_xhigh_po w=10 l=49.614382
XRinv9ibp3s3 Rinv9ibt3s2 inv9m 0 sky130_fd_pr__res_xhigh_po w=10 l=49.614382
Einv9amp in9n 0 0 inv9m 10000000
Vin10 in10 0 DC 0.827257420094178
* passive invert in10 -> in10n: R2/R1=1.0000002 closed-loop -1 at A=1e+07
* PDK sky130_fd_pr__res_xhigh_po Rinv10ia W=10 L=49.614372
* tile Rinv10ia 4s x 4p same W=10 L=49.614372
XRinv10iap0s0 in10 Rinv10iat0s0 0 sky130_fd_pr__res_xhigh_po w=10 l=49.614372
XRinv10iap0s1 Rinv10iat0s0 Rinv10iat0s1 0 sky130_fd_pr__res_xhigh_po w=10 l=49.614372
XRinv10iap0s2 Rinv10iat0s1 Rinv10iat0s2 0 sky130_fd_pr__res_xhigh_po w=10 l=49.614372
XRinv10iap0s3 Rinv10iat0s2 inv10m 0 sky130_fd_pr__res_xhigh_po w=10 l=49.614372
XRinv10iap1s0 in10 Rinv10iat1s0 0 sky130_fd_pr__res_xhigh_po w=10 l=49.614372
XRinv10iap1s1 Rinv10iat1s0 Rinv10iat1s1 0 sky130_fd_pr__res_xhigh_po w=10 l=49.614372
XRinv10iap1s2 Rinv10iat1s1 Rinv10iat1s2 0 sky130_fd_pr__res_xhigh_po w=10 l=49.614372
XRinv10iap1s3 Rinv10iat1s2 inv10m 0 sky130_fd_pr__res_xhigh_po w=10 l=49.614372
XRinv10iap2s0 in10 Rinv10iat2s0 0 sky130_fd_pr__res_xhigh_po w=10 l=49.614372
XRinv10iap2s1 Rinv10iat2s0 Rinv10iat2s1 0 sky130_fd_pr__res_xhigh_po w=10 l=49.614372
XRinv10iap2s2 Rinv10iat2s1 Rinv10iat2s2 0 sky130_fd_pr__res_xhigh_po w=10 l=49.614372
XRinv10iap2s3 Rinv10iat2s2 inv10m 0 sky130_fd_pr__res_xhigh_po w=10 l=49.614372
XRinv10iap3s0 in10 Rinv10iat3s0 0 sky130_fd_pr__res_xhigh_po w=10 l=49.614372
XRinv10iap3s1 Rinv10iat3s0 Rinv10iat3s1 0 sky130_fd_pr__res_xhigh_po w=10 l=49.614372
XRinv10iap3s2 Rinv10iat3s1 Rinv10iat3s2 0 sky130_fd_pr__res_xhigh_po w=10 l=49.614372
XRinv10iap3s3 Rinv10iat3s2 inv10m 0 sky130_fd_pr__res_xhigh_po w=10 l=49.614372
* PDK sky130_fd_pr__res_xhigh_po Rinv10ib W=10 L=49.614382
* tile Rinv10ib 4s x 4p same W=10 L=49.614382
XRinv10ibp0s0 in10n Rinv10ibt0s0 0 sky130_fd_pr__res_xhigh_po w=10 l=49.614382
XRinv10ibp0s1 Rinv10ibt0s0 Rinv10ibt0s1 0 sky130_fd_pr__res_xhigh_po w=10 l=49.614382
XRinv10ibp0s2 Rinv10ibt0s1 Rinv10ibt0s2 0 sky130_fd_pr__res_xhigh_po w=10 l=49.614382
XRinv10ibp0s3 Rinv10ibt0s2 inv10m 0 sky130_fd_pr__res_xhigh_po w=10 l=49.614382
XRinv10ibp1s0 in10n Rinv10ibt1s0 0 sky130_fd_pr__res_xhigh_po w=10 l=49.614382
XRinv10ibp1s1 Rinv10ibt1s0 Rinv10ibt1s1 0 sky130_fd_pr__res_xhigh_po w=10 l=49.614382
XRinv10ibp1s2 Rinv10ibt1s1 Rinv10ibt1s2 0 sky130_fd_pr__res_xhigh_po w=10 l=49.614382
XRinv10ibp1s3 Rinv10ibt1s2 inv10m 0 sky130_fd_pr__res_xhigh_po w=10 l=49.614382
XRinv10ibp2s0 in10n Rinv10ibt2s0 0 sky130_fd_pr__res_xhigh_po w=10 l=49.614382
XRinv10ibp2s1 Rinv10ibt2s0 Rinv10ibt2s1 0 sky130_fd_pr__res_xhigh_po w=10 l=49.614382
XRinv10ibp2s2 Rinv10ibt2s1 Rinv10ibt2s2 0 sky130_fd_pr__res_xhigh_po w=10 l=49.614382
XRinv10ibp2s3 Rinv10ibt2s2 inv10m 0 sky130_fd_pr__res_xhigh_po w=10 l=49.614382
XRinv10ibp3s0 in10n Rinv10ibt3s0 0 sky130_fd_pr__res_xhigh_po w=10 l=49.614382
XRinv10ibp3s1 Rinv10ibt3s0 Rinv10ibt3s1 0 sky130_fd_pr__res_xhigh_po w=10 l=49.614382
XRinv10ibp3s2 Rinv10ibt3s1 Rinv10ibt3s2 0 sky130_fd_pr__res_xhigh_po w=10 l=49.614382
XRinv10ibp3s3 Rinv10ibt3s2 inv10m 0 sky130_fd_pr__res_xhigh_po w=10 l=49.614382
Einv10amp in10n 0 0 inv10m 10000000
Vin11 in11 0 DC 0
Vin12 in12 0 DC 0
Vin13 in13 0 DC 0
Vin14 in14 0 DC 1.25893915448753
* passive invert in14 -> in14n: R2/R1=1.0000002 closed-loop -1 at A=1e+07
* PDK sky130_fd_pr__res_xhigh_po Rinv14ia W=10 L=49.614372
* tile Rinv14ia 4s x 4p same W=10 L=49.614372
XRinv14iap0s0 in14 Rinv14iat0s0 0 sky130_fd_pr__res_xhigh_po w=10 l=49.614372
XRinv14iap0s1 Rinv14iat0s0 Rinv14iat0s1 0 sky130_fd_pr__res_xhigh_po w=10 l=49.614372
XRinv14iap0s2 Rinv14iat0s1 Rinv14iat0s2 0 sky130_fd_pr__res_xhigh_po w=10 l=49.614372
XRinv14iap0s3 Rinv14iat0s2 inv14m 0 sky130_fd_pr__res_xhigh_po w=10 l=49.614372
XRinv14iap1s0 in14 Rinv14iat1s0 0 sky130_fd_pr__res_xhigh_po w=10 l=49.614372
XRinv14iap1s1 Rinv14iat1s0 Rinv14iat1s1 0 sky130_fd_pr__res_xhigh_po w=10 l=49.614372
XRinv14iap1s2 Rinv14iat1s1 Rinv14iat1s2 0 sky130_fd_pr__res_xhigh_po w=10 l=49.614372
XRinv14iap1s3 Rinv14iat1s2 inv14m 0 sky130_fd_pr__res_xhigh_po w=10 l=49.614372
XRinv14iap2s0 in14 Rinv14iat2s0 0 sky130_fd_pr__res_xhigh_po w=10 l=49.614372
XRinv14iap2s1 Rinv14iat2s0 Rinv14iat2s1 0 sky130_fd_pr__res_xhigh_po w=10 l=49.614372
XRinv14iap2s2 Rinv14iat2s1 Rinv14iat2s2 0 sky130_fd_pr__res_xhigh_po w=10 l=49.614372
XRinv14iap2s3 Rinv14iat2s2 inv14m 0 sky130_fd_pr__res_xhigh_po w=10 l=49.614372
XRinv14iap3s0 in14 Rinv14iat3s0 0 sky130_fd_pr__res_xhigh_po w=10 l=49.614372
XRinv14iap3s1 Rinv14iat3s0 Rinv14iat3s1 0 sky130_fd_pr__res_xhigh_po w=10 l=49.614372
XRinv14iap3s2 Rinv14iat3s1 Rinv14iat3s2 0 sky130_fd_pr__res_xhigh_po w=10 l=49.614372
XRinv14iap3s3 Rinv14iat3s2 inv14m 0 sky130_fd_pr__res_xhigh_po w=10 l=49.614372
* PDK sky130_fd_pr__res_xhigh_po Rinv14ib W=10 L=49.614382
* tile Rinv14ib 4s x 4p same W=10 L=49.614382
XRinv14ibp0s0 in14n Rinv14ibt0s0 0 sky130_fd_pr__res_xhigh_po w=10 l=49.614382
XRinv14ibp0s1 Rinv14ibt0s0 Rinv14ibt0s1 0 sky130_fd_pr__res_xhigh_po w=10 l=49.614382
XRinv14ibp0s2 Rinv14ibt0s1 Rinv14ibt0s2 0 sky130_fd_pr__res_xhigh_po w=10 l=49.614382
XRinv14ibp0s3 Rinv14ibt0s2 inv14m 0 sky130_fd_pr__res_xhigh_po w=10 l=49.614382
XRinv14ibp1s0 in14n Rinv14ibt1s0 0 sky130_fd_pr__res_xhigh_po w=10 l=49.614382
XRinv14ibp1s1 Rinv14ibt1s0 Rinv14ibt1s1 0 sky130_fd_pr__res_xhigh_po w=10 l=49.614382
XRinv14ibp1s2 Rinv14ibt1s1 Rinv14ibt1s2 0 sky130_fd_pr__res_xhigh_po w=10 l=49.614382
XRinv14ibp1s3 Rinv14ibt1s2 inv14m 0 sky130_fd_pr__res_xhigh_po w=10 l=49.614382
XRinv14ibp2s0 in14n Rinv14ibt2s0 0 sky130_fd_pr__res_xhigh_po w=10 l=49.614382
XRinv14ibp2s1 Rinv14ibt2s0 Rinv14ibt2s1 0 sky130_fd_pr__res_xhigh_po w=10 l=49.614382
XRinv14ibp2s2 Rinv14ibt2s1 Rinv14ibt2s2 0 sky130_fd_pr__res_xhigh_po w=10 l=49.614382
XRinv14ibp2s3 Rinv14ibt2s2 inv14m 0 sky130_fd_pr__res_xhigh_po w=10 l=49.614382
XRinv14ibp3s0 in14n Rinv14ibt3s0 0 sky130_fd_pr__res_xhigh_po w=10 l=49.614382
XRinv14ibp3s1 Rinv14ibt3s0 Rinv14ibt3s1 0 sky130_fd_pr__res_xhigh_po w=10 l=49.614382
XRinv14ibp3s2 Rinv14ibt3s1 Rinv14ibt3s2 0 sky130_fd_pr__res_xhigh_po w=10 l=49.614382
XRinv14ibp3s3 Rinv14ibt3s2 inv14m 0 sky130_fd_pr__res_xhigh_po w=10 l=49.614382
Einv14amp in14n 0 0 inv14m 10000000
Vin15 in15 0 DC 0.398142284790337
Vin16 in16 0 DC 0
* load-compensated divider in16->tap16: G_load=0.000666445780473128 Ra=599479.450040294 Rb=1000 target beta=0.001 (no tap buffer)
* PDK sky130_fd_pr__res_xhigh_po Rdiv16a W=10 L=2980.5062
* tile Rdiv16a 4s x 4p same W=10 L=2980.5062
XRdiv16ap0s0 in16 Rdiv16at0s0 0 sky130_fd_pr__res_xhigh_po w=10 l=2980.5062
XRdiv16ap0s1 Rdiv16at0s0 Rdiv16at0s1 0 sky130_fd_pr__res_xhigh_po w=10 l=2980.5062
XRdiv16ap0s2 Rdiv16at0s1 Rdiv16at0s2 0 sky130_fd_pr__res_xhigh_po w=10 l=2980.5062
XRdiv16ap0s3 Rdiv16at0s2 tap16 0 sky130_fd_pr__res_xhigh_po w=10 l=2980.5062
XRdiv16ap1s0 in16 Rdiv16at1s0 0 sky130_fd_pr__res_xhigh_po w=10 l=2980.5062
XRdiv16ap1s1 Rdiv16at1s0 Rdiv16at1s1 0 sky130_fd_pr__res_xhigh_po w=10 l=2980.5062
XRdiv16ap1s2 Rdiv16at1s1 Rdiv16at1s2 0 sky130_fd_pr__res_xhigh_po w=10 l=2980.5062
XRdiv16ap1s3 Rdiv16at1s2 tap16 0 sky130_fd_pr__res_xhigh_po w=10 l=2980.5062
XRdiv16ap2s0 in16 Rdiv16at2s0 0 sky130_fd_pr__res_xhigh_po w=10 l=2980.5062
XRdiv16ap2s1 Rdiv16at2s0 Rdiv16at2s1 0 sky130_fd_pr__res_xhigh_po w=10 l=2980.5062
XRdiv16ap2s2 Rdiv16at2s1 Rdiv16at2s2 0 sky130_fd_pr__res_xhigh_po w=10 l=2980.5062
XRdiv16ap2s3 Rdiv16at2s2 tap16 0 sky130_fd_pr__res_xhigh_po w=10 l=2980.5062
XRdiv16ap3s0 in16 Rdiv16at3s0 0 sky130_fd_pr__res_xhigh_po w=10 l=2980.5062
XRdiv16ap3s1 Rdiv16at3s0 Rdiv16at3s1 0 sky130_fd_pr__res_xhigh_po w=10 l=2980.5062
XRdiv16ap3s2 Rdiv16at3s1 Rdiv16at3s2 0 sky130_fd_pr__res_xhigh_po w=10 l=2980.5062
XRdiv16ap3s3 Rdiv16at3s2 tap16 0 sky130_fd_pr__res_xhigh_po w=10 l=2980.5062
* PDK sky130_fd_pr__res_xhigh_po Rdiv16b W=10 L=4.8663717
* tile Rdiv16b 4s x 4p same W=10 L=4.8663717
XRdiv16bp0s0 tap16 Rdiv16bt0s0 0 sky130_fd_pr__res_xhigh_po w=10 l=4.8663717
XRdiv16bp0s1 Rdiv16bt0s0 Rdiv16bt0s1 0 sky130_fd_pr__res_xhigh_po w=10 l=4.8663717
XRdiv16bp0s2 Rdiv16bt0s1 Rdiv16bt0s2 0 sky130_fd_pr__res_xhigh_po w=10 l=4.8663717
XRdiv16bp0s3 Rdiv16bt0s2 0 0 sky130_fd_pr__res_xhigh_po w=10 l=4.8663717
XRdiv16bp1s0 tap16 Rdiv16bt1s0 0 sky130_fd_pr__res_xhigh_po w=10 l=4.8663717
XRdiv16bp1s1 Rdiv16bt1s0 Rdiv16bt1s1 0 sky130_fd_pr__res_xhigh_po w=10 l=4.8663717
XRdiv16bp1s2 Rdiv16bt1s1 Rdiv16bt1s2 0 sky130_fd_pr__res_xhigh_po w=10 l=4.8663717
XRdiv16bp1s3 Rdiv16bt1s2 0 0 sky130_fd_pr__res_xhigh_po w=10 l=4.8663717
XRdiv16bp2s0 tap16 Rdiv16bt2s0 0 sky130_fd_pr__res_xhigh_po w=10 l=4.8663717
XRdiv16bp2s1 Rdiv16bt2s0 Rdiv16bt2s1 0 sky130_fd_pr__res_xhigh_po w=10 l=4.8663717
XRdiv16bp2s2 Rdiv16bt2s1 Rdiv16bt2s2 0 sky130_fd_pr__res_xhigh_po w=10 l=4.8663717
XRdiv16bp2s3 Rdiv16bt2s2 0 0 sky130_fd_pr__res_xhigh_po w=10 l=4.8663717
XRdiv16bp3s0 tap16 Rdiv16bt3s0 0 sky130_fd_pr__res_xhigh_po w=10 l=4.8663717
XRdiv16bp3s1 Rdiv16bt3s0 Rdiv16bt3s1 0 sky130_fd_pr__res_xhigh_po w=10 l=4.8663717
XRdiv16bp3s2 Rdiv16bt3s1 Rdiv16bt3s2 0 sky130_fd_pr__res_xhigh_po w=10 l=4.8663717
XRdiv16bp3s3 Rdiv16bt3s2 0 0 sky130_fd_pr__res_xhigh_po w=10 l=4.8663717
Vin17 in17 0 DC 0
* passive invert in17 -> in17n: R2/R1=1.0000002 closed-loop -1 at A=1e+07
* PDK sky130_fd_pr__res_xhigh_po Rinv17ia W=10 L=49.614372
* tile Rinv17ia 4s x 4p same W=10 L=49.614372
XRinv17iap0s0 in17 Rinv17iat0s0 0 sky130_fd_pr__res_xhigh_po w=10 l=49.614372
XRinv17iap0s1 Rinv17iat0s0 Rinv17iat0s1 0 sky130_fd_pr__res_xhigh_po w=10 l=49.614372
XRinv17iap0s2 Rinv17iat0s1 Rinv17iat0s2 0 sky130_fd_pr__res_xhigh_po w=10 l=49.614372
XRinv17iap0s3 Rinv17iat0s2 inv17m 0 sky130_fd_pr__res_xhigh_po w=10 l=49.614372
XRinv17iap1s0 in17 Rinv17iat1s0 0 sky130_fd_pr__res_xhigh_po w=10 l=49.614372
XRinv17iap1s1 Rinv17iat1s0 Rinv17iat1s1 0 sky130_fd_pr__res_xhigh_po w=10 l=49.614372
XRinv17iap1s2 Rinv17iat1s1 Rinv17iat1s2 0 sky130_fd_pr__res_xhigh_po w=10 l=49.614372
XRinv17iap1s3 Rinv17iat1s2 inv17m 0 sky130_fd_pr__res_xhigh_po w=10 l=49.614372
XRinv17iap2s0 in17 Rinv17iat2s0 0 sky130_fd_pr__res_xhigh_po w=10 l=49.614372
XRinv17iap2s1 Rinv17iat2s0 Rinv17iat2s1 0 sky130_fd_pr__res_xhigh_po w=10 l=49.614372
XRinv17iap2s2 Rinv17iat2s1 Rinv17iat2s2 0 sky130_fd_pr__res_xhigh_po w=10 l=49.614372
XRinv17iap2s3 Rinv17iat2s2 inv17m 0 sky130_fd_pr__res_xhigh_po w=10 l=49.614372
XRinv17iap3s0 in17 Rinv17iat3s0 0 sky130_fd_pr__res_xhigh_po w=10 l=49.614372
XRinv17iap3s1 Rinv17iat3s0 Rinv17iat3s1 0 sky130_fd_pr__res_xhigh_po w=10 l=49.614372
XRinv17iap3s2 Rinv17iat3s1 Rinv17iat3s2 0 sky130_fd_pr__res_xhigh_po w=10 l=49.614372
XRinv17iap3s3 Rinv17iat3s2 inv17m 0 sky130_fd_pr__res_xhigh_po w=10 l=49.614372
* PDK sky130_fd_pr__res_xhigh_po Rinv17ib W=10 L=49.614382
* tile Rinv17ib 4s x 4p same W=10 L=49.614382
XRinv17ibp0s0 in17n Rinv17ibt0s0 0 sky130_fd_pr__res_xhigh_po w=10 l=49.614382
XRinv17ibp0s1 Rinv17ibt0s0 Rinv17ibt0s1 0 sky130_fd_pr__res_xhigh_po w=10 l=49.614382
XRinv17ibp0s2 Rinv17ibt0s1 Rinv17ibt0s2 0 sky130_fd_pr__res_xhigh_po w=10 l=49.614382
XRinv17ibp0s3 Rinv17ibt0s2 inv17m 0 sky130_fd_pr__res_xhigh_po w=10 l=49.614382
XRinv17ibp1s0 in17n Rinv17ibt1s0 0 sky130_fd_pr__res_xhigh_po w=10 l=49.614382
XRinv17ibp1s1 Rinv17ibt1s0 Rinv17ibt1s1 0 sky130_fd_pr__res_xhigh_po w=10 l=49.614382
XRinv17ibp1s2 Rinv17ibt1s1 Rinv17ibt1s2 0 sky130_fd_pr__res_xhigh_po w=10 l=49.614382
XRinv17ibp1s3 Rinv17ibt1s2 inv17m 0 sky130_fd_pr__res_xhigh_po w=10 l=49.614382
XRinv17ibp2s0 in17n Rinv17ibt2s0 0 sky130_fd_pr__res_xhigh_po w=10 l=49.614382
XRinv17ibp2s1 Rinv17ibt2s0 Rinv17ibt2s1 0 sky130_fd_pr__res_xhigh_po w=10 l=49.614382
XRinv17ibp2s2 Rinv17ibt2s1 Rinv17ibt2s2 0 sky130_fd_pr__res_xhigh_po w=10 l=49.614382
XRinv17ibp2s3 Rinv17ibt2s2 inv17m 0 sky130_fd_pr__res_xhigh_po w=10 l=49.614382
XRinv17ibp3s0 in17n Rinv17ibt3s0 0 sky130_fd_pr__res_xhigh_po w=10 l=49.614382
XRinv17ibp3s1 Rinv17ibt3s0 Rinv17ibt3s1 0 sky130_fd_pr__res_xhigh_po w=10 l=49.614382
XRinv17ibp3s2 Rinv17ibt3s1 Rinv17ibt3s2 0 sky130_fd_pr__res_xhigh_po w=10 l=49.614382
XRinv17ibp3s3 Rinv17ibt3s2 inv17m 0 sky130_fd_pr__res_xhigh_po w=10 l=49.614382
Einv17amp in17n 0 0 inv17m 10000000
* load-compensated divider in17n->tap17n: G_load=0.000266255881165782 Ra=788940.067216326 Rb=1000 target beta=0.001 (no tap buffer)
* PDK sky130_fd_pr__res_xhigh_po Rdiv17na W=10 L=3922.5044
* tile Rdiv17na 4s x 4p same W=10 L=3922.5044
XRdiv17nap0s0 in17n Rdiv17nat0s0 0 sky130_fd_pr__res_xhigh_po w=10 l=3922.5044
XRdiv17nap0s1 Rdiv17nat0s0 Rdiv17nat0s1 0 sky130_fd_pr__res_xhigh_po w=10 l=3922.5044
XRdiv17nap0s2 Rdiv17nat0s1 Rdiv17nat0s2 0 sky130_fd_pr__res_xhigh_po w=10 l=3922.5044
XRdiv17nap0s3 Rdiv17nat0s2 tap17n 0 sky130_fd_pr__res_xhigh_po w=10 l=3922.5044
XRdiv17nap1s0 in17n Rdiv17nat1s0 0 sky130_fd_pr__res_xhigh_po w=10 l=3922.5044
XRdiv17nap1s1 Rdiv17nat1s0 Rdiv17nat1s1 0 sky130_fd_pr__res_xhigh_po w=10 l=3922.5044
XRdiv17nap1s2 Rdiv17nat1s1 Rdiv17nat1s2 0 sky130_fd_pr__res_xhigh_po w=10 l=3922.5044
XRdiv17nap1s3 Rdiv17nat1s2 tap17n 0 sky130_fd_pr__res_xhigh_po w=10 l=3922.5044
XRdiv17nap2s0 in17n Rdiv17nat2s0 0 sky130_fd_pr__res_xhigh_po w=10 l=3922.5044
XRdiv17nap2s1 Rdiv17nat2s0 Rdiv17nat2s1 0 sky130_fd_pr__res_xhigh_po w=10 l=3922.5044
XRdiv17nap2s2 Rdiv17nat2s1 Rdiv17nat2s2 0 sky130_fd_pr__res_xhigh_po w=10 l=3922.5044
XRdiv17nap2s3 Rdiv17nat2s2 tap17n 0 sky130_fd_pr__res_xhigh_po w=10 l=3922.5044
XRdiv17nap3s0 in17n Rdiv17nat3s0 0 sky130_fd_pr__res_xhigh_po w=10 l=3922.5044
XRdiv17nap3s1 Rdiv17nat3s0 Rdiv17nat3s1 0 sky130_fd_pr__res_xhigh_po w=10 l=3922.5044
XRdiv17nap3s2 Rdiv17nat3s1 Rdiv17nat3s2 0 sky130_fd_pr__res_xhigh_po w=10 l=3922.5044
XRdiv17nap3s3 Rdiv17nat3s2 tap17n 0 sky130_fd_pr__res_xhigh_po w=10 l=3922.5044
* PDK sky130_fd_pr__res_xhigh_po Rdiv17nb W=10 L=4.8663717
* tile Rdiv17nb 4s x 4p same W=10 L=4.8663717
XRdiv17nbp0s0 tap17n Rdiv17nbt0s0 0 sky130_fd_pr__res_xhigh_po w=10 l=4.8663717
XRdiv17nbp0s1 Rdiv17nbt0s0 Rdiv17nbt0s1 0 sky130_fd_pr__res_xhigh_po w=10 l=4.8663717
XRdiv17nbp0s2 Rdiv17nbt0s1 Rdiv17nbt0s2 0 sky130_fd_pr__res_xhigh_po w=10 l=4.8663717
XRdiv17nbp0s3 Rdiv17nbt0s2 0 0 sky130_fd_pr__res_xhigh_po w=10 l=4.8663717
XRdiv17nbp1s0 tap17n Rdiv17nbt1s0 0 sky130_fd_pr__res_xhigh_po w=10 l=4.8663717
XRdiv17nbp1s1 Rdiv17nbt1s0 Rdiv17nbt1s1 0 sky130_fd_pr__res_xhigh_po w=10 l=4.8663717
XRdiv17nbp1s2 Rdiv17nbt1s1 Rdiv17nbt1s2 0 sky130_fd_pr__res_xhigh_po w=10 l=4.8663717
XRdiv17nbp1s3 Rdiv17nbt1s2 0 0 sky130_fd_pr__res_xhigh_po w=10 l=4.8663717
XRdiv17nbp2s0 tap17n Rdiv17nbt2s0 0 sky130_fd_pr__res_xhigh_po w=10 l=4.8663717
XRdiv17nbp2s1 Rdiv17nbt2s0 Rdiv17nbt2s1 0 sky130_fd_pr__res_xhigh_po w=10 l=4.8663717
XRdiv17nbp2s2 Rdiv17nbt2s1 Rdiv17nbt2s2 0 sky130_fd_pr__res_xhigh_po w=10 l=4.8663717
XRdiv17nbp2s3 Rdiv17nbt2s2 0 0 sky130_fd_pr__res_xhigh_po w=10 l=4.8663717
XRdiv17nbp3s0 tap17n Rdiv17nbt3s0 0 sky130_fd_pr__res_xhigh_po w=10 l=4.8663717
XRdiv17nbp3s1 Rdiv17nbt3s0 Rdiv17nbt3s1 0 sky130_fd_pr__res_xhigh_po w=10 l=4.8663717
XRdiv17nbp3s2 Rdiv17nbt3s1 Rdiv17nbt3s2 0 sky130_fd_pr__res_xhigh_po w=10 l=4.8663717
XRdiv17nbp3s3 Rdiv17nbt3s2 0 0 sky130_fd_pr__res_xhigh_po w=10 l=4.8663717
Vin18 in18 0 DC 1.19134595226048
Vin19 in19 0 DC 0
* passive invert in19 -> in19n: R2/R1=1.0000002 closed-loop -1 at A=1e+07
* PDK sky130_fd_pr__res_xhigh_po Rinv19ia W=10 L=49.614372
* tile Rinv19ia 4s x 4p same W=10 L=49.614372
XRinv19iap0s0 in19 Rinv19iat0s0 0 sky130_fd_pr__res_xhigh_po w=10 l=49.614372
XRinv19iap0s1 Rinv19iat0s0 Rinv19iat0s1 0 sky130_fd_pr__res_xhigh_po w=10 l=49.614372
XRinv19iap0s2 Rinv19iat0s1 Rinv19iat0s2 0 sky130_fd_pr__res_xhigh_po w=10 l=49.614372
XRinv19iap0s3 Rinv19iat0s2 inv19m 0 sky130_fd_pr__res_xhigh_po w=10 l=49.614372
XRinv19iap1s0 in19 Rinv19iat1s0 0 sky130_fd_pr__res_xhigh_po w=10 l=49.614372
XRinv19iap1s1 Rinv19iat1s0 Rinv19iat1s1 0 sky130_fd_pr__res_xhigh_po w=10 l=49.614372
XRinv19iap1s2 Rinv19iat1s1 Rinv19iat1s2 0 sky130_fd_pr__res_xhigh_po w=10 l=49.614372
XRinv19iap1s3 Rinv19iat1s2 inv19m 0 sky130_fd_pr__res_xhigh_po w=10 l=49.614372
XRinv19iap2s0 in19 Rinv19iat2s0 0 sky130_fd_pr__res_xhigh_po w=10 l=49.614372
XRinv19iap2s1 Rinv19iat2s0 Rinv19iat2s1 0 sky130_fd_pr__res_xhigh_po w=10 l=49.614372
XRinv19iap2s2 Rinv19iat2s1 Rinv19iat2s2 0 sky130_fd_pr__res_xhigh_po w=10 l=49.614372
XRinv19iap2s3 Rinv19iat2s2 inv19m 0 sky130_fd_pr__res_xhigh_po w=10 l=49.614372
XRinv19iap3s0 in19 Rinv19iat3s0 0 sky130_fd_pr__res_xhigh_po w=10 l=49.614372
XRinv19iap3s1 Rinv19iat3s0 Rinv19iat3s1 0 sky130_fd_pr__res_xhigh_po w=10 l=49.614372
XRinv19iap3s2 Rinv19iat3s1 Rinv19iat3s2 0 sky130_fd_pr__res_xhigh_po w=10 l=49.614372
XRinv19iap3s3 Rinv19iat3s2 inv19m 0 sky130_fd_pr__res_xhigh_po w=10 l=49.614372
* PDK sky130_fd_pr__res_xhigh_po Rinv19ib W=10 L=49.614382
* tile Rinv19ib 4s x 4p same W=10 L=49.614382
XRinv19ibp0s0 in19n Rinv19ibt0s0 0 sky130_fd_pr__res_xhigh_po w=10 l=49.614382
XRinv19ibp0s1 Rinv19ibt0s0 Rinv19ibt0s1 0 sky130_fd_pr__res_xhigh_po w=10 l=49.614382
XRinv19ibp0s2 Rinv19ibt0s1 Rinv19ibt0s2 0 sky130_fd_pr__res_xhigh_po w=10 l=49.614382
XRinv19ibp0s3 Rinv19ibt0s2 inv19m 0 sky130_fd_pr__res_xhigh_po w=10 l=49.614382
XRinv19ibp1s0 in19n Rinv19ibt1s0 0 sky130_fd_pr__res_xhigh_po w=10 l=49.614382
XRinv19ibp1s1 Rinv19ibt1s0 Rinv19ibt1s1 0 sky130_fd_pr__res_xhigh_po w=10 l=49.614382
XRinv19ibp1s2 Rinv19ibt1s1 Rinv19ibt1s2 0 sky130_fd_pr__res_xhigh_po w=10 l=49.614382
XRinv19ibp1s3 Rinv19ibt1s2 inv19m 0 sky130_fd_pr__res_xhigh_po w=10 l=49.614382
XRinv19ibp2s0 in19n Rinv19ibt2s0 0 sky130_fd_pr__res_xhigh_po w=10 l=49.614382
XRinv19ibp2s1 Rinv19ibt2s0 Rinv19ibt2s1 0 sky130_fd_pr__res_xhigh_po w=10 l=49.614382
XRinv19ibp2s2 Rinv19ibt2s1 Rinv19ibt2s2 0 sky130_fd_pr__res_xhigh_po w=10 l=49.614382
XRinv19ibp2s3 Rinv19ibt2s2 inv19m 0 sky130_fd_pr__res_xhigh_po w=10 l=49.614382
XRinv19ibp3s0 in19n Rinv19ibt3s0 0 sky130_fd_pr__res_xhigh_po w=10 l=49.614382
XRinv19ibp3s1 Rinv19ibt3s0 Rinv19ibt3s1 0 sky130_fd_pr__res_xhigh_po w=10 l=49.614382
XRinv19ibp3s2 Rinv19ibt3s1 Rinv19ibt3s2 0 sky130_fd_pr__res_xhigh_po w=10 l=49.614382
XRinv19ibp3s3 Rinv19ibt3s2 inv19m 0 sky130_fd_pr__res_xhigh_po w=10 l=49.614382
Einv19amp in19n 0 0 inv19m 10000000
Vin20 in20 0 DC 0
* load-compensated divider in20->tap20: G_load=0.000971610549965604 Ra=506692.358700063 Rb=1000 target beta=0.001 (no tap buffer)
* PDK sky130_fd_pr__res_xhigh_po Rdiv20a W=10 L=2519.1688
* tile Rdiv20a 4s x 4p same W=10 L=2519.1688
XRdiv20ap0s0 in20 Rdiv20at0s0 0 sky130_fd_pr__res_xhigh_po w=10 l=2519.1688
XRdiv20ap0s1 Rdiv20at0s0 Rdiv20at0s1 0 sky130_fd_pr__res_xhigh_po w=10 l=2519.1688
XRdiv20ap0s2 Rdiv20at0s1 Rdiv20at0s2 0 sky130_fd_pr__res_xhigh_po w=10 l=2519.1688
XRdiv20ap0s3 Rdiv20at0s2 tap20 0 sky130_fd_pr__res_xhigh_po w=10 l=2519.1688
XRdiv20ap1s0 in20 Rdiv20at1s0 0 sky130_fd_pr__res_xhigh_po w=10 l=2519.1688
XRdiv20ap1s1 Rdiv20at1s0 Rdiv20at1s1 0 sky130_fd_pr__res_xhigh_po w=10 l=2519.1688
XRdiv20ap1s2 Rdiv20at1s1 Rdiv20at1s2 0 sky130_fd_pr__res_xhigh_po w=10 l=2519.1688
XRdiv20ap1s3 Rdiv20at1s2 tap20 0 sky130_fd_pr__res_xhigh_po w=10 l=2519.1688
XRdiv20ap2s0 in20 Rdiv20at2s0 0 sky130_fd_pr__res_xhigh_po w=10 l=2519.1688
XRdiv20ap2s1 Rdiv20at2s0 Rdiv20at2s1 0 sky130_fd_pr__res_xhigh_po w=10 l=2519.1688
XRdiv20ap2s2 Rdiv20at2s1 Rdiv20at2s2 0 sky130_fd_pr__res_xhigh_po w=10 l=2519.1688
XRdiv20ap2s3 Rdiv20at2s2 tap20 0 sky130_fd_pr__res_xhigh_po w=10 l=2519.1688
XRdiv20ap3s0 in20 Rdiv20at3s0 0 sky130_fd_pr__res_xhigh_po w=10 l=2519.1688
XRdiv20ap3s1 Rdiv20at3s0 Rdiv20at3s1 0 sky130_fd_pr__res_xhigh_po w=10 l=2519.1688
XRdiv20ap3s2 Rdiv20at3s1 Rdiv20at3s2 0 sky130_fd_pr__res_xhigh_po w=10 l=2519.1688
XRdiv20ap3s3 Rdiv20at3s2 tap20 0 sky130_fd_pr__res_xhigh_po w=10 l=2519.1688
* PDK sky130_fd_pr__res_xhigh_po Rdiv20b W=10 L=4.8663717
* tile Rdiv20b 4s x 4p same W=10 L=4.8663717
XRdiv20bp0s0 tap20 Rdiv20bt0s0 0 sky130_fd_pr__res_xhigh_po w=10 l=4.8663717
XRdiv20bp0s1 Rdiv20bt0s0 Rdiv20bt0s1 0 sky130_fd_pr__res_xhigh_po w=10 l=4.8663717
XRdiv20bp0s2 Rdiv20bt0s1 Rdiv20bt0s2 0 sky130_fd_pr__res_xhigh_po w=10 l=4.8663717
XRdiv20bp0s3 Rdiv20bt0s2 0 0 sky130_fd_pr__res_xhigh_po w=10 l=4.8663717
XRdiv20bp1s0 tap20 Rdiv20bt1s0 0 sky130_fd_pr__res_xhigh_po w=10 l=4.8663717
XRdiv20bp1s1 Rdiv20bt1s0 Rdiv20bt1s1 0 sky130_fd_pr__res_xhigh_po w=10 l=4.8663717
XRdiv20bp1s2 Rdiv20bt1s1 Rdiv20bt1s2 0 sky130_fd_pr__res_xhigh_po w=10 l=4.8663717
XRdiv20bp1s3 Rdiv20bt1s2 0 0 sky130_fd_pr__res_xhigh_po w=10 l=4.8663717
XRdiv20bp2s0 tap20 Rdiv20bt2s0 0 sky130_fd_pr__res_xhigh_po w=10 l=4.8663717
XRdiv20bp2s1 Rdiv20bt2s0 Rdiv20bt2s1 0 sky130_fd_pr__res_xhigh_po w=10 l=4.8663717
XRdiv20bp2s2 Rdiv20bt2s1 Rdiv20bt2s2 0 sky130_fd_pr__res_xhigh_po w=10 l=4.8663717
XRdiv20bp2s3 Rdiv20bt2s2 0 0 sky130_fd_pr__res_xhigh_po w=10 l=4.8663717
XRdiv20bp3s0 tap20 Rdiv20bt3s0 0 sky130_fd_pr__res_xhigh_po w=10 l=4.8663717
XRdiv20bp3s1 Rdiv20bt3s0 Rdiv20bt3s1 0 sky130_fd_pr__res_xhigh_po w=10 l=4.8663717
XRdiv20bp3s2 Rdiv20bt3s1 Rdiv20bt3s2 0 sky130_fd_pr__res_xhigh_po w=10 l=4.8663717
XRdiv20bp3s3 Rdiv20bt3s2 0 0 sky130_fd_pr__res_xhigh_po w=10 l=4.8663717
Vin21 in21 0 DC 0
Vin22 in22 0 DC 0
* passive invert in22 -> in22n: R2/R1=1.0000002 closed-loop -1 at A=1e+07
* PDK sky130_fd_pr__res_xhigh_po Rinv22ia W=10 L=49.614372
* tile Rinv22ia 4s x 4p same W=10 L=49.614372
XRinv22iap0s0 in22 Rinv22iat0s0 0 sky130_fd_pr__res_xhigh_po w=10 l=49.614372
XRinv22iap0s1 Rinv22iat0s0 Rinv22iat0s1 0 sky130_fd_pr__res_xhigh_po w=10 l=49.614372
XRinv22iap0s2 Rinv22iat0s1 Rinv22iat0s2 0 sky130_fd_pr__res_xhigh_po w=10 l=49.614372
XRinv22iap0s3 Rinv22iat0s2 inv22m 0 sky130_fd_pr__res_xhigh_po w=10 l=49.614372
XRinv22iap1s0 in22 Rinv22iat1s0 0 sky130_fd_pr__res_xhigh_po w=10 l=49.614372
XRinv22iap1s1 Rinv22iat1s0 Rinv22iat1s1 0 sky130_fd_pr__res_xhigh_po w=10 l=49.614372
XRinv22iap1s2 Rinv22iat1s1 Rinv22iat1s2 0 sky130_fd_pr__res_xhigh_po w=10 l=49.614372
XRinv22iap1s3 Rinv22iat1s2 inv22m 0 sky130_fd_pr__res_xhigh_po w=10 l=49.614372
XRinv22iap2s0 in22 Rinv22iat2s0 0 sky130_fd_pr__res_xhigh_po w=10 l=49.614372
XRinv22iap2s1 Rinv22iat2s0 Rinv22iat2s1 0 sky130_fd_pr__res_xhigh_po w=10 l=49.614372
XRinv22iap2s2 Rinv22iat2s1 Rinv22iat2s2 0 sky130_fd_pr__res_xhigh_po w=10 l=49.614372
XRinv22iap2s3 Rinv22iat2s2 inv22m 0 sky130_fd_pr__res_xhigh_po w=10 l=49.614372
XRinv22iap3s0 in22 Rinv22iat3s0 0 sky130_fd_pr__res_xhigh_po w=10 l=49.614372
XRinv22iap3s1 Rinv22iat3s0 Rinv22iat3s1 0 sky130_fd_pr__res_xhigh_po w=10 l=49.614372
XRinv22iap3s2 Rinv22iat3s1 Rinv22iat3s2 0 sky130_fd_pr__res_xhigh_po w=10 l=49.614372
XRinv22iap3s3 Rinv22iat3s2 inv22m 0 sky130_fd_pr__res_xhigh_po w=10 l=49.614372
* PDK sky130_fd_pr__res_xhigh_po Rinv22ib W=10 L=49.614382
* tile Rinv22ib 4s x 4p same W=10 L=49.614382
XRinv22ibp0s0 in22n Rinv22ibt0s0 0 sky130_fd_pr__res_xhigh_po w=10 l=49.614382
XRinv22ibp0s1 Rinv22ibt0s0 Rinv22ibt0s1 0 sky130_fd_pr__res_xhigh_po w=10 l=49.614382
XRinv22ibp0s2 Rinv22ibt0s1 Rinv22ibt0s2 0 sky130_fd_pr__res_xhigh_po w=10 l=49.614382
XRinv22ibp0s3 Rinv22ibt0s2 inv22m 0 sky130_fd_pr__res_xhigh_po w=10 l=49.614382
XRinv22ibp1s0 in22n Rinv22ibt1s0 0 sky130_fd_pr__res_xhigh_po w=10 l=49.614382
XRinv22ibp1s1 Rinv22ibt1s0 Rinv22ibt1s1 0 sky130_fd_pr__res_xhigh_po w=10 l=49.614382
XRinv22ibp1s2 Rinv22ibt1s1 Rinv22ibt1s2 0 sky130_fd_pr__res_xhigh_po w=10 l=49.614382
XRinv22ibp1s3 Rinv22ibt1s2 inv22m 0 sky130_fd_pr__res_xhigh_po w=10 l=49.614382
XRinv22ibp2s0 in22n Rinv22ibt2s0 0 sky130_fd_pr__res_xhigh_po w=10 l=49.614382
XRinv22ibp2s1 Rinv22ibt2s0 Rinv22ibt2s1 0 sky130_fd_pr__res_xhigh_po w=10 l=49.614382
XRinv22ibp2s2 Rinv22ibt2s1 Rinv22ibt2s2 0 sky130_fd_pr__res_xhigh_po w=10 l=49.614382
XRinv22ibp2s3 Rinv22ibt2s2 inv22m 0 sky130_fd_pr__res_xhigh_po w=10 l=49.614382
XRinv22ibp3s0 in22n Rinv22ibt3s0 0 sky130_fd_pr__res_xhigh_po w=10 l=49.614382
XRinv22ibp3s1 Rinv22ibt3s0 Rinv22ibt3s1 0 sky130_fd_pr__res_xhigh_po w=10 l=49.614382
XRinv22ibp3s2 Rinv22ibt3s1 Rinv22ibt3s2 0 sky130_fd_pr__res_xhigh_po w=10 l=49.614382
XRinv22ibp3s3 Rinv22ibt3s2 inv22m 0 sky130_fd_pr__res_xhigh_po w=10 l=49.614382
Einv22amp in22n 0 0 inv22m 10000000
Vin23 in23 0 DC 0.370520947636909
* passive invert in23 -> in23n: R2/R1=1.0000002 closed-loop -1 at A=1e+07
* PDK sky130_fd_pr__res_xhigh_po Rinv23ia W=10 L=49.614372
* tile Rinv23ia 4s x 4p same W=10 L=49.614372
XRinv23iap0s0 in23 Rinv23iat0s0 0 sky130_fd_pr__res_xhigh_po w=10 l=49.614372
XRinv23iap0s1 Rinv23iat0s0 Rinv23iat0s1 0 sky130_fd_pr__res_xhigh_po w=10 l=49.614372
XRinv23iap0s2 Rinv23iat0s1 Rinv23iat0s2 0 sky130_fd_pr__res_xhigh_po w=10 l=49.614372
XRinv23iap0s3 Rinv23iat0s2 inv23m 0 sky130_fd_pr__res_xhigh_po w=10 l=49.614372
XRinv23iap1s0 in23 Rinv23iat1s0 0 sky130_fd_pr__res_xhigh_po w=10 l=49.614372
XRinv23iap1s1 Rinv23iat1s0 Rinv23iat1s1 0 sky130_fd_pr__res_xhigh_po w=10 l=49.614372
XRinv23iap1s2 Rinv23iat1s1 Rinv23iat1s2 0 sky130_fd_pr__res_xhigh_po w=10 l=49.614372
XRinv23iap1s3 Rinv23iat1s2 inv23m 0 sky130_fd_pr__res_xhigh_po w=10 l=49.614372
XRinv23iap2s0 in23 Rinv23iat2s0 0 sky130_fd_pr__res_xhigh_po w=10 l=49.614372
XRinv23iap2s1 Rinv23iat2s0 Rinv23iat2s1 0 sky130_fd_pr__res_xhigh_po w=10 l=49.614372
XRinv23iap2s2 Rinv23iat2s1 Rinv23iat2s2 0 sky130_fd_pr__res_xhigh_po w=10 l=49.614372
XRinv23iap2s3 Rinv23iat2s2 inv23m 0 sky130_fd_pr__res_xhigh_po w=10 l=49.614372
XRinv23iap3s0 in23 Rinv23iat3s0 0 sky130_fd_pr__res_xhigh_po w=10 l=49.614372
XRinv23iap3s1 Rinv23iat3s0 Rinv23iat3s1 0 sky130_fd_pr__res_xhigh_po w=10 l=49.614372
XRinv23iap3s2 Rinv23iat3s1 Rinv23iat3s2 0 sky130_fd_pr__res_xhigh_po w=10 l=49.614372
XRinv23iap3s3 Rinv23iat3s2 inv23m 0 sky130_fd_pr__res_xhigh_po w=10 l=49.614372
* PDK sky130_fd_pr__res_xhigh_po Rinv23ib W=10 L=49.614382
* tile Rinv23ib 4s x 4p same W=10 L=49.614382
XRinv23ibp0s0 in23n Rinv23ibt0s0 0 sky130_fd_pr__res_xhigh_po w=10 l=49.614382
XRinv23ibp0s1 Rinv23ibt0s0 Rinv23ibt0s1 0 sky130_fd_pr__res_xhigh_po w=10 l=49.614382
XRinv23ibp0s2 Rinv23ibt0s1 Rinv23ibt0s2 0 sky130_fd_pr__res_xhigh_po w=10 l=49.614382
XRinv23ibp0s3 Rinv23ibt0s2 inv23m 0 sky130_fd_pr__res_xhigh_po w=10 l=49.614382
XRinv23ibp1s0 in23n Rinv23ibt1s0 0 sky130_fd_pr__res_xhigh_po w=10 l=49.614382
XRinv23ibp1s1 Rinv23ibt1s0 Rinv23ibt1s1 0 sky130_fd_pr__res_xhigh_po w=10 l=49.614382
XRinv23ibp1s2 Rinv23ibt1s1 Rinv23ibt1s2 0 sky130_fd_pr__res_xhigh_po w=10 l=49.614382
XRinv23ibp1s3 Rinv23ibt1s2 inv23m 0 sky130_fd_pr__res_xhigh_po w=10 l=49.614382
XRinv23ibp2s0 in23n Rinv23ibt2s0 0 sky130_fd_pr__res_xhigh_po w=10 l=49.614382
XRinv23ibp2s1 Rinv23ibt2s0 Rinv23ibt2s1 0 sky130_fd_pr__res_xhigh_po w=10 l=49.614382
XRinv23ibp2s2 Rinv23ibt2s1 Rinv23ibt2s2 0 sky130_fd_pr__res_xhigh_po w=10 l=49.614382
XRinv23ibp2s3 Rinv23ibt2s2 inv23m 0 sky130_fd_pr__res_xhigh_po w=10 l=49.614382
XRinv23ibp3s0 in23n Rinv23ibt3s0 0 sky130_fd_pr__res_xhigh_po w=10 l=49.614382
XRinv23ibp3s1 Rinv23ibt3s0 Rinv23ibt3s1 0 sky130_fd_pr__res_xhigh_po w=10 l=49.614382
XRinv23ibp3s2 Rinv23ibt3s1 Rinv23ibt3s2 0 sky130_fd_pr__res_xhigh_po w=10 l=49.614382
XRinv23ibp3s3 Rinv23ibt3s2 inv23m 0 sky130_fd_pr__res_xhigh_po w=10 l=49.614382
Einv23amp in23n 0 0 inv23m 10000000
Vin24 in24 0 DC 0
* load-compensated divider in24->tap24: G_load=0.000881349510863982 Ra=531001.812385847 Rb=1000 target beta=0.001 (no tap buffer)
* PDK sky130_fd_pr__res_xhigh_po Rdiv24a W=10 L=2640.0354
* tile Rdiv24a 4s x 4p same W=10 L=2640.0354
XRdiv24ap0s0 in24 Rdiv24at0s0 0 sky130_fd_pr__res_xhigh_po w=10 l=2640.0354
XRdiv24ap0s1 Rdiv24at0s0 Rdiv24at0s1 0 sky130_fd_pr__res_xhigh_po w=10 l=2640.0354
XRdiv24ap0s2 Rdiv24at0s1 Rdiv24at0s2 0 sky130_fd_pr__res_xhigh_po w=10 l=2640.0354
XRdiv24ap0s3 Rdiv24at0s2 tap24 0 sky130_fd_pr__res_xhigh_po w=10 l=2640.0354
XRdiv24ap1s0 in24 Rdiv24at1s0 0 sky130_fd_pr__res_xhigh_po w=10 l=2640.0354
XRdiv24ap1s1 Rdiv24at1s0 Rdiv24at1s1 0 sky130_fd_pr__res_xhigh_po w=10 l=2640.0354
XRdiv24ap1s2 Rdiv24at1s1 Rdiv24at1s2 0 sky130_fd_pr__res_xhigh_po w=10 l=2640.0354
XRdiv24ap1s3 Rdiv24at1s2 tap24 0 sky130_fd_pr__res_xhigh_po w=10 l=2640.0354
XRdiv24ap2s0 in24 Rdiv24at2s0 0 sky130_fd_pr__res_xhigh_po w=10 l=2640.0354
XRdiv24ap2s1 Rdiv24at2s0 Rdiv24at2s1 0 sky130_fd_pr__res_xhigh_po w=10 l=2640.0354
XRdiv24ap2s2 Rdiv24at2s1 Rdiv24at2s2 0 sky130_fd_pr__res_xhigh_po w=10 l=2640.0354
XRdiv24ap2s3 Rdiv24at2s2 tap24 0 sky130_fd_pr__res_xhigh_po w=10 l=2640.0354
XRdiv24ap3s0 in24 Rdiv24at3s0 0 sky130_fd_pr__res_xhigh_po w=10 l=2640.0354
XRdiv24ap3s1 Rdiv24at3s0 Rdiv24at3s1 0 sky130_fd_pr__res_xhigh_po w=10 l=2640.0354
XRdiv24ap3s2 Rdiv24at3s1 Rdiv24at3s2 0 sky130_fd_pr__res_xhigh_po w=10 l=2640.0354
XRdiv24ap3s3 Rdiv24at3s2 tap24 0 sky130_fd_pr__res_xhigh_po w=10 l=2640.0354
* PDK sky130_fd_pr__res_xhigh_po Rdiv24b W=10 L=4.8663717
* tile Rdiv24b 4s x 4p same W=10 L=4.8663717
XRdiv24bp0s0 tap24 Rdiv24bt0s0 0 sky130_fd_pr__res_xhigh_po w=10 l=4.8663717
XRdiv24bp0s1 Rdiv24bt0s0 Rdiv24bt0s1 0 sky130_fd_pr__res_xhigh_po w=10 l=4.8663717
XRdiv24bp0s2 Rdiv24bt0s1 Rdiv24bt0s2 0 sky130_fd_pr__res_xhigh_po w=10 l=4.8663717
XRdiv24bp0s3 Rdiv24bt0s2 0 0 sky130_fd_pr__res_xhigh_po w=10 l=4.8663717
XRdiv24bp1s0 tap24 Rdiv24bt1s0 0 sky130_fd_pr__res_xhigh_po w=10 l=4.8663717
XRdiv24bp1s1 Rdiv24bt1s0 Rdiv24bt1s1 0 sky130_fd_pr__res_xhigh_po w=10 l=4.8663717
XRdiv24bp1s2 Rdiv24bt1s1 Rdiv24bt1s2 0 sky130_fd_pr__res_xhigh_po w=10 l=4.8663717
XRdiv24bp1s3 Rdiv24bt1s2 0 0 sky130_fd_pr__res_xhigh_po w=10 l=4.8663717
XRdiv24bp2s0 tap24 Rdiv24bt2s0 0 sky130_fd_pr__res_xhigh_po w=10 l=4.8663717
XRdiv24bp2s1 Rdiv24bt2s0 Rdiv24bt2s1 0 sky130_fd_pr__res_xhigh_po w=10 l=4.8663717
XRdiv24bp2s2 Rdiv24bt2s1 Rdiv24bt2s2 0 sky130_fd_pr__res_xhigh_po w=10 l=4.8663717
XRdiv24bp2s3 Rdiv24bt2s2 0 0 sky130_fd_pr__res_xhigh_po w=10 l=4.8663717
XRdiv24bp3s0 tap24 Rdiv24bt3s0 0 sky130_fd_pr__res_xhigh_po w=10 l=4.8663717
XRdiv24bp3s1 Rdiv24bt3s0 Rdiv24bt3s1 0 sky130_fd_pr__res_xhigh_po w=10 l=4.8663717
XRdiv24bp3s2 Rdiv24bt3s1 Rdiv24bt3s2 0 sky130_fd_pr__res_xhigh_po w=10 l=4.8663717
XRdiv24bp3s3 Rdiv24bt3s2 0 0 sky130_fd_pr__res_xhigh_po w=10 l=4.8663717
Vin25 in25 0 DC 0
* passive invert in25 -> in25n: R2/R1=1.0000002 closed-loop -1 at A=1e+07
* PDK sky130_fd_pr__res_xhigh_po Rinv25ia W=10 L=49.614372
* tile Rinv25ia 4s x 4p same W=10 L=49.614372
XRinv25iap0s0 in25 Rinv25iat0s0 0 sky130_fd_pr__res_xhigh_po w=10 l=49.614372
XRinv25iap0s1 Rinv25iat0s0 Rinv25iat0s1 0 sky130_fd_pr__res_xhigh_po w=10 l=49.614372
XRinv25iap0s2 Rinv25iat0s1 Rinv25iat0s2 0 sky130_fd_pr__res_xhigh_po w=10 l=49.614372
XRinv25iap0s3 Rinv25iat0s2 inv25m 0 sky130_fd_pr__res_xhigh_po w=10 l=49.614372
XRinv25iap1s0 in25 Rinv25iat1s0 0 sky130_fd_pr__res_xhigh_po w=10 l=49.614372
XRinv25iap1s1 Rinv25iat1s0 Rinv25iat1s1 0 sky130_fd_pr__res_xhigh_po w=10 l=49.614372
XRinv25iap1s2 Rinv25iat1s1 Rinv25iat1s2 0 sky130_fd_pr__res_xhigh_po w=10 l=49.614372
XRinv25iap1s3 Rinv25iat1s2 inv25m 0 sky130_fd_pr__res_xhigh_po w=10 l=49.614372
XRinv25iap2s0 in25 Rinv25iat2s0 0 sky130_fd_pr__res_xhigh_po w=10 l=49.614372
XRinv25iap2s1 Rinv25iat2s0 Rinv25iat2s1 0 sky130_fd_pr__res_xhigh_po w=10 l=49.614372
XRinv25iap2s2 Rinv25iat2s1 Rinv25iat2s2 0 sky130_fd_pr__res_xhigh_po w=10 l=49.614372
XRinv25iap2s3 Rinv25iat2s2 inv25m 0 sky130_fd_pr__res_xhigh_po w=10 l=49.614372
XRinv25iap3s0 in25 Rinv25iat3s0 0 sky130_fd_pr__res_xhigh_po w=10 l=49.614372
XRinv25iap3s1 Rinv25iat3s0 Rinv25iat3s1 0 sky130_fd_pr__res_xhigh_po w=10 l=49.614372
XRinv25iap3s2 Rinv25iat3s1 Rinv25iat3s2 0 sky130_fd_pr__res_xhigh_po w=10 l=49.614372
XRinv25iap3s3 Rinv25iat3s2 inv25m 0 sky130_fd_pr__res_xhigh_po w=10 l=49.614372
* PDK sky130_fd_pr__res_xhigh_po Rinv25ib W=10 L=49.614382
* tile Rinv25ib 4s x 4p same W=10 L=49.614382
XRinv25ibp0s0 in25n Rinv25ibt0s0 0 sky130_fd_pr__res_xhigh_po w=10 l=49.614382
XRinv25ibp0s1 Rinv25ibt0s0 Rinv25ibt0s1 0 sky130_fd_pr__res_xhigh_po w=10 l=49.614382
XRinv25ibp0s2 Rinv25ibt0s1 Rinv25ibt0s2 0 sky130_fd_pr__res_xhigh_po w=10 l=49.614382
XRinv25ibp0s3 Rinv25ibt0s2 inv25m 0 sky130_fd_pr__res_xhigh_po w=10 l=49.614382
XRinv25ibp1s0 in25n Rinv25ibt1s0 0 sky130_fd_pr__res_xhigh_po w=10 l=49.614382
XRinv25ibp1s1 Rinv25ibt1s0 Rinv25ibt1s1 0 sky130_fd_pr__res_xhigh_po w=10 l=49.614382
XRinv25ibp1s2 Rinv25ibt1s1 Rinv25ibt1s2 0 sky130_fd_pr__res_xhigh_po w=10 l=49.614382
XRinv25ibp1s3 Rinv25ibt1s2 inv25m 0 sky130_fd_pr__res_xhigh_po w=10 l=49.614382
XRinv25ibp2s0 in25n Rinv25ibt2s0 0 sky130_fd_pr__res_xhigh_po w=10 l=49.614382
XRinv25ibp2s1 Rinv25ibt2s0 Rinv25ibt2s1 0 sky130_fd_pr__res_xhigh_po w=10 l=49.614382
XRinv25ibp2s2 Rinv25ibt2s1 Rinv25ibt2s2 0 sky130_fd_pr__res_xhigh_po w=10 l=49.614382
XRinv25ibp2s3 Rinv25ibt2s2 inv25m 0 sky130_fd_pr__res_xhigh_po w=10 l=49.614382
XRinv25ibp3s0 in25n Rinv25ibt3s0 0 sky130_fd_pr__res_xhigh_po w=10 l=49.614382
XRinv25ibp3s1 Rinv25ibt3s0 Rinv25ibt3s1 0 sky130_fd_pr__res_xhigh_po w=10 l=49.614382
XRinv25ibp3s2 Rinv25ibt3s1 Rinv25ibt3s2 0 sky130_fd_pr__res_xhigh_po w=10 l=49.614382
XRinv25ibp3s3 Rinv25ibt3s2 inv25m 0 sky130_fd_pr__res_xhigh_po w=10 l=49.614382
Einv25amp in25n 0 0 inv25m 10000000
Vin26 in26 0 DC 0
Vin27 in27 0 DC 1.88293545008737
* passive invert in27 -> in27n: R2/R1=1.0000002 closed-loop -1 at A=1e+07
* PDK sky130_fd_pr__res_xhigh_po Rinv27ia W=10 L=49.614372
* tile Rinv27ia 4s x 4p same W=10 L=49.614372
XRinv27iap0s0 in27 Rinv27iat0s0 0 sky130_fd_pr__res_xhigh_po w=10 l=49.614372
XRinv27iap0s1 Rinv27iat0s0 Rinv27iat0s1 0 sky130_fd_pr__res_xhigh_po w=10 l=49.614372
XRinv27iap0s2 Rinv27iat0s1 Rinv27iat0s2 0 sky130_fd_pr__res_xhigh_po w=10 l=49.614372
XRinv27iap0s3 Rinv27iat0s2 inv27m 0 sky130_fd_pr__res_xhigh_po w=10 l=49.614372
XRinv27iap1s0 in27 Rinv27iat1s0 0 sky130_fd_pr__res_xhigh_po w=10 l=49.614372
XRinv27iap1s1 Rinv27iat1s0 Rinv27iat1s1 0 sky130_fd_pr__res_xhigh_po w=10 l=49.614372
XRinv27iap1s2 Rinv27iat1s1 Rinv27iat1s2 0 sky130_fd_pr__res_xhigh_po w=10 l=49.614372
XRinv27iap1s3 Rinv27iat1s2 inv27m 0 sky130_fd_pr__res_xhigh_po w=10 l=49.614372
XRinv27iap2s0 in27 Rinv27iat2s0 0 sky130_fd_pr__res_xhigh_po w=10 l=49.614372
XRinv27iap2s1 Rinv27iat2s0 Rinv27iat2s1 0 sky130_fd_pr__res_xhigh_po w=10 l=49.614372
XRinv27iap2s2 Rinv27iat2s1 Rinv27iat2s2 0 sky130_fd_pr__res_xhigh_po w=10 l=49.614372
XRinv27iap2s3 Rinv27iat2s2 inv27m 0 sky130_fd_pr__res_xhigh_po w=10 l=49.614372
XRinv27iap3s0 in27 Rinv27iat3s0 0 sky130_fd_pr__res_xhigh_po w=10 l=49.614372
XRinv27iap3s1 Rinv27iat3s0 Rinv27iat3s1 0 sky130_fd_pr__res_xhigh_po w=10 l=49.614372
XRinv27iap3s2 Rinv27iat3s1 Rinv27iat3s2 0 sky130_fd_pr__res_xhigh_po w=10 l=49.614372
XRinv27iap3s3 Rinv27iat3s2 inv27m 0 sky130_fd_pr__res_xhigh_po w=10 l=49.614372
* PDK sky130_fd_pr__res_xhigh_po Rinv27ib W=10 L=49.614382
* tile Rinv27ib 4s x 4p same W=10 L=49.614382
XRinv27ibp0s0 in27n Rinv27ibt0s0 0 sky130_fd_pr__res_xhigh_po w=10 l=49.614382
XRinv27ibp0s1 Rinv27ibt0s0 Rinv27ibt0s1 0 sky130_fd_pr__res_xhigh_po w=10 l=49.614382
XRinv27ibp0s2 Rinv27ibt0s1 Rinv27ibt0s2 0 sky130_fd_pr__res_xhigh_po w=10 l=49.614382
XRinv27ibp0s3 Rinv27ibt0s2 inv27m 0 sky130_fd_pr__res_xhigh_po w=10 l=49.614382
XRinv27ibp1s0 in27n Rinv27ibt1s0 0 sky130_fd_pr__res_xhigh_po w=10 l=49.614382
XRinv27ibp1s1 Rinv27ibt1s0 Rinv27ibt1s1 0 sky130_fd_pr__res_xhigh_po w=10 l=49.614382
XRinv27ibp1s2 Rinv27ibt1s1 Rinv27ibt1s2 0 sky130_fd_pr__res_xhigh_po w=10 l=49.614382
XRinv27ibp1s3 Rinv27ibt1s2 inv27m 0 sky130_fd_pr__res_xhigh_po w=10 l=49.614382
XRinv27ibp2s0 in27n Rinv27ibt2s0 0 sky130_fd_pr__res_xhigh_po w=10 l=49.614382
XRinv27ibp2s1 Rinv27ibt2s0 Rinv27ibt2s1 0 sky130_fd_pr__res_xhigh_po w=10 l=49.614382
XRinv27ibp2s2 Rinv27ibt2s1 Rinv27ibt2s2 0 sky130_fd_pr__res_xhigh_po w=10 l=49.614382
XRinv27ibp2s3 Rinv27ibt2s2 inv27m 0 sky130_fd_pr__res_xhigh_po w=10 l=49.614382
XRinv27ibp3s0 in27n Rinv27ibt3s0 0 sky130_fd_pr__res_xhigh_po w=10 l=49.614382
XRinv27ibp3s1 Rinv27ibt3s0 Rinv27ibt3s1 0 sky130_fd_pr__res_xhigh_po w=10 l=49.614382
XRinv27ibp3s2 Rinv27ibt3s1 Rinv27ibt3s2 0 sky130_fd_pr__res_xhigh_po w=10 l=49.614382
XRinv27ibp3s3 Rinv27ibt3s2 inv27m 0 sky130_fd_pr__res_xhigh_po w=10 l=49.614382
Einv27amp in27n 0 0 inv27m 10000000
Vin28 in28 0 DC 1.38172289531745
* passive invert in28 -> in28n: R2/R1=1.0000002 closed-loop -1 at A=1e+07
* PDK sky130_fd_pr__res_xhigh_po Rinv28ia W=10 L=49.614372
* tile Rinv28ia 4s x 4p same W=10 L=49.614372
XRinv28iap0s0 in28 Rinv28iat0s0 0 sky130_fd_pr__res_xhigh_po w=10 l=49.614372
XRinv28iap0s1 Rinv28iat0s0 Rinv28iat0s1 0 sky130_fd_pr__res_xhigh_po w=10 l=49.614372
XRinv28iap0s2 Rinv28iat0s1 Rinv28iat0s2 0 sky130_fd_pr__res_xhigh_po w=10 l=49.614372
XRinv28iap0s3 Rinv28iat0s2 inv28m 0 sky130_fd_pr__res_xhigh_po w=10 l=49.614372
XRinv28iap1s0 in28 Rinv28iat1s0 0 sky130_fd_pr__res_xhigh_po w=10 l=49.614372
XRinv28iap1s1 Rinv28iat1s0 Rinv28iat1s1 0 sky130_fd_pr__res_xhigh_po w=10 l=49.614372
XRinv28iap1s2 Rinv28iat1s1 Rinv28iat1s2 0 sky130_fd_pr__res_xhigh_po w=10 l=49.614372
XRinv28iap1s3 Rinv28iat1s2 inv28m 0 sky130_fd_pr__res_xhigh_po w=10 l=49.614372
XRinv28iap2s0 in28 Rinv28iat2s0 0 sky130_fd_pr__res_xhigh_po w=10 l=49.614372
XRinv28iap2s1 Rinv28iat2s0 Rinv28iat2s1 0 sky130_fd_pr__res_xhigh_po w=10 l=49.614372
XRinv28iap2s2 Rinv28iat2s1 Rinv28iat2s2 0 sky130_fd_pr__res_xhigh_po w=10 l=49.614372
XRinv28iap2s3 Rinv28iat2s2 inv28m 0 sky130_fd_pr__res_xhigh_po w=10 l=49.614372
XRinv28iap3s0 in28 Rinv28iat3s0 0 sky130_fd_pr__res_xhigh_po w=10 l=49.614372
XRinv28iap3s1 Rinv28iat3s0 Rinv28iat3s1 0 sky130_fd_pr__res_xhigh_po w=10 l=49.614372
XRinv28iap3s2 Rinv28iat3s1 Rinv28iat3s2 0 sky130_fd_pr__res_xhigh_po w=10 l=49.614372
XRinv28iap3s3 Rinv28iat3s2 inv28m 0 sky130_fd_pr__res_xhigh_po w=10 l=49.614372
* PDK sky130_fd_pr__res_xhigh_po Rinv28ib W=10 L=49.614382
* tile Rinv28ib 4s x 4p same W=10 L=49.614382
XRinv28ibp0s0 in28n Rinv28ibt0s0 0 sky130_fd_pr__res_xhigh_po w=10 l=49.614382
XRinv28ibp0s1 Rinv28ibt0s0 Rinv28ibt0s1 0 sky130_fd_pr__res_xhigh_po w=10 l=49.614382
XRinv28ibp0s2 Rinv28ibt0s1 Rinv28ibt0s2 0 sky130_fd_pr__res_xhigh_po w=10 l=49.614382
XRinv28ibp0s3 Rinv28ibt0s2 inv28m 0 sky130_fd_pr__res_xhigh_po w=10 l=49.614382
XRinv28ibp1s0 in28n Rinv28ibt1s0 0 sky130_fd_pr__res_xhigh_po w=10 l=49.614382
XRinv28ibp1s1 Rinv28ibt1s0 Rinv28ibt1s1 0 sky130_fd_pr__res_xhigh_po w=10 l=49.614382
XRinv28ibp1s2 Rinv28ibt1s1 Rinv28ibt1s2 0 sky130_fd_pr__res_xhigh_po w=10 l=49.614382
XRinv28ibp1s3 Rinv28ibt1s2 inv28m 0 sky130_fd_pr__res_xhigh_po w=10 l=49.614382
XRinv28ibp2s0 in28n Rinv28ibt2s0 0 sky130_fd_pr__res_xhigh_po w=10 l=49.614382
XRinv28ibp2s1 Rinv28ibt2s0 Rinv28ibt2s1 0 sky130_fd_pr__res_xhigh_po w=10 l=49.614382
XRinv28ibp2s2 Rinv28ibt2s1 Rinv28ibt2s2 0 sky130_fd_pr__res_xhigh_po w=10 l=49.614382
XRinv28ibp2s3 Rinv28ibt2s2 inv28m 0 sky130_fd_pr__res_xhigh_po w=10 l=49.614382
XRinv28ibp3s0 in28n Rinv28ibt3s0 0 sky130_fd_pr__res_xhigh_po w=10 l=49.614382
XRinv28ibp3s1 Rinv28ibt3s0 Rinv28ibt3s1 0 sky130_fd_pr__res_xhigh_po w=10 l=49.614382
XRinv28ibp3s2 Rinv28ibt3s1 Rinv28ibt3s2 0 sky130_fd_pr__res_xhigh_po w=10 l=49.614382
XRinv28ibp3s3 Rinv28ibt3s2 inv28m 0 sky130_fd_pr__res_xhigh_po w=10 l=49.614382
Einv28amp in28n 0 0 inv28m 10000000
Vin29 in29 0 DC 0
* passive invert in29 -> in29n: R2/R1=1.0000002 closed-loop -1 at A=1e+07
* PDK sky130_fd_pr__res_xhigh_po Rinv29ia W=10 L=49.614372
* tile Rinv29ia 4s x 4p same W=10 L=49.614372
XRinv29iap0s0 in29 Rinv29iat0s0 0 sky130_fd_pr__res_xhigh_po w=10 l=49.614372
XRinv29iap0s1 Rinv29iat0s0 Rinv29iat0s1 0 sky130_fd_pr__res_xhigh_po w=10 l=49.614372
XRinv29iap0s2 Rinv29iat0s1 Rinv29iat0s2 0 sky130_fd_pr__res_xhigh_po w=10 l=49.614372
XRinv29iap0s3 Rinv29iat0s2 inv29m 0 sky130_fd_pr__res_xhigh_po w=10 l=49.614372
XRinv29iap1s0 in29 Rinv29iat1s0 0 sky130_fd_pr__res_xhigh_po w=10 l=49.614372
XRinv29iap1s1 Rinv29iat1s0 Rinv29iat1s1 0 sky130_fd_pr__res_xhigh_po w=10 l=49.614372
XRinv29iap1s2 Rinv29iat1s1 Rinv29iat1s2 0 sky130_fd_pr__res_xhigh_po w=10 l=49.614372
XRinv29iap1s3 Rinv29iat1s2 inv29m 0 sky130_fd_pr__res_xhigh_po w=10 l=49.614372
XRinv29iap2s0 in29 Rinv29iat2s0 0 sky130_fd_pr__res_xhigh_po w=10 l=49.614372
XRinv29iap2s1 Rinv29iat2s0 Rinv29iat2s1 0 sky130_fd_pr__res_xhigh_po w=10 l=49.614372
XRinv29iap2s2 Rinv29iat2s1 Rinv29iat2s2 0 sky130_fd_pr__res_xhigh_po w=10 l=49.614372
XRinv29iap2s3 Rinv29iat2s2 inv29m 0 sky130_fd_pr__res_xhigh_po w=10 l=49.614372
XRinv29iap3s0 in29 Rinv29iat3s0 0 sky130_fd_pr__res_xhigh_po w=10 l=49.614372
XRinv29iap3s1 Rinv29iat3s0 Rinv29iat3s1 0 sky130_fd_pr__res_xhigh_po w=10 l=49.614372
XRinv29iap3s2 Rinv29iat3s1 Rinv29iat3s2 0 sky130_fd_pr__res_xhigh_po w=10 l=49.614372
XRinv29iap3s3 Rinv29iat3s2 inv29m 0 sky130_fd_pr__res_xhigh_po w=10 l=49.614372
* PDK sky130_fd_pr__res_xhigh_po Rinv29ib W=10 L=49.614382
* tile Rinv29ib 4s x 4p same W=10 L=49.614382
XRinv29ibp0s0 in29n Rinv29ibt0s0 0 sky130_fd_pr__res_xhigh_po w=10 l=49.614382
XRinv29ibp0s1 Rinv29ibt0s0 Rinv29ibt0s1 0 sky130_fd_pr__res_xhigh_po w=10 l=49.614382
XRinv29ibp0s2 Rinv29ibt0s1 Rinv29ibt0s2 0 sky130_fd_pr__res_xhigh_po w=10 l=49.614382
XRinv29ibp0s3 Rinv29ibt0s2 inv29m 0 sky130_fd_pr__res_xhigh_po w=10 l=49.614382
XRinv29ibp1s0 in29n Rinv29ibt1s0 0 sky130_fd_pr__res_xhigh_po w=10 l=49.614382
XRinv29ibp1s1 Rinv29ibt1s0 Rinv29ibt1s1 0 sky130_fd_pr__res_xhigh_po w=10 l=49.614382
XRinv29ibp1s2 Rinv29ibt1s1 Rinv29ibt1s2 0 sky130_fd_pr__res_xhigh_po w=10 l=49.614382
XRinv29ibp1s3 Rinv29ibt1s2 inv29m 0 sky130_fd_pr__res_xhigh_po w=10 l=49.614382
XRinv29ibp2s0 in29n Rinv29ibt2s0 0 sky130_fd_pr__res_xhigh_po w=10 l=49.614382
XRinv29ibp2s1 Rinv29ibt2s0 Rinv29ibt2s1 0 sky130_fd_pr__res_xhigh_po w=10 l=49.614382
XRinv29ibp2s2 Rinv29ibt2s1 Rinv29ibt2s2 0 sky130_fd_pr__res_xhigh_po w=10 l=49.614382
XRinv29ibp2s3 Rinv29ibt2s2 inv29m 0 sky130_fd_pr__res_xhigh_po w=10 l=49.614382
XRinv29ibp3s0 in29n Rinv29ibt3s0 0 sky130_fd_pr__res_xhigh_po w=10 l=49.614382
XRinv29ibp3s1 Rinv29ibt3s0 Rinv29ibt3s1 0 sky130_fd_pr__res_xhigh_po w=10 l=49.614382
XRinv29ibp3s2 Rinv29ibt3s1 Rinv29ibt3s2 0 sky130_fd_pr__res_xhigh_po w=10 l=49.614382
XRinv29ibp3s3 Rinv29ibt3s2 inv29m 0 sky130_fd_pr__res_xhigh_po w=10 l=49.614382
Einv29amp in29n 0 0 inv29m 10000000
* load-compensated divider in29n->tap29n: G_load=0.000275989040257845 Ra=782922.085128668 Rb=1000 target beta=0.001 (no tap buffer)
* PDK sky130_fd_pr__res_xhigh_po Rdiv29na W=10 L=3892.583
* tile Rdiv29na 4s x 4p same W=10 L=3892.583
XRdiv29nap0s0 in29n Rdiv29nat0s0 0 sky130_fd_pr__res_xhigh_po w=10 l=3892.583
XRdiv29nap0s1 Rdiv29nat0s0 Rdiv29nat0s1 0 sky130_fd_pr__res_xhigh_po w=10 l=3892.583
XRdiv29nap0s2 Rdiv29nat0s1 Rdiv29nat0s2 0 sky130_fd_pr__res_xhigh_po w=10 l=3892.583
XRdiv29nap0s3 Rdiv29nat0s2 tap29n 0 sky130_fd_pr__res_xhigh_po w=10 l=3892.583
XRdiv29nap1s0 in29n Rdiv29nat1s0 0 sky130_fd_pr__res_xhigh_po w=10 l=3892.583
XRdiv29nap1s1 Rdiv29nat1s0 Rdiv29nat1s1 0 sky130_fd_pr__res_xhigh_po w=10 l=3892.583
XRdiv29nap1s2 Rdiv29nat1s1 Rdiv29nat1s2 0 sky130_fd_pr__res_xhigh_po w=10 l=3892.583
XRdiv29nap1s3 Rdiv29nat1s2 tap29n 0 sky130_fd_pr__res_xhigh_po w=10 l=3892.583
XRdiv29nap2s0 in29n Rdiv29nat2s0 0 sky130_fd_pr__res_xhigh_po w=10 l=3892.583
XRdiv29nap2s1 Rdiv29nat2s0 Rdiv29nat2s1 0 sky130_fd_pr__res_xhigh_po w=10 l=3892.583
XRdiv29nap2s2 Rdiv29nat2s1 Rdiv29nat2s2 0 sky130_fd_pr__res_xhigh_po w=10 l=3892.583
XRdiv29nap2s3 Rdiv29nat2s2 tap29n 0 sky130_fd_pr__res_xhigh_po w=10 l=3892.583
XRdiv29nap3s0 in29n Rdiv29nat3s0 0 sky130_fd_pr__res_xhigh_po w=10 l=3892.583
XRdiv29nap3s1 Rdiv29nat3s0 Rdiv29nat3s1 0 sky130_fd_pr__res_xhigh_po w=10 l=3892.583
XRdiv29nap3s2 Rdiv29nat3s1 Rdiv29nat3s2 0 sky130_fd_pr__res_xhigh_po w=10 l=3892.583
XRdiv29nap3s3 Rdiv29nat3s2 tap29n 0 sky130_fd_pr__res_xhigh_po w=10 l=3892.583
* PDK sky130_fd_pr__res_xhigh_po Rdiv29nb W=10 L=4.8663717
* tile Rdiv29nb 4s x 4p same W=10 L=4.8663717
XRdiv29nbp0s0 tap29n Rdiv29nbt0s0 0 sky130_fd_pr__res_xhigh_po w=10 l=4.8663717
XRdiv29nbp0s1 Rdiv29nbt0s0 Rdiv29nbt0s1 0 sky130_fd_pr__res_xhigh_po w=10 l=4.8663717
XRdiv29nbp0s2 Rdiv29nbt0s1 Rdiv29nbt0s2 0 sky130_fd_pr__res_xhigh_po w=10 l=4.8663717
XRdiv29nbp0s3 Rdiv29nbt0s2 0 0 sky130_fd_pr__res_xhigh_po w=10 l=4.8663717
XRdiv29nbp1s0 tap29n Rdiv29nbt1s0 0 sky130_fd_pr__res_xhigh_po w=10 l=4.8663717
XRdiv29nbp1s1 Rdiv29nbt1s0 Rdiv29nbt1s1 0 sky130_fd_pr__res_xhigh_po w=10 l=4.8663717
XRdiv29nbp1s2 Rdiv29nbt1s1 Rdiv29nbt1s2 0 sky130_fd_pr__res_xhigh_po w=10 l=4.8663717
XRdiv29nbp1s3 Rdiv29nbt1s2 0 0 sky130_fd_pr__res_xhigh_po w=10 l=4.8663717
XRdiv29nbp2s0 tap29n Rdiv29nbt2s0 0 sky130_fd_pr__res_xhigh_po w=10 l=4.8663717
XRdiv29nbp2s1 Rdiv29nbt2s0 Rdiv29nbt2s1 0 sky130_fd_pr__res_xhigh_po w=10 l=4.8663717
XRdiv29nbp2s2 Rdiv29nbt2s1 Rdiv29nbt2s2 0 sky130_fd_pr__res_xhigh_po w=10 l=4.8663717
XRdiv29nbp2s3 Rdiv29nbt2s2 0 0 sky130_fd_pr__res_xhigh_po w=10 l=4.8663717
XRdiv29nbp3s0 tap29n Rdiv29nbt3s0 0 sky130_fd_pr__res_xhigh_po w=10 l=4.8663717
XRdiv29nbp3s1 Rdiv29nbt3s0 Rdiv29nbt3s1 0 sky130_fd_pr__res_xhigh_po w=10 l=4.8663717
XRdiv29nbp3s2 Rdiv29nbt3s1 Rdiv29nbt3s2 0 sky130_fd_pr__res_xhigh_po w=10 l=4.8663717
XRdiv29nbp3s3 Rdiv29nbt3s2 0 0 sky130_fd_pr__res_xhigh_po w=10 l=4.8663717
Vin30 in30 0 DC 0.0467434987671904
Vin31 in31 0 DC 0.376944739491497
Vin32 in32 0 DC 0.0618086911540602
* passive invert in32 -> in32n: R2/R1=1.0000002 closed-loop -1 at A=1e+07
* PDK sky130_fd_pr__res_xhigh_po Rinv32ia W=10 L=49.614372
* tile Rinv32ia 4s x 4p same W=10 L=49.614372
XRinv32iap0s0 in32 Rinv32iat0s0 0 sky130_fd_pr__res_xhigh_po w=10 l=49.614372
XRinv32iap0s1 Rinv32iat0s0 Rinv32iat0s1 0 sky130_fd_pr__res_xhigh_po w=10 l=49.614372
XRinv32iap0s2 Rinv32iat0s1 Rinv32iat0s2 0 sky130_fd_pr__res_xhigh_po w=10 l=49.614372
XRinv32iap0s3 Rinv32iat0s2 inv32m 0 sky130_fd_pr__res_xhigh_po w=10 l=49.614372
XRinv32iap1s0 in32 Rinv32iat1s0 0 sky130_fd_pr__res_xhigh_po w=10 l=49.614372
XRinv32iap1s1 Rinv32iat1s0 Rinv32iat1s1 0 sky130_fd_pr__res_xhigh_po w=10 l=49.614372
XRinv32iap1s2 Rinv32iat1s1 Rinv32iat1s2 0 sky130_fd_pr__res_xhigh_po w=10 l=49.614372
XRinv32iap1s3 Rinv32iat1s2 inv32m 0 sky130_fd_pr__res_xhigh_po w=10 l=49.614372
XRinv32iap2s0 in32 Rinv32iat2s0 0 sky130_fd_pr__res_xhigh_po w=10 l=49.614372
XRinv32iap2s1 Rinv32iat2s0 Rinv32iat2s1 0 sky130_fd_pr__res_xhigh_po w=10 l=49.614372
XRinv32iap2s2 Rinv32iat2s1 Rinv32iat2s2 0 sky130_fd_pr__res_xhigh_po w=10 l=49.614372
XRinv32iap2s3 Rinv32iat2s2 inv32m 0 sky130_fd_pr__res_xhigh_po w=10 l=49.614372
XRinv32iap3s0 in32 Rinv32iat3s0 0 sky130_fd_pr__res_xhigh_po w=10 l=49.614372
XRinv32iap3s1 Rinv32iat3s0 Rinv32iat3s1 0 sky130_fd_pr__res_xhigh_po w=10 l=49.614372
XRinv32iap3s2 Rinv32iat3s1 Rinv32iat3s2 0 sky130_fd_pr__res_xhigh_po w=10 l=49.614372
XRinv32iap3s3 Rinv32iat3s2 inv32m 0 sky130_fd_pr__res_xhigh_po w=10 l=49.614372
* PDK sky130_fd_pr__res_xhigh_po Rinv32ib W=10 L=49.614382
* tile Rinv32ib 4s x 4p same W=10 L=49.614382
XRinv32ibp0s0 in32n Rinv32ibt0s0 0 sky130_fd_pr__res_xhigh_po w=10 l=49.614382
XRinv32ibp0s1 Rinv32ibt0s0 Rinv32ibt0s1 0 sky130_fd_pr__res_xhigh_po w=10 l=49.614382
XRinv32ibp0s2 Rinv32ibt0s1 Rinv32ibt0s2 0 sky130_fd_pr__res_xhigh_po w=10 l=49.614382
XRinv32ibp0s3 Rinv32ibt0s2 inv32m 0 sky130_fd_pr__res_xhigh_po w=10 l=49.614382
XRinv32ibp1s0 in32n Rinv32ibt1s0 0 sky130_fd_pr__res_xhigh_po w=10 l=49.614382
XRinv32ibp1s1 Rinv32ibt1s0 Rinv32ibt1s1 0 sky130_fd_pr__res_xhigh_po w=10 l=49.614382
XRinv32ibp1s2 Rinv32ibt1s1 Rinv32ibt1s2 0 sky130_fd_pr__res_xhigh_po w=10 l=49.614382
XRinv32ibp1s3 Rinv32ibt1s2 inv32m 0 sky130_fd_pr__res_xhigh_po w=10 l=49.614382
XRinv32ibp2s0 in32n Rinv32ibt2s0 0 sky130_fd_pr__res_xhigh_po w=10 l=49.614382
XRinv32ibp2s1 Rinv32ibt2s0 Rinv32ibt2s1 0 sky130_fd_pr__res_xhigh_po w=10 l=49.614382
XRinv32ibp2s2 Rinv32ibt2s1 Rinv32ibt2s2 0 sky130_fd_pr__res_xhigh_po w=10 l=49.614382
XRinv32ibp2s3 Rinv32ibt2s2 inv32m 0 sky130_fd_pr__res_xhigh_po w=10 l=49.614382
XRinv32ibp3s0 in32n Rinv32ibt3s0 0 sky130_fd_pr__res_xhigh_po w=10 l=49.614382
XRinv32ibp3s1 Rinv32ibt3s0 Rinv32ibt3s1 0 sky130_fd_pr__res_xhigh_po w=10 l=49.614382
XRinv32ibp3s2 Rinv32ibt3s1 Rinv32ibt3s2 0 sky130_fd_pr__res_xhigh_po w=10 l=49.614382
XRinv32ibp3s3 Rinv32ibt3s2 inv32m 0 sky130_fd_pr__res_xhigh_po w=10 l=49.614382
Einv32amp in32n 0 0 inv32m 10000000
Vref vref 0 DC 1
* passive invert vref -> vrefn: R2/R1=1.0000002 closed-loop -1 at A=1e+07
* PDK sky130_fd_pr__res_xhigh_po Rinvrefia W=10 L=49.614372
* tile Rinvrefia 4s x 4p same W=10 L=49.614372
XRinvrefiap0s0 vref Rinvrefiat0s0 0 sky130_fd_pr__res_xhigh_po w=10 l=49.614372
XRinvrefiap0s1 Rinvrefiat0s0 Rinvrefiat0s1 0 sky130_fd_pr__res_xhigh_po w=10 l=49.614372
XRinvrefiap0s2 Rinvrefiat0s1 Rinvrefiat0s2 0 sky130_fd_pr__res_xhigh_po w=10 l=49.614372
XRinvrefiap0s3 Rinvrefiat0s2 invrefm 0 sky130_fd_pr__res_xhigh_po w=10 l=49.614372
XRinvrefiap1s0 vref Rinvrefiat1s0 0 sky130_fd_pr__res_xhigh_po w=10 l=49.614372
XRinvrefiap1s1 Rinvrefiat1s0 Rinvrefiat1s1 0 sky130_fd_pr__res_xhigh_po w=10 l=49.614372
XRinvrefiap1s2 Rinvrefiat1s1 Rinvrefiat1s2 0 sky130_fd_pr__res_xhigh_po w=10 l=49.614372
XRinvrefiap1s3 Rinvrefiat1s2 invrefm 0 sky130_fd_pr__res_xhigh_po w=10 l=49.614372
XRinvrefiap2s0 vref Rinvrefiat2s0 0 sky130_fd_pr__res_xhigh_po w=10 l=49.614372
XRinvrefiap2s1 Rinvrefiat2s0 Rinvrefiat2s1 0 sky130_fd_pr__res_xhigh_po w=10 l=49.614372
XRinvrefiap2s2 Rinvrefiat2s1 Rinvrefiat2s2 0 sky130_fd_pr__res_xhigh_po w=10 l=49.614372
XRinvrefiap2s3 Rinvrefiat2s2 invrefm 0 sky130_fd_pr__res_xhigh_po w=10 l=49.614372
XRinvrefiap3s0 vref Rinvrefiat3s0 0 sky130_fd_pr__res_xhigh_po w=10 l=49.614372
XRinvrefiap3s1 Rinvrefiat3s0 Rinvrefiat3s1 0 sky130_fd_pr__res_xhigh_po w=10 l=49.614372
XRinvrefiap3s2 Rinvrefiat3s1 Rinvrefiat3s2 0 sky130_fd_pr__res_xhigh_po w=10 l=49.614372
XRinvrefiap3s3 Rinvrefiat3s2 invrefm 0 sky130_fd_pr__res_xhigh_po w=10 l=49.614372
* PDK sky130_fd_pr__res_xhigh_po Rinvrefib W=10 L=49.614382
* tile Rinvrefib 4s x 4p same W=10 L=49.614382
XRinvrefibp0s0 vrefn Rinvrefibt0s0 0 sky130_fd_pr__res_xhigh_po w=10 l=49.614382
XRinvrefibp0s1 Rinvrefibt0s0 Rinvrefibt0s1 0 sky130_fd_pr__res_xhigh_po w=10 l=49.614382
XRinvrefibp0s2 Rinvrefibt0s1 Rinvrefibt0s2 0 sky130_fd_pr__res_xhigh_po w=10 l=49.614382
XRinvrefibp0s3 Rinvrefibt0s2 invrefm 0 sky130_fd_pr__res_xhigh_po w=10 l=49.614382
XRinvrefibp1s0 vrefn Rinvrefibt1s0 0 sky130_fd_pr__res_xhigh_po w=10 l=49.614382
XRinvrefibp1s1 Rinvrefibt1s0 Rinvrefibt1s1 0 sky130_fd_pr__res_xhigh_po w=10 l=49.614382
XRinvrefibp1s2 Rinvrefibt1s1 Rinvrefibt1s2 0 sky130_fd_pr__res_xhigh_po w=10 l=49.614382
XRinvrefibp1s3 Rinvrefibt1s2 invrefm 0 sky130_fd_pr__res_xhigh_po w=10 l=49.614382
XRinvrefibp2s0 vrefn Rinvrefibt2s0 0 sky130_fd_pr__res_xhigh_po w=10 l=49.614382
XRinvrefibp2s1 Rinvrefibt2s0 Rinvrefibt2s1 0 sky130_fd_pr__res_xhigh_po w=10 l=49.614382
XRinvrefibp2s2 Rinvrefibt2s1 Rinvrefibt2s2 0 sky130_fd_pr__res_xhigh_po w=10 l=49.614382
XRinvrefibp2s3 Rinvrefibt2s2 invrefm 0 sky130_fd_pr__res_xhigh_po w=10 l=49.614382
XRinvrefibp3s0 vrefn Rinvrefibt3s0 0 sky130_fd_pr__res_xhigh_po w=10 l=49.614382
XRinvrefibp3s1 Rinvrefibt3s0 Rinvrefibt3s1 0 sky130_fd_pr__res_xhigh_po w=10 l=49.614382
XRinvrefibp3s2 Rinvrefibt3s1 Rinvrefibt3s2 0 sky130_fd_pr__res_xhigh_po w=10 l=49.614382
XRinvrefibp3s3 Rinvrefibt3s2 invrefm 0 sky130_fd_pr__res_xhigh_po w=10 l=49.614382
Einvrefamp vrefn 0 0 invrefm 10000000
* load-compensated divider vrefn->taprefn: G_load=0.000966391595827364 Ra=508037.159088685 Rb=1000 target beta=0.001 (no tap buffer)
* PDK sky130_fd_pr__res_xhigh_po Rdivrefna W=10 L=2525.8551
* tile Rdivrefna 4s x 4p same W=10 L=2525.8551
XRdivrefnap0s0 vrefn Rdivrefnat0s0 0 sky130_fd_pr__res_xhigh_po w=10 l=2525.8551
XRdivrefnap0s1 Rdivrefnat0s0 Rdivrefnat0s1 0 sky130_fd_pr__res_xhigh_po w=10 l=2525.8551
XRdivrefnap0s2 Rdivrefnat0s1 Rdivrefnat0s2 0 sky130_fd_pr__res_xhigh_po w=10 l=2525.8551
XRdivrefnap0s3 Rdivrefnat0s2 taprefn 0 sky130_fd_pr__res_xhigh_po w=10 l=2525.8551
XRdivrefnap1s0 vrefn Rdivrefnat1s0 0 sky130_fd_pr__res_xhigh_po w=10 l=2525.8551
XRdivrefnap1s1 Rdivrefnat1s0 Rdivrefnat1s1 0 sky130_fd_pr__res_xhigh_po w=10 l=2525.8551
XRdivrefnap1s2 Rdivrefnat1s1 Rdivrefnat1s2 0 sky130_fd_pr__res_xhigh_po w=10 l=2525.8551
XRdivrefnap1s3 Rdivrefnat1s2 taprefn 0 sky130_fd_pr__res_xhigh_po w=10 l=2525.8551
XRdivrefnap2s0 vrefn Rdivrefnat2s0 0 sky130_fd_pr__res_xhigh_po w=10 l=2525.8551
XRdivrefnap2s1 Rdivrefnat2s0 Rdivrefnat2s1 0 sky130_fd_pr__res_xhigh_po w=10 l=2525.8551
XRdivrefnap2s2 Rdivrefnat2s1 Rdivrefnat2s2 0 sky130_fd_pr__res_xhigh_po w=10 l=2525.8551
XRdivrefnap2s3 Rdivrefnat2s2 taprefn 0 sky130_fd_pr__res_xhigh_po w=10 l=2525.8551
XRdivrefnap3s0 vrefn Rdivrefnat3s0 0 sky130_fd_pr__res_xhigh_po w=10 l=2525.8551
XRdivrefnap3s1 Rdivrefnat3s0 Rdivrefnat3s1 0 sky130_fd_pr__res_xhigh_po w=10 l=2525.8551
XRdivrefnap3s2 Rdivrefnat3s1 Rdivrefnat3s2 0 sky130_fd_pr__res_xhigh_po w=10 l=2525.8551
XRdivrefnap3s3 Rdivrefnat3s2 taprefn 0 sky130_fd_pr__res_xhigh_po w=10 l=2525.8551
* PDK sky130_fd_pr__res_xhigh_po Rdivrefnb W=10 L=4.8663717
* tile Rdivrefnb 4s x 4p same W=10 L=4.8663717
XRdivrefnbp0s0 taprefn Rdivrefnbt0s0 0 sky130_fd_pr__res_xhigh_po w=10 l=4.8663717
XRdivrefnbp0s1 Rdivrefnbt0s0 Rdivrefnbt0s1 0 sky130_fd_pr__res_xhigh_po w=10 l=4.8663717
XRdivrefnbp0s2 Rdivrefnbt0s1 Rdivrefnbt0s2 0 sky130_fd_pr__res_xhigh_po w=10 l=4.8663717
XRdivrefnbp0s3 Rdivrefnbt0s2 0 0 sky130_fd_pr__res_xhigh_po w=10 l=4.8663717
XRdivrefnbp1s0 taprefn Rdivrefnbt1s0 0 sky130_fd_pr__res_xhigh_po w=10 l=4.8663717
XRdivrefnbp1s1 Rdivrefnbt1s0 Rdivrefnbt1s1 0 sky130_fd_pr__res_xhigh_po w=10 l=4.8663717
XRdivrefnbp1s2 Rdivrefnbt1s1 Rdivrefnbt1s2 0 sky130_fd_pr__res_xhigh_po w=10 l=4.8663717
XRdivrefnbp1s3 Rdivrefnbt1s2 0 0 sky130_fd_pr__res_xhigh_po w=10 l=4.8663717
XRdivrefnbp2s0 taprefn Rdivrefnbt2s0 0 sky130_fd_pr__res_xhigh_po w=10 l=4.8663717
XRdivrefnbp2s1 Rdivrefnbt2s0 Rdivrefnbt2s1 0 sky130_fd_pr__res_xhigh_po w=10 l=4.8663717
XRdivrefnbp2s2 Rdivrefnbt2s1 Rdivrefnbt2s2 0 sky130_fd_pr__res_xhigh_po w=10 l=4.8663717
XRdivrefnbp2s3 Rdivrefnbt2s2 0 0 sky130_fd_pr__res_xhigh_po w=10 l=4.8663717
XRdivrefnbp3s0 taprefn Rdivrefnbt3s0 0 sky130_fd_pr__res_xhigh_po w=10 l=4.8663717
XRdivrefnbp3s1 Rdivrefnbt3s0 Rdivrefnbt3s1 0 sky130_fd_pr__res_xhigh_po w=10 l=4.8663717
XRdivrefnbp3s2 Rdivrefnbt3s1 Rdivrefnbt3s2 0 sky130_fd_pr__res_xhigh_po w=10 l=4.8663717
XRdivrefnbp3s3 Rdivrefnbt3s2 0 0 sky130_fd_pr__res_xhigh_po w=10 l=4.8663717

* n1 input 1 w=-0.195521390350609 w-  bank=n alpha=1 R=170484.330505015 G_phys=5.86564171051827e-06 G_eff=5.86564171051827e-06
* PDK sky130_fd_pr__res_xhigh_po Rn1n1n1 W=10 L=847.54246
* tile Rn1n1n1 4s x 4p same W=10 L=847.54246
XRn1n1n1p0s0 in1 Rn1n1n1t0s0 0 sky130_fd_pr__res_xhigh_po w=10 l=847.54246
XRn1n1n1p0s1 Rn1n1n1t0s0 Rn1n1n1t0s1 0 sky130_fd_pr__res_xhigh_po w=10 l=847.54246
XRn1n1n1p0s2 Rn1n1n1t0s1 Rn1n1n1t0s2 0 sky130_fd_pr__res_xhigh_po w=10 l=847.54246
XRn1n1n1p0s3 Rn1n1n1t0s2 n1p 0 sky130_fd_pr__res_xhigh_po w=10 l=847.54246
XRn1n1n1p1s0 in1 Rn1n1n1t1s0 0 sky130_fd_pr__res_xhigh_po w=10 l=847.54246
XRn1n1n1p1s1 Rn1n1n1t1s0 Rn1n1n1t1s1 0 sky130_fd_pr__res_xhigh_po w=10 l=847.54246
XRn1n1n1p1s2 Rn1n1n1t1s1 Rn1n1n1t1s2 0 sky130_fd_pr__res_xhigh_po w=10 l=847.54246
XRn1n1n1p1s3 Rn1n1n1t1s2 n1p 0 sky130_fd_pr__res_xhigh_po w=10 l=847.54246
XRn1n1n1p2s0 in1 Rn1n1n1t2s0 0 sky130_fd_pr__res_xhigh_po w=10 l=847.54246
XRn1n1n1p2s1 Rn1n1n1t2s0 Rn1n1n1t2s1 0 sky130_fd_pr__res_xhigh_po w=10 l=847.54246
XRn1n1n1p2s2 Rn1n1n1t2s1 Rn1n1n1t2s2 0 sky130_fd_pr__res_xhigh_po w=10 l=847.54246
XRn1n1n1p2s3 Rn1n1n1t2s2 n1p 0 sky130_fd_pr__res_xhigh_po w=10 l=847.54246
XRn1n1n1p3s0 in1 Rn1n1n1t3s0 0 sky130_fd_pr__res_xhigh_po w=10 l=847.54246
XRn1n1n1p3s1 Rn1n1n1t3s0 Rn1n1n1t3s1 0 sky130_fd_pr__res_xhigh_po w=10 l=847.54246
XRn1n1n1p3s2 Rn1n1n1t3s1 Rn1n1n1t3s2 0 sky130_fd_pr__res_xhigh_po w=10 l=847.54246
XRn1n1n1p3s3 Rn1n1n1t3s2 n1p 0 sky130_fd_pr__res_xhigh_po w=10 l=847.54246
* n1 input 2 w=+0.386445174905558 w+  bank=n alpha=1 R=86256.3061926689 G_phys=1.15933552471668e-05 G_eff=1.15933552471668e-05
* PDK sky130_fd_pr__res_xhigh_po Rn1p2n1 W=10 L=428.76073
* tile Rn1p2n1 4s x 4p same W=10 L=428.76073
XRn1p2n1p0s0 in2n Rn1p2n1t0s0 0 sky130_fd_pr__res_xhigh_po w=10 l=428.76073
XRn1p2n1p0s1 Rn1p2n1t0s0 Rn1p2n1t0s1 0 sky130_fd_pr__res_xhigh_po w=10 l=428.76073
XRn1p2n1p0s2 Rn1p2n1t0s1 Rn1p2n1t0s2 0 sky130_fd_pr__res_xhigh_po w=10 l=428.76073
XRn1p2n1p0s3 Rn1p2n1t0s2 n1p 0 sky130_fd_pr__res_xhigh_po w=10 l=428.76073
XRn1p2n1p1s0 in2n Rn1p2n1t1s0 0 sky130_fd_pr__res_xhigh_po w=10 l=428.76073
XRn1p2n1p1s1 Rn1p2n1t1s0 Rn1p2n1t1s1 0 sky130_fd_pr__res_xhigh_po w=10 l=428.76073
XRn1p2n1p1s2 Rn1p2n1t1s1 Rn1p2n1t1s2 0 sky130_fd_pr__res_xhigh_po w=10 l=428.76073
XRn1p2n1p1s3 Rn1p2n1t1s2 n1p 0 sky130_fd_pr__res_xhigh_po w=10 l=428.76073
XRn1p2n1p2s0 in2n Rn1p2n1t2s0 0 sky130_fd_pr__res_xhigh_po w=10 l=428.76073
XRn1p2n1p2s1 Rn1p2n1t2s0 Rn1p2n1t2s1 0 sky130_fd_pr__res_xhigh_po w=10 l=428.76073
XRn1p2n1p2s2 Rn1p2n1t2s1 Rn1p2n1t2s2 0 sky130_fd_pr__res_xhigh_po w=10 l=428.76073
XRn1p2n1p2s3 Rn1p2n1t2s2 n1p 0 sky130_fd_pr__res_xhigh_po w=10 l=428.76073
XRn1p2n1p3s0 in2n Rn1p2n1t3s0 0 sky130_fd_pr__res_xhigh_po w=10 l=428.76073
XRn1p2n1p3s1 Rn1p2n1t3s0 Rn1p2n1t3s1 0 sky130_fd_pr__res_xhigh_po w=10 l=428.76073
XRn1p2n1p3s2 Rn1p2n1t3s1 Rn1p2n1t3s2 0 sky130_fd_pr__res_xhigh_po w=10 l=428.76073
XRn1p2n1p3s3 Rn1p2n1t3s2 n1p 0 sky130_fd_pr__res_xhigh_po w=10 l=428.76073
* n1 input 3 w=+0.296294588630229 w+  bank=n alpha=1 R=112500.648383197 G_phys=8.88883765890688e-06 G_eff=8.88883765890688e-06
* PDK sky130_fd_pr__res_xhigh_po Rn1p3n1 W=10 L=559.2476
* tile Rn1p3n1 4s x 4p same W=10 L=559.2476
XRn1p3n1p0s0 in3n Rn1p3n1t0s0 0 sky130_fd_pr__res_xhigh_po w=10 l=559.2476
XRn1p3n1p0s1 Rn1p3n1t0s0 Rn1p3n1t0s1 0 sky130_fd_pr__res_xhigh_po w=10 l=559.2476
XRn1p3n1p0s2 Rn1p3n1t0s1 Rn1p3n1t0s2 0 sky130_fd_pr__res_xhigh_po w=10 l=559.2476
XRn1p3n1p0s3 Rn1p3n1t0s2 n1p 0 sky130_fd_pr__res_xhigh_po w=10 l=559.2476
XRn1p3n1p1s0 in3n Rn1p3n1t1s0 0 sky130_fd_pr__res_xhigh_po w=10 l=559.2476
XRn1p3n1p1s1 Rn1p3n1t1s0 Rn1p3n1t1s1 0 sky130_fd_pr__res_xhigh_po w=10 l=559.2476
XRn1p3n1p1s2 Rn1p3n1t1s1 Rn1p3n1t1s2 0 sky130_fd_pr__res_xhigh_po w=10 l=559.2476
XRn1p3n1p1s3 Rn1p3n1t1s2 n1p 0 sky130_fd_pr__res_xhigh_po w=10 l=559.2476
XRn1p3n1p2s0 in3n Rn1p3n1t2s0 0 sky130_fd_pr__res_xhigh_po w=10 l=559.2476
XRn1p3n1p2s1 Rn1p3n1t2s0 Rn1p3n1t2s1 0 sky130_fd_pr__res_xhigh_po w=10 l=559.2476
XRn1p3n1p2s2 Rn1p3n1t2s1 Rn1p3n1t2s2 0 sky130_fd_pr__res_xhigh_po w=10 l=559.2476
XRn1p3n1p2s3 Rn1p3n1t2s2 n1p 0 sky130_fd_pr__res_xhigh_po w=10 l=559.2476
XRn1p3n1p3s0 in3n Rn1p3n1t3s0 0 sky130_fd_pr__res_xhigh_po w=10 l=559.2476
XRn1p3n1p3s1 Rn1p3n1t3s0 Rn1p3n1t3s1 0 sky130_fd_pr__res_xhigh_po w=10 l=559.2476
XRn1p3n1p3s2 Rn1p3n1t3s1 Rn1p3n1t3s2 0 sky130_fd_pr__res_xhigh_po w=10 l=559.2476
XRn1p3n1p3s3 Rn1p3n1t3s2 n1p 0 sky130_fd_pr__res_xhigh_po w=10 l=559.2476
* n1 input 4 w=-0.299308681857295 w-  bank=n alpha=1 R=111367.746256108 G_phys=8.97926045571886e-06 G_eff=8.97926045571886e-06
* PDK sky130_fd_pr__res_xhigh_po Rn1n4n1 W=10 L=553.61481
* tile Rn1n4n1 4s x 4p same W=10 L=553.61481
XRn1n4n1p0s0 in4 Rn1n4n1t0s0 0 sky130_fd_pr__res_xhigh_po w=10 l=553.61481
XRn1n4n1p0s1 Rn1n4n1t0s0 Rn1n4n1t0s1 0 sky130_fd_pr__res_xhigh_po w=10 l=553.61481
XRn1n4n1p0s2 Rn1n4n1t0s1 Rn1n4n1t0s2 0 sky130_fd_pr__res_xhigh_po w=10 l=553.61481
XRn1n4n1p0s3 Rn1n4n1t0s2 n1p 0 sky130_fd_pr__res_xhigh_po w=10 l=553.61481
XRn1n4n1p1s0 in4 Rn1n4n1t1s0 0 sky130_fd_pr__res_xhigh_po w=10 l=553.61481
XRn1n4n1p1s1 Rn1n4n1t1s0 Rn1n4n1t1s1 0 sky130_fd_pr__res_xhigh_po w=10 l=553.61481
XRn1n4n1p1s2 Rn1n4n1t1s1 Rn1n4n1t1s2 0 sky130_fd_pr__res_xhigh_po w=10 l=553.61481
XRn1n4n1p1s3 Rn1n4n1t1s2 n1p 0 sky130_fd_pr__res_xhigh_po w=10 l=553.61481
XRn1n4n1p2s0 in4 Rn1n4n1t2s0 0 sky130_fd_pr__res_xhigh_po w=10 l=553.61481
XRn1n4n1p2s1 Rn1n4n1t2s0 Rn1n4n1t2s1 0 sky130_fd_pr__res_xhigh_po w=10 l=553.61481
XRn1n4n1p2s2 Rn1n4n1t2s1 Rn1n4n1t2s2 0 sky130_fd_pr__res_xhigh_po w=10 l=553.61481
XRn1n4n1p2s3 Rn1n4n1t2s2 n1p 0 sky130_fd_pr__res_xhigh_po w=10 l=553.61481
XRn1n4n1p3s0 in4 Rn1n4n1t3s0 0 sky130_fd_pr__res_xhigh_po w=10 l=553.61481
XRn1n4n1p3s1 Rn1n4n1t3s0 Rn1n4n1t3s1 0 sky130_fd_pr__res_xhigh_po w=10 l=553.61481
XRn1n4n1p3s2 Rn1n4n1t3s1 Rn1n4n1t3s2 0 sky130_fd_pr__res_xhigh_po w=10 l=553.61481
XRn1n4n1p3s3 Rn1n4n1t3s2 n1p 0 sky130_fd_pr__res_xhigh_po w=10 l=553.61481
* n1 input 5 w=+0.732671792857329 w+  bank=n alpha=1 R=45495.5870531571 G_phys=2.19801537857199e-05 G_eff=2.19801537857199e-05
* PDK sky130_fd_pr__res_xhigh_po Rn1p5n1 W=10 L=226.09843
* tile Rn1p5n1 4s x 4p same W=10 L=226.09843
XRn1p5n1p0s0 in5n Rn1p5n1t0s0 0 sky130_fd_pr__res_xhigh_po w=10 l=226.09843
XRn1p5n1p0s1 Rn1p5n1t0s0 Rn1p5n1t0s1 0 sky130_fd_pr__res_xhigh_po w=10 l=226.09843
XRn1p5n1p0s2 Rn1p5n1t0s1 Rn1p5n1t0s2 0 sky130_fd_pr__res_xhigh_po w=10 l=226.09843
XRn1p5n1p0s3 Rn1p5n1t0s2 n1p 0 sky130_fd_pr__res_xhigh_po w=10 l=226.09843
XRn1p5n1p1s0 in5n Rn1p5n1t1s0 0 sky130_fd_pr__res_xhigh_po w=10 l=226.09843
XRn1p5n1p1s1 Rn1p5n1t1s0 Rn1p5n1t1s1 0 sky130_fd_pr__res_xhigh_po w=10 l=226.09843
XRn1p5n1p1s2 Rn1p5n1t1s1 Rn1p5n1t1s2 0 sky130_fd_pr__res_xhigh_po w=10 l=226.09843
XRn1p5n1p1s3 Rn1p5n1t1s2 n1p 0 sky130_fd_pr__res_xhigh_po w=10 l=226.09843
XRn1p5n1p2s0 in5n Rn1p5n1t2s0 0 sky130_fd_pr__res_xhigh_po w=10 l=226.09843
XRn1p5n1p2s1 Rn1p5n1t2s0 Rn1p5n1t2s1 0 sky130_fd_pr__res_xhigh_po w=10 l=226.09843
XRn1p5n1p2s2 Rn1p5n1t2s1 Rn1p5n1t2s2 0 sky130_fd_pr__res_xhigh_po w=10 l=226.09843
XRn1p5n1p2s3 Rn1p5n1t2s2 n1p 0 sky130_fd_pr__res_xhigh_po w=10 l=226.09843
XRn1p5n1p3s0 in5n Rn1p5n1t3s0 0 sky130_fd_pr__res_xhigh_po w=10 l=226.09843
XRn1p5n1p3s1 Rn1p5n1t3s0 Rn1p5n1t3s1 0 sky130_fd_pr__res_xhigh_po w=10 l=226.09843
XRn1p5n1p3s2 Rn1p5n1t3s1 Rn1p5n1t3s2 0 sky130_fd_pr__res_xhigh_po w=10 l=226.09843
XRn1p5n1p3s3 Rn1p5n1t3s2 n1p 0 sky130_fd_pr__res_xhigh_po w=10 l=226.09843
* n1 input 6 w=+0.124925987288217 w+  bank=n alpha=1 R=266824.65399637 G_phys=3.7477796186465e-06 G_eff=3.7477796186465e-06
* PDK sky130_fd_pr__res_xhigh_po Rn1p6n1 W=10 L=1326.5466
* tile Rn1p6n1 4s x 4p same W=10 L=1326.5466
XRn1p6n1p0s0 in6n Rn1p6n1t0s0 0 sky130_fd_pr__res_xhigh_po w=10 l=1326.5466
XRn1p6n1p0s1 Rn1p6n1t0s0 Rn1p6n1t0s1 0 sky130_fd_pr__res_xhigh_po w=10 l=1326.5466
XRn1p6n1p0s2 Rn1p6n1t0s1 Rn1p6n1t0s2 0 sky130_fd_pr__res_xhigh_po w=10 l=1326.5466
XRn1p6n1p0s3 Rn1p6n1t0s2 n1p 0 sky130_fd_pr__res_xhigh_po w=10 l=1326.5466
XRn1p6n1p1s0 in6n Rn1p6n1t1s0 0 sky130_fd_pr__res_xhigh_po w=10 l=1326.5466
XRn1p6n1p1s1 Rn1p6n1t1s0 Rn1p6n1t1s1 0 sky130_fd_pr__res_xhigh_po w=10 l=1326.5466
XRn1p6n1p1s2 Rn1p6n1t1s1 Rn1p6n1t1s2 0 sky130_fd_pr__res_xhigh_po w=10 l=1326.5466
XRn1p6n1p1s3 Rn1p6n1t1s2 n1p 0 sky130_fd_pr__res_xhigh_po w=10 l=1326.5466
XRn1p6n1p2s0 in6n Rn1p6n1t2s0 0 sky130_fd_pr__res_xhigh_po w=10 l=1326.5466
XRn1p6n1p2s1 Rn1p6n1t2s0 Rn1p6n1t2s1 0 sky130_fd_pr__res_xhigh_po w=10 l=1326.5466
XRn1p6n1p2s2 Rn1p6n1t2s1 Rn1p6n1t2s2 0 sky130_fd_pr__res_xhigh_po w=10 l=1326.5466
XRn1p6n1p2s3 Rn1p6n1t2s2 n1p 0 sky130_fd_pr__res_xhigh_po w=10 l=1326.5466
XRn1p6n1p3s0 in6n Rn1p6n1t3s0 0 sky130_fd_pr__res_xhigh_po w=10 l=1326.5466
XRn1p6n1p3s1 Rn1p6n1t3s0 Rn1p6n1t3s1 0 sky130_fd_pr__res_xhigh_po w=10 l=1326.5466
XRn1p6n1p3s2 Rn1p6n1t3s1 Rn1p6n1t3s2 0 sky130_fd_pr__res_xhigh_po w=10 l=1326.5466
XRn1p6n1p3s3 Rn1p6n1t3s2 n1p 0 sky130_fd_pr__res_xhigh_po w=10 l=1326.5466
* n1 input 7 w=-0.0857938493267301 w-  bank=n alpha=1 R=388528.240601368 G_phys=2.5738154798019e-06 G_eff=2.5738154798019e-06
* PDK sky130_fd_pr__res_xhigh_po Rn1n7n1 W=10 L=1931.6568
* tile Rn1n7n1 4s x 4p same W=10 L=1931.6568
XRn1n7n1p0s0 in7 Rn1n7n1t0s0 0 sky130_fd_pr__res_xhigh_po w=10 l=1931.6568
XRn1n7n1p0s1 Rn1n7n1t0s0 Rn1n7n1t0s1 0 sky130_fd_pr__res_xhigh_po w=10 l=1931.6568
XRn1n7n1p0s2 Rn1n7n1t0s1 Rn1n7n1t0s2 0 sky130_fd_pr__res_xhigh_po w=10 l=1931.6568
XRn1n7n1p0s3 Rn1n7n1t0s2 n1p 0 sky130_fd_pr__res_xhigh_po w=10 l=1931.6568
XRn1n7n1p1s0 in7 Rn1n7n1t1s0 0 sky130_fd_pr__res_xhigh_po w=10 l=1931.6568
XRn1n7n1p1s1 Rn1n7n1t1s0 Rn1n7n1t1s1 0 sky130_fd_pr__res_xhigh_po w=10 l=1931.6568
XRn1n7n1p1s2 Rn1n7n1t1s1 Rn1n7n1t1s2 0 sky130_fd_pr__res_xhigh_po w=10 l=1931.6568
XRn1n7n1p1s3 Rn1n7n1t1s2 n1p 0 sky130_fd_pr__res_xhigh_po w=10 l=1931.6568
XRn1n7n1p2s0 in7 Rn1n7n1t2s0 0 sky130_fd_pr__res_xhigh_po w=10 l=1931.6568
XRn1n7n1p2s1 Rn1n7n1t2s0 Rn1n7n1t2s1 0 sky130_fd_pr__res_xhigh_po w=10 l=1931.6568
XRn1n7n1p2s2 Rn1n7n1t2s1 Rn1n7n1t2s2 0 sky130_fd_pr__res_xhigh_po w=10 l=1931.6568
XRn1n7n1p2s3 Rn1n7n1t2s2 n1p 0 sky130_fd_pr__res_xhigh_po w=10 l=1931.6568
XRn1n7n1p3s0 in7 Rn1n7n1t3s0 0 sky130_fd_pr__res_xhigh_po w=10 l=1931.6568
XRn1n7n1p3s1 Rn1n7n1t3s0 Rn1n7n1t3s1 0 sky130_fd_pr__res_xhigh_po w=10 l=1931.6568
XRn1n7n1p3s2 Rn1n7n1t3s1 Rn1n7n1t3s2 0 sky130_fd_pr__res_xhigh_po w=10 l=1931.6568
XRn1n7n1p3s3 Rn1n7n1t3s2 n1p 0 sky130_fd_pr__res_xhigh_po w=10 l=1931.6568
* n1 input 8 w=-0.0609936542707342 w-  bank=n alpha=1 R=546504.939438057 G_phys=1.82980962812202e-06 G_eff=1.82980962812202e-06
* PDK sky130_fd_pr__res_xhigh_po Rn1n8n1 W=10 L=2717.1169
* tile Rn1n8n1 4s x 4p same W=10 L=2717.1169
XRn1n8n1p0s0 in8 Rn1n8n1t0s0 0 sky130_fd_pr__res_xhigh_po w=10 l=2717.1169
XRn1n8n1p0s1 Rn1n8n1t0s0 Rn1n8n1t0s1 0 sky130_fd_pr__res_xhigh_po w=10 l=2717.1169
XRn1n8n1p0s2 Rn1n8n1t0s1 Rn1n8n1t0s2 0 sky130_fd_pr__res_xhigh_po w=10 l=2717.1169
XRn1n8n1p0s3 Rn1n8n1t0s2 n1p 0 sky130_fd_pr__res_xhigh_po w=10 l=2717.1169
XRn1n8n1p1s0 in8 Rn1n8n1t1s0 0 sky130_fd_pr__res_xhigh_po w=10 l=2717.1169
XRn1n8n1p1s1 Rn1n8n1t1s0 Rn1n8n1t1s1 0 sky130_fd_pr__res_xhigh_po w=10 l=2717.1169
XRn1n8n1p1s2 Rn1n8n1t1s1 Rn1n8n1t1s2 0 sky130_fd_pr__res_xhigh_po w=10 l=2717.1169
XRn1n8n1p1s3 Rn1n8n1t1s2 n1p 0 sky130_fd_pr__res_xhigh_po w=10 l=2717.1169
XRn1n8n1p2s0 in8 Rn1n8n1t2s0 0 sky130_fd_pr__res_xhigh_po w=10 l=2717.1169
XRn1n8n1p2s1 Rn1n8n1t2s0 Rn1n8n1t2s1 0 sky130_fd_pr__res_xhigh_po w=10 l=2717.1169
XRn1n8n1p2s2 Rn1n8n1t2s1 Rn1n8n1t2s2 0 sky130_fd_pr__res_xhigh_po w=10 l=2717.1169
XRn1n8n1p2s3 Rn1n8n1t2s2 n1p 0 sky130_fd_pr__res_xhigh_po w=10 l=2717.1169
XRn1n8n1p3s0 in8 Rn1n8n1t3s0 0 sky130_fd_pr__res_xhigh_po w=10 l=2717.1169
XRn1n8n1p3s1 Rn1n8n1t3s0 Rn1n8n1t3s1 0 sky130_fd_pr__res_xhigh_po w=10 l=2717.1169
XRn1n8n1p3s2 Rn1n8n1t3s1 Rn1n8n1t3s2 0 sky130_fd_pr__res_xhigh_po w=10 l=2717.1169
XRn1n8n1p3s3 Rn1n8n1t3s2 n1p 0 sky130_fd_pr__res_xhigh_po w=10 l=2717.1169
* n1 input 9 w=+0.256981204903229 w+  bank=n alpha=1 R=129711.172246568 G_phys=7.70943614709688e-06 G_eff=7.70943614709688e-06
* PDK sky130_fd_pr__res_xhigh_po Rn1p9n1 W=10 L=644.81832
* tile Rn1p9n1 4s x 4p same W=10 L=644.81832
XRn1p9n1p0s0 in9n Rn1p9n1t0s0 0 sky130_fd_pr__res_xhigh_po w=10 l=644.81832
XRn1p9n1p0s1 Rn1p9n1t0s0 Rn1p9n1t0s1 0 sky130_fd_pr__res_xhigh_po w=10 l=644.81832
XRn1p9n1p0s2 Rn1p9n1t0s1 Rn1p9n1t0s2 0 sky130_fd_pr__res_xhigh_po w=10 l=644.81832
XRn1p9n1p0s3 Rn1p9n1t0s2 n1p 0 sky130_fd_pr__res_xhigh_po w=10 l=644.81832
XRn1p9n1p1s0 in9n Rn1p9n1t1s0 0 sky130_fd_pr__res_xhigh_po w=10 l=644.81832
XRn1p9n1p1s1 Rn1p9n1t1s0 Rn1p9n1t1s1 0 sky130_fd_pr__res_xhigh_po w=10 l=644.81832
XRn1p9n1p1s2 Rn1p9n1t1s1 Rn1p9n1t1s2 0 sky130_fd_pr__res_xhigh_po w=10 l=644.81832
XRn1p9n1p1s3 Rn1p9n1t1s2 n1p 0 sky130_fd_pr__res_xhigh_po w=10 l=644.81832
XRn1p9n1p2s0 in9n Rn1p9n1t2s0 0 sky130_fd_pr__res_xhigh_po w=10 l=644.81832
XRn1p9n1p2s1 Rn1p9n1t2s0 Rn1p9n1t2s1 0 sky130_fd_pr__res_xhigh_po w=10 l=644.81832
XRn1p9n1p2s2 Rn1p9n1t2s1 Rn1p9n1t2s2 0 sky130_fd_pr__res_xhigh_po w=10 l=644.81832
XRn1p9n1p2s3 Rn1p9n1t2s2 n1p 0 sky130_fd_pr__res_xhigh_po w=10 l=644.81832
XRn1p9n1p3s0 in9n Rn1p9n1t3s0 0 sky130_fd_pr__res_xhigh_po w=10 l=644.81832
XRn1p9n1p3s1 Rn1p9n1t3s0 Rn1p9n1t3s1 0 sky130_fd_pr__res_xhigh_po w=10 l=644.81832
XRn1p9n1p3s2 Rn1p9n1t3s1 Rn1p9n1t3s2 0 sky130_fd_pr__res_xhigh_po w=10 l=644.81832
XRn1p9n1p3s3 Rn1p9n1t3s2 n1p 0 sky130_fd_pr__res_xhigh_po w=10 l=644.81832
* n1 input 10 w=+0.073638013162671 w+  bank=n alpha=1 R=452664.756987643 G_phys=2.20914039488013e-06 G_eff=2.20914039488013e-06
* PDK sky130_fd_pr__res_xhigh_po Rn1p10n1 W=10 L=2250.5435
* tile Rn1p10n1 4s x 4p same W=10 L=2250.5435
XRn1p10n1p0s0 in10n Rn1p10n1t0s0 0 sky130_fd_pr__res_xhigh_po w=10 l=2250.5435
XRn1p10n1p0s1 Rn1p10n1t0s0 Rn1p10n1t0s1 0 sky130_fd_pr__res_xhigh_po w=10 l=2250.5435
XRn1p10n1p0s2 Rn1p10n1t0s1 Rn1p10n1t0s2 0 sky130_fd_pr__res_xhigh_po w=10 l=2250.5435
XRn1p10n1p0s3 Rn1p10n1t0s2 n1p 0 sky130_fd_pr__res_xhigh_po w=10 l=2250.5435
XRn1p10n1p1s0 in10n Rn1p10n1t1s0 0 sky130_fd_pr__res_xhigh_po w=10 l=2250.5435
XRn1p10n1p1s1 Rn1p10n1t1s0 Rn1p10n1t1s1 0 sky130_fd_pr__res_xhigh_po w=10 l=2250.5435
XRn1p10n1p1s2 Rn1p10n1t1s1 Rn1p10n1t1s2 0 sky130_fd_pr__res_xhigh_po w=10 l=2250.5435
XRn1p10n1p1s3 Rn1p10n1t1s2 n1p 0 sky130_fd_pr__res_xhigh_po w=10 l=2250.5435
XRn1p10n1p2s0 in10n Rn1p10n1t2s0 0 sky130_fd_pr__res_xhigh_po w=10 l=2250.5435
XRn1p10n1p2s1 Rn1p10n1t2s0 Rn1p10n1t2s1 0 sky130_fd_pr__res_xhigh_po w=10 l=2250.5435
XRn1p10n1p2s2 Rn1p10n1t2s1 Rn1p10n1t2s2 0 sky130_fd_pr__res_xhigh_po w=10 l=2250.5435
XRn1p10n1p2s3 Rn1p10n1t2s2 n1p 0 sky130_fd_pr__res_xhigh_po w=10 l=2250.5435
XRn1p10n1p3s0 in10n Rn1p10n1t3s0 0 sky130_fd_pr__res_xhigh_po w=10 l=2250.5435
XRn1p10n1p3s1 Rn1p10n1t3s0 Rn1p10n1t3s1 0 sky130_fd_pr__res_xhigh_po w=10 l=2250.5435
XRn1p10n1p3s2 Rn1p10n1t3s1 Rn1p10n1t3s2 0 sky130_fd_pr__res_xhigh_po w=10 l=2250.5435
XRn1p10n1p3s3 Rn1p10n1t3s2 n1p 0 sky130_fd_pr__res_xhigh_po w=10 l=2250.5435
* n1 input 11 w=-0.149208279345328 w-  bank=n alpha=1 R=223401.365390634 G_phys=4.47624838035983e-06 G_eff=4.47624838035983e-06
* PDK sky130_fd_pr__res_xhigh_po Rn1n11n1 W=10 L=1110.646
* tile Rn1n11n1 4s x 4p same W=10 L=1110.646
XRn1n11n1p0s0 in11 Rn1n11n1t0s0 0 sky130_fd_pr__res_xhigh_po w=10 l=1110.646
XRn1n11n1p0s1 Rn1n11n1t0s0 Rn1n11n1t0s1 0 sky130_fd_pr__res_xhigh_po w=10 l=1110.646
XRn1n11n1p0s2 Rn1n11n1t0s1 Rn1n11n1t0s2 0 sky130_fd_pr__res_xhigh_po w=10 l=1110.646
XRn1n11n1p0s3 Rn1n11n1t0s2 n1p 0 sky130_fd_pr__res_xhigh_po w=10 l=1110.646
XRn1n11n1p1s0 in11 Rn1n11n1t1s0 0 sky130_fd_pr__res_xhigh_po w=10 l=1110.646
XRn1n11n1p1s1 Rn1n11n1t1s0 Rn1n11n1t1s1 0 sky130_fd_pr__res_xhigh_po w=10 l=1110.646
XRn1n11n1p1s2 Rn1n11n1t1s1 Rn1n11n1t1s2 0 sky130_fd_pr__res_xhigh_po w=10 l=1110.646
XRn1n11n1p1s3 Rn1n11n1t1s2 n1p 0 sky130_fd_pr__res_xhigh_po w=10 l=1110.646
XRn1n11n1p2s0 in11 Rn1n11n1t2s0 0 sky130_fd_pr__res_xhigh_po w=10 l=1110.646
XRn1n11n1p2s1 Rn1n11n1t2s0 Rn1n11n1t2s1 0 sky130_fd_pr__res_xhigh_po w=10 l=1110.646
XRn1n11n1p2s2 Rn1n11n1t2s1 Rn1n11n1t2s2 0 sky130_fd_pr__res_xhigh_po w=10 l=1110.646
XRn1n11n1p2s3 Rn1n11n1t2s2 n1p 0 sky130_fd_pr__res_xhigh_po w=10 l=1110.646
XRn1n11n1p3s0 in11 Rn1n11n1t3s0 0 sky130_fd_pr__res_xhigh_po w=10 l=1110.646
XRn1n11n1p3s1 Rn1n11n1t3s0 Rn1n11n1t3s1 0 sky130_fd_pr__res_xhigh_po w=10 l=1110.646
XRn1n11n1p3s2 Rn1n11n1t3s1 Rn1n11n1t3s2 0 sky130_fd_pr__res_xhigh_po w=10 l=1110.646
XRn1n11n1p3s3 Rn1n11n1t3s2 n1p 0 sky130_fd_pr__res_xhigh_po w=10 l=1110.646
* n1 input 12 w=-0.475362564845884 w-  bank=n alpha=1 R=70121.9149306388 G_phys=1.42608769453765e-05 G_eff=1.42608769453765e-05
* PDK sky130_fd_pr__res_xhigh_po Rn1n12n1 W=10 L=348.54053
* tile Rn1n12n1 4s x 4p same W=10 L=348.54053
XRn1n12n1p0s0 in12 Rn1n12n1t0s0 0 sky130_fd_pr__res_xhigh_po w=10 l=348.54053
XRn1n12n1p0s1 Rn1n12n1t0s0 Rn1n12n1t0s1 0 sky130_fd_pr__res_xhigh_po w=10 l=348.54053
XRn1n12n1p0s2 Rn1n12n1t0s1 Rn1n12n1t0s2 0 sky130_fd_pr__res_xhigh_po w=10 l=348.54053
XRn1n12n1p0s3 Rn1n12n1t0s2 n1p 0 sky130_fd_pr__res_xhigh_po w=10 l=348.54053
XRn1n12n1p1s0 in12 Rn1n12n1t1s0 0 sky130_fd_pr__res_xhigh_po w=10 l=348.54053
XRn1n12n1p1s1 Rn1n12n1t1s0 Rn1n12n1t1s1 0 sky130_fd_pr__res_xhigh_po w=10 l=348.54053
XRn1n12n1p1s2 Rn1n12n1t1s1 Rn1n12n1t1s2 0 sky130_fd_pr__res_xhigh_po w=10 l=348.54053
XRn1n12n1p1s3 Rn1n12n1t1s2 n1p 0 sky130_fd_pr__res_xhigh_po w=10 l=348.54053
XRn1n12n1p2s0 in12 Rn1n12n1t2s0 0 sky130_fd_pr__res_xhigh_po w=10 l=348.54053
XRn1n12n1p2s1 Rn1n12n1t2s0 Rn1n12n1t2s1 0 sky130_fd_pr__res_xhigh_po w=10 l=348.54053
XRn1n12n1p2s2 Rn1n12n1t2s1 Rn1n12n1t2s2 0 sky130_fd_pr__res_xhigh_po w=10 l=348.54053
XRn1n12n1p2s3 Rn1n12n1t2s2 n1p 0 sky130_fd_pr__res_xhigh_po w=10 l=348.54053
XRn1n12n1p3s0 in12 Rn1n12n1t3s0 0 sky130_fd_pr__res_xhigh_po w=10 l=348.54053
XRn1n12n1p3s1 Rn1n12n1t3s0 Rn1n12n1t3s1 0 sky130_fd_pr__res_xhigh_po w=10 l=348.54053
XRn1n12n1p3s2 Rn1n12n1t3s1 Rn1n12n1t3s2 0 sky130_fd_pr__res_xhigh_po w=10 l=348.54053
XRn1n12n1p3s3 Rn1n12n1t3s2 n1p 0 sky130_fd_pr__res_xhigh_po w=10 l=348.54053
* n1 input 13 w=-0.0533811781970356 w-  bank=n alpha=1 R=624439.820535554 G_phys=1.60143534591107e-06 G_eff=1.60143534591107e-06
* PDK sky130_fd_pr__res_xhigh_po Rn1n13n1 W=10 L=3104.6092
* tile Rn1n13n1 4s x 4p same W=10 L=3104.6092
XRn1n13n1p0s0 in13 Rn1n13n1t0s0 0 sky130_fd_pr__res_xhigh_po w=10 l=3104.6092
XRn1n13n1p0s1 Rn1n13n1t0s0 Rn1n13n1t0s1 0 sky130_fd_pr__res_xhigh_po w=10 l=3104.6092
XRn1n13n1p0s2 Rn1n13n1t0s1 Rn1n13n1t0s2 0 sky130_fd_pr__res_xhigh_po w=10 l=3104.6092
XRn1n13n1p0s3 Rn1n13n1t0s2 n1p 0 sky130_fd_pr__res_xhigh_po w=10 l=3104.6092
XRn1n13n1p1s0 in13 Rn1n13n1t1s0 0 sky130_fd_pr__res_xhigh_po w=10 l=3104.6092
XRn1n13n1p1s1 Rn1n13n1t1s0 Rn1n13n1t1s1 0 sky130_fd_pr__res_xhigh_po w=10 l=3104.6092
XRn1n13n1p1s2 Rn1n13n1t1s1 Rn1n13n1t1s2 0 sky130_fd_pr__res_xhigh_po w=10 l=3104.6092
XRn1n13n1p1s3 Rn1n13n1t1s2 n1p 0 sky130_fd_pr__res_xhigh_po w=10 l=3104.6092
XRn1n13n1p2s0 in13 Rn1n13n1t2s0 0 sky130_fd_pr__res_xhigh_po w=10 l=3104.6092
XRn1n13n1p2s1 Rn1n13n1t2s0 Rn1n13n1t2s1 0 sky130_fd_pr__res_xhigh_po w=10 l=3104.6092
XRn1n13n1p2s2 Rn1n13n1t2s1 Rn1n13n1t2s2 0 sky130_fd_pr__res_xhigh_po w=10 l=3104.6092
XRn1n13n1p2s3 Rn1n13n1t2s2 n1p 0 sky130_fd_pr__res_xhigh_po w=10 l=3104.6092
XRn1n13n1p3s0 in13 Rn1n13n1t3s0 0 sky130_fd_pr__res_xhigh_po w=10 l=3104.6092
XRn1n13n1p3s1 Rn1n13n1t3s0 Rn1n13n1t3s1 0 sky130_fd_pr__res_xhigh_po w=10 l=3104.6092
XRn1n13n1p3s2 Rn1n13n1t3s1 Rn1n13n1t3s2 0 sky130_fd_pr__res_xhigh_po w=10 l=3104.6092
XRn1n13n1p3s3 Rn1n13n1t3s2 n1p 0 sky130_fd_pr__res_xhigh_po w=10 l=3104.6092
* n1 input 14 w=+0.279456004632752 w+  bank=n alpha=1 R=119279.359830319 G_phys=8.38368013898257e-06 G_eff=8.38368013898257e-06
* PDK sky130_fd_pr__res_xhigh_po Rn1p14n1 W=10 L=592.95135
* tile Rn1p14n1 4s x 4p same W=10 L=592.95135
XRn1p14n1p0s0 in14n Rn1p14n1t0s0 0 sky130_fd_pr__res_xhigh_po w=10 l=592.95135
XRn1p14n1p0s1 Rn1p14n1t0s0 Rn1p14n1t0s1 0 sky130_fd_pr__res_xhigh_po w=10 l=592.95135
XRn1p14n1p0s2 Rn1p14n1t0s1 Rn1p14n1t0s2 0 sky130_fd_pr__res_xhigh_po w=10 l=592.95135
XRn1p14n1p0s3 Rn1p14n1t0s2 n1p 0 sky130_fd_pr__res_xhigh_po w=10 l=592.95135
XRn1p14n1p1s0 in14n Rn1p14n1t1s0 0 sky130_fd_pr__res_xhigh_po w=10 l=592.95135
XRn1p14n1p1s1 Rn1p14n1t1s0 Rn1p14n1t1s1 0 sky130_fd_pr__res_xhigh_po w=10 l=592.95135
XRn1p14n1p1s2 Rn1p14n1t1s1 Rn1p14n1t1s2 0 sky130_fd_pr__res_xhigh_po w=10 l=592.95135
XRn1p14n1p1s3 Rn1p14n1t1s2 n1p 0 sky130_fd_pr__res_xhigh_po w=10 l=592.95135
XRn1p14n1p2s0 in14n Rn1p14n1t2s0 0 sky130_fd_pr__res_xhigh_po w=10 l=592.95135
XRn1p14n1p2s1 Rn1p14n1t2s0 Rn1p14n1t2s1 0 sky130_fd_pr__res_xhigh_po w=10 l=592.95135
XRn1p14n1p2s2 Rn1p14n1t2s1 Rn1p14n1t2s2 0 sky130_fd_pr__res_xhigh_po w=10 l=592.95135
XRn1p14n1p2s3 Rn1p14n1t2s2 n1p 0 sky130_fd_pr__res_xhigh_po w=10 l=592.95135
XRn1p14n1p3s0 in14n Rn1p14n1t3s0 0 sky130_fd_pr__res_xhigh_po w=10 l=592.95135
XRn1p14n1p3s1 Rn1p14n1t3s0 Rn1p14n1t3s1 0 sky130_fd_pr__res_xhigh_po w=10 l=592.95135
XRn1p14n1p3s2 Rn1p14n1t3s1 Rn1p14n1t3s2 0 sky130_fd_pr__res_xhigh_po w=10 l=592.95135
XRn1p14n1p3s3 Rn1p14n1t3s2 n1p 0 sky130_fd_pr__res_xhigh_po w=10 l=592.95135
* n1 input 15 w=-0.0744870090943736 w-  bank=n alpha=1 R=447505.326614748 G_phys=2.23461027283121e-06 G_eff=2.23461027283121e-06
* PDK sky130_fd_pr__res_xhigh_po Rn1n15n1 W=10 L=2224.8909
* tile Rn1n15n1 4s x 4p same W=10 L=2224.8909
XRn1n15n1p0s0 in15 Rn1n15n1t0s0 0 sky130_fd_pr__res_xhigh_po w=10 l=2224.8909
XRn1n15n1p0s1 Rn1n15n1t0s0 Rn1n15n1t0s1 0 sky130_fd_pr__res_xhigh_po w=10 l=2224.8909
XRn1n15n1p0s2 Rn1n15n1t0s1 Rn1n15n1t0s2 0 sky130_fd_pr__res_xhigh_po w=10 l=2224.8909
XRn1n15n1p0s3 Rn1n15n1t0s2 n1p 0 sky130_fd_pr__res_xhigh_po w=10 l=2224.8909
XRn1n15n1p1s0 in15 Rn1n15n1t1s0 0 sky130_fd_pr__res_xhigh_po w=10 l=2224.8909
XRn1n15n1p1s1 Rn1n15n1t1s0 Rn1n15n1t1s1 0 sky130_fd_pr__res_xhigh_po w=10 l=2224.8909
XRn1n15n1p1s2 Rn1n15n1t1s1 Rn1n15n1t1s2 0 sky130_fd_pr__res_xhigh_po w=10 l=2224.8909
XRn1n15n1p1s3 Rn1n15n1t1s2 n1p 0 sky130_fd_pr__res_xhigh_po w=10 l=2224.8909
XRn1n15n1p2s0 in15 Rn1n15n1t2s0 0 sky130_fd_pr__res_xhigh_po w=10 l=2224.8909
XRn1n15n1p2s1 Rn1n15n1t2s0 Rn1n15n1t2s1 0 sky130_fd_pr__res_xhigh_po w=10 l=2224.8909
XRn1n15n1p2s2 Rn1n15n1t2s1 Rn1n15n1t2s2 0 sky130_fd_pr__res_xhigh_po w=10 l=2224.8909
XRn1n15n1p2s3 Rn1n15n1t2s2 n1p 0 sky130_fd_pr__res_xhigh_po w=10 l=2224.8909
XRn1n15n1p3s0 in15 Rn1n15n1t3s0 0 sky130_fd_pr__res_xhigh_po w=10 l=2224.8909
XRn1n15n1p3s1 Rn1n15n1t3s0 Rn1n15n1t3s1 0 sky130_fd_pr__res_xhigh_po w=10 l=2224.8909
XRn1n15n1p3s2 Rn1n15n1t3s1 Rn1n15n1t3s2 0 sky130_fd_pr__res_xhigh_po w=10 l=2224.8909
XRn1n15n1p3s3 Rn1n15n1t3s2 n1p 0 sky130_fd_pr__res_xhigh_po w=10 l=2224.8909
* n1 input 16 w=-0.0222148593491043 w-  bank=f alpha=0.001 R=1500.49715865869 G_phys=0.000666445780473128 G_eff=6.66445780473128e-07
* PDK sky130_fd_pr__res_xhigh_po Rn1n16f1 W=10 L=7.3548435
* tile Rn1n16f1 4s x 4p same W=10 L=7.3548435
XRn1n16f1p0s0 tap16 Rn1n16f1t0s0 0 sky130_fd_pr__res_xhigh_po w=10 l=7.3548435
XRn1n16f1p0s1 Rn1n16f1t0s0 Rn1n16f1t0s1 0 sky130_fd_pr__res_xhigh_po w=10 l=7.3548435
XRn1n16f1p0s2 Rn1n16f1t0s1 Rn1n16f1t0s2 0 sky130_fd_pr__res_xhigh_po w=10 l=7.3548435
XRn1n16f1p0s3 Rn1n16f1t0s2 n1p 0 sky130_fd_pr__res_xhigh_po w=10 l=7.3548435
XRn1n16f1p1s0 tap16 Rn1n16f1t1s0 0 sky130_fd_pr__res_xhigh_po w=10 l=7.3548435
XRn1n16f1p1s1 Rn1n16f1t1s0 Rn1n16f1t1s1 0 sky130_fd_pr__res_xhigh_po w=10 l=7.3548435
XRn1n16f1p1s2 Rn1n16f1t1s1 Rn1n16f1t1s2 0 sky130_fd_pr__res_xhigh_po w=10 l=7.3548435
XRn1n16f1p1s3 Rn1n16f1t1s2 n1p 0 sky130_fd_pr__res_xhigh_po w=10 l=7.3548435
XRn1n16f1p2s0 tap16 Rn1n16f1t2s0 0 sky130_fd_pr__res_xhigh_po w=10 l=7.3548435
XRn1n16f1p2s1 Rn1n16f1t2s0 Rn1n16f1t2s1 0 sky130_fd_pr__res_xhigh_po w=10 l=7.3548435
XRn1n16f1p2s2 Rn1n16f1t2s1 Rn1n16f1t2s2 0 sky130_fd_pr__res_xhigh_po w=10 l=7.3548435
XRn1n16f1p2s3 Rn1n16f1t2s2 n1p 0 sky130_fd_pr__res_xhigh_po w=10 l=7.3548435
XRn1n16f1p3s0 tap16 Rn1n16f1t3s0 0 sky130_fd_pr__res_xhigh_po w=10 l=7.3548435
XRn1n16f1p3s1 Rn1n16f1t3s0 Rn1n16f1t3s1 0 sky130_fd_pr__res_xhigh_po w=10 l=7.3548435
XRn1n16f1p3s2 Rn1n16f1t3s1 Rn1n16f1t3s2 0 sky130_fd_pr__res_xhigh_po w=10 l=7.3548435
XRn1n16f1p3s3 Rn1n16f1t3s2 n1p 0 sky130_fd_pr__res_xhigh_po w=10 l=7.3548435
* n1 input 17 w=+0.0088751960388594 w+  bank=f alpha=0.001 R=3755.78558348297 G_phys=0.000266255881165782 G_eff=2.66255881165782e-07
* PDK sky130_fd_pr__res_xhigh_po Rn1p17f1 W=10 L=18.568138
* tile Rn1p17f1 4s x 4p same W=10 L=18.568138
XRn1p17f1p0s0 tap17n Rn1p17f1t0s0 0 sky130_fd_pr__res_xhigh_po w=10 l=18.568138
XRn1p17f1p0s1 Rn1p17f1t0s0 Rn1p17f1t0s1 0 sky130_fd_pr__res_xhigh_po w=10 l=18.568138
XRn1p17f1p0s2 Rn1p17f1t0s1 Rn1p17f1t0s2 0 sky130_fd_pr__res_xhigh_po w=10 l=18.568138
XRn1p17f1p0s3 Rn1p17f1t0s2 n1p 0 sky130_fd_pr__res_xhigh_po w=10 l=18.568138
XRn1p17f1p1s0 tap17n Rn1p17f1t1s0 0 sky130_fd_pr__res_xhigh_po w=10 l=18.568138
XRn1p17f1p1s1 Rn1p17f1t1s0 Rn1p17f1t1s1 0 sky130_fd_pr__res_xhigh_po w=10 l=18.568138
XRn1p17f1p1s2 Rn1p17f1t1s1 Rn1p17f1t1s2 0 sky130_fd_pr__res_xhigh_po w=10 l=18.568138
XRn1p17f1p1s3 Rn1p17f1t1s2 n1p 0 sky130_fd_pr__res_xhigh_po w=10 l=18.568138
XRn1p17f1p2s0 tap17n Rn1p17f1t2s0 0 sky130_fd_pr__res_xhigh_po w=10 l=18.568138
XRn1p17f1p2s1 Rn1p17f1t2s0 Rn1p17f1t2s1 0 sky130_fd_pr__res_xhigh_po w=10 l=18.568138
XRn1p17f1p2s2 Rn1p17f1t2s1 Rn1p17f1t2s2 0 sky130_fd_pr__res_xhigh_po w=10 l=18.568138
XRn1p17f1p2s3 Rn1p17f1t2s2 n1p 0 sky130_fd_pr__res_xhigh_po w=10 l=18.568138
XRn1p17f1p3s0 tap17n Rn1p17f1t3s0 0 sky130_fd_pr__res_xhigh_po w=10 l=18.568138
XRn1p17f1p3s1 Rn1p17f1t3s0 Rn1p17f1t3s1 0 sky130_fd_pr__res_xhigh_po w=10 l=18.568138
XRn1p17f1p3s2 Rn1p17f1t3s1 Rn1p17f1t3s2 0 sky130_fd_pr__res_xhigh_po w=10 l=18.568138
XRn1p17f1p3s3 Rn1p17f1t3s2 n1p 0 sky130_fd_pr__res_xhigh_po w=10 l=18.568138
* n1 input 18 w=-0.194172060066752 w-  bank=n alpha=1 R=171669.051262443 G_phys=5.82516180200256e-06 G_eff=5.82516180200256e-06
* PDK sky130_fd_pr__res_xhigh_po Rn1n18n1 W=10 L=853.43289
* tile Rn1n18n1 4s x 4p same W=10 L=853.43289
XRn1n18n1p0s0 in18 Rn1n18n1t0s0 0 sky130_fd_pr__res_xhigh_po w=10 l=853.43289
XRn1n18n1p0s1 Rn1n18n1t0s0 Rn1n18n1t0s1 0 sky130_fd_pr__res_xhigh_po w=10 l=853.43289
XRn1n18n1p0s2 Rn1n18n1t0s1 Rn1n18n1t0s2 0 sky130_fd_pr__res_xhigh_po w=10 l=853.43289
XRn1n18n1p0s3 Rn1n18n1t0s2 n1p 0 sky130_fd_pr__res_xhigh_po w=10 l=853.43289
XRn1n18n1p1s0 in18 Rn1n18n1t1s0 0 sky130_fd_pr__res_xhigh_po w=10 l=853.43289
XRn1n18n1p1s1 Rn1n18n1t1s0 Rn1n18n1t1s1 0 sky130_fd_pr__res_xhigh_po w=10 l=853.43289
XRn1n18n1p1s2 Rn1n18n1t1s1 Rn1n18n1t1s2 0 sky130_fd_pr__res_xhigh_po w=10 l=853.43289
XRn1n18n1p1s3 Rn1n18n1t1s2 n1p 0 sky130_fd_pr__res_xhigh_po w=10 l=853.43289
XRn1n18n1p2s0 in18 Rn1n18n1t2s0 0 sky130_fd_pr__res_xhigh_po w=10 l=853.43289
XRn1n18n1p2s1 Rn1n18n1t2s0 Rn1n18n1t2s1 0 sky130_fd_pr__res_xhigh_po w=10 l=853.43289
XRn1n18n1p2s2 Rn1n18n1t2s1 Rn1n18n1t2s2 0 sky130_fd_pr__res_xhigh_po w=10 l=853.43289
XRn1n18n1p2s3 Rn1n18n1t2s2 n1p 0 sky130_fd_pr__res_xhigh_po w=10 l=853.43289
XRn1n18n1p3s0 in18 Rn1n18n1t3s0 0 sky130_fd_pr__res_xhigh_po w=10 l=853.43289
XRn1n18n1p3s1 Rn1n18n1t3s0 Rn1n18n1t3s1 0 sky130_fd_pr__res_xhigh_po w=10 l=853.43289
XRn1n18n1p3s2 Rn1n18n1t3s1 Rn1n18n1t3s2 0 sky130_fd_pr__res_xhigh_po w=10 l=853.43289
XRn1n18n1p3s3 Rn1n18n1t3s2 n1p 0 sky130_fd_pr__res_xhigh_po w=10 l=853.43289
* n1 input 19 w=+0.341327626188232 w+  bank=n alpha=1 R=97657.8828546125 G_phys=1.0239828785647e-05 G_eff=1.0239828785647e-05
* PDK sky130_fd_pr__res_xhigh_po Rn1p19n1 W=10 L=485.44937
* tile Rn1p19n1 4s x 4p same W=10 L=485.44937
XRn1p19n1p0s0 in19n Rn1p19n1t0s0 0 sky130_fd_pr__res_xhigh_po w=10 l=485.44937
XRn1p19n1p0s1 Rn1p19n1t0s0 Rn1p19n1t0s1 0 sky130_fd_pr__res_xhigh_po w=10 l=485.44937
XRn1p19n1p0s2 Rn1p19n1t0s1 Rn1p19n1t0s2 0 sky130_fd_pr__res_xhigh_po w=10 l=485.44937
XRn1p19n1p0s3 Rn1p19n1t0s2 n1p 0 sky130_fd_pr__res_xhigh_po w=10 l=485.44937
XRn1p19n1p1s0 in19n Rn1p19n1t1s0 0 sky130_fd_pr__res_xhigh_po w=10 l=485.44937
XRn1p19n1p1s1 Rn1p19n1t1s0 Rn1p19n1t1s1 0 sky130_fd_pr__res_xhigh_po w=10 l=485.44937
XRn1p19n1p1s2 Rn1p19n1t1s1 Rn1p19n1t1s2 0 sky130_fd_pr__res_xhigh_po w=10 l=485.44937
XRn1p19n1p1s3 Rn1p19n1t1s2 n1p 0 sky130_fd_pr__res_xhigh_po w=10 l=485.44937
XRn1p19n1p2s0 in19n Rn1p19n1t2s0 0 sky130_fd_pr__res_xhigh_po w=10 l=485.44937
XRn1p19n1p2s1 Rn1p19n1t2s0 Rn1p19n1t2s1 0 sky130_fd_pr__res_xhigh_po w=10 l=485.44937
XRn1p19n1p2s2 Rn1p19n1t2s1 Rn1p19n1t2s2 0 sky130_fd_pr__res_xhigh_po w=10 l=485.44937
XRn1p19n1p2s3 Rn1p19n1t2s2 n1p 0 sky130_fd_pr__res_xhigh_po w=10 l=485.44937
XRn1p19n1p3s0 in19n Rn1p19n1t3s0 0 sky130_fd_pr__res_xhigh_po w=10 l=485.44937
XRn1p19n1p3s1 Rn1p19n1t3s0 Rn1p19n1t3s1 0 sky130_fd_pr__res_xhigh_po w=10 l=485.44937
XRn1p19n1p3s2 Rn1p19n1t3s1 Rn1p19n1t3s2 0 sky130_fd_pr__res_xhigh_po w=10 l=485.44937
XRn1p19n1p3s3 Rn1p19n1t3s2 n1p 0 sky130_fd_pr__res_xhigh_po w=10 l=485.44937
* n1 input 20 w=-0.0323870183321868 w-  bank=f alpha=0.001 R=1029.21896024637 G_phys=0.000971610549965604 G_eff=9.71610549965604e-07
* PDK sky130_fd_pr__res_xhigh_po Rn1n20f1 W=10 L=5.0116483
* tile Rn1n20f1 4s x 4p same W=10 L=5.0116483
XRn1n20f1p0s0 tap20 Rn1n20f1t0s0 0 sky130_fd_pr__res_xhigh_po w=10 l=5.0116483
XRn1n20f1p0s1 Rn1n20f1t0s0 Rn1n20f1t0s1 0 sky130_fd_pr__res_xhigh_po w=10 l=5.0116483
XRn1n20f1p0s2 Rn1n20f1t0s1 Rn1n20f1t0s2 0 sky130_fd_pr__res_xhigh_po w=10 l=5.0116483
XRn1n20f1p0s3 Rn1n20f1t0s2 n1p 0 sky130_fd_pr__res_xhigh_po w=10 l=5.0116483
XRn1n20f1p1s0 tap20 Rn1n20f1t1s0 0 sky130_fd_pr__res_xhigh_po w=10 l=5.0116483
XRn1n20f1p1s1 Rn1n20f1t1s0 Rn1n20f1t1s1 0 sky130_fd_pr__res_xhigh_po w=10 l=5.0116483
XRn1n20f1p1s2 Rn1n20f1t1s1 Rn1n20f1t1s2 0 sky130_fd_pr__res_xhigh_po w=10 l=5.0116483
XRn1n20f1p1s3 Rn1n20f1t1s2 n1p 0 sky130_fd_pr__res_xhigh_po w=10 l=5.0116483
XRn1n20f1p2s0 tap20 Rn1n20f1t2s0 0 sky130_fd_pr__res_xhigh_po w=10 l=5.0116483
XRn1n20f1p2s1 Rn1n20f1t2s0 Rn1n20f1t2s1 0 sky130_fd_pr__res_xhigh_po w=10 l=5.0116483
XRn1n20f1p2s2 Rn1n20f1t2s1 Rn1n20f1t2s2 0 sky130_fd_pr__res_xhigh_po w=10 l=5.0116483
XRn1n20f1p2s3 Rn1n20f1t2s2 n1p 0 sky130_fd_pr__res_xhigh_po w=10 l=5.0116483
XRn1n20f1p3s0 tap20 Rn1n20f1t3s0 0 sky130_fd_pr__res_xhigh_po w=10 l=5.0116483
XRn1n20f1p3s1 Rn1n20f1t3s0 Rn1n20f1t3s1 0 sky130_fd_pr__res_xhigh_po w=10 l=5.0116483
XRn1n20f1p3s2 Rn1n20f1t3s1 Rn1n20f1t3s2 0 sky130_fd_pr__res_xhigh_po w=10 l=5.0116483
XRn1n20f1p3s3 Rn1n20f1t3s2 n1p 0 sky130_fd_pr__res_xhigh_po w=10 l=5.0116483
* n1 input 21 w=-0.0999542141187652 w-  bank=n alpha=1 R=333486.022847689 G_phys=2.99862642356296e-06 G_eff=2.99862642356296e-06
* PDK sky130_fd_pr__res_xhigh_po Rn1n21n1 W=10 L=1657.9869
* tile Rn1n21n1 4s x 4p same W=10 L=1657.9869
XRn1n21n1p0s0 in21 Rn1n21n1t0s0 0 sky130_fd_pr__res_xhigh_po w=10 l=1657.9869
XRn1n21n1p0s1 Rn1n21n1t0s0 Rn1n21n1t0s1 0 sky130_fd_pr__res_xhigh_po w=10 l=1657.9869
XRn1n21n1p0s2 Rn1n21n1t0s1 Rn1n21n1t0s2 0 sky130_fd_pr__res_xhigh_po w=10 l=1657.9869
XRn1n21n1p0s3 Rn1n21n1t0s2 n1p 0 sky130_fd_pr__res_xhigh_po w=10 l=1657.9869
XRn1n21n1p1s0 in21 Rn1n21n1t1s0 0 sky130_fd_pr__res_xhigh_po w=10 l=1657.9869
XRn1n21n1p1s1 Rn1n21n1t1s0 Rn1n21n1t1s1 0 sky130_fd_pr__res_xhigh_po w=10 l=1657.9869
XRn1n21n1p1s2 Rn1n21n1t1s1 Rn1n21n1t1s2 0 sky130_fd_pr__res_xhigh_po w=10 l=1657.9869
XRn1n21n1p1s3 Rn1n21n1t1s2 n1p 0 sky130_fd_pr__res_xhigh_po w=10 l=1657.9869
XRn1n21n1p2s0 in21 Rn1n21n1t2s0 0 sky130_fd_pr__res_xhigh_po w=10 l=1657.9869
XRn1n21n1p2s1 Rn1n21n1t2s0 Rn1n21n1t2s1 0 sky130_fd_pr__res_xhigh_po w=10 l=1657.9869
XRn1n21n1p2s2 Rn1n21n1t2s1 Rn1n21n1t2s2 0 sky130_fd_pr__res_xhigh_po w=10 l=1657.9869
XRn1n21n1p2s3 Rn1n21n1t2s2 n1p 0 sky130_fd_pr__res_xhigh_po w=10 l=1657.9869
XRn1n21n1p3s0 in21 Rn1n21n1t3s0 0 sky130_fd_pr__res_xhigh_po w=10 l=1657.9869
XRn1n21n1p3s1 Rn1n21n1t3s0 Rn1n21n1t3s1 0 sky130_fd_pr__res_xhigh_po w=10 l=1657.9869
XRn1n21n1p3s2 Rn1n21n1t3s1 Rn1n21n1t3s2 0 sky130_fd_pr__res_xhigh_po w=10 l=1657.9869
XRn1n21n1p3s3 Rn1n21n1t3s2 n1p 0 sky130_fd_pr__res_xhigh_po w=10 l=1657.9869
* n1 input 22 w=+0.693789300406694 w+  bank=n alpha=1 R=48045.3263170729 G_phys=2.08136790122008e-05 G_eff=2.08136790122008e-05
* PDK sky130_fd_pr__res_xhigh_po Rn1p22n1 W=10 L=238.77573
* tile Rn1p22n1 4s x 4p same W=10 L=238.77573
XRn1p22n1p0s0 in22n Rn1p22n1t0s0 0 sky130_fd_pr__res_xhigh_po w=10 l=238.77573
XRn1p22n1p0s1 Rn1p22n1t0s0 Rn1p22n1t0s1 0 sky130_fd_pr__res_xhigh_po w=10 l=238.77573
XRn1p22n1p0s2 Rn1p22n1t0s1 Rn1p22n1t0s2 0 sky130_fd_pr__res_xhigh_po w=10 l=238.77573
XRn1p22n1p0s3 Rn1p22n1t0s2 n1p 0 sky130_fd_pr__res_xhigh_po w=10 l=238.77573
XRn1p22n1p1s0 in22n Rn1p22n1t1s0 0 sky130_fd_pr__res_xhigh_po w=10 l=238.77573
XRn1p22n1p1s1 Rn1p22n1t1s0 Rn1p22n1t1s1 0 sky130_fd_pr__res_xhigh_po w=10 l=238.77573
XRn1p22n1p1s2 Rn1p22n1t1s1 Rn1p22n1t1s2 0 sky130_fd_pr__res_xhigh_po w=10 l=238.77573
XRn1p22n1p1s3 Rn1p22n1t1s2 n1p 0 sky130_fd_pr__res_xhigh_po w=10 l=238.77573
XRn1p22n1p2s0 in22n Rn1p22n1t2s0 0 sky130_fd_pr__res_xhigh_po w=10 l=238.77573
XRn1p22n1p2s1 Rn1p22n1t2s0 Rn1p22n1t2s1 0 sky130_fd_pr__res_xhigh_po w=10 l=238.77573
XRn1p22n1p2s2 Rn1p22n1t2s1 Rn1p22n1t2s2 0 sky130_fd_pr__res_xhigh_po w=10 l=238.77573
XRn1p22n1p2s3 Rn1p22n1t2s2 n1p 0 sky130_fd_pr__res_xhigh_po w=10 l=238.77573
XRn1p22n1p3s0 in22n Rn1p22n1t3s0 0 sky130_fd_pr__res_xhigh_po w=10 l=238.77573
XRn1p22n1p3s1 Rn1p22n1t3s0 Rn1p22n1t3s1 0 sky130_fd_pr__res_xhigh_po w=10 l=238.77573
XRn1p22n1p3s2 Rn1p22n1t3s1 Rn1p22n1t3s2 0 sky130_fd_pr__res_xhigh_po w=10 l=238.77573
XRn1p22n1p3s3 Rn1p22n1t3s2 n1p 0 sky130_fd_pr__res_xhigh_po w=10 l=238.77573
* n1 input 23 w=+0.0972685864670828 w+  bank=n alpha=1 R=342693.715864925 G_phys=2.91805759401248e-06 G_eff=2.91805759401248e-06
* PDK sky130_fd_pr__res_xhigh_po Rn1p23n1 W=10 L=1703.7675
* tile Rn1p23n1 4s x 4p same W=10 L=1703.7675
XRn1p23n1p0s0 in23n Rn1p23n1t0s0 0 sky130_fd_pr__res_xhigh_po w=10 l=1703.7675
XRn1p23n1p0s1 Rn1p23n1t0s0 Rn1p23n1t0s1 0 sky130_fd_pr__res_xhigh_po w=10 l=1703.7675
XRn1p23n1p0s2 Rn1p23n1t0s1 Rn1p23n1t0s2 0 sky130_fd_pr__res_xhigh_po w=10 l=1703.7675
XRn1p23n1p0s3 Rn1p23n1t0s2 n1p 0 sky130_fd_pr__res_xhigh_po w=10 l=1703.7675
XRn1p23n1p1s0 in23n Rn1p23n1t1s0 0 sky130_fd_pr__res_xhigh_po w=10 l=1703.7675
XRn1p23n1p1s1 Rn1p23n1t1s0 Rn1p23n1t1s1 0 sky130_fd_pr__res_xhigh_po w=10 l=1703.7675
XRn1p23n1p1s2 Rn1p23n1t1s1 Rn1p23n1t1s2 0 sky130_fd_pr__res_xhigh_po w=10 l=1703.7675
XRn1p23n1p1s3 Rn1p23n1t1s2 n1p 0 sky130_fd_pr__res_xhigh_po w=10 l=1703.7675
XRn1p23n1p2s0 in23n Rn1p23n1t2s0 0 sky130_fd_pr__res_xhigh_po w=10 l=1703.7675
XRn1p23n1p2s1 Rn1p23n1t2s0 Rn1p23n1t2s1 0 sky130_fd_pr__res_xhigh_po w=10 l=1703.7675
XRn1p23n1p2s2 Rn1p23n1t2s1 Rn1p23n1t2s2 0 sky130_fd_pr__res_xhigh_po w=10 l=1703.7675
XRn1p23n1p2s3 Rn1p23n1t2s2 n1p 0 sky130_fd_pr__res_xhigh_po w=10 l=1703.7675
XRn1p23n1p3s0 in23n Rn1p23n1t3s0 0 sky130_fd_pr__res_xhigh_po w=10 l=1703.7675
XRn1p23n1p3s1 Rn1p23n1t3s0 Rn1p23n1t3s1 0 sky130_fd_pr__res_xhigh_po w=10 l=1703.7675
XRn1p23n1p3s2 Rn1p23n1t3s1 Rn1p23n1t3s2 0 sky130_fd_pr__res_xhigh_po w=10 l=1703.7675
XRn1p23n1p3s3 Rn1p23n1t3s2 n1p 0 sky130_fd_pr__res_xhigh_po w=10 l=1703.7675
* n1 input 24 w=-0.0293783170287994 w-  bank=f alpha=0.001 R=1134.6236512002 G_phys=0.000881349510863982 G_eff=8.81349510863982e-07
* PDK sky130_fd_pr__res_xhigh_po Rn1n24f1 W=10 L=5.5357205
* tile Rn1n24f1 4s x 4p same W=10 L=5.5357205
XRn1n24f1p0s0 tap24 Rn1n24f1t0s0 0 sky130_fd_pr__res_xhigh_po w=10 l=5.5357205
XRn1n24f1p0s1 Rn1n24f1t0s0 Rn1n24f1t0s1 0 sky130_fd_pr__res_xhigh_po w=10 l=5.5357205
XRn1n24f1p0s2 Rn1n24f1t0s1 Rn1n24f1t0s2 0 sky130_fd_pr__res_xhigh_po w=10 l=5.5357205
XRn1n24f1p0s3 Rn1n24f1t0s2 n1p 0 sky130_fd_pr__res_xhigh_po w=10 l=5.5357205
XRn1n24f1p1s0 tap24 Rn1n24f1t1s0 0 sky130_fd_pr__res_xhigh_po w=10 l=5.5357205
XRn1n24f1p1s1 Rn1n24f1t1s0 Rn1n24f1t1s1 0 sky130_fd_pr__res_xhigh_po w=10 l=5.5357205
XRn1n24f1p1s2 Rn1n24f1t1s1 Rn1n24f1t1s2 0 sky130_fd_pr__res_xhigh_po w=10 l=5.5357205
XRn1n24f1p1s3 Rn1n24f1t1s2 n1p 0 sky130_fd_pr__res_xhigh_po w=10 l=5.5357205
XRn1n24f1p2s0 tap24 Rn1n24f1t2s0 0 sky130_fd_pr__res_xhigh_po w=10 l=5.5357205
XRn1n24f1p2s1 Rn1n24f1t2s0 Rn1n24f1t2s1 0 sky130_fd_pr__res_xhigh_po w=10 l=5.5357205
XRn1n24f1p2s2 Rn1n24f1t2s1 Rn1n24f1t2s2 0 sky130_fd_pr__res_xhigh_po w=10 l=5.5357205
XRn1n24f1p2s3 Rn1n24f1t2s2 n1p 0 sky130_fd_pr__res_xhigh_po w=10 l=5.5357205
XRn1n24f1p3s0 tap24 Rn1n24f1t3s0 0 sky130_fd_pr__res_xhigh_po w=10 l=5.5357205
XRn1n24f1p3s1 Rn1n24f1t3s0 Rn1n24f1t3s1 0 sky130_fd_pr__res_xhigh_po w=10 l=5.5357205
XRn1n24f1p3s2 Rn1n24f1t3s1 Rn1n24f1t3s2 0 sky130_fd_pr__res_xhigh_po w=10 l=5.5357205
XRn1n24f1p3s3 Rn1n24f1t3s2 n1p 0 sky130_fd_pr__res_xhigh_po w=10 l=5.5357205
* n1 input 25 w=+0.0497492024826392 w+  bank=n alpha=1 R=670027.491294269 G_phys=1.49247607447918e-06 G_eff=1.49247607447918e-06
* PDK sky130_fd_pr__res_xhigh_po Rn1p25n1 W=10 L=3331.2711
* tile Rn1p25n1 4s x 4p same W=10 L=3331.2711
XRn1p25n1p0s0 in25n Rn1p25n1t0s0 0 sky130_fd_pr__res_xhigh_po w=10 l=3331.2711
XRn1p25n1p0s1 Rn1p25n1t0s0 Rn1p25n1t0s1 0 sky130_fd_pr__res_xhigh_po w=10 l=3331.2711
XRn1p25n1p0s2 Rn1p25n1t0s1 Rn1p25n1t0s2 0 sky130_fd_pr__res_xhigh_po w=10 l=3331.2711
XRn1p25n1p0s3 Rn1p25n1t0s2 n1p 0 sky130_fd_pr__res_xhigh_po w=10 l=3331.2711
XRn1p25n1p1s0 in25n Rn1p25n1t1s0 0 sky130_fd_pr__res_xhigh_po w=10 l=3331.2711
XRn1p25n1p1s1 Rn1p25n1t1s0 Rn1p25n1t1s1 0 sky130_fd_pr__res_xhigh_po w=10 l=3331.2711
XRn1p25n1p1s2 Rn1p25n1t1s1 Rn1p25n1t1s2 0 sky130_fd_pr__res_xhigh_po w=10 l=3331.2711
XRn1p25n1p1s3 Rn1p25n1t1s2 n1p 0 sky130_fd_pr__res_xhigh_po w=10 l=3331.2711
XRn1p25n1p2s0 in25n Rn1p25n1t2s0 0 sky130_fd_pr__res_xhigh_po w=10 l=3331.2711
XRn1p25n1p2s1 Rn1p25n1t2s0 Rn1p25n1t2s1 0 sky130_fd_pr__res_xhigh_po w=10 l=3331.2711
XRn1p25n1p2s2 Rn1p25n1t2s1 Rn1p25n1t2s2 0 sky130_fd_pr__res_xhigh_po w=10 l=3331.2711
XRn1p25n1p2s3 Rn1p25n1t2s2 n1p 0 sky130_fd_pr__res_xhigh_po w=10 l=3331.2711
XRn1p25n1p3s0 in25n Rn1p25n1t3s0 0 sky130_fd_pr__res_xhigh_po w=10 l=3331.2711
XRn1p25n1p3s1 Rn1p25n1t3s0 Rn1p25n1t3s1 0 sky130_fd_pr__res_xhigh_po w=10 l=3331.2711
XRn1p25n1p3s2 Rn1p25n1t3s1 Rn1p25n1t3s2 0 sky130_fd_pr__res_xhigh_po w=10 l=3331.2711
XRn1p25n1p3s3 Rn1p25n1t3s2 n1p 0 sky130_fd_pr__res_xhigh_po w=10 l=3331.2711
* n1 input 26 w=-0.466063512962686 w-  bank=n alpha=1 R=71521.0103477937 G_phys=1.39819053888806e-05 G_eff=1.39819053888806e-05
* PDK sky130_fd_pr__res_xhigh_po Rn1n26n1 W=10 L=355.49684
* tile Rn1n26n1 4s x 4p same W=10 L=355.49684
XRn1n26n1p0s0 in26 Rn1n26n1t0s0 0 sky130_fd_pr__res_xhigh_po w=10 l=355.49684
XRn1n26n1p0s1 Rn1n26n1t0s0 Rn1n26n1t0s1 0 sky130_fd_pr__res_xhigh_po w=10 l=355.49684
XRn1n26n1p0s2 Rn1n26n1t0s1 Rn1n26n1t0s2 0 sky130_fd_pr__res_xhigh_po w=10 l=355.49684
XRn1n26n1p0s3 Rn1n26n1t0s2 n1p 0 sky130_fd_pr__res_xhigh_po w=10 l=355.49684
XRn1n26n1p1s0 in26 Rn1n26n1t1s0 0 sky130_fd_pr__res_xhigh_po w=10 l=355.49684
XRn1n26n1p1s1 Rn1n26n1t1s0 Rn1n26n1t1s1 0 sky130_fd_pr__res_xhigh_po w=10 l=355.49684
XRn1n26n1p1s2 Rn1n26n1t1s1 Rn1n26n1t1s2 0 sky130_fd_pr__res_xhigh_po w=10 l=355.49684
XRn1n26n1p1s3 Rn1n26n1t1s2 n1p 0 sky130_fd_pr__res_xhigh_po w=10 l=355.49684
XRn1n26n1p2s0 in26 Rn1n26n1t2s0 0 sky130_fd_pr__res_xhigh_po w=10 l=355.49684
XRn1n26n1p2s1 Rn1n26n1t2s0 Rn1n26n1t2s1 0 sky130_fd_pr__res_xhigh_po w=10 l=355.49684
XRn1n26n1p2s2 Rn1n26n1t2s1 Rn1n26n1t2s2 0 sky130_fd_pr__res_xhigh_po w=10 l=355.49684
XRn1n26n1p2s3 Rn1n26n1t2s2 n1p 0 sky130_fd_pr__res_xhigh_po w=10 l=355.49684
XRn1n26n1p3s0 in26 Rn1n26n1t3s0 0 sky130_fd_pr__res_xhigh_po w=10 l=355.49684
XRn1n26n1p3s1 Rn1n26n1t3s0 Rn1n26n1t3s1 0 sky130_fd_pr__res_xhigh_po w=10 l=355.49684
XRn1n26n1p3s2 Rn1n26n1t3s1 Rn1n26n1t3s2 0 sky130_fd_pr__res_xhigh_po w=10 l=355.49684
XRn1n26n1p3s3 Rn1n26n1t3s2 n1p 0 sky130_fd_pr__res_xhigh_po w=10 l=355.49684
* n1 input 27 w=+0.194887582685885 w+  bank=n alpha=1 R=171038.774630702 G_phys=5.84662748057655e-06 G_eff=5.84662748057655e-06
* PDK sky130_fd_pr__res_xhigh_po Rn1p27n1 W=10 L=850.29916
* tile Rn1p27n1 4s x 4p same W=10 L=850.29916
XRn1p27n1p0s0 in27n Rn1p27n1t0s0 0 sky130_fd_pr__res_xhigh_po w=10 l=850.29916
XRn1p27n1p0s1 Rn1p27n1t0s0 Rn1p27n1t0s1 0 sky130_fd_pr__res_xhigh_po w=10 l=850.29916
XRn1p27n1p0s2 Rn1p27n1t0s1 Rn1p27n1t0s2 0 sky130_fd_pr__res_xhigh_po w=10 l=850.29916
XRn1p27n1p0s3 Rn1p27n1t0s2 n1p 0 sky130_fd_pr__res_xhigh_po w=10 l=850.29916
XRn1p27n1p1s0 in27n Rn1p27n1t1s0 0 sky130_fd_pr__res_xhigh_po w=10 l=850.29916
XRn1p27n1p1s1 Rn1p27n1t1s0 Rn1p27n1t1s1 0 sky130_fd_pr__res_xhigh_po w=10 l=850.29916
XRn1p27n1p1s2 Rn1p27n1t1s1 Rn1p27n1t1s2 0 sky130_fd_pr__res_xhigh_po w=10 l=850.29916
XRn1p27n1p1s3 Rn1p27n1t1s2 n1p 0 sky130_fd_pr__res_xhigh_po w=10 l=850.29916
XRn1p27n1p2s0 in27n Rn1p27n1t2s0 0 sky130_fd_pr__res_xhigh_po w=10 l=850.29916
XRn1p27n1p2s1 Rn1p27n1t2s0 Rn1p27n1t2s1 0 sky130_fd_pr__res_xhigh_po w=10 l=850.29916
XRn1p27n1p2s2 Rn1p27n1t2s1 Rn1p27n1t2s2 0 sky130_fd_pr__res_xhigh_po w=10 l=850.29916
XRn1p27n1p2s3 Rn1p27n1t2s2 n1p 0 sky130_fd_pr__res_xhigh_po w=10 l=850.29916
XRn1p27n1p3s0 in27n Rn1p27n1t3s0 0 sky130_fd_pr__res_xhigh_po w=10 l=850.29916
XRn1p27n1p3s1 Rn1p27n1t3s0 Rn1p27n1t3s1 0 sky130_fd_pr__res_xhigh_po w=10 l=850.29916
XRn1p27n1p3s2 Rn1p27n1t3s1 Rn1p27n1t3s2 0 sky130_fd_pr__res_xhigh_po w=10 l=850.29916
XRn1p27n1p3s3 Rn1p27n1t3s2 n1p 0 sky130_fd_pr__res_xhigh_po w=10 l=850.29916
* n1 input 28 w=+0.209047565197081 w+  bank=n alpha=1 R=159453.344036359 G_phys=6.27142695591242e-06 G_eff=6.27142695591242e-06
* PDK sky130_fd_pr__res_xhigh_po Rn1p28n1 W=10 L=792.6964
* tile Rn1p28n1 4s x 4p same W=10 L=792.6964
XRn1p28n1p0s0 in28n Rn1p28n1t0s0 0 sky130_fd_pr__res_xhigh_po w=10 l=792.6964
XRn1p28n1p0s1 Rn1p28n1t0s0 Rn1p28n1t0s1 0 sky130_fd_pr__res_xhigh_po w=10 l=792.6964
XRn1p28n1p0s2 Rn1p28n1t0s1 Rn1p28n1t0s2 0 sky130_fd_pr__res_xhigh_po w=10 l=792.6964
XRn1p28n1p0s3 Rn1p28n1t0s2 n1p 0 sky130_fd_pr__res_xhigh_po w=10 l=792.6964
XRn1p28n1p1s0 in28n Rn1p28n1t1s0 0 sky130_fd_pr__res_xhigh_po w=10 l=792.6964
XRn1p28n1p1s1 Rn1p28n1t1s0 Rn1p28n1t1s1 0 sky130_fd_pr__res_xhigh_po w=10 l=792.6964
XRn1p28n1p1s2 Rn1p28n1t1s1 Rn1p28n1t1s2 0 sky130_fd_pr__res_xhigh_po w=10 l=792.6964
XRn1p28n1p1s3 Rn1p28n1t1s2 n1p 0 sky130_fd_pr__res_xhigh_po w=10 l=792.6964
XRn1p28n1p2s0 in28n Rn1p28n1t2s0 0 sky130_fd_pr__res_xhigh_po w=10 l=792.6964
XRn1p28n1p2s1 Rn1p28n1t2s0 Rn1p28n1t2s1 0 sky130_fd_pr__res_xhigh_po w=10 l=792.6964
XRn1p28n1p2s2 Rn1p28n1t2s1 Rn1p28n1t2s2 0 sky130_fd_pr__res_xhigh_po w=10 l=792.6964
XRn1p28n1p2s3 Rn1p28n1t2s2 n1p 0 sky130_fd_pr__res_xhigh_po w=10 l=792.6964
XRn1p28n1p3s0 in28n Rn1p28n1t3s0 0 sky130_fd_pr__res_xhigh_po w=10 l=792.6964
XRn1p28n1p3s1 Rn1p28n1t3s0 Rn1p28n1t3s1 0 sky130_fd_pr__res_xhigh_po w=10 l=792.6964
XRn1p28n1p3s2 Rn1p28n1t3s1 Rn1p28n1t3s2 0 sky130_fd_pr__res_xhigh_po w=10 l=792.6964
XRn1p28n1p3s3 Rn1p28n1t3s2 n1p 0 sky130_fd_pr__res_xhigh_po w=10 l=792.6964
* n1 input 29 w=+0.00919963467526149 w+  bank=f alpha=0.001 R=3623.33228546229 G_phys=0.000275989040257845 G_eff=2.75989040257845e-07
* PDK sky130_fd_pr__res_xhigh_po Rn1p29f1 W=10 L=17.90958
* tile Rn1p29f1 4s x 4p same W=10 L=17.90958
XRn1p29f1p0s0 tap29n Rn1p29f1t0s0 0 sky130_fd_pr__res_xhigh_po w=10 l=17.90958
XRn1p29f1p0s1 Rn1p29f1t0s0 Rn1p29f1t0s1 0 sky130_fd_pr__res_xhigh_po w=10 l=17.90958
XRn1p29f1p0s2 Rn1p29f1t0s1 Rn1p29f1t0s2 0 sky130_fd_pr__res_xhigh_po w=10 l=17.90958
XRn1p29f1p0s3 Rn1p29f1t0s2 n1p 0 sky130_fd_pr__res_xhigh_po w=10 l=17.90958
XRn1p29f1p1s0 tap29n Rn1p29f1t1s0 0 sky130_fd_pr__res_xhigh_po w=10 l=17.90958
XRn1p29f1p1s1 Rn1p29f1t1s0 Rn1p29f1t1s1 0 sky130_fd_pr__res_xhigh_po w=10 l=17.90958
XRn1p29f1p1s2 Rn1p29f1t1s1 Rn1p29f1t1s2 0 sky130_fd_pr__res_xhigh_po w=10 l=17.90958
XRn1p29f1p1s3 Rn1p29f1t1s2 n1p 0 sky130_fd_pr__res_xhigh_po w=10 l=17.90958
XRn1p29f1p2s0 tap29n Rn1p29f1t2s0 0 sky130_fd_pr__res_xhigh_po w=10 l=17.90958
XRn1p29f1p2s1 Rn1p29f1t2s0 Rn1p29f1t2s1 0 sky130_fd_pr__res_xhigh_po w=10 l=17.90958
XRn1p29f1p2s2 Rn1p29f1t2s1 Rn1p29f1t2s2 0 sky130_fd_pr__res_xhigh_po w=10 l=17.90958
XRn1p29f1p2s3 Rn1p29f1t2s2 n1p 0 sky130_fd_pr__res_xhigh_po w=10 l=17.90958
XRn1p29f1p3s0 tap29n Rn1p29f1t3s0 0 sky130_fd_pr__res_xhigh_po w=10 l=17.90958
XRn1p29f1p3s1 Rn1p29f1t3s0 Rn1p29f1t3s1 0 sky130_fd_pr__res_xhigh_po w=10 l=17.90958
XRn1p29f1p3s2 Rn1p29f1t3s1 Rn1p29f1t3s2 0 sky130_fd_pr__res_xhigh_po w=10 l=17.90958
XRn1p29f1p3s3 Rn1p29f1t3s2 n1p 0 sky130_fd_pr__res_xhigh_po w=10 l=17.90958
* n1 input 30 w=-0.379437042796868 w-  bank=n alpha=1 R=87849.4442388387 G_phys=1.13831112839061e-05 G_eff=1.13831112839061e-05
* PDK sky130_fd_pr__res_xhigh_po Rn1n30n1 W=10 L=436.68181
* tile Rn1n30n1 4s x 4p same W=10 L=436.68181
XRn1n30n1p0s0 in30 Rn1n30n1t0s0 0 sky130_fd_pr__res_xhigh_po w=10 l=436.68181
XRn1n30n1p0s1 Rn1n30n1t0s0 Rn1n30n1t0s1 0 sky130_fd_pr__res_xhigh_po w=10 l=436.68181
XRn1n30n1p0s2 Rn1n30n1t0s1 Rn1n30n1t0s2 0 sky130_fd_pr__res_xhigh_po w=10 l=436.68181
XRn1n30n1p0s3 Rn1n30n1t0s2 n1p 0 sky130_fd_pr__res_xhigh_po w=10 l=436.68181
XRn1n30n1p1s0 in30 Rn1n30n1t1s0 0 sky130_fd_pr__res_xhigh_po w=10 l=436.68181
XRn1n30n1p1s1 Rn1n30n1t1s0 Rn1n30n1t1s1 0 sky130_fd_pr__res_xhigh_po w=10 l=436.68181
XRn1n30n1p1s2 Rn1n30n1t1s1 Rn1n30n1t1s2 0 sky130_fd_pr__res_xhigh_po w=10 l=436.68181
XRn1n30n1p1s3 Rn1n30n1t1s2 n1p 0 sky130_fd_pr__res_xhigh_po w=10 l=436.68181
XRn1n30n1p2s0 in30 Rn1n30n1t2s0 0 sky130_fd_pr__res_xhigh_po w=10 l=436.68181
XRn1n30n1p2s1 Rn1n30n1t2s0 Rn1n30n1t2s1 0 sky130_fd_pr__res_xhigh_po w=10 l=436.68181
XRn1n30n1p2s2 Rn1n30n1t2s1 Rn1n30n1t2s2 0 sky130_fd_pr__res_xhigh_po w=10 l=436.68181
XRn1n30n1p2s3 Rn1n30n1t2s2 n1p 0 sky130_fd_pr__res_xhigh_po w=10 l=436.68181
XRn1n30n1p3s0 in30 Rn1n30n1t3s0 0 sky130_fd_pr__res_xhigh_po w=10 l=436.68181
XRn1n30n1p3s1 Rn1n30n1t3s0 Rn1n30n1t3s1 0 sky130_fd_pr__res_xhigh_po w=10 l=436.68181
XRn1n30n1p3s2 Rn1n30n1t3s1 Rn1n30n1t3s2 0 sky130_fd_pr__res_xhigh_po w=10 l=436.68181
XRn1n30n1p3s3 Rn1n30n1t3s2 n1p 0 sky130_fd_pr__res_xhigh_po w=10 l=436.68181
* n1 input 31 w=-0.216631724491884 w-  bank=n alpha=1 R=153870.96885979 G_phys=6.49895173475653e-06 G_eff=6.49895173475653e-06
* PDK sky130_fd_pr__res_xhigh_po Rn1n31n1 W=10 L=764.94083
* tile Rn1n31n1 4s x 4p same W=10 L=764.94083
XRn1n31n1p0s0 in31 Rn1n31n1t0s0 0 sky130_fd_pr__res_xhigh_po w=10 l=764.94083
XRn1n31n1p0s1 Rn1n31n1t0s0 Rn1n31n1t0s1 0 sky130_fd_pr__res_xhigh_po w=10 l=764.94083
XRn1n31n1p0s2 Rn1n31n1t0s1 Rn1n31n1t0s2 0 sky130_fd_pr__res_xhigh_po w=10 l=764.94083
XRn1n31n1p0s3 Rn1n31n1t0s2 n1p 0 sky130_fd_pr__res_xhigh_po w=10 l=764.94083
XRn1n31n1p1s0 in31 Rn1n31n1t1s0 0 sky130_fd_pr__res_xhigh_po w=10 l=764.94083
XRn1n31n1p1s1 Rn1n31n1t1s0 Rn1n31n1t1s1 0 sky130_fd_pr__res_xhigh_po w=10 l=764.94083
XRn1n31n1p1s2 Rn1n31n1t1s1 Rn1n31n1t1s2 0 sky130_fd_pr__res_xhigh_po w=10 l=764.94083
XRn1n31n1p1s3 Rn1n31n1t1s2 n1p 0 sky130_fd_pr__res_xhigh_po w=10 l=764.94083
XRn1n31n1p2s0 in31 Rn1n31n1t2s0 0 sky130_fd_pr__res_xhigh_po w=10 l=764.94083
XRn1n31n1p2s1 Rn1n31n1t2s0 Rn1n31n1t2s1 0 sky130_fd_pr__res_xhigh_po w=10 l=764.94083
XRn1n31n1p2s2 Rn1n31n1t2s1 Rn1n31n1t2s2 0 sky130_fd_pr__res_xhigh_po w=10 l=764.94083
XRn1n31n1p2s3 Rn1n31n1t2s2 n1p 0 sky130_fd_pr__res_xhigh_po w=10 l=764.94083
XRn1n31n1p3s0 in31 Rn1n31n1t3s0 0 sky130_fd_pr__res_xhigh_po w=10 l=764.94083
XRn1n31n1p3s1 Rn1n31n1t3s0 Rn1n31n1t3s1 0 sky130_fd_pr__res_xhigh_po w=10 l=764.94083
XRn1n31n1p3s2 Rn1n31n1t3s1 Rn1n31n1t3s2 0 sky130_fd_pr__res_xhigh_po w=10 l=764.94083
XRn1n31n1p3s3 Rn1n31n1t3s2 n1p 0 sky130_fd_pr__res_xhigh_po w=10 l=764.94083
* n1 input 32 w=+0.139103822260271 w+  bank=n alpha=1 R=239629.169002738 G_phys=4.17311466780814e-06 G_eff=4.17311466780814e-06
* PDK sky130_fd_pr__res_xhigh_po Rn1p32n1 W=10 L=1191.3306
* tile Rn1p32n1 4s x 4p same W=10 L=1191.3306
XRn1p32n1p0s0 in32n Rn1p32n1t0s0 0 sky130_fd_pr__res_xhigh_po w=10 l=1191.3306
XRn1p32n1p0s1 Rn1p32n1t0s0 Rn1p32n1t0s1 0 sky130_fd_pr__res_xhigh_po w=10 l=1191.3306
XRn1p32n1p0s2 Rn1p32n1t0s1 Rn1p32n1t0s2 0 sky130_fd_pr__res_xhigh_po w=10 l=1191.3306
XRn1p32n1p0s3 Rn1p32n1t0s2 n1p 0 sky130_fd_pr__res_xhigh_po w=10 l=1191.3306
XRn1p32n1p1s0 in32n Rn1p32n1t1s0 0 sky130_fd_pr__res_xhigh_po w=10 l=1191.3306
XRn1p32n1p1s1 Rn1p32n1t1s0 Rn1p32n1t1s1 0 sky130_fd_pr__res_xhigh_po w=10 l=1191.3306
XRn1p32n1p1s2 Rn1p32n1t1s1 Rn1p32n1t1s2 0 sky130_fd_pr__res_xhigh_po w=10 l=1191.3306
XRn1p32n1p1s3 Rn1p32n1t1s2 n1p 0 sky130_fd_pr__res_xhigh_po w=10 l=1191.3306
XRn1p32n1p2s0 in32n Rn1p32n1t2s0 0 sky130_fd_pr__res_xhigh_po w=10 l=1191.3306
XRn1p32n1p2s1 Rn1p32n1t2s0 Rn1p32n1t2s1 0 sky130_fd_pr__res_xhigh_po w=10 l=1191.3306
XRn1p32n1p2s2 Rn1p32n1t2s1 Rn1p32n1t2s2 0 sky130_fd_pr__res_xhigh_po w=10 l=1191.3306
XRn1p32n1p2s3 Rn1p32n1t2s2 n1p 0 sky130_fd_pr__res_xhigh_po w=10 l=1191.3306
XRn1p32n1p3s0 in32n Rn1p32n1t3s0 0 sky130_fd_pr__res_xhigh_po w=10 l=1191.3306
XRn1p32n1p3s1 Rn1p32n1t3s0 Rn1p32n1t3s1 0 sky130_fd_pr__res_xhigh_po w=10 l=1191.3306
XRn1p32n1p3s2 Rn1p32n1t3s1 Rn1p32n1t3s2 0 sky130_fd_pr__res_xhigh_po w=10 l=1191.3306
XRn1p32n1p3s3 Rn1p32n1t3s2 n1p 0 sky130_fd_pr__res_xhigh_po w=10 l=1191.3306
* n1 bias w+  bank=f alpha=0.001 R=1034.77721072674 G_phys=0.000966391595827364 G_eff=9.66391595827364e-07
* PDK sky130_fd_pr__res_xhigh_po Rn1bpf1 W=10 L=5.039284
* tile Rn1bpf1 4s x 4p same W=10 L=5.039284
XRn1bpf1p0s0 taprefn Rn1bpf1t0s0 0 sky130_fd_pr__res_xhigh_po w=10 l=5.039284
XRn1bpf1p0s1 Rn1bpf1t0s0 Rn1bpf1t0s1 0 sky130_fd_pr__res_xhigh_po w=10 l=5.039284
XRn1bpf1p0s2 Rn1bpf1t0s1 Rn1bpf1t0s2 0 sky130_fd_pr__res_xhigh_po w=10 l=5.039284
XRn1bpf1p0s3 Rn1bpf1t0s2 n1p 0 sky130_fd_pr__res_xhigh_po w=10 l=5.039284
XRn1bpf1p1s0 taprefn Rn1bpf1t1s0 0 sky130_fd_pr__res_xhigh_po w=10 l=5.039284
XRn1bpf1p1s1 Rn1bpf1t1s0 Rn1bpf1t1s1 0 sky130_fd_pr__res_xhigh_po w=10 l=5.039284
XRn1bpf1p1s2 Rn1bpf1t1s1 Rn1bpf1t1s2 0 sky130_fd_pr__res_xhigh_po w=10 l=5.039284
XRn1bpf1p1s3 Rn1bpf1t1s2 n1p 0 sky130_fd_pr__res_xhigh_po w=10 l=5.039284
XRn1bpf1p2s0 taprefn Rn1bpf1t2s0 0 sky130_fd_pr__res_xhigh_po w=10 l=5.039284
XRn1bpf1p2s1 Rn1bpf1t2s0 Rn1bpf1t2s1 0 sky130_fd_pr__res_xhigh_po w=10 l=5.039284
XRn1bpf1p2s2 Rn1bpf1t2s1 Rn1bpf1t2s2 0 sky130_fd_pr__res_xhigh_po w=10 l=5.039284
XRn1bpf1p2s3 Rn1bpf1t2s2 n1p 0 sky130_fd_pr__res_xhigh_po w=10 l=5.039284
XRn1bpf1p3s0 taprefn Rn1bpf1t3s0 0 sky130_fd_pr__res_xhigh_po w=10 l=5.039284
XRn1bpf1p3s1 Rn1bpf1t3s0 Rn1bpf1t3s1 0 sky130_fd_pr__res_xhigh_po w=10 l=5.039284
XRn1bpf1p3s2 Rn1bpf1t3s1 Rn1bpf1t3s2 0 sky130_fd_pr__res_xhigh_po w=10 l=5.039284
XRn1bpf1p3s3 Rn1bpf1t3s2 n1p 0 sky130_fd_pr__res_xhigh_po w=10 l=5.039284
* feedback TIA n1: Rf=33333.3333333333 A=1000000 V(n1lin) = -I(n1p)*Rf*A/(A+1)  (uncompensated)
En1tia n1lin 0 0 n1p 1000000
* PDK sky130_fd_pr__res_xhigh_po Rn1f W=10 L=165.62771
* tile Rn1f 4s x 4p same W=10 L=165.62771
XRn1fp0s0 n1lin Rn1ft0s0 0 sky130_fd_pr__res_xhigh_po w=10 l=165.62771
XRn1fp0s1 Rn1ft0s0 Rn1ft0s1 0 sky130_fd_pr__res_xhigh_po w=10 l=165.62771
XRn1fp0s2 Rn1ft0s1 Rn1ft0s2 0 sky130_fd_pr__res_xhigh_po w=10 l=165.62771
XRn1fp0s3 Rn1ft0s2 n1p 0 sky130_fd_pr__res_xhigh_po w=10 l=165.62771
XRn1fp1s0 n1lin Rn1ft1s0 0 sky130_fd_pr__res_xhigh_po w=10 l=165.62771
XRn1fp1s1 Rn1ft1s0 Rn1ft1s1 0 sky130_fd_pr__res_xhigh_po w=10 l=165.62771
XRn1fp1s2 Rn1ft1s1 Rn1ft1s2 0 sky130_fd_pr__res_xhigh_po w=10 l=165.62771
XRn1fp1s3 Rn1ft1s2 n1p 0 sky130_fd_pr__res_xhigh_po w=10 l=165.62771
XRn1fp2s0 n1lin Rn1ft2s0 0 sky130_fd_pr__res_xhigh_po w=10 l=165.62771
XRn1fp2s1 Rn1ft2s0 Rn1ft2s1 0 sky130_fd_pr__res_xhigh_po w=10 l=165.62771
XRn1fp2s2 Rn1ft2s1 Rn1ft2s2 0 sky130_fd_pr__res_xhigh_po w=10 l=165.62771
XRn1fp2s3 Rn1ft2s2 n1p 0 sky130_fd_pr__res_xhigh_po w=10 l=165.62771
XRn1fp3s0 n1lin Rn1ft3s0 0 sky130_fd_pr__res_xhigh_po w=10 l=165.62771
XRn1fp3s1 Rn1ft3s0 Rn1ft3s1 0 sky130_fd_pr__res_xhigh_po w=10 l=165.62771
XRn1fp3s2 Rn1ft3s1 Rn1ft3s2 0 sky130_fd_pr__res_xhigh_po w=10 l=165.62771
XRn1fp3s3 Rn1ft3s2 n1p 0 sky130_fd_pr__res_xhigh_po w=10 l=165.62771

.control
set numdgt=12
set seed=54013
op
print v(n1lin)
print v(n1p)
.endc
.end
