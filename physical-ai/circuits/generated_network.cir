* Physical AI - Experiment 4: linear layer + precision ReLU
*
* I_j = sum_i V_i * G_ji     (virtual-ground current sum)
* V_lin_j = I_j / G_SCALE    (H-source transimpedance)
* V_y_j ≈ max(0, V_lin_j)    (diode precision rectifier)
*
* The H source is an analog of a transimpedance amplifier so the
* rectifier can operate in voltage mode at the same scale as Y.
* The diode is the nonlinear element; op-amp feedback cancels Vf.
*
* G_SCALE = 0.0001 S per unit weight

V_1 in1 0 DC 10
V_2 in2 0 DC -5
V_3 in3 0 DC -1

* --- Neuron 1 ---
* W[1,1] = 0.1 -> R_1_1 = 100000 Ohm
R_1_1 in1 sum1 100000
* W[1,2] = 0.2 -> R_1_2 = 50000 Ohm
R_1_2 in2 sum1 50000
* W[1,3] = 0.3 -> R_1_3 = 33333.3333333333 Ohm
R_1_3 in3 sum1 33333.3333333333
Vam1 sum1 0 DC 0
Hlin1 lin1 0 Vam1 10000
Bop1 amp1 0 V = max(-15, min(15, 100000 * v(lin1, y1)))
Drelu1 amp1 y1 Dsi
Rload1 y1 0 10000

* --- Neuron 2 ---
* W[2,1] = 0.4 -> R_2_1 = 25000 Ohm
R_2_1 in1 sum2 25000
* W[2,2] = 0.5 -> R_2_2 = 20000 Ohm
R_2_2 in2 sum2 20000
* W[2,3] = 0.6 -> R_2_3 = 16666.6666666667 Ohm
R_2_3 in3 sum2 16666.6666666667
Vam2 sum2 0 DC 0
Hlin2 lin2 0 Vam2 10000
Bop2 amp2 0 V = max(-15, min(15, 100000 * v(lin2, y2)))
Drelu2 amp2 y2 Dsi
Rload2 y2 0 10000

.model Dsi D(Is=1e-14 N=1 Rs=1)

.control
op
print i(Vam1)
print v(lin1)
print v(y1)
print v(sum1)
print i(Vam2)
print v(lin2)
print v(y2)
print v(sum2)
.endc

.end
