* Experiment 40 SKY130 isolated catalog o2 / W2[1]
* PDK sky130A open_pdks 1689ac3f2dc763876eaf967227c7dfe831b031ae
* Frozen weights were not edited. SPICE is not Python-corrected.
.lib "C:/dev/pdk/sky130A/libs.tech/ngspice/sky130.lib.spice" hh
.temp 27

* Experiment 22 isolated TIA neuron n1
* frozen n=32 L1=6.7601697 b=0.0322130531942455
* A=100000 vos=0 Ileak=0 Rout=0 fp=0 invertA=1e+07
* Behavioral TIA. Not transistor-level. Weights were not edited.
* shape: 32 -> 1 (linear Vlin vs z unless ReLU requested)

Vin1 in1 0 DC 0.288635987619693
Vin2 in2 0 DC 0.653552961415873
* passive invert in2 -> in2n: R2/R1=1.0000002 closed-loop -1 at A=1e+07
* PDK sky130_fd_pr__res_xhigh_po for Rinv2ia target=10000 pred=10000
XRinv2ia in2 inv2m 0 sky130_fd_pr__res_xhigh_po w=1 l=4.7037281
* PDK sky130_fd_pr__res_xhigh_po for Rinv2ib target=10000.002 pred=10000.002
XRinv2ib in2n inv2m 0 sky130_fd_pr__res_xhigh_po w=1 l=4.7037291
Einv2amp in2n 0 0 inv2m 10000000
Vin3 in3 0 DC 1.14933536319878
* passive invert in3 -> in3n: R2/R1=1.0000002 closed-loop -1 at A=1e+07
* PDK sky130_fd_pr__res_xhigh_po for Rinv3ia target=10000 pred=10000
XRinv3ia in3 inv3m 0 sky130_fd_pr__res_xhigh_po w=1 l=4.7037281
* PDK sky130_fd_pr__res_xhigh_po for Rinv3ib target=10000.002 pred=10000.002
XRinv3ib in3n inv3m 0 sky130_fd_pr__res_xhigh_po w=1 l=4.7037291
Einv3amp in3n 0 0 inv3m 10000000
Vin4 in4 0 DC 0
Vin5 in5 0 DC 1.37476380462716
* passive invert in5 -> in5n: R2/R1=1.0000002 closed-loop -1 at A=1e+07
* PDK sky130_fd_pr__res_xhigh_po for Rinv5ia target=10000 pred=10000
XRinv5ia in5 inv5m 0 sky130_fd_pr__res_xhigh_po w=1 l=4.7037281
* PDK sky130_fd_pr__res_xhigh_po for Rinv5ib target=10000.002 pred=10000.002
XRinv5ib in5n inv5m 0 sky130_fd_pr__res_xhigh_po w=1 l=4.7037291
Einv5amp in5n 0 0 inv5m 10000000
Vin6 in6 0 DC 1.19986134609244
* passive invert in6 -> in6n: R2/R1=1.0000002 closed-loop -1 at A=1e+07
* PDK sky130_fd_pr__res_xhigh_po for Rinv6ia target=10000 pred=10000
XRinv6ia in6 inv6m 0 sky130_fd_pr__res_xhigh_po w=1 l=4.7037281
* PDK sky130_fd_pr__res_xhigh_po for Rinv6ib target=10000.002 pred=10000.002
XRinv6ib in6n inv6m 0 sky130_fd_pr__res_xhigh_po w=1 l=4.7037291
Einv6amp in6n 0 0 inv6m 10000000
Vin7 in7 0 DC 0
Vin8 in8 0 DC 0.317097301363568
Vin9 in9 0 DC 0
* passive invert in9 -> in9n: R2/R1=1.0000002 closed-loop -1 at A=1e+07
* PDK sky130_fd_pr__res_xhigh_po for Rinv9ia target=10000 pred=10000
XRinv9ia in9 inv9m 0 sky130_fd_pr__res_xhigh_po w=1 l=4.7037281
* PDK sky130_fd_pr__res_xhigh_po for Rinv9ib target=10000.002 pred=10000.002
XRinv9ib in9n inv9m 0 sky130_fd_pr__res_xhigh_po w=1 l=4.7037291
Einv9amp in9n 0 0 inv9m 10000000
Vin10 in10 0 DC 0.827257420094178
* passive invert in10 -> in10n: R2/R1=1.0000002 closed-loop -1 at A=1e+07
* PDK sky130_fd_pr__res_xhigh_po for Rinv10ia target=10000 pred=10000
XRinv10ia in10 inv10m 0 sky130_fd_pr__res_xhigh_po w=1 l=4.7037281
* PDK sky130_fd_pr__res_xhigh_po for Rinv10ib target=10000.002 pred=10000.002
XRinv10ib in10n inv10m 0 sky130_fd_pr__res_xhigh_po w=1 l=4.7037291
Einv10amp in10n 0 0 inv10m 10000000
Vin11 in11 0 DC 0
Vin12 in12 0 DC 0
Vin13 in13 0 DC 0
Vin14 in14 0 DC 1.25893915448753
* passive invert in14 -> in14n: R2/R1=1.0000002 closed-loop -1 at A=1e+07
* PDK sky130_fd_pr__res_xhigh_po for Rinv14ia target=10000 pred=10000
XRinv14ia in14 inv14m 0 sky130_fd_pr__res_xhigh_po w=1 l=4.7037281
* PDK sky130_fd_pr__res_xhigh_po for Rinv14ib target=10000.002 pred=10000.002
XRinv14ib in14n inv14m 0 sky130_fd_pr__res_xhigh_po w=1 l=4.7037291
Einv14amp in14n 0 0 inv14m 10000000
Vin15 in15 0 DC 0.398142284790337
Vin16 in16 0 DC 0
* load-compensated divider in16->tap16: G_load=0.000666445780473128 Ra=599479.450040294 Rb=1000 target beta=0.001 (no tap buffer)
* PDK sky130_fd_pr__res_xhigh_po for Rdiv16a target=599479.45 pred=599479.45
XRdiv16a in16 tap16 0 sky130_fd_pr__res_xhigh_po w=1 l=282.93803
* PDK sky130_fd_pr__res_xhigh_po for Rdiv16b target=1000 pred=1000
XRdiv16b tap16 0 0 sky130_fd_pr__res_xhigh_po w=1.0975115 l=0.5
Vin17 in17 0 DC 0
* passive invert in17 -> in17n: R2/R1=1.0000002 closed-loop -1 at A=1e+07
* PDK sky130_fd_pr__res_xhigh_po for Rinv17ia target=10000 pred=10000
XRinv17ia in17 inv17m 0 sky130_fd_pr__res_xhigh_po w=1 l=4.7037281
* PDK sky130_fd_pr__res_xhigh_po for Rinv17ib target=10000.002 pred=10000.002
XRinv17ib in17n inv17m 0 sky130_fd_pr__res_xhigh_po w=1 l=4.7037291
Einv17amp in17n 0 0 inv17m 10000000
* load-compensated divider in17n->tap17n: G_load=0.000266255881165782 Ra=788940.067216326 Rb=1000 target beta=0.001 (no tap buffer)
* PDK sky130_fd_pr__res_xhigh_po for Rdiv17na target=788940.07 pred=788940.07
XRdiv17na in17n tap17n 0 sky130_fd_pr__res_xhigh_po w=1 l=372.36344
* PDK sky130_fd_pr__res_xhigh_po for Rdiv17nb target=1000 pred=1000
XRdiv17nb tap17n 0 0 sky130_fd_pr__res_xhigh_po w=1.0975115 l=0.5
Vin18 in18 0 DC 1.19134595226048
Vin19 in19 0 DC 0
* passive invert in19 -> in19n: R2/R1=1.0000002 closed-loop -1 at A=1e+07
* PDK sky130_fd_pr__res_xhigh_po for Rinv19ia target=10000 pred=10000
XRinv19ia in19 inv19m 0 sky130_fd_pr__res_xhigh_po w=1 l=4.7037281
* PDK sky130_fd_pr__res_xhigh_po for Rinv19ib target=10000.002 pred=10000.002
XRinv19ib in19n inv19m 0 sky130_fd_pr__res_xhigh_po w=1 l=4.7037291
Einv19amp in19n 0 0 inv19m 10000000
Vin20 in20 0 DC 0
* load-compensated divider in20->tap20: G_load=0.000971610549965604 Ra=506692.358700063 Rb=1000 target beta=0.001 (no tap buffer)
* PDK sky130_fd_pr__res_xhigh_po for Rdiv20a target=506692.36 pred=506692.36
XRdiv20a in20 tap20 0 sky130_fd_pr__res_xhigh_po w=1 l=239.14252
* PDK sky130_fd_pr__res_xhigh_po for Rdiv20b target=1000 pred=1000
XRdiv20b tap20 0 0 sky130_fd_pr__res_xhigh_po w=1.0975115 l=0.5
Vin21 in21 0 DC 0
Vin22 in22 0 DC 0
* passive invert in22 -> in22n: R2/R1=1.0000002 closed-loop -1 at A=1e+07
* PDK sky130_fd_pr__res_xhigh_po for Rinv22ia target=10000 pred=10000
XRinv22ia in22 inv22m 0 sky130_fd_pr__res_xhigh_po w=1 l=4.7037281
* PDK sky130_fd_pr__res_xhigh_po for Rinv22ib target=10000.002 pred=10000.002
XRinv22ib in22n inv22m 0 sky130_fd_pr__res_xhigh_po w=1 l=4.7037291
Einv22amp in22n 0 0 inv22m 10000000
Vin23 in23 0 DC 0.370520947636909
* passive invert in23 -> in23n: R2/R1=1.0000002 closed-loop -1 at A=1e+07
* PDK sky130_fd_pr__res_xhigh_po for Rinv23ia target=10000 pred=10000
XRinv23ia in23 inv23m 0 sky130_fd_pr__res_xhigh_po w=1 l=4.7037281
* PDK sky130_fd_pr__res_xhigh_po for Rinv23ib target=10000.002 pred=10000.002
XRinv23ib in23n inv23m 0 sky130_fd_pr__res_xhigh_po w=1 l=4.7037291
Einv23amp in23n 0 0 inv23m 10000000
Vin24 in24 0 DC 0
* load-compensated divider in24->tap24: G_load=0.000881349510863982 Ra=531001.812385847 Rb=1000 target beta=0.001 (no tap buffer)
* PDK sky130_fd_pr__res_xhigh_po for Rdiv24a target=531001.81 pred=531001.81
XRdiv24a in24 tap24 0 sky130_fd_pr__res_xhigh_po w=1 l=250.61658
* PDK sky130_fd_pr__res_xhigh_po for Rdiv24b target=1000 pred=1000
XRdiv24b tap24 0 0 sky130_fd_pr__res_xhigh_po w=1.0975115 l=0.5
Vin25 in25 0 DC 0
* passive invert in25 -> in25n: R2/R1=1.0000002 closed-loop -1 at A=1e+07
* PDK sky130_fd_pr__res_xhigh_po for Rinv25ia target=10000 pred=10000
XRinv25ia in25 inv25m 0 sky130_fd_pr__res_xhigh_po w=1 l=4.7037281
* PDK sky130_fd_pr__res_xhigh_po for Rinv25ib target=10000.002 pred=10000.002
XRinv25ib in25n inv25m 0 sky130_fd_pr__res_xhigh_po w=1 l=4.7037291
Einv25amp in25n 0 0 inv25m 10000000
Vin26 in26 0 DC 0
Vin27 in27 0 DC 1.88293545008737
* passive invert in27 -> in27n: R2/R1=1.0000002 closed-loop -1 at A=1e+07
* PDK sky130_fd_pr__res_xhigh_po for Rinv27ia target=10000 pred=10000
XRinv27ia in27 inv27m 0 sky130_fd_pr__res_xhigh_po w=1 l=4.7037281
* PDK sky130_fd_pr__res_xhigh_po for Rinv27ib target=10000.002 pred=10000.002
XRinv27ib in27n inv27m 0 sky130_fd_pr__res_xhigh_po w=1 l=4.7037291
Einv27amp in27n 0 0 inv27m 10000000
Vin28 in28 0 DC 1.38172289531745
* passive invert in28 -> in28n: R2/R1=1.0000002 closed-loop -1 at A=1e+07
* PDK sky130_fd_pr__res_xhigh_po for Rinv28ia target=10000 pred=10000
XRinv28ia in28 inv28m 0 sky130_fd_pr__res_xhigh_po w=1 l=4.7037281
* PDK sky130_fd_pr__res_xhigh_po for Rinv28ib target=10000.002 pred=10000.002
XRinv28ib in28n inv28m 0 sky130_fd_pr__res_xhigh_po w=1 l=4.7037291
Einv28amp in28n 0 0 inv28m 10000000
Vin29 in29 0 DC 0
* passive invert in29 -> in29n: R2/R1=1.0000002 closed-loop -1 at A=1e+07
* PDK sky130_fd_pr__res_xhigh_po for Rinv29ia target=10000 pred=10000
XRinv29ia in29 inv29m 0 sky130_fd_pr__res_xhigh_po w=1 l=4.7037281
* PDK sky130_fd_pr__res_xhigh_po for Rinv29ib target=10000.002 pred=10000.002
XRinv29ib in29n inv29m 0 sky130_fd_pr__res_xhigh_po w=1 l=4.7037291
Einv29amp in29n 0 0 inv29m 10000000
* load-compensated divider in29n->tap29n: G_load=0.000275989040257845 Ra=782922.085128668 Rb=1000 target beta=0.001 (no tap buffer)
* PDK sky130_fd_pr__res_xhigh_po for Rdiv29na target=782922.09 pred=782922.09
XRdiv29na in29n tap29n 0 sky130_fd_pr__res_xhigh_po w=1 l=369.52295
* PDK sky130_fd_pr__res_xhigh_po for Rdiv29nb target=1000 pred=1000
XRdiv29nb tap29n 0 0 sky130_fd_pr__res_xhigh_po w=1.0975115 l=0.5
Vin30 in30 0 DC 0.0467434987671904
Vin31 in31 0 DC 0.376944739491497
Vin32 in32 0 DC 0.0618086911540602
* passive invert in32 -> in32n: R2/R1=1.0000002 closed-loop -1 at A=1e+07
* PDK sky130_fd_pr__res_xhigh_po for Rinv32ia target=10000 pred=10000
XRinv32ia in32 inv32m 0 sky130_fd_pr__res_xhigh_po w=1 l=4.7037281
* PDK sky130_fd_pr__res_xhigh_po for Rinv32ib target=10000.002 pred=10000.002
XRinv32ib in32n inv32m 0 sky130_fd_pr__res_xhigh_po w=1 l=4.7037291
Einv32amp in32n 0 0 inv32m 10000000
Vref vref 0 DC 1
* passive invert vref -> vrefn: R2/R1=1.0000002 closed-loop -1 at A=1e+07
* PDK sky130_fd_pr__res_xhigh_po for Rinvrefia target=10000 pred=10000
XRinvrefia vref invrefm 0 sky130_fd_pr__res_xhigh_po w=1 l=4.7037281
* PDK sky130_fd_pr__res_xhigh_po for Rinvrefib target=10000.002 pred=10000.002
XRinvrefib vrefn invrefm 0 sky130_fd_pr__res_xhigh_po w=1 l=4.7037291
Einvrefamp vrefn 0 0 invrefm 10000000
* load-compensated divider vrefn->taprefn: G_load=0.000966391595827364 Ra=508037.159088685 Rb=1000 target beta=0.001 (no tap buffer)
* PDK sky130_fd_pr__res_xhigh_po for Rdivrefna target=508037.16 pred=508037.16
XRdivrefna vrefn taprefn 0 sky130_fd_pr__res_xhigh_po w=1 l=239.77727
* PDK sky130_fd_pr__res_xhigh_po for Rdivrefnb target=1000 pred=1000
XRdivrefnb taprefn 0 0 sky130_fd_pr__res_xhigh_po w=1.0975115 l=0.5

* n1 input 1 w=-0.195521390350609 w-  bank=n alpha=1 R=170484.330505015 G_phys=5.86564171051827e-06 G_eff=5.86564171051827e-06
* PDK sky130_fd_pr__res_xhigh_po for Rn1n1n1 target=170484.33 pred=170484.33
XRn1n1n1 in1 n1p 0 sky130_fd_pr__res_xhigh_po w=1 l=80.452332
* n1 input 2 w=+0.386445174905558 w+  bank=n alpha=1 R=86256.3061926689 G_phys=1.15933552471668e-05 G_eff=1.15933552471668e-05
* PDK sky130_fd_pr__res_xhigh_po for Rn1p2n1 target=86256.306 pred=86256.306
XRn1p2n1 in2n n1p 0 sky130_fd_pr__res_xhigh_po w=1 l=40.696705
* n1 input 3 w=+0.296294588630229 w+  bank=n alpha=1 R=112500.648383197 G_phys=8.88883765890688e-06 G_eff=8.88883765890688e-06
* PDK sky130_fd_pr__res_xhigh_po for Rn1p3n1 target=112500.65 pred=112500.65
XRn1p3n1 in3n n1p 0 sky130_fd_pr__res_xhigh_po w=1 l=53.084034
* n1 input 4 w=-0.299308681857295 w-  bank=n alpha=1 R=111367.746256108 G_phys=8.97926045571886e-06 G_eff=8.97926045571886e-06
* PDK sky130_fd_pr__res_xhigh_po for Rn1n4n1 target=111367.75 pred=111367.75
XRn1n4n1 in4 n1p 0 sky130_fd_pr__res_xhigh_po w=1 l=52.549304
* n1 input 5 w=+0.732671792857329 w+  bank=n alpha=1 R=45495.5870531571 G_phys=2.19801537857199e-05 G_eff=2.19801537857199e-05
* PDK sky130_fd_pr__res_xhigh_po for Rn1p5n1 target=45495.587 pred=45495.587
XRn1p5n1 in5n n1p 0 sky130_fd_pr__res_xhigh_po w=1 l=21.457645
* n1 input 6 w=+0.124925987288217 w+  bank=n alpha=1 R=266824.65399637 G_phys=3.7477796186465e-06 G_eff=3.7477796186465e-06
* PDK sky130_fd_pr__res_xhigh_po for Rn1p6n1 target=266824.65 pred=266824.65
XRn1p6n1 in6n n1p 0 sky130_fd_pr__res_xhigh_po w=1 l=125.92496
* n1 input 7 w=-0.0857938493267301 w-  bank=n alpha=1 R=388528.240601368 G_phys=2.5738154798019e-06 G_eff=2.5738154798019e-06
* PDK sky130_fd_pr__res_xhigh_po for Rn1n7n1 target=388528.24 pred=388528.24
XRn1n7n1 in7 n1p 0 sky130_fd_pr__res_xhigh_po w=1 l=183.36906
* n1 input 8 w=-0.0609936542707342 w-  bank=n alpha=1 R=546504.939438057 G_phys=1.82980962812202e-06 G_eff=1.82980962812202e-06
* PDK sky130_fd_pr__res_xhigh_po for Rn1n8n1 target=546504.94 pred=546504.94
XRn1n8n1 in8 n1p 0 sky130_fd_pr__res_xhigh_po w=1 l=257.93406
* n1 input 9 w=+0.256981204903229 w+  bank=n alpha=1 R=129711.172246568 G_phys=7.70943614709688e-06 G_eff=7.70943614709688e-06
* PDK sky130_fd_pr__res_xhigh_po for Rn1p9n1 target=129711.17 pred=129711.17
XRn1p9n1 in9n n1p 0 sky130_fd_pr__res_xhigh_po w=1 l=61.207401
* n1 input 10 w=+0.073638013162671 w+  bank=n alpha=1 R=452664.756987643 G_phys=2.20914039488013e-06 G_eff=2.20914039488013e-06
* PDK sky130_fd_pr__res_xhigh_po for Rn1p10n1 target=452664.76 pred=452664.76
XRn1p10n1 in10n n1p 0 sky130_fd_pr__res_xhigh_po w=1 l=213.64149
* n1 input 11 w=-0.149208279345328 w-  bank=n alpha=1 R=223401.365390634 G_phys=4.47624838035983e-06 G_eff=4.47624838035983e-06
* PDK sky130_fd_pr__res_xhigh_po for Rn1n11n1 target=223401.37 pred=223401.37
XRn1n11n1 in11 n1p 0 sky130_fd_pr__res_xhigh_po w=1 l=105.42917
* n1 input 12 w=-0.475362564845884 w-  bank=n alpha=1 R=70121.9149306388 G_phys=1.42608769453765e-05 G_eff=1.42608769453765e-05
* PDK sky130_fd_pr__res_xhigh_po for Rn1n12n1 target=70121.915 pred=70121.915
XRn1n12n1 in12 n1p 0 sky130_fd_pr__res_xhigh_po w=1 l=33.081272
* n1 input 13 w=-0.0533811781970356 w-  bank=n alpha=1 R=624439.820535554 G_phys=1.60143534591107e-06 G_eff=1.60143534591107e-06
* PDK sky130_fd_pr__res_xhigh_po for Rn1n13n1 target=624439.82 pred=624439.82
XRn1n13n1 in13 n1p 0 sky130_fd_pr__res_xhigh_po w=1 l=294.71932
* n1 input 14 w=+0.279456004632752 w+  bank=n alpha=1 R=119279.359830319 G_phys=8.38368013898257e-06 G_eff=8.38368013898257e-06
* PDK sky130_fd_pr__res_xhigh_po for Rn1p14n1 target=119279.36 pred=119279.36
XRn1p14n1 in14n n1p 0 sky130_fd_pr__res_xhigh_po w=1 l=56.283586
* n1 input 15 w=-0.0744870090943736 w-  bank=n alpha=1 R=447505.326614748 G_phys=2.23461027283121e-06 G_eff=2.23461027283121e-06
* PDK sky130_fd_pr__res_xhigh_po for Rn1n15n1 target=447505.33 pred=447505.33
XRn1n15n1 in15 n1p 0 sky130_fd_pr__res_xhigh_po w=1 l=211.20624
* n1 input 16 w=-0.0222148593491043 w-  bank=f alpha=0.001 R=1500.49715865869 G_phys=0.000666445780473128 G_eff=6.66445780473128e-07
* PDK sky130_fd_pr__res_xhigh_po for Rn1n16f1 target=1500.4972 pred=1500.4972
XRn1n16f1 tap16 n1p 0 sky130_fd_pr__res_xhigh_po w=1 l=0.69196278
* n1 input 17 w=+0.0088751960388594 w+  bank=f alpha=0.001 R=3755.78558348297 G_phys=0.000266255881165782 G_eff=2.66255881165782e-07
* PDK sky130_fd_pr__res_xhigh_po for Rn1p17f1 target=3755.7856 pred=3755.7856
XRn1p17f1 tap17n n1p 0 sky130_fd_pr__res_xhigh_po w=1 l=1.7564589
* n1 input 18 w=-0.194172060066752 w-  bank=n alpha=1 R=171669.051262443 G_phys=5.82516180200256e-06 G_eff=5.82516180200256e-06
* PDK sky130_fd_pr__res_xhigh_po for Rn1n18n1 target=171669.05 pred=171669.05
XRn1n18n1 in18 n1p 0 sky130_fd_pr__res_xhigh_po w=1 l=81.01152
* n1 input 19 w=+0.341327626188232 w+  bank=n alpha=1 R=97657.8828546125 G_phys=1.0239828785647e-05 G_eff=1.0239828785647e-05
* PDK sky130_fd_pr__res_xhigh_po for Rn1p19n1 target=97657.883 pred=97657.883
XRn1p19n1 in19n n1p 0 sky130_fd_pr__res_xhigh_po w=1 l=46.078249
* n1 input 20 w=-0.0323870183321868 w-  bank=f alpha=0.001 R=1029.21896024637 G_phys=0.000971610549965604 G_eff=9.71610549965604e-07
* PDK sky130_fd_pr__res_xhigh_po for Rn1n20f1 target=1029.219 pred=1029.219
XRn1n20f1 tap20 n1p 0 sky130_fd_pr__res_xhigh_po w=1.0651278 l=0.5
* n1 input 21 w=-0.0999542141187652 w-  bank=n alpha=1 R=333486.022847689 G_phys=2.99862642356296e-06 G_eff=2.99862642356296e-06
* PDK sky130_fd_pr__res_xhigh_po for Rn1n21n1 target=333486.02 pred=333486.02
XRn1n21n1 in21 n1p 0 sky130_fd_pr__res_xhigh_po w=1 l=157.38913
* n1 input 22 w=+0.693789300406694 w+  bank=n alpha=1 R=48045.3263170729 G_phys=2.08136790122008e-05 G_eff=2.08136790122008e-05
* PDK sky130_fd_pr__res_xhigh_po for Rn1p22n1 target=48045.326 pred=48045.326
XRn1p22n1 in22n n1p 0 sky130_fd_pr__res_xhigh_po w=1 l=22.661122
* n1 input 23 w=+0.0972685864670828 w+  bank=n alpha=1 R=342693.715864925 G_phys=2.91805759401248e-06 G_eff=2.91805759401248e-06
* PDK sky130_fd_pr__res_xhigh_po for Rn1p23n1 target=342693.72 pred=342693.72
XRn1p23n1 in23n n1p 0 sky130_fd_pr__res_xhigh_po w=1 l=161.73516
* n1 input 24 w=-0.0293783170287994 w-  bank=f alpha=0.001 R=1134.6236512002 G_phys=0.000881349510863982 G_eff=8.81349510863982e-07
* PDK sky130_fd_pr__res_xhigh_po for Rn1n24f1 target=1134.6237 pred=1134.6236
XRn1n24f1 tap24 n1p 0 sky130_fd_pr__res_xhigh_po w=1 l=0.51927048
* n1 input 25 w=+0.0497492024826392 w+  bank=n alpha=1 R=670027.491294269 G_phys=1.49247607447918e-06 G_eff=1.49247607447918e-06
* PDK sky130_fd_pr__res_xhigh_po for Rn1p25n1 target=670027.49 pred=670027.49
XRn1p25n1 in25n n1p 0 sky130_fd_pr__res_xhigh_po w=1 l=316.2367
* n1 input 26 w=-0.466063512962686 w-  bank=n alpha=1 R=71521.0103477937 G_phys=1.39819053888806e-05 G_eff=1.39819053888806e-05
* PDK sky130_fd_pr__res_xhigh_po for Rn1n26n1 target=71521.01 pred=71521.01
XRn1n26n1 in26 n1p 0 sky130_fd_pr__res_xhigh_po w=1 l=33.741645
* n1 input 27 w=+0.194887582685885 w+  bank=n alpha=1 R=171038.774630702 G_phys=5.84662748057655e-06 G_eff=5.84662748057655e-06
* PDK sky130_fd_pr__res_xhigh_po for Rn1p27n1 target=171038.77 pred=171038.77
XRn1p27n1 in27n n1p 0 sky130_fd_pr__res_xhigh_po w=1 l=80.71403
* n1 input 28 w=+0.209047565197081 w+  bank=n alpha=1 R=159453.344036359 G_phys=6.27142695591242e-06 G_eff=6.27142695591242e-06
* PDK sky130_fd_pr__res_xhigh_po for Rn1p28n1 target=159453.34 pred=159453.34
XRn1p28n1 in28n n1p 0 sky130_fd_pr__res_xhigh_po w=1 l=75.245707
* n1 input 29 w=+0.00919963467526149 w+  bank=f alpha=0.001 R=3623.33228546229 G_phys=0.000275989040257845 G_eff=2.75989040257845e-07
* PDK sky130_fd_pr__res_xhigh_po for Rn1p29f1 target=3623.3323 pred=3623.3323
XRn1p29f1 tap29n n1p 0 sky130_fd_pr__res_xhigh_po w=1 l=1.693941
* n1 input 30 w=-0.379437042796868 w-  bank=n alpha=1 R=87849.4442388387 G_phys=1.13831112839061e-05 G_eff=1.13831112839061e-05
* PDK sky130_fd_pr__res_xhigh_po for Rn1n30n1 target=87849.444 pred=87849.444
XRn1n30n1 in30 n1p 0 sky130_fd_pr__res_xhigh_po w=1 l=41.448666
* n1 input 31 w=-0.216631724491884 w-  bank=n alpha=1 R=153870.96885979 G_phys=6.49895173475653e-06 G_eff=6.49895173475653e-06
* PDK sky130_fd_pr__res_xhigh_po for Rn1n31n1 target=153870.97 pred=153870.97
XRn1n31n1 in31 n1p 0 sky130_fd_pr__res_xhigh_po w=1 l=72.610825
* n1 input 32 w=+0.139103822260271 w+  bank=n alpha=1 R=239629.169002738 G_phys=4.17311466780814e-06 G_eff=4.17311466780814e-06
* PDK sky130_fd_pr__res_xhigh_po for Rn1p32n1 target=239629.17 pred=239629.17
XRn1p32n1 in32n n1p 0 sky130_fd_pr__res_xhigh_po w=1 l=113.0887
* n1 bias w+  bank=f alpha=0.001 R=1034.77721072674 G_phys=0.000966391595827364 G_eff=9.66391595827364e-07
* PDK sky130_fd_pr__res_xhigh_po for Rn1bpf1 target=1034.7772 pred=1034.7772
XRn1bpf1 taprefn n1p 0 sky130_fd_pr__res_xhigh_po w=1.0591853 l=0.5
* feedback TIA n1: Rf=33333.3333333333 A=100000 V(n1lin) = -I(n1p)*Rf*A/(A+1)  (uncompensated)
En1tia n1lin 0 0 n1p 100000
* PDK sky130_fd_pr__res_xhigh_po for Rn1f target=33333.333 pred=33333.333
XRn1f n1lin n1p 0 sky130_fd_pr__res_xhigh_po w=1 l=15.717061

.control
set numdgt=12
op
print v(n1lin)
print v(n1p)
.endc
.end
