* Experiment 62 OPA189 superdiode ReLU diode=teaching_dsi
* Level-1 documented macromodel. Not silicon. Not MOS.
.include "C:/dev/neuron-physical-brain/physical-ai/models/vendor/ti/opa189/OPAx189.LIB"
Vin in 0 DC -3.7
Vdd vdd 0 DC 15
Vss vss 0 DC -15
Xamp in out vdd vss amp OPAx189
* Teaching diode (same card as Experiment 4). Isolates the op-amp host.
D1 amp out Dsi
.model Dsi D(Is=1e-14 N=1 Rs=1)
Rload out 0 10000
Cload out 0 1p

.control
set numdgt=15
op
print v(in) v(out) v(amp)
print i(Vin) i(Vdd) i(Vss)
.endc

.end
