* Experiment 22 isolated TIA neuron n1
* frozen n=32 L1=6.7601697 b=0.0322130531942455
* A=100000 vos=0 Ileak=0 Rout=0 fp=0 invertA=1e+07
* Behavioral TIA. Not transistor-level. Weights were not edited.
* shape: 32 -> 1 (linear Vlin vs z unless ReLU requested)

Vin1 in1 0 DC 0
Vin2 in2 0 DC 0
* passive invert in2 -> in2n: R2/R1=1.0000002 closed-loop -1 at A=1e+07
Rinv2ia in2 inv2m 9960.67649467367
Rinv2ib in2n inv2m 10005.6915149696
Einv2amp in2n 0 0 inv2m 10000000
Vin3 in3 0 DC 0
* passive invert in3 -> in3n: R2/R1=1.0000002 closed-loop -1 at A=1e+07
Rinv3ia in3 inv3m 10032.5149284686
Rinv3ib in3n inv3m 9996.35181340146
Einv3amp in3n 0 0 inv3m 10000000
Vin4 in4 0 DC 0
Vin5 in5 0 DC 0
* passive invert in5 -> in5n: R2/R1=1.0000002 closed-loop -1 at A=1e+07
Rinv5ia in5 inv5m 9965.58123855732
Rinv5ib in5n inv5m 10048.1875578189
Einv5amp in5n 0 0 inv5m 10000000
Vin6 in6 0 DC 0
* passive invert in6 -> in6n: R2/R1=1.0000002 closed-loop -1 at A=1e+07
Rinv6ia in6 inv6m 10037.4223263648
Rinv6ib in6n inv6m 10034.2955104309
Einv6amp in6n 0 0 inv6m 10000000
Vin7 in7 0 DC 0
Vin8 in8 0 DC 0
Vin9 in9 0 DC 0
* passive invert in9 -> in9n: R2/R1=1.0000002 closed-loop -1 at A=1e+07
Rinv9ia in9 inv9m 9973.04365364096
Rinv9ib in9n inv9m 10019.6569010391
Einv9amp in9n 0 0 inv9m 10000000
Vin10 in10 0 DC 0
* passive invert in10 -> in10n: R2/R1=1.0000002 closed-loop -1 at A=1e+07
Rinv10ia in10 inv10m 10048.4641209754
Rinv10ib in10n inv10m 10033.1535242727
Einv10amp in10n 0 0 inv10m 10000000
Vin11 in11 0 DC 0
Vin12 in12 0 DC 0
Vin13 in13 0 DC 0
Vin14 in14 0 DC 0
* passive invert in14 -> in14n: R2/R1=1.0000002 closed-loop -1 at A=1e+07
Rinv14ia in14 inv14m 10010.9308066311
Rinv14ib in14n inv14m 10030.8496746867
Einv14amp in14n 0 0 inv14m 10000000
Vin15 in15 0 DC 0
Vin16 in16 0 DC 0
* load-compensated divider in16->tap16: G_load=0.000666445780473128 Ra=599479.450040294 Rb=1000 target beta=0.001 (no tap buffer)
Rdiv16a in16 tap16 600895.037390036
Rdiv16b tap16 0 1001.27877964362
Vin17 in17 0 DC 0
* passive invert in17 -> in17n: R2/R1=1.0000002 closed-loop -1 at A=1e+07
Rinv17ia in17 inv17m 10035.1609112841
Rinv17ib in17n inv17m 9994.17526811265
Einv17amp in17n 0 0 inv17m 10000000
* load-compensated divider in17n->tap17n: G_load=0.000266255881165782 Ra=788940.067216326 Rb=1000 target beta=0.001 (no tap buffer)
Rdiv17na in17n tap17n 792493.079392568
Rdiv17nb tap17n 0 1002.08690241578
Vin18 in18 0 DC 0
Vin19 in19 0 DC 0
* passive invert in19 -> in19n: R2/R1=1.0000002 closed-loop -1 at A=1e+07
Rinv19ia in19 inv19m 10035.3722715177
Rinv19ib in19n inv19m 10030.671386287
Einv19amp in19n 0 0 inv19m 10000000
Vin20 in20 0 DC 0
* load-compensated divider in20->tap20: G_load=0.000971610549965604 Ra=506692.358700063 Rb=1000 target beta=0.001 (no tap buffer)
Rdiv20a in20 tap20 507696.515397782
Rdiv20b tap20 0 995.263460179624
Vin21 in21 0 DC 0
Vin22 in22 0 DC 0
* passive invert in22 -> in22n: R2/R1=1.0000002 closed-loop -1 at A=1e+07
Rinv22ia in22 inv22m 10039.6100550252
Rinv22ib in22n inv22m 10026.0701198723
Einv22amp in22n 0 0 inv22m 10000000
Vin23 in23 0 DC 0
* passive invert in23 -> in23n: R2/R1=1.0000002 closed-loop -1 at A=1e+07
Rinv23ia in23 inv23m 10031.4160887312
Rinv23ib in23n inv23m 9985.46860380959
Einv23amp in23n 0 0 inv23m 10000000
Vin24 in24 0 DC 0
* load-compensated divider in24->tap24: G_load=0.000881349510863982 Ra=531001.812385847 Rb=1000 target beta=0.001 (no tap buffer)
Rdiv24a in24 tap24 528607.162729443
Rdiv24b tap24 0 995.090919860522
Vin25 in25 0 DC 0
* passive invert in25 -> in25n: R2/R1=1.0000002 closed-loop -1 at A=1e+07
Rinv25ia in25 inv25m 9975.65333091867
Rinv25ib in25n inv25m 9976.94931400279
Einv25amp in25n 0 0 inv25m 10000000
Vin26 in26 0 DC 0
Vin27 in27 0 DC 0
* passive invert in27 -> in27n: R2/R1=1.0000002 closed-loop -1 at A=1e+07
Rinv27ia in27 inv27m 10003.2589158006
Rinv27ib in27n inv27m 10000.6688782622
Einv27amp in27n 0 0 inv27m 10000000
Vin28 in28 0 DC 0
* passive invert in28 -> in28n: R2/R1=1.0000002 closed-loop -1 at A=1e+07
Rinv28ia in28 inv28m 10019.6409972248
Rinv28ib in28n inv28m 9970.38976643058
Einv28amp in28n 0 0 inv28m 10000000
Vin29 in29 0 DC 0
* passive invert in29 -> in29n: R2/R1=1.0000002 closed-loop -1 at A=1e+07
Rinv29ia in29 inv29m 9968.13696529042
Rinv29ib in29n inv29m 9960.71270931918
Einv29amp in29n 0 0 inv29m 10000000
* load-compensated divider in29n->tap29n: G_load=0.000275989040257845 Ra=782922.085128668 Rb=1000 target beta=0.001 (no tap buffer)
Rdiv29na in29n tap29n 779604.781965816
Rdiv29nb tap29n 0 996.465964671234
Vin30 in30 0 DC 0
Vin31 in31 0 DC 0
Vin32 in32 0 DC 0
* passive invert in32 -> in32n: R2/R1=1.0000002 closed-loop -1 at A=1e+07
Rinv32ia in32 inv32m 10016.623895975
Rinv32ib in32n inv32m 9985.58160610456
Einv32amp in32n 0 0 inv32m 10000000
Vref vref 0 DC 1
* passive invert vref -> vrefn: R2/R1=1.0000002 closed-loop -1 at A=1e+07
Rinvrefia vref invrefm 9952.47299953595
Rinvrefib vrefn invrefm 10048.0283806915
Einvrefamp vrefn 0 0 invrefm 10000000
* load-compensated divider vrefn->taprefn: G_load=0.000966391595827364 Ra=508037.159088685 Rb=1000 target beta=0.001 (no tap buffer)
Rdivrefna vrefn taprefn 505562.079742438
Rdivrefnb taprefn 0 1002.73498427645

* n1 input 1 w=-0.195521390350609 w-  bank=n alpha=1 R=170484.330505015 G_phys=5.86564171051827e-06 G_eff=5.86564171051827e-06
* tiled Rn1n1n1 series x8  each=21310.5413131269
Rn1n1n1t1 in1 Rn1n1n1n1 21364.9294674856
Rn1n1n1t2 Rn1n1n1n1 Rn1n1n1n2 21333.2235793864
Rn1n1n1t3 Rn1n1n1n2 Rn1n1n1n3 21268.8677155146
Rn1n1n1t4 Rn1n1n1n3 Rn1n1n1n4 21412.2138632493
Rn1n1n1t5 Rn1n1n1n4 Rn1n1n1n5 21327.7621198302
Rn1n1n1t6 Rn1n1n1n5 Rn1n1n1n6 21305.1517083166
Rn1n1n1t7 Rn1n1n1n6 Rn1n1n1n7 21293.542726102
Rn1n1n1t8 Rn1n1n1n7 n1p 21296.3948279067
* n1 input 2 w=+0.386445174905558 w+  bank=n alpha=1 R=86256.3061926689 G_phys=1.15933552471668e-05 G_eff=1.15933552471668e-05
* tiled Rn1p2n1 series x8  each=10782.0382740836
Rn1p2n1t1 in2n Rn1p2n1n1 10763.8741675394
Rn1p2n1t2 Rn1p2n1n1 Rn1p2n1n2 10828.4684584073
Rn1p2n1t3 Rn1p2n1n2 Rn1p2n1n3 10787.961604315
Rn1p2n1t4 Rn1p2n1n3 Rn1p2n1n4 10759.6424302665
Rn1p2n1t5 Rn1p2n1n4 Rn1p2n1n5 10821.6013942816
Rn1p2n1t6 Rn1p2n1n5 Rn1p2n1n6 10783.3673901365
Rn1p2n1t7 Rn1p2n1n6 Rn1p2n1n7 10750.2435546956
Rn1p2n1t8 Rn1p2n1n7 n1p 10771.0501023129
* n1 input 3 w=+0.296294588630229 w+  bank=n alpha=1 R=112500.648383197 G_phys=8.88883765890688e-06 G_eff=8.88883765890688e-06
* tiled Rn1p3n1 series x8  each=14062.5810478996
Rn1p3n1t1 in3n Rn1p3n1n1 14019.0023434156
Rn1p3n1t2 Rn1p3n1n1 Rn1p3n1n2 14099.7423063894
Rn1p3n1t3 Rn1p3n1n2 Rn1p3n1n3 13993.0276781113
Rn1p3n1t4 Rn1p3n1n3 Rn1p3n1n4 14055.837135545
Rn1p3n1t5 Rn1p3n1n4 Rn1p3n1n5 14111.0457253492
Rn1p3n1t6 Rn1p3n1n5 Rn1p3n1n6 14083.2374854896
Rn1p3n1t7 Rn1p3n1n6 Rn1p3n1n7 14023.0626972648
Rn1p3n1t8 Rn1p3n1n7 n1p 14010.9993914693
* n1 input 4 w=-0.299308681857295 w-  bank=n alpha=1 R=111367.746256108 G_phys=8.97926045571886e-06 G_eff=8.97926045571886e-06
* tiled Rn1n4n1 series x8  each=13920.9682820135
Rn1n4n1t1 in4 Rn1n4n1n1 13852.754490629
Rn1n4n1t2 Rn1n4n1n1 Rn1n4n1n2 13983.6961813579
Rn1n4n1t3 Rn1n4n1n2 Rn1n4n1n3 13949.403797451
Rn1n4n1t4 Rn1n4n1n3 Rn1n4n1n4 13893.7051323826
Rn1n4n1t5 Rn1n4n1n4 Rn1n4n1n5 13891.7039103209
Rn1n4n1t6 Rn1n4n1n5 Rn1n4n1n6 13947.6125850777
Rn1n4n1t7 Rn1n4n1n6 Rn1n4n1n7 13967.8995296626
Rn1n4n1t8 Rn1n4n1n7 n1p 13916.1197899472
* n1 input 5 w=+0.732671792857329 w+  bank=n alpha=1 R=45495.5870531571 G_phys=2.19801537857199e-05 G_eff=2.19801537857199e-05
* tiled Rn1p5n1 series x8  each=5686.94838164464
Rn1p5n1t1 in5n Rn1p5n1n1 5675.15791592561
Rn1p5n1t2 Rn1p5n1n1 Rn1p5n1n2 5692.26211701702
Rn1p5n1t3 Rn1p5n1n2 Rn1p5n1n3 5662.75860116863
Rn1p5n1t4 Rn1p5n1n3 Rn1p5n1n4 5676.81035052184
Rn1p5n1t5 Rn1p5n1n4 Rn1p5n1n5 5679.48329819381
Rn1p5n1t6 Rn1p5n1n5 Rn1p5n1n6 5678.57023370328
Rn1p5n1t7 Rn1p5n1n6 Rn1p5n1n7 5662.52990792457
Rn1p5n1t8 Rn1p5n1n7 n1p 5674.7832403618
* n1 input 6 w=+0.124925987288217 w+  bank=n alpha=1 R=266824.65399637 G_phys=3.7477796186465e-06 G_eff=3.7477796186465e-06
* tiled Rn1p6n1 series x8  each=33353.0817495463
Rn1p6n1t1 in6n Rn1p6n1n1 33201.2644821677
Rn1p6n1t2 Rn1p6n1n1 Rn1p6n1n2 33487.6799624364
Rn1p6n1t3 Rn1p6n1n2 Rn1p6n1n3 33235.9181656486
Rn1p6n1t4 Rn1p6n1n3 Rn1p6n1n4 33390.5367710786
Rn1p6n1t5 Rn1p6n1n4 Rn1p6n1n5 33443.3703825953
Rn1p6n1t6 Rn1p6n1n5 Rn1p6n1n6 33398.0944967967
Rn1p6n1t7 Rn1p6n1n6 Rn1p6n1n7 33432.9194886264
Rn1p6n1t8 Rn1p6n1n7 n1p 33458.2890241591
* n1 input 7 w=-0.0857938493267301 w-  bank=n alpha=1 R=388528.240601368 G_phys=2.5738154798019e-06 G_eff=2.5738154798019e-06
* tiled Rn1n7n1 series x8  each=48566.030075171
Rn1n7n1t1 in7 Rn1n7n1n1 48598.3157003443
Rn1n7n1t2 Rn1n7n1n1 Rn1n7n1n2 48610.9374804449
Rn1n7n1t3 Rn1n7n1n2 Rn1n7n1n3 48351.8980147936
Rn1n7n1t4 Rn1n7n1n3 Rn1n7n1n4 48795.0161350425
Rn1n7n1t5 Rn1n7n1n4 Rn1n7n1n5 48572.8610345775
Rn1n7n1t6 Rn1n7n1n5 Rn1n7n1n6 48604.4533026946
Rn1n7n1t7 Rn1n7n1n6 Rn1n7n1n7 48494.8406901633
Rn1n7n1t8 Rn1n7n1n7 n1p 48512.1632149006
* n1 input 8 w=-0.0609936542707342 w-  bank=n alpha=1 R=546504.939438057 G_phys=1.82980962812202e-06 G_eff=1.82980962812202e-06
* tiled Rn1n8n1 series x8  each=68313.1174297571
Rn1n8n1t1 in8 Rn1n8n1n1 68327.2208475936
Rn1n8n1t2 Rn1n8n1n1 Rn1n8n1n2 68349.5218469493
Rn1n8n1t3 Rn1n8n1n2 Rn1n8n1n3 68223.1403878956
Rn1n8n1t4 Rn1n8n1n3 Rn1n8n1n4 68062.5244709175
Rn1n8n1t5 Rn1n8n1n4 Rn1n8n1n5 68265.4976499181
Rn1n8n1t6 Rn1n8n1n5 Rn1n8n1n6 68629.976442202
Rn1n8n1t7 Rn1n8n1n6 Rn1n8n1n7 68295.8747889807
Rn1n8n1t8 Rn1n8n1n7 n1p 68564.1843409213
* n1 input 9 w=+0.256981204903229 w+  bank=n alpha=1 R=129711.172246568 G_phys=7.70943614709688e-06 G_eff=7.70943614709688e-06
* tiled Rn1p9n1 series x8  each=16213.896530821
Rn1p9n1t1 in9n Rn1p9n1n1 16223.4639911612
Rn1p9n1t2 Rn1p9n1n1 Rn1p9n1n2 16220.8316125954
Rn1p9n1t3 Rn1p9n1n2 Rn1p9n1n3 16215.2500943548
Rn1p9n1t4 Rn1p9n1n3 Rn1p9n1n4 16291.9472191509
Rn1p9n1t5 Rn1p9n1n4 Rn1p9n1n5 16207.6980043094
Rn1p9n1t6 Rn1p9n1n5 Rn1p9n1n6 16290.2946945374
Rn1p9n1t7 Rn1p9n1n6 Rn1p9n1n7 16214.5122943308
Rn1p9n1t8 Rn1p9n1n7 n1p 16249.0602968702
* n1 input 10 w=+0.073638013162671 w+  bank=n alpha=1 R=452664.756987643 G_phys=2.20914039488013e-06 G_eff=2.20914039488013e-06
* tiled Rn1p10n1 series x8  each=56583.0946234554
Rn1p10n1t1 in10n Rn1p10n1n1 56675.9862422727
Rn1p10n1t2 Rn1p10n1n1 Rn1p10n1n2 56561.571818991
Rn1p10n1t3 Rn1p10n1n2 Rn1p10n1n3 56697.6091108758
Rn1p10n1t4 Rn1p10n1n3 Rn1p10n1n4 56696.2308060476
Rn1p10n1t5 Rn1p10n1n4 Rn1p10n1n5 56471.7060916461
Rn1p10n1t6 Rn1p10n1n5 Rn1p10n1n6 56738.8576476164
Rn1p10n1t7 Rn1p10n1n6 Rn1p10n1n7 56831.7447403104
Rn1p10n1t8 Rn1p10n1n7 n1p 56822.8398823006
* n1 input 11 w=-0.149208279345328 w-  bank=n alpha=1 R=223401.365390634 G_phys=4.47624838035983e-06 G_eff=4.47624838035983e-06
* tiled Rn1n11n1 series x8  each=27925.1706738292
Rn1n11n1t1 in11 Rn1n11n1n1 27916.2939454383
Rn1n11n1t2 Rn1n11n1n1 Rn1n11n1n2 27933.8620061168
Rn1n11n1t3 Rn1n11n1n2 Rn1n11n1n3 27926.9453526173
Rn1n11n1t4 Rn1n11n1n3 Rn1n11n1n4 27891.6009512874
Rn1n11n1t5 Rn1n11n1n4 Rn1n11n1n5 27938.0120751816
Rn1n11n1t6 Rn1n11n1n5 Rn1n11n1n6 27925.9384231278
Rn1n11n1t7 Rn1n11n1n6 Rn1n11n1n7 27877.4602660995
Rn1n11n1t8 Rn1n11n1n7 n1p 27894.2658415763
* n1 input 12 w=-0.475362564845884 w-  bank=n alpha=1 R=70121.9149306388 G_phys=1.42608769453765e-05 G_eff=1.42608769453765e-05
* tiled Rn1n12n1 series x8  each=8765.23936632985
Rn1n12n1t1 in12 Rn1n12n1n1 8763.07265825218
Rn1n12n1t2 Rn1n12n1n1 Rn1n12n1n2 8731.08120620828
Rn1n12n1t3 Rn1n12n1n2 Rn1n12n1n3 8785.66096470646
Rn1n12n1t4 Rn1n12n1n3 Rn1n12n1n4 8776.23319684941
Rn1n12n1t5 Rn1n12n1n4 Rn1n12n1n5 8799.18827478519
Rn1n12n1t6 Rn1n12n1n5 Rn1n12n1n6 8764.06016432111
Rn1n12n1t7 Rn1n12n1n6 Rn1n12n1n7 8748.49524200254
Rn1n12n1t8 Rn1n12n1n7 n1p 8806.55478472051
* n1 input 13 w=-0.0533811781970356 w-  bank=n alpha=1 R=624439.820535554 G_phys=1.60143534591107e-06 G_eff=1.60143534591107e-06
* tiled Rn1n13n1 series x8  each=78054.9775669443
Rn1n13n1t1 in13 Rn1n13n1n1 78402.3003141212
Rn1n13n1t2 Rn1n13n1n1 Rn1n13n1n2 77973.3968241219
Rn1n13n1t3 Rn1n13n1n2 Rn1n13n1n3 77757.2552153578
Rn1n13n1t4 Rn1n13n1n3 Rn1n13n1n4 77879.2341133317
Rn1n13n1t5 Rn1n13n1n4 Rn1n13n1n5 77840.6625499621
Rn1n13n1t6 Rn1n13n1n5 Rn1n13n1n6 77795.5583489322
Rn1n13n1t7 Rn1n13n1n6 Rn1n13n1n7 77692.7530328407
Rn1n13n1t8 Rn1n13n1n7 n1p 77723.8026561889
* n1 input 14 w=+0.279456004632752 w+  bank=n alpha=1 R=119279.359830319 G_phys=8.38368013898257e-06 G_eff=8.38368013898257e-06
* tiled Rn1p14n1 series x8  each=14909.9199787899
Rn1p14n1t1 in14n Rn1p14n1n1 14870.0916640015
Rn1p14n1t2 Rn1p14n1n1 Rn1p14n1n2 14950.6527702898
Rn1p14n1t3 Rn1p14n1n2 Rn1p14n1n3 14879.9748356345
Rn1p14n1t4 Rn1p14n1n3 Rn1p14n1n4 14948.5585413864
Rn1p14n1t5 Rn1p14n1n4 Rn1p14n1n5 14917.9468559064
Rn1p14n1t6 Rn1p14n1n5 Rn1p14n1n6 14900.6728392377
Rn1p14n1t7 Rn1p14n1n6 Rn1p14n1n7 14947.9063156978
Rn1p14n1t8 Rn1p14n1n7 n1p 14925.4321546739
* n1 input 15 w=-0.0744870090943736 w-  bank=n alpha=1 R=447505.326614748 G_phys=2.23461027283121e-06 G_eff=2.23461027283121e-06
* tiled Rn1n15n1 series x8  each=55938.1658268434
Rn1n15n1t1 in15 Rn1n15n1n1 56168.7036374846
Rn1n15n1t2 Rn1n15n1n1 Rn1n15n1n2 56099.3135425951
Rn1n15n1t3 Rn1n15n1n2 Rn1n15n1n3 55774.0117788281
Rn1n15n1t4 Rn1n15n1n3 Rn1n15n1n4 55877.2275525149
Rn1n15n1t5 Rn1n15n1n4 Rn1n15n1n5 56195.4104812649
Rn1n15n1t6 Rn1n15n1n5 Rn1n15n1n6 55718.2110796926
Rn1n15n1t7 Rn1n15n1n6 Rn1n15n1n7 55713.7384198544
Rn1n15n1t8 Rn1n15n1n7 n1p 55705.9808941467
* n1 input 16 w=-0.0222148593491043 w-  bank=f alpha=0.001 R=1500.49715865869 G_phys=0.000666445780473128 G_eff=6.66445780473128e-07
* tiled Rn1n16f1 parallel x8  each=12003.9772692695
Rn1n16f1t1 tap16 n1p 12015.0677657132
Rn1n16f1t2 tap16 n1p 11980.0494674033
Rn1n16f1t3 tap16 n1p 12061.2402093371
Rn1n16f1t4 tap16 n1p 11971.0800811259
Rn1n16f1t5 tap16 n1p 12052.9763416519
Rn1n16f1t6 tap16 n1p 12051.0279911389
Rn1n16f1t7 tap16 n1p 11961.9041900283
Rn1n16f1t8 tap16 n1p 11944.9672576728
* n1 input 17 w=+0.0088751960388594 w+  bank=f alpha=0.001 R=3755.78558348297 G_phys=0.000266255881165782 G_eff=2.66255881165782e-07
* tiled Rn1p17f1 parallel x8  each=30046.2846678638
Rn1p17f1t1 tap17n n1p 29919.0751194347
Rn1p17f1t2 tap17n n1p 30184.3747863981
Rn1p17f1t3 tap17n n1p 29896.5842007793
Rn1p17f1t4 tap17n n1p 30072.0539340576
Rn1p17f1t5 tap17n n1p 30133.2732360036
Rn1p17f1t6 tap17n n1p 29971.1858842654
Rn1p17f1t7 tap17n n1p 30030.8133880013
Rn1p17f1t8 tap17n n1p 30164.1374155928
* n1 input 18 w=-0.194172060066752 w-  bank=n alpha=1 R=171669.051262443 G_phys=5.82516180200256e-06 G_eff=5.82516180200256e-06
* tiled Rn1n18n1 series x8  each=21458.6314078053
Rn1n18n1t1 in18 Rn1n18n1n1 21530.7321994381
Rn1n18n1t2 Rn1n18n1n1 Rn1n18n1n2 21402.2481327607
Rn1n18n1t3 Rn1n18n1n2 Rn1n18n1n3 21485.2236631799
Rn1n18n1t4 Rn1n18n1n3 Rn1n18n1n4 21408.7226335586
Rn1n18n1t5 Rn1n18n1n4 Rn1n18n1n5 21539.4197655043
Rn1n18n1t6 Rn1n18n1n5 Rn1n18n1n6 21369.1058864055
Rn1n18n1t7 Rn1n18n1n6 Rn1n18n1n7 21413.5090280173
Rn1n18n1t8 Rn1n18n1n7 n1p 21486.9490096509
* n1 input 19 w=+0.341327626188232 w+  bank=n alpha=1 R=97657.8828546125 G_phys=1.0239828785647e-05 G_eff=1.0239828785647e-05
* tiled Rn1p19n1 series x8  each=12207.2353568266
Rn1p19n1t1 in19n Rn1p19n1n1 12155.9595820597
Rn1p19n1t2 Rn1p19n1n1 Rn1p19n1n2 12183.7317648232
Rn1p19n1t3 Rn1p19n1n2 Rn1p19n1n3 12154.9874176984
Rn1p19n1t4 Rn1p19n1n3 Rn1p19n1n4 12265.8957324613
Rn1p19n1t5 Rn1p19n1n4 Rn1p19n1n5 12178.7333838475
Rn1p19n1t6 Rn1p19n1n5 Rn1p19n1n6 12180.9888523165
Rn1p19n1t7 Rn1p19n1n6 Rn1p19n1n7 12247.3179717032
Rn1p19n1t8 Rn1p19n1n7 n1p 12242.9091056901
* n1 input 20 w=-0.0323870183321868 w-  bank=f alpha=0.001 R=1029.21896024637 G_phys=0.000971610549965604 G_eff=9.71610549965604e-07
* tiled Rn1n20f1 parallel x8  each=8233.75168197093
Rn1n20f1t1 tap20 n1p 8244.27150316986
Rn1n20f1t2 tap20 n1p 8199.586769391
Rn1n20f1t3 tap20 n1p 8232.60315832003
Rn1n20f1t4 tap20 n1p 8194.76778781111
Rn1n20f1t5 tap20 n1p 8244.54120991339
Rn1n20f1t6 tap20 n1p 8253.74183585335
Rn1n20f1t7 tap20 n1p 8243.35492738291
Rn1n20f1t8 tap20 n1p 8254.19651080521
* n1 input 21 w=-0.0999542141187652 w-  bank=n alpha=1 R=333486.022847689 G_phys=2.99862642356296e-06 G_eff=2.99862642356296e-06
* tiled Rn1n21n1 series x8  each=41685.7528559611
Rn1n21n1t1 in21 Rn1n21n1n1 41777.1686459142
Rn1n21n1t2 Rn1n21n1n1 Rn1n21n1n2 41633.3034871752
Rn1n21n1t3 Rn1n21n1n2 Rn1n21n1n3 41675.9227196833
Rn1n21n1t4 Rn1n21n1n3 Rn1n21n1n4 41865.4089424129
Rn1n21n1t5 Rn1n21n1n4 Rn1n21n1n5 41841.204433533
Rn1n21n1t6 Rn1n21n1n5 Rn1n21n1n6 41626.5317869475
Rn1n21n1t7 Rn1n21n1n6 Rn1n21n1n7 41837.2304089455
Rn1n21n1t8 Rn1n21n1n7 n1p 41626.6176013372
* n1 input 22 w=+0.693789300406694 w+  bank=n alpha=1 R=48045.3263170729 G_phys=2.08136790122008e-05 G_eff=2.08136790122008e-05
* tiled Rn1p22n1 series x8  each=6005.66578963411
Rn1p22n1t1 in22n Rn1p22n1n1 5997.28166003491
Rn1p22n1t2 Rn1p22n1n1 Rn1p22n1n2 5992.12037522528
Rn1p22n1t3 Rn1p22n1n2 Rn1p22n1n3 5987.50093024719
Rn1p22n1t4 Rn1p22n1n3 Rn1p22n1n4 5977.01107047963
Rn1p22n1t5 Rn1p22n1n4 Rn1p22n1n5 5994.84401486576
Rn1p22n1t6 Rn1p22n1n5 Rn1p22n1n6 5988.99057360696
Rn1p22n1t7 Rn1p22n1n6 Rn1p22n1n7 6023.90390669962
Rn1p22n1t8 Rn1p22n1n7 n1p 6026.4272400365
* n1 input 23 w=+0.0972685864670828 w+  bank=n alpha=1 R=342693.715864925 G_phys=2.91805759401248e-06 G_eff=2.91805759401248e-06
* tiled Rn1p23n1 series x8  each=42836.7144831156
Rn1p23n1t1 in23n Rn1p23n1n1 42864.3772416464
Rn1p23n1t2 Rn1p23n1n1 Rn1p23n1n2 42715.8085808701
Rn1p23n1t3 Rn1p23n1n2 Rn1p23n1n3 42747.6643743123
Rn1p23n1t4 Rn1p23n1n3 Rn1p23n1n4 42843.2544189148
Rn1p23n1t5 Rn1p23n1n4 Rn1p23n1n5 42657.3152397844
Rn1p23n1t6 Rn1p23n1n5 Rn1p23n1n6 42801.3499624174
Rn1p23n1t7 Rn1p23n1n6 Rn1p23n1n7 42699.1976981271
Rn1p23n1t8 Rn1p23n1n7 n1p 42903.3863574585
* n1 input 24 w=-0.0293783170287994 w-  bank=f alpha=0.001 R=1134.6236512002 G_phys=0.000881349510863982 G_eff=8.81349510863982e-07
* tiled Rn1n24f1 parallel x8  each=9076.98920960159
Rn1n24f1t1 tap24 n1p 9053.55031250423
Rn1n24f1t2 tap24 n1p 9096.80034608651
Rn1n24f1t3 tap24 n1p 9059.85576942643
Rn1n24f1t4 tap24 n1p 9034.58435927096
Rn1n24f1t5 tap24 n1p 9070.43178159576
Rn1n24f1t6 tap24 n1p 9120.08519918664
Rn1n24f1t7 tap24 n1p 9081.3814970363
Rn1n24f1t8 tap24 n1p 9094.3768022158
* n1 input 25 w=+0.0497492024826392 w+  bank=n alpha=1 R=670027.491294269 G_phys=1.49247607447918e-06 G_eff=1.49247607447918e-06
* tiled Rn1p25n1 series x8  each=83753.4364117836
Rn1p25n1t1 in25n Rn1p25n1n1 83619.282568176
Rn1p25n1t2 Rn1p25n1n1 Rn1p25n1n2 83941.262641829
Rn1p25n1t3 Rn1p25n1n2 Rn1p25n1n3 83632.3035137355
Rn1p25n1t4 Rn1p25n1n3 Rn1p25n1n4 83591.7066767148
Rn1p25n1t5 Rn1p25n1n4 Rn1p25n1n5 84111.7646699727
Rn1p25n1t6 Rn1p25n1n5 Rn1p25n1n6 83458.5294967442
Rn1p25n1t7 Rn1p25n1n6 Rn1p25n1n7 83698.3843090884
Rn1p25n1t8 Rn1p25n1n7 n1p 83638.5371462753
* n1 input 26 w=-0.466063512962686 w-  bank=n alpha=1 R=71521.0103477937 G_phys=1.39819053888806e-05 G_eff=1.39819053888806e-05
* tiled Rn1n26n1 series x8  each=8940.12629347421
Rn1n26n1t1 in26 Rn1n26n1n1 8946.90568494404
Rn1n26n1t2 Rn1n26n1n1 Rn1n26n1n2 8933.59981823842
Rn1n26n1t3 Rn1n26n1n2 Rn1n26n1n3 8901.83875519954
Rn1n26n1t4 Rn1n26n1n3 Rn1n26n1n4 8945.93261140867
Rn1n26n1t5 Rn1n26n1n4 Rn1n26n1n5 8951.0010817815
Rn1n26n1t6 Rn1n26n1n5 Rn1n26n1n6 8946.95358675683
Rn1n26n1t7 Rn1n26n1n6 Rn1n26n1n7 8952.40818871858
Rn1n26n1t8 Rn1n26n1n7 n1p 8959.42160055835
* n1 input 27 w=+0.194887582685885 w+  bank=n alpha=1 R=171038.774630702 G_phys=5.84662748057655e-06 G_eff=5.84662748057655e-06
* tiled Rn1p27n1 series x8  each=21379.8468288377
Rn1p27n1t1 in27n Rn1p27n1n1 21427.6186768404
Rn1p27n1t2 Rn1p27n1n1 Rn1p27n1n2 21283.0670480669
Rn1p27n1t3 Rn1p27n1n2 Rn1p27n1n3 21366.5291659996
Rn1p27n1t4 Rn1p27n1n3 Rn1p27n1n4 21315.6768129133
Rn1p27n1t5 Rn1p27n1n4 Rn1p27n1n5 21382.5176789868
Rn1p27n1t6 Rn1p27n1n5 Rn1p27n1n6 21460.5601619219
Rn1p27n1t7 Rn1p27n1n6 Rn1p27n1n7 21314.1372947095
Rn1p27n1t8 Rn1p27n1n7 n1p 21445.9548127488
* n1 input 28 w=+0.209047565197081 w+  bank=n alpha=1 R=159453.344036359 G_phys=6.27142695591242e-06 G_eff=6.27142695591242e-06
* tiled Rn1p28n1 series x8  each=19931.6680045449
Rn1p28n1t1 in28n Rn1p28n1n1 19879.5017352244
Rn1p28n1t2 Rn1p28n1n1 Rn1p28n1n2 20030.6208417306
Rn1p28n1t3 Rn1p28n1n2 Rn1p28n1n3 19949.6044734182
Rn1p28n1t4 Rn1p28n1n3 Rn1p28n1n4 19884.1350983017
Rn1p28n1t5 Rn1p28n1n4 Rn1p28n1n5 19998.6383409898
Rn1p28n1t6 Rn1p28n1n5 Rn1p28n1n6 19874.577475285
Rn1p28n1t7 Rn1p28n1n6 Rn1p28n1n7 19942.4623937122
Rn1p28n1t8 Rn1p28n1n7 n1p 19983.9446208842
* n1 input 29 w=+0.00919963467526149 w+  bank=f alpha=0.001 R=3623.33228546229 G_phys=0.000275989040257845 G_eff=2.75989040257845e-07
* tiled Rn1p29f1 parallel x8  each=28986.6582836983
Rn1p29f1t1 tap29n n1p 28923.4104698422
Rn1p29f1t2 tap29n n1p 29002.5680849652
Rn1p29f1t3 tap29n n1p 29098.5794187762
Rn1p29f1t4 tap29n n1p 28881.7202390295
Rn1p29f1t5 tap29n n1p 29121.8541537918
Rn1p29f1t6 tap29n n1p 29063.5269297737
Rn1p29f1t7 tap29n n1p 29111.1456996447
Rn1p29f1t8 tap29n n1p 29120.3714584381
* n1 input 30 w=-0.379437042796868 w-  bank=n alpha=1 R=87849.4442388387 G_phys=1.13831112839061e-05 G_eff=1.13831112839061e-05
* tiled Rn1n30n1 series x8  each=10981.1805298548
Rn1n30n1t1 in30 Rn1n30n1n1 10995.2688684854
Rn1n30n1t2 Rn1n30n1n1 Rn1n30n1n2 11034.0471983838
Rn1n30n1t3 Rn1n30n1n2 Rn1n30n1n3 10927.9731519609
Rn1n30n1t4 Rn1n30n1n3 Rn1n30n1n4 10950.5682286515
Rn1n30n1t5 Rn1n30n1n4 Rn1n30n1n5 10946.0181147046
Rn1n30n1t6 Rn1n30n1n5 Rn1n30n1n6 11033.8760767333
Rn1n30n1t7 Rn1n30n1n6 Rn1n30n1n7 10990.2833741733
Rn1n30n1t8 Rn1n30n1n7 n1p 11010.4041374022
* n1 input 31 w=-0.216631724491884 w-  bank=n alpha=1 R=153870.96885979 G_phys=6.49895173475653e-06 G_eff=6.49895173475653e-06
* tiled Rn1n31n1 series x8  each=19233.8711074737
Rn1n31n1t1 in31 Rn1n31n1n1 19170.0801909622
Rn1n31n1t2 Rn1n31n1n1 Rn1n31n1n2 19239.7704093145
Rn1n31n1t3 Rn1n31n1n2 Rn1n31n1n3 19153.139655692
Rn1n31n1t4 Rn1n31n1n3 Rn1n31n1n4 19316.5448923624
Rn1n31n1t5 Rn1n31n1n4 Rn1n31n1n5 19266.2754982973
Rn1n31n1t6 Rn1n31n1n5 Rn1n31n1n6 19327.5504065507
Rn1n31n1t7 Rn1n31n1n6 Rn1n31n1n7 19302.3505147459
Rn1n31n1t8 Rn1n31n1n7 n1p 19285.6289697821
* n1 input 32 w=+0.139103822260271 w+  bank=n alpha=1 R=239629.169002738 G_phys=4.17311466780814e-06 G_eff=4.17311466780814e-06
* tiled Rn1p32n1 series x8  each=29953.6461253422
Rn1p32n1t1 in32n Rn1p32n1n1 29961.0005425796
Rn1p32n1t2 Rn1p32n1n1 Rn1p32n1n2 30075.7720380457
Rn1p32n1t3 Rn1p32n1n2 Rn1p32n1n3 29982.0465742257
Rn1p32n1t4 Rn1p32n1n3 Rn1p32n1n4 29951.8275937813
Rn1p32n1t5 Rn1p32n1n4 Rn1p32n1n5 30020.2931238425
Rn1p32n1t6 Rn1p32n1n5 Rn1p32n1n6 29804.6265897487
Rn1p32n1t7 Rn1p32n1n6 Rn1p32n1n7 30017.6186429287
Rn1p32n1t8 Rn1p32n1n7 n1p 30093.9689436425
* n1 bias w+  bank=f alpha=0.001 R=1034.77721072674 G_phys=0.000966391595827364 G_eff=9.66391595827364e-07
* tiled Rn1bpf1 parallel x8  each=8278.2176858139
Rn1bpf1t1 taprefn n1p 8290.09426492893
Rn1bpf1t2 taprefn n1p 8315.57651226168
Rn1bpf1t3 taprefn n1p 8280.27409463207
Rn1bpf1t4 taprefn n1p 8301.97727679151
Rn1bpf1t5 taprefn n1p 8280.12522035107
Rn1bpf1t6 taprefn n1p 8296.737309525
Rn1bpf1t7 taprefn n1p 8276.9516976383
Rn1bpf1t8 taprefn n1p 8249.36630821487
* feedback TIA n1: Rf=33333.3333333333 A=100000 V(n1lin) = -I(n1p)*Rf*A/(A+1)  (uncompensated)
En1tia n1lin 0 0 n1p 100000
* tiled Rn1f series x8  each=4166.66666666667
Rn1ft1 n1lin Rn1fn1 4172.09748284618
Rn1ft2 Rn1fn1 Rn1fn2 4171.72225499465
Rn1ft3 Rn1fn2 Rn1fn3 4170.01064214371
Rn1ft4 Rn1fn3 Rn1fn4 4160.00980127516
Rn1ft5 Rn1fn4 Rn1fn5 4172.8723223726
Rn1ft6 Rn1fn5 Rn1fn6 4163.19503832639
Rn1ft7 Rn1fn6 Rn1fn7 4159.10728893328
Rn1ft8 Rn1fn7 n1p 4182.57706323034
.control
set numdgt=15
alter Vin1 DC 0
alter Vin2 DC 0
alter Vin3 DC 0
alter Vin4 DC 0
alter Vin5 DC 0
alter Vin6 DC 0
alter Vin7 DC 0
alter Vin8 DC 0
alter Vin9 DC 0
alter Vin10 DC 0
alter Vin11 DC 0
alter Vin12 DC 0
alter Vin13 DC 0
alter Vin14 DC 0
alter Vin15 DC 0
alter Vin16 DC 0
alter Vin17 DC 0
alter Vin18 DC 0
alter Vin19 DC 0
alter Vin20 DC 0
alter Vin21 DC 0
alter Vin22 DC 0
alter Vin23 DC 0
alter Vin24 DC 0
alter Vin25 DC 0
alter Vin26 DC 0
alter Vin27 DC 0
alter Vin28 DC 0
alter Vin29 DC 0
alter Vin30 DC 0
alter Vin31 DC 0
alter Vin32 DC 0
op
print v(n1lin)
alter Vin1 DC 1
alter Vin2 DC 0
alter Vin3 DC 0
alter Vin4 DC 0
alter Vin5 DC 0
alter Vin6 DC 0
alter Vin7 DC 0
alter Vin8 DC 0
alter Vin9 DC 0
alter Vin10 DC 0
alter Vin11 DC 0
alter Vin12 DC 0
alter Vin13 DC 0
alter Vin14 DC 0
alter Vin15 DC 0
alter Vin16 DC 0
alter Vin17 DC 0
alter Vin18 DC 0
alter Vin19 DC 0
alter Vin20 DC 0
alter Vin21 DC 0
alter Vin22 DC 0
alter Vin23 DC 0
alter Vin24 DC 0
alter Vin25 DC 0
alter Vin26 DC 0
alter Vin27 DC 0
alter Vin28 DC 0
alter Vin29 DC 0
alter Vin30 DC 0
alter Vin31 DC 0
alter Vin32 DC 0
op
print v(n1lin)
alter Vin1 DC 0.336281146288125
alter Vin2 DC 0
alter Vin3 DC 0
alter Vin4 DC 0
alter Vin5 DC 0
alter Vin6 DC 0.777243957364389
alter Vin7 DC 0
alter Vin8 DC 0.0705982519785909
alter Vin9 DC 0.361068022357012
alter Vin10 DC 0
alter Vin11 DC 1.1565823149901
alter Vin12 DC 0
alter Vin13 DC 0
alter Vin14 DC 0
alter Vin15 DC 0.0416289190497384
alter Vin16 DC 0.436458566192918
alter Vin17 DC 0.366244026736095
alter Vin18 DC 1.52626596704316
alter Vin19 DC 1.7315038027247
alter Vin20 DC 0
alter Vin21 DC 0.518920693033615
alter Vin22 DC 2.14599413442392
alter Vin23 DC 1.20942836359533
alter Vin24 DC 0
alter Vin25 DC 0
alter Vin26 DC 0.119125138158868
alter Vin27 DC 0
alter Vin28 DC 0.1550269134803
alter Vin29 DC 1.87754084678094
alter Vin30 DC 0.223511482191497
alter Vin31 DC 0
alter Vin32 DC 0
op
print v(n1lin)
alter Vin1 DC 0.336281146288125
alter Vin2 DC 0
alter Vin3 DC 0
alter Vin4 DC 0
alter Vin5 DC 0
alter Vin6 DC 0.777243957364389
alter Vin7 DC 0
alter Vin8 DC 0.0705982519785909
alter Vin9 DC 0.361068022357012
alter Vin10 DC 0
alter Vin11 DC 1.1565823149901
alter Vin12 DC 0
alter Vin13 DC 0
alter Vin14 DC 0
alter Vin15 DC 0.0416289190497384
alter Vin16 DC 0.436458566192918
alter Vin17 DC 0.366244026736095
alter Vin18 DC 1.52626596704316
alter Vin19 DC 1.7315038027247
alter Vin20 DC 0
alter Vin21 DC 0.518920693033615
alter Vin22 DC 2.14599413442392
alter Vin23 DC 1.20942836359533
alter Vin24 DC 0
alter Vin25 DC 0
alter Vin26 DC 0.119125138158868
alter Vin27 DC 0
alter Vin28 DC 0.1550269134803
alter Vin29 DC 1.87754084678094
alter Vin30 DC 0.223511482191497
alter Vin31 DC 0
alter Vin32 DC 0
op
print v(n1lin)
alter Vin1 DC 0
alter Vin2 DC 0
alter Vin3 DC 0
alter Vin4 DC 0.119173373006553
alter Vin5 DC 0.497054869761023
alter Vin6 DC 0
alter Vin7 DC 0.548908183770197
alter Vin8 DC 0.30149266638977
alter Vin9 DC 0.306029487966532
alter Vin10 DC 0
alter Vin11 DC 0.536498907294107
alter Vin12 DC 1.11519389272358
alter Vin13 DC 0.27592089519523
alter Vin14 DC 0
alter Vin15 DC 0
alter Vin16 DC 0.0165565543628049
alter Vin17 DC 0.00164813252705659
alter Vin18 DC 0
alter Vin19 DC 0
alter Vin20 DC 1.0634963563705
alter Vin21 DC 1.1607314606698
alter Vin22 DC 0.319853224833038
alter Vin23 DC 0
alter Vin24 DC 0.776224206115732
alter Vin25 DC 1.14964974033376
alter Vin26 DC 0.84927123300762
alter Vin27 DC 0
alter Vin28 DC 0
alter Vin29 DC 0.0384024414581247
alter Vin30 DC 0.273175901376051
alter Vin31 DC 0
alter Vin32 DC 0.113039635921703
op
print v(n1lin)
.endc

.end
