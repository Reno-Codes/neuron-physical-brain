* Experiment 22 isolated TIA neuron n1
* frozen n=16 L1=4.9259203 b=-0.00602264402556266
* A=100000 vos=0 Ileak=0 Rout=0 fp=0 invertA=1e+07
* Behavioral TIA. Not transistor-level. Weights were not edited.
* shape: 16 -> 1 (linear Vlin vs z unless ReLU requested)

* Experiment 23 candidate OPA171
* TI OPA171 Green-Williams-Lis macromodel
* source: C:\ngspice\examples\p-to-n-examples\OPA171.txt
* Not copied into this repo. Included from ngspice examples. 36 V-class; model Vos ~214 uV. Requires ngbehavior=ps. A 1 pF output capacitor is added so the GWL operating-point analysis exists on this loaded TIA; that is not a datasheet CL.
* Weights were not edited. SPICE is not Python-corrected.
.include "C:/ngspice/examples/p-to-n-examples/OPA171.txt"
Vdd vdd 0 DC 15
Vss vss 0 DC -15

Vin1 in1 0 DC -0.707411361117319
* load-compensated divider in1->tap1: G_load=0.000204403468527266 Ra=829456.2628764 Rb=1000 target beta=0.001 (no tap buffer)
Rdiv1a in1 tap1 829456.2628764
Rdiv1b tap1 0 1000
Vin2 in2 0 DC 0.192585157815974
* passive invert in2 -> in2n: R2/R1=1.0000002 closed-loop -1 at A=1e+07
Rinv2ia in2 inv2m 10000
Rinv2ib in2n inv2m 10000.0020000002
Einv2amp in2n 0 0 inv2m 10000000
Vin3 in3 0 DC 0.99773657682682
Vin4 in4 0 DC -0.937223757621676
Vin5 in5 0 DC 0.772568616968369
* passive invert in5 -> in5n: R2/R1=1.0000002 closed-loop -1 at A=1e+07
Rinv5ia in5 inv5m 10000
Rinv5ib in5n inv5m 10000.0020000002
Einv5amp in5n 0 0 inv5m 10000000
Vin6 in6 0 DC -0.102221909597799
Vin7 in7 0 DC 0.920006092908996
Vin8 in8 0 DC -0.396577255594017
Vin9 in9 0 DC 0.80645150320269
Vin10 in10 0 DC 0.725993004534669
* passive invert in10 -> in10n: R2/R1=1.0000002 closed-loop -1 at A=1e+07
Rinv10ia in10 inv10m 10000
Rinv10ib in10n inv10m 10000.0020000002
Einv10amp in10n 0 0 inv10m 10000000
* load-compensated divider in10n->tap10n: G_load=0.000661819331650786 Ra=601148.380556888 Rb=1000 target beta=0.001 (no tap buffer)
Rdiv10na in10n tap10n 601148.380556888
Rdiv10nb tap10n 0 1000
Vin11 in11 0 DC -0.0848066212195946
* passive invert in11 -> in11n: R2/R1=1.0000002 closed-loop -1 at A=1e+07
Rinv11ia in11 inv11m 10000
Rinv11ib in11n inv11m 10000.0020000002
Einv11amp in11n 0 0 inv11m 10000000
Vin12 in12 0 DC 0.661312190394981
* passive invert in12 -> in12n: R2/R1=1.0000002 closed-loop -1 at A=1e+07
Rinv12ia in12 inv12m 10000
Rinv12ib in12n inv12m 10000.0020000002
Einv12amp in12n 0 0 inv12m 10000000
Vin13 in13 0 DC -0.696642667940951
Vin14 in14 0 DC 0.170544479274995
* passive invert in14 -> in14n: R2/R1=1.0000002 closed-loop -1 at A=1e+07
Rinv14ia in14 inv14m 10000
Rinv14ib in14n inv14m 10000.0020000002
Einv14amp in14n 0 0 inv14m 10000000
Vin15 in15 0 DC -0.213385292260152
Vin16 in16 0 DC 0.90366890547886
* passive invert in16 -> in16n: R2/R1=1.0000002 closed-loop -1 at A=1e+07
Rinv16ia in16 inv16m 10000
Rinv16ib in16n inv16m 10000.0020000002
Einv16amp in16n 0 0 inv16m 10000000
Vref vref 0 DC 1
* load-compensated divider vref->tapref: G_load=0.00018067932076688 Ra=846123.060198196 Rb=1000 target beta=0.001 (no tap buffer)
Rdivrefa vref tapref 846123.060198196
Rdivrefb tapref 0 1000

* n1 input 1 w=-0.00681344895090886 w-  bank=f alpha=0.001 R=4892.28488736045 G_phys=0.000204403468527266 G_eff=2.04403468527266e-07
Rn1n1f1 tap1 n1p 4892.28488736045
* n1 input 2 w=+0.17215275761211 w+  bank=n alpha=1 R=193626.484964238 G_phys=5.1645827283633e-06 G_eff=5.1645827283633e-06
Rn1p2n1 in2n n1p 193626.484964238
* n1 input 3 w=-0.241244992284912 w-  bank=n alpha=1 R=138172.12542993 G_phys=7.23734976854735e-06 G_eff=7.23734976854735e-06
Rn1n3n1 in3 n1p 138172.12542993
* n1 input 4 w=-0.253516997925259 w-  bank=n alpha=1 R=131483.622818698 G_phys=7.60550993775776e-06 G_eff=7.60550993775776e-06
Rn1n4n1 in4 n1p 131483.622818698
* n1 input 5 w=+0.732528033504134 w+  bank=n alpha=1 R=45504.515607245 G_phys=2.1975841005124e-05 G_eff=2.1975841005124e-05
Rn1p5n1 in5n n1p 45504.515607245
* n1 input 6 w=-0.335745026911547 w-  bank=n alpha=1 R=99281.6889648676 G_phys=1.00723508073464e-05 G_eff=1.00723508073464e-05
Rn1n6n1 in6 n1p 99281.6889648676
* n1 input 7 w=-0.133397447206163 w-  bank=n alpha=1 R=249879.844265815 G_phys=4.00192341618489e-06 G_eff=4.00192341618489e-06
Rn1n7n1 in7 n1p 249879.844265815
* n1 input 8 w=-0.602502751086194 w-  bank=n alpha=1 R=55324.7819586548 G_phys=1.80750825325858e-05 G_eff=1.80750825325858e-05
Rn1n8n1 in8 n1p 55324.7819586548
* n1 input 9 w=-0.464313715662176 w-  bank=n alpha=1 R=71790.5420601142 G_phys=1.39294114698653e-05 G_eff=1.39294114698653e-05
Rn1n9n1 in9 n1p 71790.5420601142
* n1 input 10 w=+0.0220606443883595 w+  bank=f alpha=0.001 R=1510.98638582479 G_phys=0.000661819331650786 G_eff=6.61819331650786e-07
Rn1p10f1 tap10n n1p 1510.98638582479
* n1 input 11 w=+0.293613135845564 w+  bank=n alpha=1 R=113528.072364127 G_phys=8.80839407536691e-06 G_eff=8.80839407536691e-06
Rn1p11n1 in11n n1p 113528.072364127
* n1 input 12 w=+0.585788543436 w+  bank=n alpha=1 R=56903.3548143728 G_phys=1.757365630308e-05 G_eff=1.757365630308e-05
Rn1p12n1 in12n n1p 56903.3548143728
* n1 input 13 w=-0.255400978522459 w-  bank=n alpha=1 R=130513.726009089 G_phys=7.66202935567376e-06 G_eff=7.66202935567376e-06
Rn1n13n1 in13 n1p 130513.726009089
* n1 input 14 w=+0.15251581562556 w+  bank=n alpha=1 R=218556.568685111 G_phys=4.57547446876679e-06 G_eff=4.57547446876679e-06
Rn1p14n1 in14n n1p 218556.568685111
* n1 input 15 w=-0.610279514665944 w-  bank=n alpha=1 R=54619.7808254787 G_phys=1.83083854399783e-05 G_eff=1.83083854399783e-05
Rn1n15n1 in15 n1p 54619.7808254787
* n1 input 16 w=+0.0580238118020399 w+  bank=n alpha=1 R=574476.793200985 G_phys=1.7407143540612e-06 G_eff=1.7407143540612e-06
Rn1p16n1 in16n n1p 574476.793200985
* n1 bias w-  bank=f alpha=0.001 R=5534.66769609038 G_phys=0.00018067932076688 G_eff=1.8067932076688e-07
Rn1bnf1 tapref n1p 5534.66769609038
* feedback TIA n1: Rf=33333.3333333333 A=100000 V(n1lin) = -I(n1p)*Rf*A/(A+1)  (uncompensated)
* Exp 23 OPA171 TIA n1 -> n1lin, vg=n1p
Vn1os n1osp 0 DC 0
* 1 pF output C so GWL OP exists; not a datasheet CL guarantee
Xn1tia n1osp n1p vdd vss n1lin OPA171
Cn1load n1lin 0 1p
Rn1f n1lin n1p 33333.3333333333
.control
set numdgt=15
op
print v(n1lin)
print v(n1p)
.endc

.end
