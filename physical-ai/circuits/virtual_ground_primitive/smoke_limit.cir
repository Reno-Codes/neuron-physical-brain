* Experiment 23 smoke: XSPICE limit (gain + rails)
Vin in 0 DC 1
Rw in sum 10000
Vvos vos 0 DC 0
atia %vd(vos sum) lin limmod
.model limmod limit(gain=1e5 in_offset=0.0 out_lower_limit=-15 out_upper_limit=15 fraction=false limit_range=0.2)
Rf lin sum 10000

.control
set numdgt=15
op
print v(lin)
print v(sum)
.endc
.end
