* Experiment 22 isolated TIA neuron n1
* frozen n=16 L1=4.9158066 b=0.0857431075924666
* A=100000 vos=0 Ileak=0 Rout=0 fp=0 invertA=1e+07
* Behavioral TIA. Not transistor-level. Weights were not edited.
* shape: 16 -> 1 (linear Vlin vs z unless ReLU requested)

* Experiment 23 candidate L
* XSPICE limit (finite A, in_offset, output rails)
* source: ngspice built-in analog code model `limit`
* Same DC TIA identity as Exp 17 VCVS, with explicit rails.
* Weights were not edited. SPICE is not Python-corrected.
.model limtia limit(gain=100000 in_offset=0.0 out_lower_limit=-15 out_upper_limit=15 fraction=false limit_range=0.05)

Vin1 in1 0 DC 0
Vin2 in2 0 DC 0
Vin3 in3 0 DC 0
Vin4 in4 0 DC 0
Vin5 in5 0 DC 0
* passive invert in5 -> in5n: R2/R1=1.0000002 closed-loop -1 at A=1e+07
Rinv5ia in5 inv5m 10000
Rinv5ib in5n inv5m 10000.0020000002
Einv5amp in5n 0 0 inv5m 10000000
Vin6 in6 0 DC 0
Vin7 in7 0 DC 0
Vin8 in8 0 DC 0
Vin9 in9 0 DC 0
* passive invert in9 -> in9n: R2/R1=1.0000002 closed-loop -1 at A=1e+07
Rinv9ia in9 inv9m 10000
Rinv9ib in9n inv9m 10000.0020000002
Einv9amp in9n 0 0 inv9m 10000000
Vin10 in10 0 DC 0
* passive invert in10 -> in10n: R2/R1=1.0000002 closed-loop -1 at A=1e+07
Rinv10ia in10 inv10m 10000
Rinv10ib in10n inv10m 10000.0020000002
Einv10amp in10n 0 0 inv10m 10000000
Vin11 in11 0 DC 0
Vin12 in12 0 DC 0
Vin13 in13 0 DC 0
Vin14 in14 0 DC 0
Vin15 in15 0 DC 0
Vin16 in16 0 DC 0
Vref vref 0 DC 1
* passive invert vref -> vrefn: R2/R1=1.0000002 closed-loop -1 at A=1e+07
Rinvrefia vref invrefm 10000
Rinvrefib vrefn invrefm 10000.0020000002
Einvrefamp vrefn 0 0 invrefm 10000000

* n1 input 1 w=-0.211528252190937 w-  bank=n alpha=1 R=157583.362922343 G_phys=6.3458475657281e-06 G_eff=6.3458475657281e-06
Rn1n1n1 in1 n1p 157583.362922343
* n1 input 2 w=-0.194947045242045 w-  bank=n alpha=1 R=170986.604551748 G_phys=5.84841135726135e-06 G_eff=5.84841135726135e-06
Rn1n2n1 in2 n1p 170986.604551748
* n1 input 3 w=-0.281660896127353 w-  bank=n alpha=1 R=118345.619827403 G_phys=8.44982688382059e-06 G_eff=8.44982688382059e-06
Rn1n3n1 in3 n1p 118345.619827403
* n1 input 4 w=-0.246854224570453 w-  bank=n alpha=1 R=135032.460519305 G_phys=7.4056267371136e-06 G_eff=7.4056267371136e-06
Rn1n4n1 in4 n1p 135032.460519305
* n1 input 5 w=+0.785179968580328 w+  bank=n alpha=1 R=42453.112238208 G_phys=2.35553990574098e-05 G_eff=2.35553990574098e-05
Rn1p5n1 in5n n1p 42453.112238208
* n1 input 6 w=-0.342055263707418 w-  bank=n alpha=1 R=97450.1399921314 G_phys=1.02616579112226e-05 G_eff=1.02616579112226e-05
Rn1n6n1 in6 n1p 97450.1399921314
* n1 input 7 w=-0.213390213186068 w-  bank=n alpha=1 R=156208.351056231 G_phys=6.40170639558203e-06 G_eff=6.40170639558203e-06
Rn1n7n1 in7 n1p 156208.351056231
* n1 input 8 w=-0.06183287092446 w-  bank=n alpha=1 R=539087.589415927 G_phys=1.8549861277338e-06 G_eff=1.8549861277338e-06
Rn1n8n1 in8 n1p 539087.589415927
* n1 input 9 w=+0.114369297885863 w+  bank=n alpha=1 R=291453.510247121 G_phys=3.43107893657588e-06 G_eff=3.43107893657588e-06
Rn1p9n1 in9n n1p 291453.510247121
* n1 input 10 w=+0.418702574206734 w+  bank=n alpha=1 R=79611.0064440994 G_phys=1.2561077226202e-05 G_eff=1.2561077226202e-05
Rn1p10n1 in10n n1p 79611.0064440994
* n1 input 11 w=-0.38263995973155 w-  bank=n alpha=1 R=87114.0937729534 G_phys=1.14791987919465e-05 G_eff=1.14791987919465e-05
Rn1n11n1 in11 n1p 87114.0937729534
* n1 input 12 w=-0.447982918675276 w-  bank=n alpha=1 R=74407.5989144918 G_phys=1.34394875602583e-05 G_eff=1.34394875602583e-05
Rn1n12n1 in12 n1p 74407.5989144918
* n1 input 13 w=-0.354860709093241 w-  bank=n alpha=1 R=93933.5702126856 G_phys=1.06458212727972e-05 G_eff=1.06458212727972e-05
Rn1n13n1 in13 n1p 93933.5702126856
* n1 input 14 w=-0.245379266072843 w-  bank=n alpha=1 R=135844.131685674 G_phys=7.36137798218528e-06 G_eff=7.36137798218528e-06
Rn1n14n1 in14 n1p 135844.131685674
* n1 input 15 w=-0.0999148922371372 w-  bank=n alpha=1 R=333617.267526249 G_phys=2.99744676711412e-06 G_eff=2.99744676711412e-06
Rn1n15n1 in15 n1p 333617.267526249
* n1 input 16 w=-0.428765175056332 w-  bank=n alpha=1 R=77742.632267077 G_phys=1.286295525169e-05 G_eff=1.286295525169e-05
Rn1n16n1 in16 n1p 77742.632267077
* n1 bias w+  bank=n alpha=1 R=388758.166916054 G_phys=2.572293227774e-06 G_eff=2.572293227774e-06
Rn1bpn1 vrefn n1p 388758.166916054
* feedback TIA n1: Rf=33333.3333333333 A=100000 V(n1lin) = -I(n1p)*Rf*A/(A+1)  (uncompensated)
* Exp 23 L TIA n1 -> n1lin, vg=n1p
Vn1os n1osp 0 DC 0
An1tia %vd(n1osp n1p) n1lin limtia
Rn1f n1lin n1p 33333.3333333333
.control
set numdgt=15
alter Vin1 DC -0.905130302970119
alter Vin2 DC 0.298063549267431
alter Vin3 DC -0.72388123353863
alter Vin4 DC 0.842062816765734
alter Vin5 DC 0.498351001590039
alter Vin6 DC -0.207763853292497
alter Vin7 DC -0.657110617348315
alter Vin8 DC -0.351791940617473
alter Vin9 DC -0.95465561426785
alter Vin10 DC -0.446406160594792
alter Vin11 DC -0.345913287152631
alter Vin12 DC -0.281859690816107
alter Vin13 DC -0.636304031746199
alter Vin14 DC -0.0171047715068544
alter Vin15 DC 0.852925443215993
alter Vin16 DC -0.830824160650566
op
print v(n1lin)
print v(n1p)
alter Vin1 DC -0.655877690395259
alter Vin2 DC 0.389979429035535
alter Vin3 DC 0.865674619744339
alter Vin4 DC -0.677630960011785
alter Vin5 DC -0.0503924405794702
alter Vin6 DC -0.120006739711034
alter Vin7 DC -0.134557676635459
alter Vin8 DC -0.0250515121451966
alter Vin9 DC 0.355622934668435
alter Vin10 DC 0.367768499333051
alter Vin11 DC 0.593279157623712
alter Vin12 DC -0.246232807186363
alter Vin13 DC 0.668985676828484
alter Vin14 DC 0.948662592332796
alter Vin15 DC -0.211849827616565
alter Vin16 DC 0.966843119717598
op
print v(n1lin)
print v(n1p)
alter Vin1 DC -0.995535243553177
alter Vin2 DC -0.876478246734878
alter Vin3 DC -0.236303533022777
alter Vin4 DC 0.219091498465029
alter Vin5 DC 0.982319158621755
alter Vin6 DC 0.21591220404829
alter Vin7 DC 0.983066958791041
alter Vin8 DC 0.489987628366737
alter Vin9 DC 0.557435237861056
alter Vin10 DC 0.201559894451993
alter Vin11 DC -0.322159548434205
alter Vin12 DC 0.546051311376606
alter Vin13 DC -0.109912221888115
alter Vin14 DC -0.196965782408006
alter Vin15 DC 0.738232751886714
alter Vin16 DC -0.550413216147577
op
print v(n1lin)
print v(n1p)
alter Vin1 DC 0.943523738987551
alter Vin2 DC 0.166125711006907
alter Vin3 DC -0.703339754409994
alter Vin4 DC 0.495336010632811
alter Vin5 DC -0.586590827476665
alter Vin6 DC -0.860167113127832
alter Vin7 DC -0.00394123964668491
alter Vin8 DC -0.855319559335296
alter Vin9 DC 0.544443706922747
alter Vin10 DC -0.944687247324227
alter Vin11 DC -0.165886489441072
alter Vin12 DC -0.771506273821579
alter Vin13 DC -0.758241037077482
alter Vin14 DC -0.386942692729898
alter Vin15 DC -0.0376153232567815
alter Vin16 DC -0.0657535338652873
op
print v(n1lin)
print v(n1p)
alter Vin1 DC 0.240798958186445
alter Vin2 DC 0.898824660770117
alter Vin3 DC -0.840140855837425
alter Vin4 DC 0.363507270486692
alter Vin5 DC -0.11225494755518
alter Vin6 DC 0.445757098086936
alter Vin7 DC -0.759370059582333
alter Vin8 DC 0.820288957206514
alter Vin9 DC -0.440760629976169
alter Vin10 DC 0.82761676388661
alter Vin11 DC -0.782001686707658
alter Vin12 DC 0.0763997919917068
alter Vin13 DC -0.0676701135552247
alter Vin14 DC 0.78927680022103
alter Vin15 DC 0.403609701237855
alter Vin16 DC 0.360596419638703
op
print v(n1lin)
print v(n1p)
alter Vin1 DC 0.242668660394116
alter Vin2 DC 0.663282261085532
alter Vin3 DC -0.321780931582985
alter Vin4 DC -0.724649449712332
alter Vin5 DC 0.943067214544064
alter Vin6 DC 0.629023689503847
alter Vin7 DC -0.829098470024122
alter Vin8 DC -0.959482165891484
alter Vin9 DC 0.288110940155833
alter Vin10 DC -0.150673656151015
alter Vin11 DC -0.186504882038696
alter Vin12 DC 0.501937597218957
alter Vin13 DC 0.454101316651503
alter Vin14 DC -0.846964242033359
alter Vin15 DC 0.13806619012755
alter Vin16 DC 0.76935470625933
op
print v(n1lin)
print v(n1p)
alter Vin1 DC 0.205947168035198
alter Vin2 DC -0.120700737718696
alter Vin3 DC -0.557720292881574
alter Vin4 DC 0.431255334718869
alter Vin5 DC -0.310423030320166
alter Vin6 DC 0.681520998795015
alter Vin7 DC 0.9532895612687
alter Vin8 DC -0.449212649056643
alter Vin9 DC 0.830333316015942
alter Vin10 DC 0.510663900782784
alter Vin11 DC -0.482095269791425
alter Vin12 DC 0.265634791528404
alter Vin13 DC -0.159157530909079
alter Vin14 DC 0.434221717275752
alter Vin15 DC -0.015567509088388
alter Vin16 DC -0.241649273892548
op
print v(n1lin)
print v(n1p)
alter Vin1 DC -0.873439516915047
alter Vin2 DC 0.0972306740836644
alter Vin3 DC -0.832688368302085
alter Vin4 DC 0.867862835067697
alter Vin5 DC 0.678103702355201
alter Vin6 DC -0.167162038555679
alter Vin7 DC -0.745946556878925
alter Vin8 DC 0.161640896882724
alter Vin9 DC -0.540229874629786
alter Vin10 DC -0.353320677600896
alter Vin11 DC 0.156698291588234
alter Vin12 DC 0.0606661097135426
alter Vin13 DC 0.833208073183203
alter Vin14 DC -0.721393336066475
alter Vin15 DC -0.638338405736675
alter Vin16 DC -0.58602039856544
op
print v(n1lin)
print v(n1p)
alter Vin1 DC -0.687486127621812
alter Vin2 DC 0.780669374901893
alter Vin3 DC 0.665109923663327
alter Vin4 DC 0.135071074413168
alter Vin5 DC 0.0683537017683116
alter Vin6 DC 0.0948977005366645
alter Vin7 DC 0.476702361621921
alter Vin8 DC -0.916617666140897
alter Vin9 DC -0.779725726092845
alter Vin10 DC -0.622563911651246
alter Vin11 DC 0.318301037318878
alter Vin12 DC 0.498581053201804
alter Vin13 DC 0.293728257802828
alter Vin14 DC 0.258604659947492
alter Vin15 DC -0.951315504519968
alter Vin16 DC 0.700185849499871
op
print v(n1lin)
print v(n1p)
alter Vin1 DC 0.720199571917749
alter Vin2 DC 0.842689987442785
alter Vin3 DC -0.37300247917726
alter Vin4 DC 0.891864489828675
alter Vin5 DC 0.953502418741368
alter Vin6 DC 0.55879141243812
alter Vin7 DC 0.899281547022618
alter Vin8 DC -0.0763682105048216
alter Vin9 DC 0.273803667364943
alter Vin10 DC 0.546857551957738
alter Vin11 DC -0.289710768201981
alter Vin12 DC -0.360588804991074
alter Vin13 DC 0.715012724899109
alter Vin14 DC -0.434396837998367
alter Vin15 DC -0.759434505250835
alter Vin16 DC -0.668931058186232
op
print v(n1lin)
print v(n1p)
alter Vin1 DC -0.707411361117319
alter Vin2 DC 0.192585157815974
alter Vin3 DC 0.99773657682682
alter Vin4 DC -0.937223757621676
alter Vin5 DC 0.772568616968369
alter Vin6 DC -0.102221909597799
alter Vin7 DC 0.920006092908996
alter Vin8 DC -0.396577255594017
alter Vin9 DC 0.80645150320269
alter Vin10 DC 0.725993004534669
alter Vin11 DC -0.0848066212195946
alter Vin12 DC 0.661312190394981
alter Vin13 DC -0.696642667940951
alter Vin14 DC 0.170544479274995
alter Vin15 DC -0.213385292260152
alter Vin16 DC 0.90366890547886
op
print v(n1lin)
print v(n1p)
alter Vin1 DC -0.211780571732066
alter Vin2 DC -0.960229689294304
alter Vin3 DC -0.0354827089919028
alter Vin4 DC -0.859913904197798
alter Vin5 DC -0.852639297900248
alter Vin6 DC 0.288211558384638
alter Vin7 DC -0.561936792816558
alter Vin8 DC -0.00629564268003913
alter Vin9 DC 0.748490029425805
alter Vin10 DC 0.939432004658647
alter Vin11 DC -0.162123151188592
alter Vin12 DC 0.306376287698891
alter Vin13 DC 0.812842675544145
alter Vin14 DC -0.572143230913467
alter Vin15 DC 0.508145226177871
alter Vin16 DC -0.552064624488184
op
print v(n1lin)
print v(n1p)
alter Vin1 DC 0.729667606766826
alter Vin2 DC -0.164809925262465
alter Vin3 DC 0.659001667681764
alter Vin4 DC -0.333502271892039
alter Vin5 DC -0.745327701902088
alter Vin6 DC -0.889610902333129
alter Vin7 DC 0.514921552187058
alter Vin8 DC 0.955925412643982
alter Vin9 DC 0.815350743451948
alter Vin10 DC 0.117940418031942
alter Vin11 DC 0.58941707332947
alter Vin12 DC -0.732138557942406
alter Vin13 DC 0.54459774171462
alter Vin14 DC 0.566413325786553
alter Vin15 DC 0.823216792393066
alter Vin16 DC -0.367822793259647
op
print v(n1lin)
print v(n1p)
alter Vin1 DC -0.958214670191638
alter Vin2 DC -0.443768316007133
alter Vin3 DC 0.611124498931104
alter Vin4 DC 0.071134287324472
alter Vin5 DC 0.300431747094275
alter Vin6 DC -0.316079871628401
alter Vin7 DC 0.264601753271364
alter Vin8 DC -0.631597289239306
alter Vin9 DC 0.672132631648563
alter Vin10 DC 0.450699825820963
alter Vin11 DC 0.458260188664694
alter Vin12 DC 0.792148056059215
alter Vin13 DC -0.680097857625347
alter Vin14 DC 0.191620871144605
alter Vin15 DC -0.122857521278826
alter Vin16 DC -0.310769649423763
op
print v(n1lin)
print v(n1p)
alter Vin1 DC 0.345370439303641
alter Vin2 DC 0.774643103341817
alter Vin3 DC 0.328057742106546
alter Vin4 DC -0.10503282170679
alter Vin5 DC 0.570607791347666
alter Vin6 DC 0.626512360049154
alter Vin7 DC -0.807644088098176
alter Vin8 DC 0.610831840818696
alter Vin9 DC -0.667464863599281
alter Vin10 DC 0.72760718695077
alter Vin11 DC -0.139813058354401
alter Vin12 DC 0.920457747073463
alter Vin13 DC 0.0465226390147579
alter Vin14 DC -0.74220960340449
alter Vin15 DC 0.782223839263231
alter Vin16 DC 0.463338366605082
op
print v(n1lin)
print v(n1p)
alter Vin1 DC -0.725325853132183
alter Vin2 DC 0.238363767127081
alter Vin3 DC 0.775984221663296
alter Vin4 DC -0.658159734437862
alter Vin5 DC 0.224966005305728
alter Vin6 DC -0.47855104694634
alter Vin7 DC 0.124604255286087
alter Vin8 DC -0.476847505200957
alter Vin9 DC -0.687051028078248
alter Vin10 DC 0.39935250785032
alter Vin11 DC -0.43570027848793
alter Vin12 DC -0.357934451139409
alter Vin13 DC -0.347125300075155
alter Vin14 DC 0.491804293021817
alter Vin15 DC -0.0657688099520746
alter Vin16 DC 0.360540536093544
op
print v(n1lin)
print v(n1p)
.endc

.end
