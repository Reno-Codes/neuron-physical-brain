* Physical AI - Experiment 17 architecture A: feedback resistor TIA
* Inverting TIA. Vout = I * Rf * A/(A+1). Summing node held by the amplifier, not by a 0 V source. Rf = 1/G_WEIGHT.
* Frozen Experiment 9 network A. Weights were not edited.
* Behavioral circuit analysis. Not transistor-level or PCB power.
* A_tia=100000 A_inv=1e+07 rail=15 vos=0 rout=0 Ileak=0 clip=False linear=False
* shape: 2 -> 4 -> 1

* Experiment 23 candidate O-VF
* XSPICE OTA as voltage-gain TIA (A = gm*rout, rout=1 ohm)
* source: ngspice built-in analog code model `ota`
* A 1-stage OTA driving Rf would collapse to A~gm*Rf. O-VF sets rout=1 ohm so A=gm*rout survives Rf. That is a voltage op-amp equivalent, not a high-Z OTA.
* Weights were not edited. SPICE is not Python-corrected.
.model otavf ota (gm=100000 rout=1 rin=1e12)

Vin1 in1 0 DC 0
* passive invert in1 -> in1n: R2/R1=1.0000002 closed-loop -1 at A=1e+07
Rinv1ia in1 inv1m 10000
Rinv1ib in1n inv1m 10000.0020000002
Einv1amp in1n 0 0 inv1m 10000000
Vin2 in2 0 DC 0
* passive invert in2 -> in2n: R2/R1=1.0000002 closed-loop -1 at A=1e+07
Rinv2ia in2 inv2m 10000
Rinv2ib in2n inv2m 10000.0020000002
Einv2amp in2n 0 0 inv2m 10000000
Vref vref 0 DC 1
* passive invert vref -> vrefn: R2/R1=1.0000002 closed-loop -1 at A=1e+07
Rinvrefia vref invrefm 10000
Rinvrefib vrefn invrefm 10000.0020000002
Einvrefamp vrefn 0 0 invrefm 10000000
* load-compensated divider vref->tapref: G_load=0.00135041774642313 Ra=425030.827613635 Rb=1000 target beta=0.001 (no tap buffer)
Rdivrefa vref tapref 425030.827613635
Rdivrefb tapref 0 1000
* load-compensated divider vrefn->taprefn: G_load=0.000833646933955897 Ra=544815.897488381 Rb=1000 target beta=0.001 (no tap buffer)
Rdivrefna vrefn taprefn 544815.897488381
Rdivrefnb taprefn 0 1000

* h1 input 1 w=+0.683760795348816 w+  bank=n alpha=1 R=48749.9920441162 G_phys=2.05128238604645e-05 G_eff=2.05128238604645e-05
Rh1p1n1 in1n h1p 48749.9920441162
* h1 input 2 w=+0.309366783045794 w+  bank=n alpha=1 R=107746.969487669 G_phys=9.28100349137382e-06 G_eff=9.28100349137382e-06
Rh1p2n1 in2n h1p 107746.969487669
* h1 bias w-  bank=f alpha=0.001 R=1253.18954325804 G_phys=0.000797963887729386 G_eff=7.97963887729385e-07
Rh1bnf1 tapref h1p 1253.18954325804
* feedback TIA h1: Rf=33333.3333333333 A=100000 V(h1lin) = -I(h1p)*Rf*A/(A+1)  (uncompensated)
* Exp 23 O-VF TIA h1 -> h1lin, vg=h1p
Vh1os h1osp 0 DC 0
Ah1tia h1osp h1p h1lin otavf
* A=100000 = gm*rout, gm=100000, rout=1
Rh1f h1lin h1p 33333.3333333333
* direct bounded ReLU: y=max(0, min(15, v(h1lin)))
Bh1relu h1y 0 V = max(0, min(15, v(h1lin)))

* h2 input 1 w=-0.884821731731664 w-  bank=n alpha=1 R=37672.3718890781 G_phys=2.65446519519499e-05 G_eff=2.65446519519499e-05
Rh2n1n1 in1 h2p 37672.3718890781
* h2 input 2 w=+0.782653240240456 w+  bank=n alpha=1 R=42590.1684417639 G_phys=2.34795972072137e-05 G_eff=2.34795972072137e-05
Rh2p2n1 in2n h2p 42590.1684417639
* h2 bias w+  bank=f alpha=0.001 R=560963.988396833 G_phys=1.78264562553806e-06 G_eff=1.78264562553806e-09
Rh2bpf1 taprefn h2p 560963.988396833
* feedback TIA h2: Rf=33333.3333333333 A=100000 V(h2lin) = -I(h2p)*Rf*A/(A+1)  (uncompensated)
* Exp 23 O-VF TIA h2 -> h2lin, vg=h2p
Vh2os h2osp 0 DC 0
Ah2tia h2osp h2p h2lin otavf
* A=100000 = gm*rout, gm=100000, rout=1
Rh2f h2lin h2p 33333.3333333333
* direct bounded ReLU: y=max(0, min(15, v(h2lin)))
Bh2relu h2y 0 V = max(0, min(15, v(h2lin)))

* h3 input 1 w=+0.80723931339229 w+  bank=n alpha=1 R=41293.0004526854 G_phys=2.42171794017687e-05 G_eff=2.42171794017687e-05
Rh3p1n1 in1n h3p 41293.0004526854
* h3 input 2 w=+1.71882311343666 w+  bank=n alpha=1 R=19393.1144355429 G_phys=5.15646934030999e-05 G_eff=5.15646934030999e-05
Rh3p2n1 in2n h3p 19393.1144355429
* h3 bias w+  bank=f alpha=0.001 R=1918.09451080035 G_phys=0.000521350743860236 G_eff=5.21350743860236e-07
Rh3bpf1 taprefn h3p 1918.09451080035
* feedback TIA h3: Rf=33333.3333333333 A=100000 V(h3lin) = -I(h3p)*Rf*A/(A+1)  (uncompensated)
* Exp 23 O-VF TIA h3 -> h3lin, vg=h3p
Vh3os h3osp 0 DC 0
Ah3tia h3osp h3p h3lin otavf
* A=100000 = gm*rout, gm=100000, rout=1
Rh3f h3lin h3p 33333.3333333333
* direct bounded ReLU: y=max(0, min(15, v(h3lin)))
Bh3relu h3y 0 V = max(0, min(15, v(h3lin)))

* h4 input 1 w=-2.16286246457598 w-  bank=n alpha=1 R=15411.6749813161 G_phys=6.48858739372794e-05 G_eff=6.48858739372794e-05
Rh4n1n1 in1 h4p 15411.6749813161
* h4 input 2 w=+0.726967919426763 w+  bank=n alpha=1 R=45852.5506319697 G_phys=2.18090375828029e-05 G_eff=2.18090375828029e-05
Rh4p2n1 in2n h4p 45852.5506319697
* h4 bias w-  bank=f alpha=0.001 R=1810.10591973139 G_phys=0.000552453858693748 G_eff=5.52453858693748e-07
Rh4bnf1 tapref h4p 1810.10591973139
* feedback TIA h4: Rf=33333.3333333333 A=100000 V(h4lin) = -I(h4p)*Rf*A/(A+1)  (uncompensated)
* Exp 23 O-VF TIA h4 -> h4lin, vg=h4p
Vh4os h4osp 0 DC 0
Ah4tia h4osp h4p h4lin otavf
* A=100000 = gm*rout, gm=100000, rout=1
Rh4f h4lin h4p 33333.3333333333
* direct bounded ReLU: y=max(0, min(15, v(h4lin)))
Bh4relu h4y 0 V = max(0, min(15, v(h4lin)))

* passive invert h1y -> h1yn: R2/R1=1.0000002 closed-loop -1 at A=1e+07
Rinvh1ia h1y invh1m 10000
Rinvh1ib h1yn invh1m 10000.0020000002
Einvh1amp h1yn 0 0 invh1m 10000000
* passive invert h2y -> h2yn: R2/R1=1.0000002 closed-loop -1 at A=1e+07
Rinvh2ia h2y invh2m 10000
Rinvh2ib h2yn invh2m 10000.0020000002
Einvh2amp h2yn 0 0 invh2m 10000000
* passive invert h3y -> h3yn: R2/R1=1.0000002 closed-loop -1 at A=1e+07
Rinvh3ia h3y invh3m 10000
Rinvh3ib h3yn invh3m 10000.0020000002
Einvh3amp h3yn 0 0 invh3m 10000000
* passive invert h4y -> h4yn: R2/R1=1.0000002 closed-loop -1 at A=1e+07
Rinvh4ia h4y invh4m 10000
Rinvh4ib h4yn invh4m 10000.0020000002
Einvh4amp h4yn 0 0 invh4m 10000000

* o1 input 1 w=+0.601889648539537 w+  bank=n alpha=1 R=55381.137413171 G_phys=1.80566894561861e-05 G_eff=1.80566894561861e-05
Ro1p1n1 h1yn o1p 55381.137413171
* o1 input 2 w=+0.347315954504283 w+  bank=n alpha=1 R=95974.0918925228 G_phys=1.04194786351285e-05 G_eff=1.04194786351285e-05
Ro1p2n1 h2yn o1p 95974.0918925228
* o1 input 3 w=+0.876922607606196 w+  bank=n alpha=1 R=38011.716249768 G_phys=2.63076782281859e-05 G_eff=2.63076782281859e-05
Ro1p3n1 h3yn o1p 38011.716249768
* o1 input 4 w=+0.929527796434486 w+  bank=n alpha=1 R=35860.5019249499 G_phys=2.78858338930346e-05 G_eff=2.78858338930346e-05
Ro1p4n1 h4yn o1p 35860.5019249499
* o1 bias w+  bank=f alpha=0.001 R=3220.47143452777 G_phys=0.000310513544470123 G_eff=3.10513544470123e-07
Ro1bpf1 taprefn o1p 3220.47143452777
* feedback TIA o1: Rf=33333.3333333333 A=100000 V(o1lin) = -I(o1p)*Rf*A/(A+1)  (uncompensated)
* Exp 23 O-VF TIA o1 -> o1lin, vg=o1p
Vo1os o1osp 0 DC 0
Ao1tia o1osp o1p o1lin otavf
* A=100000 = gm*rout, gm=100000, rout=1
Ro1f o1lin o1p 33333.3333333333
.control
set numdgt=15
alter Vin1 DC -0.7512789591571
alter Vin2 DC 0.793426140956844
op
print v(o1lin)
alter Vin1 DC 0.737011679466137
alter Vin2 DC 0.253221305433947
op
print v(o1lin)
alter Vin1 DC -0.962326702147222
alter Vin2 DC -0.800333912329652
op
print v(o1lin)
alter Vin1 DC -0.704187166725597
alter Vin2 DC 0.57072365590305
op
print v(o1lin)
alter Vin1 DC 0.291357424745929
alter Vin2 DC -0.660077398417701
op
print v(o1lin)
alter Vin1 DC -0.828751960917257
alter Vin2 DC 0.537842135415398
op
print v(o1lin)
alter Vin1 DC -0.594521095500554
alter Vin2 DC -0.86241227119949
op
print v(o1lin)
alter Vin1 DC 0.788175827371089
alter Vin2 DC 0.0661861225642744
op
print v(o1lin)
alter Vin1 DC -0.332078026732493
alter Vin2 DC -0.349322740431655
op
print v(o1lin)
alter Vin1 DC -0.0860475841593056
alter Vin2 DC 0.981737389421505
op
print v(o1lin)
alter Vin1 DC 0.342598276792323
alter Vin2 DC 0.014868275494659
op
print v(o1lin)
alter Vin1 DC -0.0324508542404287
alter Vin2 DC 0.569296145294465
op
print v(o1lin)
alter Vin1 DC -0.305912833837623
alter Vin2 DC -0.466656636224801
op
print v(o1lin)
alter Vin1 DC 0.581398619117705
alter Vin2 DC -0.620080497078598
op
print v(o1lin)
alter Vin1 DC 0.546656379789679
alter Vin2 DC -0.275778980299946
op
print v(o1lin)
alter Vin1 DC 0.702746991529333
alter Vin2 DC -0.967442294726138
op
print v(o1lin)
alter Vin1 DC 0.430251475869944
alter Vin2 DC -0.231375868985145
op
print v(o1lin)
alter Vin1 DC -0.0730934983317464
alter Vin2 DC 0.877524647339455
op
print v(o1lin)
alter Vin1 DC 0.663360686014629
alter Vin2 DC -0.567092785084031
op
print v(o1lin)
alter Vin1 DC 0.310122183912505
alter Vin2 DC 0.41216175037246
op
print v(o1lin)
alter Vin1 DC 0.275204177449065
alter Vin2 DC -0.565027738081837
op
print v(o1lin)
alter Vin1 DC 0.165424296664586
alter Vin2 DC -0.570698348095794
op
print v(o1lin)
alter Vin1 DC -0.0421981297911425
alter Vin2 DC -0.859930172686353
op
print v(o1lin)
alter Vin1 DC 0.517934478911771
alter Vin2 DC -0.398266539145449
op
print v(o1lin)
alter Vin1 DC -0.480958123202562
alter Vin2 DC 0.973883341722669
op
print v(o1lin)
alter Vin1 DC -0.28759759325468
alter Vin2 DC -0.289750006316214
op
print v(o1lin)
alter Vin1 DC -0.13222565882422
alter Vin2 DC -0.57536778604852
op
print v(o1lin)
alter Vin1 DC -0.401376325884751
alter Vin2 DC -0.283490219330854
op
print v(o1lin)
alter Vin1 DC -0.00515167976791631
alter Vin2 DC -0.123768525272332
op
print v(o1lin)
alter Vin1 DC 0.358870976803522
alter Vin2 DC 0.272103029594862
op
print v(o1lin)
alter Vin1 DC 0.271265003440755
alter Vin2 DC -0.161727486941131
op
print v(o1lin)
alter Vin1 DC -0.302041169017737
alter Vin2 DC 0.784929120623181
op
print v(o1lin)
alter Vin1 DC -0.979549183557856
alter Vin2 DC -0.0777642274553534
op
print v(o1lin)
alter Vin1 DC -0.445968802425597
alter Vin2 DC 0.149045838642873
op
print v(o1lin)
alter Vin1 DC 0.325945246494308
alter Vin2 DC -0.891252050524818
op
print v(o1lin)
alter Vin1 DC 0.449584243082808
alter Vin2 DC 0.658194780490362
op
print v(o1lin)
alter Vin1 DC -0.347789320927898
alter Vin2 DC -0.452894085840111
op
print v(o1lin)
alter Vin1 DC -0.624615246283157
alter Vin2 DC -0.772204631559217
op
print v(o1lin)
alter Vin1 DC 0.687790425897961
alter Vin2 DC 0.773838714503767
op
print v(o1lin)
alter Vin1 DC 0.0661775855218119
alter Vin2 DC -0.205572803792462
op
print v(o1lin)
alter Vin1 DC -0.145049948088765
alter Vin2 DC 0.385060844112093
op
print v(o1lin)
alter Vin1 DC -0.657912541094572
alter Vin2 DC -0.0274657952419224
op
print v(o1lin)
alter Vin1 DC -0.775623536912958
alter Vin2 DC -0.604364412129406
op
print v(o1lin)
alter Vin1 DC 0.321437071817283
alter Vin2 DC -0.720016581472481
op
print v(o1lin)
alter Vin1 DC -0.273748451092144
alter Vin2 DC -0.405610243583189
op
print v(o1lin)
alter Vin1 DC -0.94663871244697
alter Vin2 DC 0.869097124500827
op
print v(o1lin)
alter Vin1 DC -0.286044701269175
alter Vin2 DC -0.845286725731619
op
print v(o1lin)
alter Vin1 DC 0.552772370354273
alter Vin2 DC -0.522809292714258
op
print v(o1lin)
alter Vin1 DC -0.49380435668623
alter Vin2 DC 0.654919687890156
op
print v(o1lin)
alter Vin1 DC -0.790861755081204
alter Vin2 DC -0.409559569398771
op
print v(o1lin)
alter Vin1 DC 0.162427378867956
alter Vin2 DC -0.0413853417830077
op
print v(o1lin)
alter Vin1 DC 0.48090119984303
alter Vin2 DC -0.716881142547644
op
print v(o1lin)
alter Vin1 DC -0.123617907004929
alter Vin2 DC 0.959410421593022
op
print v(o1lin)
alter Vin1 DC -0.561428372828054
alter Vin2 DC 0.968660456046287
op
print v(o1lin)
alter Vin1 DC 0.295838906017345
alter Vin2 DC 0.406941377010295
op
print v(o1lin)
alter Vin1 DC 0.108315401234658
alter Vin2 DC -0.00387463109971886
op
print v(o1lin)
alter Vin1 DC 0.0953763622200163
alter Vin2 DC 0.0651336966741083
op
print v(o1lin)
alter Vin1 DC -0.738363368816784
alter Vin2 DC -0.731166473981731
op
print v(o1lin)
alter Vin1 DC 0.900770866996425
alter Vin2 DC -0.727591913031204
op
print v(o1lin)
alter Vin1 DC -0.229497264853719
alter Vin2 DC 0.743126682396477
op
print v(o1lin)
alter Vin1 DC -0.0277529114913251
alter Vin2 DC -0.965870039445897
op
print v(o1lin)
alter Vin1 DC -0.1386827486622
alter Vin2 DC 0.9647450347454
op
print v(o1lin)
alter Vin1 DC -0.582634984354567
alter Vin2 DC 0.00831014144086217
op
print v(o1lin)
alter Vin1 DC -0.0295605981423275
alter Vin2 DC 0.281918069228581
op
print v(o1lin)
alter Vin1 DC -0.423480979370264
alter Vin2 DC -0.907710478438457
op
print v(o1lin)
alter Vin1 DC -0.650883954801436
alter Vin2 DC -0.373940781784671
op
print v(o1lin)
alter Vin1 DC 0.644314476543554
alter Vin2 DC -0.825065348332962
op
print v(o1lin)
alter Vin1 DC 0.506272032353642
alter Vin2 DC -0.668174123158548
op
print v(o1lin)
alter Vin1 DC 0.0238412324848796
alter Vin2 DC 0.799666788064388
op
print v(o1lin)
alter Vin1 DC -0.871890757986558
alter Vin2 DC -0.802272603189513
op
print v(o1lin)
alter Vin1 DC 0.639715952230046
alter Vin2 DC 0.82962311673376
op
print v(o1lin)
alter Vin1 DC 0.106458421195492
alter Vin2 DC 0.431930959926236
op
print v(o1lin)
alter Vin1 DC -0.27066028071708
alter Vin2 DC 0.499639009112291
op
print v(o1lin)
alter Vin1 DC -0.500079353504042
alter Vin2 DC 0.804193620004335
op
print v(o1lin)
alter Vin1 DC 0.195166837064654
alter Vin2 DC -0.993334590801065
op
print v(o1lin)
alter Vin1 DC 0.153538702768493
alter Vin2 DC 0.117073568516961
op
print v(o1lin)
alter Vin1 DC 0.616461184505021
alter Vin2 DC 0.97751037507061
op
print v(o1lin)
alter Vin1 DC -0.171605997943848
alter Vin2 DC -0.625907494288791
op
print v(o1lin)
alter Vin1 DC 0.656362252013657
alter Vin2 DC -0.493355654595241
op
print v(o1lin)
alter Vin1 DC 0.90960234225549
alter Vin2 DC -0.392225306959621
op
print v(o1lin)
alter Vin1 DC 0.695159451481169
alter Vin2 DC 0.704073309151083
op
print v(o1lin)
alter Vin1 DC 0.869084194561222
alter Vin2 DC 0.788229614236844
op
print v(o1lin)
alter Vin1 DC -0.0147861221256795
alter Vin2 DC -0.360810132060194
op
print v(o1lin)
alter Vin1 DC -0.557625038089645
alter Vin2 DC 0.732904002300183
op
print v(o1lin)
alter Vin1 DC -0.143569074787465
alter Vin2 DC -0.84170110616263
op
print v(o1lin)
alter Vin1 DC -0.787632811350421
alter Vin2 DC 0.888724435544662
op
print v(o1lin)
alter Vin1 DC 0.0306351105059532
alter Vin2 DC -0.489098022219137
op
print v(o1lin)
alter Vin1 DC 0.89866282660489
alter Vin2 DC 0.149013784827019
op
print v(o1lin)
alter Vin1 DC 0.619606813124752
alter Vin2 DC 0.609683236880137
op
print v(o1lin)
alter Vin1 DC -0.672017000669777
alter Vin2 DC -0.316258512783531
op
print v(o1lin)
alter Vin1 DC -0.360529380991153
alter Vin2 DC -0.685762387487058
op
print v(o1lin)
alter Vin1 DC 0.913787226621682
alter Vin2 DC 0.378342879646435
op
print v(o1lin)
alter Vin1 DC 0.303251430428411
alter Vin2 DC 0.0256726240370879
op
print v(o1lin)
alter Vin1 DC -0.0374480358922866
alter Vin2 DC 0.53293738679307
op
print v(o1lin)
alter Vin1 DC -0.868870512124355
alter Vin2 DC -0.646079816585292
op
print v(o1lin)
alter Vin1 DC -0.829676703307725
alter Vin2 DC 0.715800414451996
op
print v(o1lin)
alter Vin1 DC -0.37273955892152
alter Vin2 DC -0.867501305651521
op
print v(o1lin)
alter Vin1 DC -0.414804726377363
alter Vin2 DC -0.328706488427591
op
print v(o1lin)
alter Vin1 DC -0.246770673837979
alter Vin2 DC 0.133832253837596
op
print v(o1lin)
alter Vin1 DC 0.337097983477451
alter Vin2 DC 0.900488249171949
op
print v(o1lin)
.endc

.end
