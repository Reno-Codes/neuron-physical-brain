* Experiment 45 SKY130 tt R+C via official .include (no .lib section)
* PDK C:/dev/pdk/sky130A/libs.tech/ngspice
* Frozen weights were not edited. SPICE is not Python-corrected.
.param mc_mm_switch=1
.param MC_MM_SWITCH=1
.param mc_pr_switch=0
.include "C:/dev/pdk/sky130A/libs.tech/ngspice/sky130_fd_pr__model__linear.model.spice"
.include "C:/dev/pdk/sky130A/libs.tech/ngspice/r+c/res_typical__cap_typical.spice"
.include "C:/dev/pdk/sky130A/libs.tech/ngspice/r+c/res_typical__cap_typical__lin.spice"
.temp 27

* Experiment 22 isolated TIA neuron n1
* frozen n=32 L1=6.7601697 b=0.0322130531942455
* A=1000000 vos=0 Ileak=0 Rout=0 fp=0 invertA=1e+07
* Behavioral TIA. Not transistor-level. Weights were not edited.
* shape: 32 -> 1 (linear Vlin vs z unless ReLU requested)

* Experiment 45 phase2 OPA189 TIA · LEVEL 3 TI GWL (unmodified vendor zip)
.include "C:/dev/neuron-physical-brain/physical-ai/models/vendor/ti/opa189/OPAx189.LIB"
Vddtia vddtia 0 DC 15
Vsstia vsstia 0 DC -15
Vin1 in1 0 DC 0.288635987619693
Vin2 in2 0 DC 0.653552961415873
* passive invert in2 -> in2n: R2/R1=1.0000002 closed-loop -1 at A=1e+07
* PDK sky130_fd_pr__res_xhigh_po Rinv2ia W=10 L=49.614372
* tile Rinv2ia 8s x 8p same W=10 L=49.614372
XRinv2iap0s0 in2 Rinv2iat0s0 0 sky130_fd_pr__res_xhigh_po w=10 l=49.614372
XRinv2iap0s1 Rinv2iat0s0 Rinv2iat0s1 0 sky130_fd_pr__res_xhigh_po w=10 l=49.614372
XRinv2iap0s2 Rinv2iat0s1 Rinv2iat0s2 0 sky130_fd_pr__res_xhigh_po w=10 l=49.614372
XRinv2iap0s3 Rinv2iat0s2 Rinv2iat0s3 0 sky130_fd_pr__res_xhigh_po w=10 l=49.614372
XRinv2iap0s4 Rinv2iat0s3 Rinv2iat0s4 0 sky130_fd_pr__res_xhigh_po w=10 l=49.614372
XRinv2iap0s5 Rinv2iat0s4 Rinv2iat0s5 0 sky130_fd_pr__res_xhigh_po w=10 l=49.614372
XRinv2iap0s6 Rinv2iat0s5 Rinv2iat0s6 0 sky130_fd_pr__res_xhigh_po w=10 l=49.614372
XRinv2iap0s7 Rinv2iat0s6 inv2m 0 sky130_fd_pr__res_xhigh_po w=10 l=49.614372
XRinv2iap1s0 in2 Rinv2iat1s0 0 sky130_fd_pr__res_xhigh_po w=10 l=49.614372
XRinv2iap1s1 Rinv2iat1s0 Rinv2iat1s1 0 sky130_fd_pr__res_xhigh_po w=10 l=49.614372
XRinv2iap1s2 Rinv2iat1s1 Rinv2iat1s2 0 sky130_fd_pr__res_xhigh_po w=10 l=49.614372
XRinv2iap1s3 Rinv2iat1s2 Rinv2iat1s3 0 sky130_fd_pr__res_xhigh_po w=10 l=49.614372
XRinv2iap1s4 Rinv2iat1s3 Rinv2iat1s4 0 sky130_fd_pr__res_xhigh_po w=10 l=49.614372
XRinv2iap1s5 Rinv2iat1s4 Rinv2iat1s5 0 sky130_fd_pr__res_xhigh_po w=10 l=49.614372
XRinv2iap1s6 Rinv2iat1s5 Rinv2iat1s6 0 sky130_fd_pr__res_xhigh_po w=10 l=49.614372
XRinv2iap1s7 Rinv2iat1s6 inv2m 0 sky130_fd_pr__res_xhigh_po w=10 l=49.614372
XRinv2iap2s0 in2 Rinv2iat2s0 0 sky130_fd_pr__res_xhigh_po w=10 l=49.614372
XRinv2iap2s1 Rinv2iat2s0 Rinv2iat2s1 0 sky130_fd_pr__res_xhigh_po w=10 l=49.614372
XRinv2iap2s2 Rinv2iat2s1 Rinv2iat2s2 0 sky130_fd_pr__res_xhigh_po w=10 l=49.614372
XRinv2iap2s3 Rinv2iat2s2 Rinv2iat2s3 0 sky130_fd_pr__res_xhigh_po w=10 l=49.614372
XRinv2iap2s4 Rinv2iat2s3 Rinv2iat2s4 0 sky130_fd_pr__res_xhigh_po w=10 l=49.614372
XRinv2iap2s5 Rinv2iat2s4 Rinv2iat2s5 0 sky130_fd_pr__res_xhigh_po w=10 l=49.614372
XRinv2iap2s6 Rinv2iat2s5 Rinv2iat2s6 0 sky130_fd_pr__res_xhigh_po w=10 l=49.614372
XRinv2iap2s7 Rinv2iat2s6 inv2m 0 sky130_fd_pr__res_xhigh_po w=10 l=49.614372
XRinv2iap3s0 in2 Rinv2iat3s0 0 sky130_fd_pr__res_xhigh_po w=10 l=49.614372
XRinv2iap3s1 Rinv2iat3s0 Rinv2iat3s1 0 sky130_fd_pr__res_xhigh_po w=10 l=49.614372
XRinv2iap3s2 Rinv2iat3s1 Rinv2iat3s2 0 sky130_fd_pr__res_xhigh_po w=10 l=49.614372
XRinv2iap3s3 Rinv2iat3s2 Rinv2iat3s3 0 sky130_fd_pr__res_xhigh_po w=10 l=49.614372
XRinv2iap3s4 Rinv2iat3s3 Rinv2iat3s4 0 sky130_fd_pr__res_xhigh_po w=10 l=49.614372
XRinv2iap3s5 Rinv2iat3s4 Rinv2iat3s5 0 sky130_fd_pr__res_xhigh_po w=10 l=49.614372
XRinv2iap3s6 Rinv2iat3s5 Rinv2iat3s6 0 sky130_fd_pr__res_xhigh_po w=10 l=49.614372
XRinv2iap3s7 Rinv2iat3s6 inv2m 0 sky130_fd_pr__res_xhigh_po w=10 l=49.614372
XRinv2iap4s0 in2 Rinv2iat4s0 0 sky130_fd_pr__res_xhigh_po w=10 l=49.614372
XRinv2iap4s1 Rinv2iat4s0 Rinv2iat4s1 0 sky130_fd_pr__res_xhigh_po w=10 l=49.614372
XRinv2iap4s2 Rinv2iat4s1 Rinv2iat4s2 0 sky130_fd_pr__res_xhigh_po w=10 l=49.614372
XRinv2iap4s3 Rinv2iat4s2 Rinv2iat4s3 0 sky130_fd_pr__res_xhigh_po w=10 l=49.614372
XRinv2iap4s4 Rinv2iat4s3 Rinv2iat4s4 0 sky130_fd_pr__res_xhigh_po w=10 l=49.614372
XRinv2iap4s5 Rinv2iat4s4 Rinv2iat4s5 0 sky130_fd_pr__res_xhigh_po w=10 l=49.614372
XRinv2iap4s6 Rinv2iat4s5 Rinv2iat4s6 0 sky130_fd_pr__res_xhigh_po w=10 l=49.614372
XRinv2iap4s7 Rinv2iat4s6 inv2m 0 sky130_fd_pr__res_xhigh_po w=10 l=49.614372
XRinv2iap5s0 in2 Rinv2iat5s0 0 sky130_fd_pr__res_xhigh_po w=10 l=49.614372
XRinv2iap5s1 Rinv2iat5s0 Rinv2iat5s1 0 sky130_fd_pr__res_xhigh_po w=10 l=49.614372
XRinv2iap5s2 Rinv2iat5s1 Rinv2iat5s2 0 sky130_fd_pr__res_xhigh_po w=10 l=49.614372
XRinv2iap5s3 Rinv2iat5s2 Rinv2iat5s3 0 sky130_fd_pr__res_xhigh_po w=10 l=49.614372
XRinv2iap5s4 Rinv2iat5s3 Rinv2iat5s4 0 sky130_fd_pr__res_xhigh_po w=10 l=49.614372
XRinv2iap5s5 Rinv2iat5s4 Rinv2iat5s5 0 sky130_fd_pr__res_xhigh_po w=10 l=49.614372
XRinv2iap5s6 Rinv2iat5s5 Rinv2iat5s6 0 sky130_fd_pr__res_xhigh_po w=10 l=49.614372
XRinv2iap5s7 Rinv2iat5s6 inv2m 0 sky130_fd_pr__res_xhigh_po w=10 l=49.614372
XRinv2iap6s0 in2 Rinv2iat6s0 0 sky130_fd_pr__res_xhigh_po w=10 l=49.614372
XRinv2iap6s1 Rinv2iat6s0 Rinv2iat6s1 0 sky130_fd_pr__res_xhigh_po w=10 l=49.614372
XRinv2iap6s2 Rinv2iat6s1 Rinv2iat6s2 0 sky130_fd_pr__res_xhigh_po w=10 l=49.614372
XRinv2iap6s3 Rinv2iat6s2 Rinv2iat6s3 0 sky130_fd_pr__res_xhigh_po w=10 l=49.614372
XRinv2iap6s4 Rinv2iat6s3 Rinv2iat6s4 0 sky130_fd_pr__res_xhigh_po w=10 l=49.614372
XRinv2iap6s5 Rinv2iat6s4 Rinv2iat6s5 0 sky130_fd_pr__res_xhigh_po w=10 l=49.614372
XRinv2iap6s6 Rinv2iat6s5 Rinv2iat6s6 0 sky130_fd_pr__res_xhigh_po w=10 l=49.614372
XRinv2iap6s7 Rinv2iat6s6 inv2m 0 sky130_fd_pr__res_xhigh_po w=10 l=49.614372
XRinv2iap7s0 in2 Rinv2iat7s0 0 sky130_fd_pr__res_xhigh_po w=10 l=49.614372
XRinv2iap7s1 Rinv2iat7s0 Rinv2iat7s1 0 sky130_fd_pr__res_xhigh_po w=10 l=49.614372
XRinv2iap7s2 Rinv2iat7s1 Rinv2iat7s2 0 sky130_fd_pr__res_xhigh_po w=10 l=49.614372
XRinv2iap7s3 Rinv2iat7s2 Rinv2iat7s3 0 sky130_fd_pr__res_xhigh_po w=10 l=49.614372
XRinv2iap7s4 Rinv2iat7s3 Rinv2iat7s4 0 sky130_fd_pr__res_xhigh_po w=10 l=49.614372
XRinv2iap7s5 Rinv2iat7s4 Rinv2iat7s5 0 sky130_fd_pr__res_xhigh_po w=10 l=49.614372
XRinv2iap7s6 Rinv2iat7s5 Rinv2iat7s6 0 sky130_fd_pr__res_xhigh_po w=10 l=49.614372
XRinv2iap7s7 Rinv2iat7s6 inv2m 0 sky130_fd_pr__res_xhigh_po w=10 l=49.614372
* PDK sky130_fd_pr__res_xhigh_po Rinv2ib W=10 L=49.614382
* tile Rinv2ib 8s x 8p same W=10 L=49.614382
XRinv2ibp0s0 in2n Rinv2ibt0s0 0 sky130_fd_pr__res_xhigh_po w=10 l=49.614382
XRinv2ibp0s1 Rinv2ibt0s0 Rinv2ibt0s1 0 sky130_fd_pr__res_xhigh_po w=10 l=49.614382
XRinv2ibp0s2 Rinv2ibt0s1 Rinv2ibt0s2 0 sky130_fd_pr__res_xhigh_po w=10 l=49.614382
XRinv2ibp0s3 Rinv2ibt0s2 Rinv2ibt0s3 0 sky130_fd_pr__res_xhigh_po w=10 l=49.614382
XRinv2ibp0s4 Rinv2ibt0s3 Rinv2ibt0s4 0 sky130_fd_pr__res_xhigh_po w=10 l=49.614382
XRinv2ibp0s5 Rinv2ibt0s4 Rinv2ibt0s5 0 sky130_fd_pr__res_xhigh_po w=10 l=49.614382
XRinv2ibp0s6 Rinv2ibt0s5 Rinv2ibt0s6 0 sky130_fd_pr__res_xhigh_po w=10 l=49.614382
XRinv2ibp0s7 Rinv2ibt0s6 inv2m 0 sky130_fd_pr__res_xhigh_po w=10 l=49.614382
XRinv2ibp1s0 in2n Rinv2ibt1s0 0 sky130_fd_pr__res_xhigh_po w=10 l=49.614382
XRinv2ibp1s1 Rinv2ibt1s0 Rinv2ibt1s1 0 sky130_fd_pr__res_xhigh_po w=10 l=49.614382
XRinv2ibp1s2 Rinv2ibt1s1 Rinv2ibt1s2 0 sky130_fd_pr__res_xhigh_po w=10 l=49.614382
XRinv2ibp1s3 Rinv2ibt1s2 Rinv2ibt1s3 0 sky130_fd_pr__res_xhigh_po w=10 l=49.614382
XRinv2ibp1s4 Rinv2ibt1s3 Rinv2ibt1s4 0 sky130_fd_pr__res_xhigh_po w=10 l=49.614382
XRinv2ibp1s5 Rinv2ibt1s4 Rinv2ibt1s5 0 sky130_fd_pr__res_xhigh_po w=10 l=49.614382
XRinv2ibp1s6 Rinv2ibt1s5 Rinv2ibt1s6 0 sky130_fd_pr__res_xhigh_po w=10 l=49.614382
XRinv2ibp1s7 Rinv2ibt1s6 inv2m 0 sky130_fd_pr__res_xhigh_po w=10 l=49.614382
XRinv2ibp2s0 in2n Rinv2ibt2s0 0 sky130_fd_pr__res_xhigh_po w=10 l=49.614382
XRinv2ibp2s1 Rinv2ibt2s0 Rinv2ibt2s1 0 sky130_fd_pr__res_xhigh_po w=10 l=49.614382
XRinv2ibp2s2 Rinv2ibt2s1 Rinv2ibt2s2 0 sky130_fd_pr__res_xhigh_po w=10 l=49.614382
XRinv2ibp2s3 Rinv2ibt2s2 Rinv2ibt2s3 0 sky130_fd_pr__res_xhigh_po w=10 l=49.614382
XRinv2ibp2s4 Rinv2ibt2s3 Rinv2ibt2s4 0 sky130_fd_pr__res_xhigh_po w=10 l=49.614382
XRinv2ibp2s5 Rinv2ibt2s4 Rinv2ibt2s5 0 sky130_fd_pr__res_xhigh_po w=10 l=49.614382
XRinv2ibp2s6 Rinv2ibt2s5 Rinv2ibt2s6 0 sky130_fd_pr__res_xhigh_po w=10 l=49.614382
XRinv2ibp2s7 Rinv2ibt2s6 inv2m 0 sky130_fd_pr__res_xhigh_po w=10 l=49.614382
XRinv2ibp3s0 in2n Rinv2ibt3s0 0 sky130_fd_pr__res_xhigh_po w=10 l=49.614382
XRinv2ibp3s1 Rinv2ibt3s0 Rinv2ibt3s1 0 sky130_fd_pr__res_xhigh_po w=10 l=49.614382
XRinv2ibp3s2 Rinv2ibt3s1 Rinv2ibt3s2 0 sky130_fd_pr__res_xhigh_po w=10 l=49.614382
XRinv2ibp3s3 Rinv2ibt3s2 Rinv2ibt3s3 0 sky130_fd_pr__res_xhigh_po w=10 l=49.614382
XRinv2ibp3s4 Rinv2ibt3s3 Rinv2ibt3s4 0 sky130_fd_pr__res_xhigh_po w=10 l=49.614382
XRinv2ibp3s5 Rinv2ibt3s4 Rinv2ibt3s5 0 sky130_fd_pr__res_xhigh_po w=10 l=49.614382
XRinv2ibp3s6 Rinv2ibt3s5 Rinv2ibt3s6 0 sky130_fd_pr__res_xhigh_po w=10 l=49.614382
XRinv2ibp3s7 Rinv2ibt3s6 inv2m 0 sky130_fd_pr__res_xhigh_po w=10 l=49.614382
XRinv2ibp4s0 in2n Rinv2ibt4s0 0 sky130_fd_pr__res_xhigh_po w=10 l=49.614382
XRinv2ibp4s1 Rinv2ibt4s0 Rinv2ibt4s1 0 sky130_fd_pr__res_xhigh_po w=10 l=49.614382
XRinv2ibp4s2 Rinv2ibt4s1 Rinv2ibt4s2 0 sky130_fd_pr__res_xhigh_po w=10 l=49.614382
XRinv2ibp4s3 Rinv2ibt4s2 Rinv2ibt4s3 0 sky130_fd_pr__res_xhigh_po w=10 l=49.614382
XRinv2ibp4s4 Rinv2ibt4s3 Rinv2ibt4s4 0 sky130_fd_pr__res_xhigh_po w=10 l=49.614382
XRinv2ibp4s5 Rinv2ibt4s4 Rinv2ibt4s5 0 sky130_fd_pr__res_xhigh_po w=10 l=49.614382
XRinv2ibp4s6 Rinv2ibt4s5 Rinv2ibt4s6 0 sky130_fd_pr__res_xhigh_po w=10 l=49.614382
XRinv2ibp4s7 Rinv2ibt4s6 inv2m 0 sky130_fd_pr__res_xhigh_po w=10 l=49.614382
XRinv2ibp5s0 in2n Rinv2ibt5s0 0 sky130_fd_pr__res_xhigh_po w=10 l=49.614382
XRinv2ibp5s1 Rinv2ibt5s0 Rinv2ibt5s1 0 sky130_fd_pr__res_xhigh_po w=10 l=49.614382
XRinv2ibp5s2 Rinv2ibt5s1 Rinv2ibt5s2 0 sky130_fd_pr__res_xhigh_po w=10 l=49.614382
XRinv2ibp5s3 Rinv2ibt5s2 Rinv2ibt5s3 0 sky130_fd_pr__res_xhigh_po w=10 l=49.614382
XRinv2ibp5s4 Rinv2ibt5s3 Rinv2ibt5s4 0 sky130_fd_pr__res_xhigh_po w=10 l=49.614382
XRinv2ibp5s5 Rinv2ibt5s4 Rinv2ibt5s5 0 sky130_fd_pr__res_xhigh_po w=10 l=49.614382
XRinv2ibp5s6 Rinv2ibt5s5 Rinv2ibt5s6 0 sky130_fd_pr__res_xhigh_po w=10 l=49.614382
XRinv2ibp5s7 Rinv2ibt5s6 inv2m 0 sky130_fd_pr__res_xhigh_po w=10 l=49.614382
XRinv2ibp6s0 in2n Rinv2ibt6s0 0 sky130_fd_pr__res_xhigh_po w=10 l=49.614382
XRinv2ibp6s1 Rinv2ibt6s0 Rinv2ibt6s1 0 sky130_fd_pr__res_xhigh_po w=10 l=49.614382
XRinv2ibp6s2 Rinv2ibt6s1 Rinv2ibt6s2 0 sky130_fd_pr__res_xhigh_po w=10 l=49.614382
XRinv2ibp6s3 Rinv2ibt6s2 Rinv2ibt6s3 0 sky130_fd_pr__res_xhigh_po w=10 l=49.614382
XRinv2ibp6s4 Rinv2ibt6s3 Rinv2ibt6s4 0 sky130_fd_pr__res_xhigh_po w=10 l=49.614382
XRinv2ibp6s5 Rinv2ibt6s4 Rinv2ibt6s5 0 sky130_fd_pr__res_xhigh_po w=10 l=49.614382
XRinv2ibp6s6 Rinv2ibt6s5 Rinv2ibt6s6 0 sky130_fd_pr__res_xhigh_po w=10 l=49.614382
XRinv2ibp6s7 Rinv2ibt6s6 inv2m 0 sky130_fd_pr__res_xhigh_po w=10 l=49.614382
XRinv2ibp7s0 in2n Rinv2ibt7s0 0 sky130_fd_pr__res_xhigh_po w=10 l=49.614382
XRinv2ibp7s1 Rinv2ibt7s0 Rinv2ibt7s1 0 sky130_fd_pr__res_xhigh_po w=10 l=49.614382
XRinv2ibp7s2 Rinv2ibt7s1 Rinv2ibt7s2 0 sky130_fd_pr__res_xhigh_po w=10 l=49.614382
XRinv2ibp7s3 Rinv2ibt7s2 Rinv2ibt7s3 0 sky130_fd_pr__res_xhigh_po w=10 l=49.614382
XRinv2ibp7s4 Rinv2ibt7s3 Rinv2ibt7s4 0 sky130_fd_pr__res_xhigh_po w=10 l=49.614382
XRinv2ibp7s5 Rinv2ibt7s4 Rinv2ibt7s5 0 sky130_fd_pr__res_xhigh_po w=10 l=49.614382
XRinv2ibp7s6 Rinv2ibt7s5 Rinv2ibt7s6 0 sky130_fd_pr__res_xhigh_po w=10 l=49.614382
XRinv2ibp7s7 Rinv2ibt7s6 inv2m 0 sky130_fd_pr__res_xhigh_po w=10 l=49.614382
Einv2amp in2n 0 0 inv2m 10000000
Vin3 in3 0 DC 1.14933536319878
* passive invert in3 -> in3n: R2/R1=1.0000002 closed-loop -1 at A=1e+07
* PDK sky130_fd_pr__res_xhigh_po Rinv3ia W=10 L=49.614372
* tile Rinv3ia 8s x 8p same W=10 L=49.614372
XRinv3iap0s0 in3 Rinv3iat0s0 0 sky130_fd_pr__res_xhigh_po w=10 l=49.614372
XRinv3iap0s1 Rinv3iat0s0 Rinv3iat0s1 0 sky130_fd_pr__res_xhigh_po w=10 l=49.614372
XRinv3iap0s2 Rinv3iat0s1 Rinv3iat0s2 0 sky130_fd_pr__res_xhigh_po w=10 l=49.614372
XRinv3iap0s3 Rinv3iat0s2 Rinv3iat0s3 0 sky130_fd_pr__res_xhigh_po w=10 l=49.614372
XRinv3iap0s4 Rinv3iat0s3 Rinv3iat0s4 0 sky130_fd_pr__res_xhigh_po w=10 l=49.614372
XRinv3iap0s5 Rinv3iat0s4 Rinv3iat0s5 0 sky130_fd_pr__res_xhigh_po w=10 l=49.614372
XRinv3iap0s6 Rinv3iat0s5 Rinv3iat0s6 0 sky130_fd_pr__res_xhigh_po w=10 l=49.614372
XRinv3iap0s7 Rinv3iat0s6 inv3m 0 sky130_fd_pr__res_xhigh_po w=10 l=49.614372
XRinv3iap1s0 in3 Rinv3iat1s0 0 sky130_fd_pr__res_xhigh_po w=10 l=49.614372
XRinv3iap1s1 Rinv3iat1s0 Rinv3iat1s1 0 sky130_fd_pr__res_xhigh_po w=10 l=49.614372
XRinv3iap1s2 Rinv3iat1s1 Rinv3iat1s2 0 sky130_fd_pr__res_xhigh_po w=10 l=49.614372
XRinv3iap1s3 Rinv3iat1s2 Rinv3iat1s3 0 sky130_fd_pr__res_xhigh_po w=10 l=49.614372
XRinv3iap1s4 Rinv3iat1s3 Rinv3iat1s4 0 sky130_fd_pr__res_xhigh_po w=10 l=49.614372
XRinv3iap1s5 Rinv3iat1s4 Rinv3iat1s5 0 sky130_fd_pr__res_xhigh_po w=10 l=49.614372
XRinv3iap1s6 Rinv3iat1s5 Rinv3iat1s6 0 sky130_fd_pr__res_xhigh_po w=10 l=49.614372
XRinv3iap1s7 Rinv3iat1s6 inv3m 0 sky130_fd_pr__res_xhigh_po w=10 l=49.614372
XRinv3iap2s0 in3 Rinv3iat2s0 0 sky130_fd_pr__res_xhigh_po w=10 l=49.614372
XRinv3iap2s1 Rinv3iat2s0 Rinv3iat2s1 0 sky130_fd_pr__res_xhigh_po w=10 l=49.614372
XRinv3iap2s2 Rinv3iat2s1 Rinv3iat2s2 0 sky130_fd_pr__res_xhigh_po w=10 l=49.614372
XRinv3iap2s3 Rinv3iat2s2 Rinv3iat2s3 0 sky130_fd_pr__res_xhigh_po w=10 l=49.614372
XRinv3iap2s4 Rinv3iat2s3 Rinv3iat2s4 0 sky130_fd_pr__res_xhigh_po w=10 l=49.614372
XRinv3iap2s5 Rinv3iat2s4 Rinv3iat2s5 0 sky130_fd_pr__res_xhigh_po w=10 l=49.614372
XRinv3iap2s6 Rinv3iat2s5 Rinv3iat2s6 0 sky130_fd_pr__res_xhigh_po w=10 l=49.614372
XRinv3iap2s7 Rinv3iat2s6 inv3m 0 sky130_fd_pr__res_xhigh_po w=10 l=49.614372
XRinv3iap3s0 in3 Rinv3iat3s0 0 sky130_fd_pr__res_xhigh_po w=10 l=49.614372
XRinv3iap3s1 Rinv3iat3s0 Rinv3iat3s1 0 sky130_fd_pr__res_xhigh_po w=10 l=49.614372
XRinv3iap3s2 Rinv3iat3s1 Rinv3iat3s2 0 sky130_fd_pr__res_xhigh_po w=10 l=49.614372
XRinv3iap3s3 Rinv3iat3s2 Rinv3iat3s3 0 sky130_fd_pr__res_xhigh_po w=10 l=49.614372
XRinv3iap3s4 Rinv3iat3s3 Rinv3iat3s4 0 sky130_fd_pr__res_xhigh_po w=10 l=49.614372
XRinv3iap3s5 Rinv3iat3s4 Rinv3iat3s5 0 sky130_fd_pr__res_xhigh_po w=10 l=49.614372
XRinv3iap3s6 Rinv3iat3s5 Rinv3iat3s6 0 sky130_fd_pr__res_xhigh_po w=10 l=49.614372
XRinv3iap3s7 Rinv3iat3s6 inv3m 0 sky130_fd_pr__res_xhigh_po w=10 l=49.614372
XRinv3iap4s0 in3 Rinv3iat4s0 0 sky130_fd_pr__res_xhigh_po w=10 l=49.614372
XRinv3iap4s1 Rinv3iat4s0 Rinv3iat4s1 0 sky130_fd_pr__res_xhigh_po w=10 l=49.614372
XRinv3iap4s2 Rinv3iat4s1 Rinv3iat4s2 0 sky130_fd_pr__res_xhigh_po w=10 l=49.614372
XRinv3iap4s3 Rinv3iat4s2 Rinv3iat4s3 0 sky130_fd_pr__res_xhigh_po w=10 l=49.614372
XRinv3iap4s4 Rinv3iat4s3 Rinv3iat4s4 0 sky130_fd_pr__res_xhigh_po w=10 l=49.614372
XRinv3iap4s5 Rinv3iat4s4 Rinv3iat4s5 0 sky130_fd_pr__res_xhigh_po w=10 l=49.614372
XRinv3iap4s6 Rinv3iat4s5 Rinv3iat4s6 0 sky130_fd_pr__res_xhigh_po w=10 l=49.614372
XRinv3iap4s7 Rinv3iat4s6 inv3m 0 sky130_fd_pr__res_xhigh_po w=10 l=49.614372
XRinv3iap5s0 in3 Rinv3iat5s0 0 sky130_fd_pr__res_xhigh_po w=10 l=49.614372
XRinv3iap5s1 Rinv3iat5s0 Rinv3iat5s1 0 sky130_fd_pr__res_xhigh_po w=10 l=49.614372
XRinv3iap5s2 Rinv3iat5s1 Rinv3iat5s2 0 sky130_fd_pr__res_xhigh_po w=10 l=49.614372
XRinv3iap5s3 Rinv3iat5s2 Rinv3iat5s3 0 sky130_fd_pr__res_xhigh_po w=10 l=49.614372
XRinv3iap5s4 Rinv3iat5s3 Rinv3iat5s4 0 sky130_fd_pr__res_xhigh_po w=10 l=49.614372
XRinv3iap5s5 Rinv3iat5s4 Rinv3iat5s5 0 sky130_fd_pr__res_xhigh_po w=10 l=49.614372
XRinv3iap5s6 Rinv3iat5s5 Rinv3iat5s6 0 sky130_fd_pr__res_xhigh_po w=10 l=49.614372
XRinv3iap5s7 Rinv3iat5s6 inv3m 0 sky130_fd_pr__res_xhigh_po w=10 l=49.614372
XRinv3iap6s0 in3 Rinv3iat6s0 0 sky130_fd_pr__res_xhigh_po w=10 l=49.614372
XRinv3iap6s1 Rinv3iat6s0 Rinv3iat6s1 0 sky130_fd_pr__res_xhigh_po w=10 l=49.614372
XRinv3iap6s2 Rinv3iat6s1 Rinv3iat6s2 0 sky130_fd_pr__res_xhigh_po w=10 l=49.614372
XRinv3iap6s3 Rinv3iat6s2 Rinv3iat6s3 0 sky130_fd_pr__res_xhigh_po w=10 l=49.614372
XRinv3iap6s4 Rinv3iat6s3 Rinv3iat6s4 0 sky130_fd_pr__res_xhigh_po w=10 l=49.614372
XRinv3iap6s5 Rinv3iat6s4 Rinv3iat6s5 0 sky130_fd_pr__res_xhigh_po w=10 l=49.614372
XRinv3iap6s6 Rinv3iat6s5 Rinv3iat6s6 0 sky130_fd_pr__res_xhigh_po w=10 l=49.614372
XRinv3iap6s7 Rinv3iat6s6 inv3m 0 sky130_fd_pr__res_xhigh_po w=10 l=49.614372
XRinv3iap7s0 in3 Rinv3iat7s0 0 sky130_fd_pr__res_xhigh_po w=10 l=49.614372
XRinv3iap7s1 Rinv3iat7s0 Rinv3iat7s1 0 sky130_fd_pr__res_xhigh_po w=10 l=49.614372
XRinv3iap7s2 Rinv3iat7s1 Rinv3iat7s2 0 sky130_fd_pr__res_xhigh_po w=10 l=49.614372
XRinv3iap7s3 Rinv3iat7s2 Rinv3iat7s3 0 sky130_fd_pr__res_xhigh_po w=10 l=49.614372
XRinv3iap7s4 Rinv3iat7s3 Rinv3iat7s4 0 sky130_fd_pr__res_xhigh_po w=10 l=49.614372
XRinv3iap7s5 Rinv3iat7s4 Rinv3iat7s5 0 sky130_fd_pr__res_xhigh_po w=10 l=49.614372
XRinv3iap7s6 Rinv3iat7s5 Rinv3iat7s6 0 sky130_fd_pr__res_xhigh_po w=10 l=49.614372
XRinv3iap7s7 Rinv3iat7s6 inv3m 0 sky130_fd_pr__res_xhigh_po w=10 l=49.614372
* PDK sky130_fd_pr__res_xhigh_po Rinv3ib W=10 L=49.614382
* tile Rinv3ib 8s x 8p same W=10 L=49.614382
XRinv3ibp0s0 in3n Rinv3ibt0s0 0 sky130_fd_pr__res_xhigh_po w=10 l=49.614382
XRinv3ibp0s1 Rinv3ibt0s0 Rinv3ibt0s1 0 sky130_fd_pr__res_xhigh_po w=10 l=49.614382
XRinv3ibp0s2 Rinv3ibt0s1 Rinv3ibt0s2 0 sky130_fd_pr__res_xhigh_po w=10 l=49.614382
XRinv3ibp0s3 Rinv3ibt0s2 Rinv3ibt0s3 0 sky130_fd_pr__res_xhigh_po w=10 l=49.614382
XRinv3ibp0s4 Rinv3ibt0s3 Rinv3ibt0s4 0 sky130_fd_pr__res_xhigh_po w=10 l=49.614382
XRinv3ibp0s5 Rinv3ibt0s4 Rinv3ibt0s5 0 sky130_fd_pr__res_xhigh_po w=10 l=49.614382
XRinv3ibp0s6 Rinv3ibt0s5 Rinv3ibt0s6 0 sky130_fd_pr__res_xhigh_po w=10 l=49.614382
XRinv3ibp0s7 Rinv3ibt0s6 inv3m 0 sky130_fd_pr__res_xhigh_po w=10 l=49.614382
XRinv3ibp1s0 in3n Rinv3ibt1s0 0 sky130_fd_pr__res_xhigh_po w=10 l=49.614382
XRinv3ibp1s1 Rinv3ibt1s0 Rinv3ibt1s1 0 sky130_fd_pr__res_xhigh_po w=10 l=49.614382
XRinv3ibp1s2 Rinv3ibt1s1 Rinv3ibt1s2 0 sky130_fd_pr__res_xhigh_po w=10 l=49.614382
XRinv3ibp1s3 Rinv3ibt1s2 Rinv3ibt1s3 0 sky130_fd_pr__res_xhigh_po w=10 l=49.614382
XRinv3ibp1s4 Rinv3ibt1s3 Rinv3ibt1s4 0 sky130_fd_pr__res_xhigh_po w=10 l=49.614382
XRinv3ibp1s5 Rinv3ibt1s4 Rinv3ibt1s5 0 sky130_fd_pr__res_xhigh_po w=10 l=49.614382
XRinv3ibp1s6 Rinv3ibt1s5 Rinv3ibt1s6 0 sky130_fd_pr__res_xhigh_po w=10 l=49.614382
XRinv3ibp1s7 Rinv3ibt1s6 inv3m 0 sky130_fd_pr__res_xhigh_po w=10 l=49.614382
XRinv3ibp2s0 in3n Rinv3ibt2s0 0 sky130_fd_pr__res_xhigh_po w=10 l=49.614382
XRinv3ibp2s1 Rinv3ibt2s0 Rinv3ibt2s1 0 sky130_fd_pr__res_xhigh_po w=10 l=49.614382
XRinv3ibp2s2 Rinv3ibt2s1 Rinv3ibt2s2 0 sky130_fd_pr__res_xhigh_po w=10 l=49.614382
XRinv3ibp2s3 Rinv3ibt2s2 Rinv3ibt2s3 0 sky130_fd_pr__res_xhigh_po w=10 l=49.614382
XRinv3ibp2s4 Rinv3ibt2s3 Rinv3ibt2s4 0 sky130_fd_pr__res_xhigh_po w=10 l=49.614382
XRinv3ibp2s5 Rinv3ibt2s4 Rinv3ibt2s5 0 sky130_fd_pr__res_xhigh_po w=10 l=49.614382
XRinv3ibp2s6 Rinv3ibt2s5 Rinv3ibt2s6 0 sky130_fd_pr__res_xhigh_po w=10 l=49.614382
XRinv3ibp2s7 Rinv3ibt2s6 inv3m 0 sky130_fd_pr__res_xhigh_po w=10 l=49.614382
XRinv3ibp3s0 in3n Rinv3ibt3s0 0 sky130_fd_pr__res_xhigh_po w=10 l=49.614382
XRinv3ibp3s1 Rinv3ibt3s0 Rinv3ibt3s1 0 sky130_fd_pr__res_xhigh_po w=10 l=49.614382
XRinv3ibp3s2 Rinv3ibt3s1 Rinv3ibt3s2 0 sky130_fd_pr__res_xhigh_po w=10 l=49.614382
XRinv3ibp3s3 Rinv3ibt3s2 Rinv3ibt3s3 0 sky130_fd_pr__res_xhigh_po w=10 l=49.614382
XRinv3ibp3s4 Rinv3ibt3s3 Rinv3ibt3s4 0 sky130_fd_pr__res_xhigh_po w=10 l=49.614382
XRinv3ibp3s5 Rinv3ibt3s4 Rinv3ibt3s5 0 sky130_fd_pr__res_xhigh_po w=10 l=49.614382
XRinv3ibp3s6 Rinv3ibt3s5 Rinv3ibt3s6 0 sky130_fd_pr__res_xhigh_po w=10 l=49.614382
XRinv3ibp3s7 Rinv3ibt3s6 inv3m 0 sky130_fd_pr__res_xhigh_po w=10 l=49.614382
XRinv3ibp4s0 in3n Rinv3ibt4s0 0 sky130_fd_pr__res_xhigh_po w=10 l=49.614382
XRinv3ibp4s1 Rinv3ibt4s0 Rinv3ibt4s1 0 sky130_fd_pr__res_xhigh_po w=10 l=49.614382
XRinv3ibp4s2 Rinv3ibt4s1 Rinv3ibt4s2 0 sky130_fd_pr__res_xhigh_po w=10 l=49.614382
XRinv3ibp4s3 Rinv3ibt4s2 Rinv3ibt4s3 0 sky130_fd_pr__res_xhigh_po w=10 l=49.614382
XRinv3ibp4s4 Rinv3ibt4s3 Rinv3ibt4s4 0 sky130_fd_pr__res_xhigh_po w=10 l=49.614382
XRinv3ibp4s5 Rinv3ibt4s4 Rinv3ibt4s5 0 sky130_fd_pr__res_xhigh_po w=10 l=49.614382
XRinv3ibp4s6 Rinv3ibt4s5 Rinv3ibt4s6 0 sky130_fd_pr__res_xhigh_po w=10 l=49.614382
XRinv3ibp4s7 Rinv3ibt4s6 inv3m 0 sky130_fd_pr__res_xhigh_po w=10 l=49.614382
XRinv3ibp5s0 in3n Rinv3ibt5s0 0 sky130_fd_pr__res_xhigh_po w=10 l=49.614382
XRinv3ibp5s1 Rinv3ibt5s0 Rinv3ibt5s1 0 sky130_fd_pr__res_xhigh_po w=10 l=49.614382
XRinv3ibp5s2 Rinv3ibt5s1 Rinv3ibt5s2 0 sky130_fd_pr__res_xhigh_po w=10 l=49.614382
XRinv3ibp5s3 Rinv3ibt5s2 Rinv3ibt5s3 0 sky130_fd_pr__res_xhigh_po w=10 l=49.614382
XRinv3ibp5s4 Rinv3ibt5s3 Rinv3ibt5s4 0 sky130_fd_pr__res_xhigh_po w=10 l=49.614382
XRinv3ibp5s5 Rinv3ibt5s4 Rinv3ibt5s5 0 sky130_fd_pr__res_xhigh_po w=10 l=49.614382
XRinv3ibp5s6 Rinv3ibt5s5 Rinv3ibt5s6 0 sky130_fd_pr__res_xhigh_po w=10 l=49.614382
XRinv3ibp5s7 Rinv3ibt5s6 inv3m 0 sky130_fd_pr__res_xhigh_po w=10 l=49.614382
XRinv3ibp6s0 in3n Rinv3ibt6s0 0 sky130_fd_pr__res_xhigh_po w=10 l=49.614382
XRinv3ibp6s1 Rinv3ibt6s0 Rinv3ibt6s1 0 sky130_fd_pr__res_xhigh_po w=10 l=49.614382
XRinv3ibp6s2 Rinv3ibt6s1 Rinv3ibt6s2 0 sky130_fd_pr__res_xhigh_po w=10 l=49.614382
XRinv3ibp6s3 Rinv3ibt6s2 Rinv3ibt6s3 0 sky130_fd_pr__res_xhigh_po w=10 l=49.614382
XRinv3ibp6s4 Rinv3ibt6s3 Rinv3ibt6s4 0 sky130_fd_pr__res_xhigh_po w=10 l=49.614382
XRinv3ibp6s5 Rinv3ibt6s4 Rinv3ibt6s5 0 sky130_fd_pr__res_xhigh_po w=10 l=49.614382
XRinv3ibp6s6 Rinv3ibt6s5 Rinv3ibt6s6 0 sky130_fd_pr__res_xhigh_po w=10 l=49.614382
XRinv3ibp6s7 Rinv3ibt6s6 inv3m 0 sky130_fd_pr__res_xhigh_po w=10 l=49.614382
XRinv3ibp7s0 in3n Rinv3ibt7s0 0 sky130_fd_pr__res_xhigh_po w=10 l=49.614382
XRinv3ibp7s1 Rinv3ibt7s0 Rinv3ibt7s1 0 sky130_fd_pr__res_xhigh_po w=10 l=49.614382
XRinv3ibp7s2 Rinv3ibt7s1 Rinv3ibt7s2 0 sky130_fd_pr__res_xhigh_po w=10 l=49.614382
XRinv3ibp7s3 Rinv3ibt7s2 Rinv3ibt7s3 0 sky130_fd_pr__res_xhigh_po w=10 l=49.614382
XRinv3ibp7s4 Rinv3ibt7s3 Rinv3ibt7s4 0 sky130_fd_pr__res_xhigh_po w=10 l=49.614382
XRinv3ibp7s5 Rinv3ibt7s4 Rinv3ibt7s5 0 sky130_fd_pr__res_xhigh_po w=10 l=49.614382
XRinv3ibp7s6 Rinv3ibt7s5 Rinv3ibt7s6 0 sky130_fd_pr__res_xhigh_po w=10 l=49.614382
XRinv3ibp7s7 Rinv3ibt7s6 inv3m 0 sky130_fd_pr__res_xhigh_po w=10 l=49.614382
Einv3amp in3n 0 0 inv3m 10000000
Vin4 in4 0 DC 0
Vin5 in5 0 DC 1.37476380462716
* passive invert in5 -> in5n: R2/R1=1.0000002 closed-loop -1 at A=1e+07
* PDK sky130_fd_pr__res_xhigh_po Rinv5ia W=10 L=49.614372
* tile Rinv5ia 8s x 8p same W=10 L=49.614372
XRinv5iap0s0 in5 Rinv5iat0s0 0 sky130_fd_pr__res_xhigh_po w=10 l=49.614372
XRinv5iap0s1 Rinv5iat0s0 Rinv5iat0s1 0 sky130_fd_pr__res_xhigh_po w=10 l=49.614372
XRinv5iap0s2 Rinv5iat0s1 Rinv5iat0s2 0 sky130_fd_pr__res_xhigh_po w=10 l=49.614372
XRinv5iap0s3 Rinv5iat0s2 Rinv5iat0s3 0 sky130_fd_pr__res_xhigh_po w=10 l=49.614372
XRinv5iap0s4 Rinv5iat0s3 Rinv5iat0s4 0 sky130_fd_pr__res_xhigh_po w=10 l=49.614372
XRinv5iap0s5 Rinv5iat0s4 Rinv5iat0s5 0 sky130_fd_pr__res_xhigh_po w=10 l=49.614372
XRinv5iap0s6 Rinv5iat0s5 Rinv5iat0s6 0 sky130_fd_pr__res_xhigh_po w=10 l=49.614372
XRinv5iap0s7 Rinv5iat0s6 inv5m 0 sky130_fd_pr__res_xhigh_po w=10 l=49.614372
XRinv5iap1s0 in5 Rinv5iat1s0 0 sky130_fd_pr__res_xhigh_po w=10 l=49.614372
XRinv5iap1s1 Rinv5iat1s0 Rinv5iat1s1 0 sky130_fd_pr__res_xhigh_po w=10 l=49.614372
XRinv5iap1s2 Rinv5iat1s1 Rinv5iat1s2 0 sky130_fd_pr__res_xhigh_po w=10 l=49.614372
XRinv5iap1s3 Rinv5iat1s2 Rinv5iat1s3 0 sky130_fd_pr__res_xhigh_po w=10 l=49.614372
XRinv5iap1s4 Rinv5iat1s3 Rinv5iat1s4 0 sky130_fd_pr__res_xhigh_po w=10 l=49.614372
XRinv5iap1s5 Rinv5iat1s4 Rinv5iat1s5 0 sky130_fd_pr__res_xhigh_po w=10 l=49.614372
XRinv5iap1s6 Rinv5iat1s5 Rinv5iat1s6 0 sky130_fd_pr__res_xhigh_po w=10 l=49.614372
XRinv5iap1s7 Rinv5iat1s6 inv5m 0 sky130_fd_pr__res_xhigh_po w=10 l=49.614372
XRinv5iap2s0 in5 Rinv5iat2s0 0 sky130_fd_pr__res_xhigh_po w=10 l=49.614372
XRinv5iap2s1 Rinv5iat2s0 Rinv5iat2s1 0 sky130_fd_pr__res_xhigh_po w=10 l=49.614372
XRinv5iap2s2 Rinv5iat2s1 Rinv5iat2s2 0 sky130_fd_pr__res_xhigh_po w=10 l=49.614372
XRinv5iap2s3 Rinv5iat2s2 Rinv5iat2s3 0 sky130_fd_pr__res_xhigh_po w=10 l=49.614372
XRinv5iap2s4 Rinv5iat2s3 Rinv5iat2s4 0 sky130_fd_pr__res_xhigh_po w=10 l=49.614372
XRinv5iap2s5 Rinv5iat2s4 Rinv5iat2s5 0 sky130_fd_pr__res_xhigh_po w=10 l=49.614372
XRinv5iap2s6 Rinv5iat2s5 Rinv5iat2s6 0 sky130_fd_pr__res_xhigh_po w=10 l=49.614372
XRinv5iap2s7 Rinv5iat2s6 inv5m 0 sky130_fd_pr__res_xhigh_po w=10 l=49.614372
XRinv5iap3s0 in5 Rinv5iat3s0 0 sky130_fd_pr__res_xhigh_po w=10 l=49.614372
XRinv5iap3s1 Rinv5iat3s0 Rinv5iat3s1 0 sky130_fd_pr__res_xhigh_po w=10 l=49.614372
XRinv5iap3s2 Rinv5iat3s1 Rinv5iat3s2 0 sky130_fd_pr__res_xhigh_po w=10 l=49.614372
XRinv5iap3s3 Rinv5iat3s2 Rinv5iat3s3 0 sky130_fd_pr__res_xhigh_po w=10 l=49.614372
XRinv5iap3s4 Rinv5iat3s3 Rinv5iat3s4 0 sky130_fd_pr__res_xhigh_po w=10 l=49.614372
XRinv5iap3s5 Rinv5iat3s4 Rinv5iat3s5 0 sky130_fd_pr__res_xhigh_po w=10 l=49.614372
XRinv5iap3s6 Rinv5iat3s5 Rinv5iat3s6 0 sky130_fd_pr__res_xhigh_po w=10 l=49.614372
XRinv5iap3s7 Rinv5iat3s6 inv5m 0 sky130_fd_pr__res_xhigh_po w=10 l=49.614372
XRinv5iap4s0 in5 Rinv5iat4s0 0 sky130_fd_pr__res_xhigh_po w=10 l=49.614372
XRinv5iap4s1 Rinv5iat4s0 Rinv5iat4s1 0 sky130_fd_pr__res_xhigh_po w=10 l=49.614372
XRinv5iap4s2 Rinv5iat4s1 Rinv5iat4s2 0 sky130_fd_pr__res_xhigh_po w=10 l=49.614372
XRinv5iap4s3 Rinv5iat4s2 Rinv5iat4s3 0 sky130_fd_pr__res_xhigh_po w=10 l=49.614372
XRinv5iap4s4 Rinv5iat4s3 Rinv5iat4s4 0 sky130_fd_pr__res_xhigh_po w=10 l=49.614372
XRinv5iap4s5 Rinv5iat4s4 Rinv5iat4s5 0 sky130_fd_pr__res_xhigh_po w=10 l=49.614372
XRinv5iap4s6 Rinv5iat4s5 Rinv5iat4s6 0 sky130_fd_pr__res_xhigh_po w=10 l=49.614372
XRinv5iap4s7 Rinv5iat4s6 inv5m 0 sky130_fd_pr__res_xhigh_po w=10 l=49.614372
XRinv5iap5s0 in5 Rinv5iat5s0 0 sky130_fd_pr__res_xhigh_po w=10 l=49.614372
XRinv5iap5s1 Rinv5iat5s0 Rinv5iat5s1 0 sky130_fd_pr__res_xhigh_po w=10 l=49.614372
XRinv5iap5s2 Rinv5iat5s1 Rinv5iat5s2 0 sky130_fd_pr__res_xhigh_po w=10 l=49.614372
XRinv5iap5s3 Rinv5iat5s2 Rinv5iat5s3 0 sky130_fd_pr__res_xhigh_po w=10 l=49.614372
XRinv5iap5s4 Rinv5iat5s3 Rinv5iat5s4 0 sky130_fd_pr__res_xhigh_po w=10 l=49.614372
XRinv5iap5s5 Rinv5iat5s4 Rinv5iat5s5 0 sky130_fd_pr__res_xhigh_po w=10 l=49.614372
XRinv5iap5s6 Rinv5iat5s5 Rinv5iat5s6 0 sky130_fd_pr__res_xhigh_po w=10 l=49.614372
XRinv5iap5s7 Rinv5iat5s6 inv5m 0 sky130_fd_pr__res_xhigh_po w=10 l=49.614372
XRinv5iap6s0 in5 Rinv5iat6s0 0 sky130_fd_pr__res_xhigh_po w=10 l=49.614372
XRinv5iap6s1 Rinv5iat6s0 Rinv5iat6s1 0 sky130_fd_pr__res_xhigh_po w=10 l=49.614372
XRinv5iap6s2 Rinv5iat6s1 Rinv5iat6s2 0 sky130_fd_pr__res_xhigh_po w=10 l=49.614372
XRinv5iap6s3 Rinv5iat6s2 Rinv5iat6s3 0 sky130_fd_pr__res_xhigh_po w=10 l=49.614372
XRinv5iap6s4 Rinv5iat6s3 Rinv5iat6s4 0 sky130_fd_pr__res_xhigh_po w=10 l=49.614372
XRinv5iap6s5 Rinv5iat6s4 Rinv5iat6s5 0 sky130_fd_pr__res_xhigh_po w=10 l=49.614372
XRinv5iap6s6 Rinv5iat6s5 Rinv5iat6s6 0 sky130_fd_pr__res_xhigh_po w=10 l=49.614372
XRinv5iap6s7 Rinv5iat6s6 inv5m 0 sky130_fd_pr__res_xhigh_po w=10 l=49.614372
XRinv5iap7s0 in5 Rinv5iat7s0 0 sky130_fd_pr__res_xhigh_po w=10 l=49.614372
XRinv5iap7s1 Rinv5iat7s0 Rinv5iat7s1 0 sky130_fd_pr__res_xhigh_po w=10 l=49.614372
XRinv5iap7s2 Rinv5iat7s1 Rinv5iat7s2 0 sky130_fd_pr__res_xhigh_po w=10 l=49.614372
XRinv5iap7s3 Rinv5iat7s2 Rinv5iat7s3 0 sky130_fd_pr__res_xhigh_po w=10 l=49.614372
XRinv5iap7s4 Rinv5iat7s3 Rinv5iat7s4 0 sky130_fd_pr__res_xhigh_po w=10 l=49.614372
XRinv5iap7s5 Rinv5iat7s4 Rinv5iat7s5 0 sky130_fd_pr__res_xhigh_po w=10 l=49.614372
XRinv5iap7s6 Rinv5iat7s5 Rinv5iat7s6 0 sky130_fd_pr__res_xhigh_po w=10 l=49.614372
XRinv5iap7s7 Rinv5iat7s6 inv5m 0 sky130_fd_pr__res_xhigh_po w=10 l=49.614372
* PDK sky130_fd_pr__res_xhigh_po Rinv5ib W=10 L=49.614382
* tile Rinv5ib 8s x 8p same W=10 L=49.614382
XRinv5ibp0s0 in5n Rinv5ibt0s0 0 sky130_fd_pr__res_xhigh_po w=10 l=49.614382
XRinv5ibp0s1 Rinv5ibt0s0 Rinv5ibt0s1 0 sky130_fd_pr__res_xhigh_po w=10 l=49.614382
XRinv5ibp0s2 Rinv5ibt0s1 Rinv5ibt0s2 0 sky130_fd_pr__res_xhigh_po w=10 l=49.614382
XRinv5ibp0s3 Rinv5ibt0s2 Rinv5ibt0s3 0 sky130_fd_pr__res_xhigh_po w=10 l=49.614382
XRinv5ibp0s4 Rinv5ibt0s3 Rinv5ibt0s4 0 sky130_fd_pr__res_xhigh_po w=10 l=49.614382
XRinv5ibp0s5 Rinv5ibt0s4 Rinv5ibt0s5 0 sky130_fd_pr__res_xhigh_po w=10 l=49.614382
XRinv5ibp0s6 Rinv5ibt0s5 Rinv5ibt0s6 0 sky130_fd_pr__res_xhigh_po w=10 l=49.614382
XRinv5ibp0s7 Rinv5ibt0s6 inv5m 0 sky130_fd_pr__res_xhigh_po w=10 l=49.614382
XRinv5ibp1s0 in5n Rinv5ibt1s0 0 sky130_fd_pr__res_xhigh_po w=10 l=49.614382
XRinv5ibp1s1 Rinv5ibt1s0 Rinv5ibt1s1 0 sky130_fd_pr__res_xhigh_po w=10 l=49.614382
XRinv5ibp1s2 Rinv5ibt1s1 Rinv5ibt1s2 0 sky130_fd_pr__res_xhigh_po w=10 l=49.614382
XRinv5ibp1s3 Rinv5ibt1s2 Rinv5ibt1s3 0 sky130_fd_pr__res_xhigh_po w=10 l=49.614382
XRinv5ibp1s4 Rinv5ibt1s3 Rinv5ibt1s4 0 sky130_fd_pr__res_xhigh_po w=10 l=49.614382
XRinv5ibp1s5 Rinv5ibt1s4 Rinv5ibt1s5 0 sky130_fd_pr__res_xhigh_po w=10 l=49.614382
XRinv5ibp1s6 Rinv5ibt1s5 Rinv5ibt1s6 0 sky130_fd_pr__res_xhigh_po w=10 l=49.614382
XRinv5ibp1s7 Rinv5ibt1s6 inv5m 0 sky130_fd_pr__res_xhigh_po w=10 l=49.614382
XRinv5ibp2s0 in5n Rinv5ibt2s0 0 sky130_fd_pr__res_xhigh_po w=10 l=49.614382
XRinv5ibp2s1 Rinv5ibt2s0 Rinv5ibt2s1 0 sky130_fd_pr__res_xhigh_po w=10 l=49.614382
XRinv5ibp2s2 Rinv5ibt2s1 Rinv5ibt2s2 0 sky130_fd_pr__res_xhigh_po w=10 l=49.614382
XRinv5ibp2s3 Rinv5ibt2s2 Rinv5ibt2s3 0 sky130_fd_pr__res_xhigh_po w=10 l=49.614382
XRinv5ibp2s4 Rinv5ibt2s3 Rinv5ibt2s4 0 sky130_fd_pr__res_xhigh_po w=10 l=49.614382
XRinv5ibp2s5 Rinv5ibt2s4 Rinv5ibt2s5 0 sky130_fd_pr__res_xhigh_po w=10 l=49.614382
XRinv5ibp2s6 Rinv5ibt2s5 Rinv5ibt2s6 0 sky130_fd_pr__res_xhigh_po w=10 l=49.614382
XRinv5ibp2s7 Rinv5ibt2s6 inv5m 0 sky130_fd_pr__res_xhigh_po w=10 l=49.614382
XRinv5ibp3s0 in5n Rinv5ibt3s0 0 sky130_fd_pr__res_xhigh_po w=10 l=49.614382
XRinv5ibp3s1 Rinv5ibt3s0 Rinv5ibt3s1 0 sky130_fd_pr__res_xhigh_po w=10 l=49.614382
XRinv5ibp3s2 Rinv5ibt3s1 Rinv5ibt3s2 0 sky130_fd_pr__res_xhigh_po w=10 l=49.614382
XRinv5ibp3s3 Rinv5ibt3s2 Rinv5ibt3s3 0 sky130_fd_pr__res_xhigh_po w=10 l=49.614382
XRinv5ibp3s4 Rinv5ibt3s3 Rinv5ibt3s4 0 sky130_fd_pr__res_xhigh_po w=10 l=49.614382
XRinv5ibp3s5 Rinv5ibt3s4 Rinv5ibt3s5 0 sky130_fd_pr__res_xhigh_po w=10 l=49.614382
XRinv5ibp3s6 Rinv5ibt3s5 Rinv5ibt3s6 0 sky130_fd_pr__res_xhigh_po w=10 l=49.614382
XRinv5ibp3s7 Rinv5ibt3s6 inv5m 0 sky130_fd_pr__res_xhigh_po w=10 l=49.614382
XRinv5ibp4s0 in5n Rinv5ibt4s0 0 sky130_fd_pr__res_xhigh_po w=10 l=49.614382
XRinv5ibp4s1 Rinv5ibt4s0 Rinv5ibt4s1 0 sky130_fd_pr__res_xhigh_po w=10 l=49.614382
XRinv5ibp4s2 Rinv5ibt4s1 Rinv5ibt4s2 0 sky130_fd_pr__res_xhigh_po w=10 l=49.614382
XRinv5ibp4s3 Rinv5ibt4s2 Rinv5ibt4s3 0 sky130_fd_pr__res_xhigh_po w=10 l=49.614382
XRinv5ibp4s4 Rinv5ibt4s3 Rinv5ibt4s4 0 sky130_fd_pr__res_xhigh_po w=10 l=49.614382
XRinv5ibp4s5 Rinv5ibt4s4 Rinv5ibt4s5 0 sky130_fd_pr__res_xhigh_po w=10 l=49.614382
XRinv5ibp4s6 Rinv5ibt4s5 Rinv5ibt4s6 0 sky130_fd_pr__res_xhigh_po w=10 l=49.614382
XRinv5ibp4s7 Rinv5ibt4s6 inv5m 0 sky130_fd_pr__res_xhigh_po w=10 l=49.614382
XRinv5ibp5s0 in5n Rinv5ibt5s0 0 sky130_fd_pr__res_xhigh_po w=10 l=49.614382
XRinv5ibp5s1 Rinv5ibt5s0 Rinv5ibt5s1 0 sky130_fd_pr__res_xhigh_po w=10 l=49.614382
XRinv5ibp5s2 Rinv5ibt5s1 Rinv5ibt5s2 0 sky130_fd_pr__res_xhigh_po w=10 l=49.614382
XRinv5ibp5s3 Rinv5ibt5s2 Rinv5ibt5s3 0 sky130_fd_pr__res_xhigh_po w=10 l=49.614382
XRinv5ibp5s4 Rinv5ibt5s3 Rinv5ibt5s4 0 sky130_fd_pr__res_xhigh_po w=10 l=49.614382
XRinv5ibp5s5 Rinv5ibt5s4 Rinv5ibt5s5 0 sky130_fd_pr__res_xhigh_po w=10 l=49.614382
XRinv5ibp5s6 Rinv5ibt5s5 Rinv5ibt5s6 0 sky130_fd_pr__res_xhigh_po w=10 l=49.614382
XRinv5ibp5s7 Rinv5ibt5s6 inv5m 0 sky130_fd_pr__res_xhigh_po w=10 l=49.614382
XRinv5ibp6s0 in5n Rinv5ibt6s0 0 sky130_fd_pr__res_xhigh_po w=10 l=49.614382
XRinv5ibp6s1 Rinv5ibt6s0 Rinv5ibt6s1 0 sky130_fd_pr__res_xhigh_po w=10 l=49.614382
XRinv5ibp6s2 Rinv5ibt6s1 Rinv5ibt6s2 0 sky130_fd_pr__res_xhigh_po w=10 l=49.614382
XRinv5ibp6s3 Rinv5ibt6s2 Rinv5ibt6s3 0 sky130_fd_pr__res_xhigh_po w=10 l=49.614382
XRinv5ibp6s4 Rinv5ibt6s3 Rinv5ibt6s4 0 sky130_fd_pr__res_xhigh_po w=10 l=49.614382
XRinv5ibp6s5 Rinv5ibt6s4 Rinv5ibt6s5 0 sky130_fd_pr__res_xhigh_po w=10 l=49.614382
XRinv5ibp6s6 Rinv5ibt6s5 Rinv5ibt6s6 0 sky130_fd_pr__res_xhigh_po w=10 l=49.614382
XRinv5ibp6s7 Rinv5ibt6s6 inv5m 0 sky130_fd_pr__res_xhigh_po w=10 l=49.614382
XRinv5ibp7s0 in5n Rinv5ibt7s0 0 sky130_fd_pr__res_xhigh_po w=10 l=49.614382
XRinv5ibp7s1 Rinv5ibt7s0 Rinv5ibt7s1 0 sky130_fd_pr__res_xhigh_po w=10 l=49.614382
XRinv5ibp7s2 Rinv5ibt7s1 Rinv5ibt7s2 0 sky130_fd_pr__res_xhigh_po w=10 l=49.614382
XRinv5ibp7s3 Rinv5ibt7s2 Rinv5ibt7s3 0 sky130_fd_pr__res_xhigh_po w=10 l=49.614382
XRinv5ibp7s4 Rinv5ibt7s3 Rinv5ibt7s4 0 sky130_fd_pr__res_xhigh_po w=10 l=49.614382
XRinv5ibp7s5 Rinv5ibt7s4 Rinv5ibt7s5 0 sky130_fd_pr__res_xhigh_po w=10 l=49.614382
XRinv5ibp7s6 Rinv5ibt7s5 Rinv5ibt7s6 0 sky130_fd_pr__res_xhigh_po w=10 l=49.614382
XRinv5ibp7s7 Rinv5ibt7s6 inv5m 0 sky130_fd_pr__res_xhigh_po w=10 l=49.614382
Einv5amp in5n 0 0 inv5m 10000000
Vin6 in6 0 DC 1.19986134609244
* passive invert in6 -> in6n: R2/R1=1.0000002 closed-loop -1 at A=1e+07
* PDK sky130_fd_pr__res_xhigh_po Rinv6ia W=10 L=49.614372
* tile Rinv6ia 8s x 8p same W=10 L=49.614372
XRinv6iap0s0 in6 Rinv6iat0s0 0 sky130_fd_pr__res_xhigh_po w=10 l=49.614372
XRinv6iap0s1 Rinv6iat0s0 Rinv6iat0s1 0 sky130_fd_pr__res_xhigh_po w=10 l=49.614372
XRinv6iap0s2 Rinv6iat0s1 Rinv6iat0s2 0 sky130_fd_pr__res_xhigh_po w=10 l=49.614372
XRinv6iap0s3 Rinv6iat0s2 Rinv6iat0s3 0 sky130_fd_pr__res_xhigh_po w=10 l=49.614372
XRinv6iap0s4 Rinv6iat0s3 Rinv6iat0s4 0 sky130_fd_pr__res_xhigh_po w=10 l=49.614372
XRinv6iap0s5 Rinv6iat0s4 Rinv6iat0s5 0 sky130_fd_pr__res_xhigh_po w=10 l=49.614372
XRinv6iap0s6 Rinv6iat0s5 Rinv6iat0s6 0 sky130_fd_pr__res_xhigh_po w=10 l=49.614372
XRinv6iap0s7 Rinv6iat0s6 inv6m 0 sky130_fd_pr__res_xhigh_po w=10 l=49.614372
XRinv6iap1s0 in6 Rinv6iat1s0 0 sky130_fd_pr__res_xhigh_po w=10 l=49.614372
XRinv6iap1s1 Rinv6iat1s0 Rinv6iat1s1 0 sky130_fd_pr__res_xhigh_po w=10 l=49.614372
XRinv6iap1s2 Rinv6iat1s1 Rinv6iat1s2 0 sky130_fd_pr__res_xhigh_po w=10 l=49.614372
XRinv6iap1s3 Rinv6iat1s2 Rinv6iat1s3 0 sky130_fd_pr__res_xhigh_po w=10 l=49.614372
XRinv6iap1s4 Rinv6iat1s3 Rinv6iat1s4 0 sky130_fd_pr__res_xhigh_po w=10 l=49.614372
XRinv6iap1s5 Rinv6iat1s4 Rinv6iat1s5 0 sky130_fd_pr__res_xhigh_po w=10 l=49.614372
XRinv6iap1s6 Rinv6iat1s5 Rinv6iat1s6 0 sky130_fd_pr__res_xhigh_po w=10 l=49.614372
XRinv6iap1s7 Rinv6iat1s6 inv6m 0 sky130_fd_pr__res_xhigh_po w=10 l=49.614372
XRinv6iap2s0 in6 Rinv6iat2s0 0 sky130_fd_pr__res_xhigh_po w=10 l=49.614372
XRinv6iap2s1 Rinv6iat2s0 Rinv6iat2s1 0 sky130_fd_pr__res_xhigh_po w=10 l=49.614372
XRinv6iap2s2 Rinv6iat2s1 Rinv6iat2s2 0 sky130_fd_pr__res_xhigh_po w=10 l=49.614372
XRinv6iap2s3 Rinv6iat2s2 Rinv6iat2s3 0 sky130_fd_pr__res_xhigh_po w=10 l=49.614372
XRinv6iap2s4 Rinv6iat2s3 Rinv6iat2s4 0 sky130_fd_pr__res_xhigh_po w=10 l=49.614372
XRinv6iap2s5 Rinv6iat2s4 Rinv6iat2s5 0 sky130_fd_pr__res_xhigh_po w=10 l=49.614372
XRinv6iap2s6 Rinv6iat2s5 Rinv6iat2s6 0 sky130_fd_pr__res_xhigh_po w=10 l=49.614372
XRinv6iap2s7 Rinv6iat2s6 inv6m 0 sky130_fd_pr__res_xhigh_po w=10 l=49.614372
XRinv6iap3s0 in6 Rinv6iat3s0 0 sky130_fd_pr__res_xhigh_po w=10 l=49.614372
XRinv6iap3s1 Rinv6iat3s0 Rinv6iat3s1 0 sky130_fd_pr__res_xhigh_po w=10 l=49.614372
XRinv6iap3s2 Rinv6iat3s1 Rinv6iat3s2 0 sky130_fd_pr__res_xhigh_po w=10 l=49.614372
XRinv6iap3s3 Rinv6iat3s2 Rinv6iat3s3 0 sky130_fd_pr__res_xhigh_po w=10 l=49.614372
XRinv6iap3s4 Rinv6iat3s3 Rinv6iat3s4 0 sky130_fd_pr__res_xhigh_po w=10 l=49.614372
XRinv6iap3s5 Rinv6iat3s4 Rinv6iat3s5 0 sky130_fd_pr__res_xhigh_po w=10 l=49.614372
XRinv6iap3s6 Rinv6iat3s5 Rinv6iat3s6 0 sky130_fd_pr__res_xhigh_po w=10 l=49.614372
XRinv6iap3s7 Rinv6iat3s6 inv6m 0 sky130_fd_pr__res_xhigh_po w=10 l=49.614372
XRinv6iap4s0 in6 Rinv6iat4s0 0 sky130_fd_pr__res_xhigh_po w=10 l=49.614372
XRinv6iap4s1 Rinv6iat4s0 Rinv6iat4s1 0 sky130_fd_pr__res_xhigh_po w=10 l=49.614372
XRinv6iap4s2 Rinv6iat4s1 Rinv6iat4s2 0 sky130_fd_pr__res_xhigh_po w=10 l=49.614372
XRinv6iap4s3 Rinv6iat4s2 Rinv6iat4s3 0 sky130_fd_pr__res_xhigh_po w=10 l=49.614372
XRinv6iap4s4 Rinv6iat4s3 Rinv6iat4s4 0 sky130_fd_pr__res_xhigh_po w=10 l=49.614372
XRinv6iap4s5 Rinv6iat4s4 Rinv6iat4s5 0 sky130_fd_pr__res_xhigh_po w=10 l=49.614372
XRinv6iap4s6 Rinv6iat4s5 Rinv6iat4s6 0 sky130_fd_pr__res_xhigh_po w=10 l=49.614372
XRinv6iap4s7 Rinv6iat4s6 inv6m 0 sky130_fd_pr__res_xhigh_po w=10 l=49.614372
XRinv6iap5s0 in6 Rinv6iat5s0 0 sky130_fd_pr__res_xhigh_po w=10 l=49.614372
XRinv6iap5s1 Rinv6iat5s0 Rinv6iat5s1 0 sky130_fd_pr__res_xhigh_po w=10 l=49.614372
XRinv6iap5s2 Rinv6iat5s1 Rinv6iat5s2 0 sky130_fd_pr__res_xhigh_po w=10 l=49.614372
XRinv6iap5s3 Rinv6iat5s2 Rinv6iat5s3 0 sky130_fd_pr__res_xhigh_po w=10 l=49.614372
XRinv6iap5s4 Rinv6iat5s3 Rinv6iat5s4 0 sky130_fd_pr__res_xhigh_po w=10 l=49.614372
XRinv6iap5s5 Rinv6iat5s4 Rinv6iat5s5 0 sky130_fd_pr__res_xhigh_po w=10 l=49.614372
XRinv6iap5s6 Rinv6iat5s5 Rinv6iat5s6 0 sky130_fd_pr__res_xhigh_po w=10 l=49.614372
XRinv6iap5s7 Rinv6iat5s6 inv6m 0 sky130_fd_pr__res_xhigh_po w=10 l=49.614372
XRinv6iap6s0 in6 Rinv6iat6s0 0 sky130_fd_pr__res_xhigh_po w=10 l=49.614372
XRinv6iap6s1 Rinv6iat6s0 Rinv6iat6s1 0 sky130_fd_pr__res_xhigh_po w=10 l=49.614372
XRinv6iap6s2 Rinv6iat6s1 Rinv6iat6s2 0 sky130_fd_pr__res_xhigh_po w=10 l=49.614372
XRinv6iap6s3 Rinv6iat6s2 Rinv6iat6s3 0 sky130_fd_pr__res_xhigh_po w=10 l=49.614372
XRinv6iap6s4 Rinv6iat6s3 Rinv6iat6s4 0 sky130_fd_pr__res_xhigh_po w=10 l=49.614372
XRinv6iap6s5 Rinv6iat6s4 Rinv6iat6s5 0 sky130_fd_pr__res_xhigh_po w=10 l=49.614372
XRinv6iap6s6 Rinv6iat6s5 Rinv6iat6s6 0 sky130_fd_pr__res_xhigh_po w=10 l=49.614372
XRinv6iap6s7 Rinv6iat6s6 inv6m 0 sky130_fd_pr__res_xhigh_po w=10 l=49.614372
XRinv6iap7s0 in6 Rinv6iat7s0 0 sky130_fd_pr__res_xhigh_po w=10 l=49.614372
XRinv6iap7s1 Rinv6iat7s0 Rinv6iat7s1 0 sky130_fd_pr__res_xhigh_po w=10 l=49.614372
XRinv6iap7s2 Rinv6iat7s1 Rinv6iat7s2 0 sky130_fd_pr__res_xhigh_po w=10 l=49.614372
XRinv6iap7s3 Rinv6iat7s2 Rinv6iat7s3 0 sky130_fd_pr__res_xhigh_po w=10 l=49.614372
XRinv6iap7s4 Rinv6iat7s3 Rinv6iat7s4 0 sky130_fd_pr__res_xhigh_po w=10 l=49.614372
XRinv6iap7s5 Rinv6iat7s4 Rinv6iat7s5 0 sky130_fd_pr__res_xhigh_po w=10 l=49.614372
XRinv6iap7s6 Rinv6iat7s5 Rinv6iat7s6 0 sky130_fd_pr__res_xhigh_po w=10 l=49.614372
XRinv6iap7s7 Rinv6iat7s6 inv6m 0 sky130_fd_pr__res_xhigh_po w=10 l=49.614372
* PDK sky130_fd_pr__res_xhigh_po Rinv6ib W=10 L=49.614382
* tile Rinv6ib 8s x 8p same W=10 L=49.614382
XRinv6ibp0s0 in6n Rinv6ibt0s0 0 sky130_fd_pr__res_xhigh_po w=10 l=49.614382
XRinv6ibp0s1 Rinv6ibt0s0 Rinv6ibt0s1 0 sky130_fd_pr__res_xhigh_po w=10 l=49.614382
XRinv6ibp0s2 Rinv6ibt0s1 Rinv6ibt0s2 0 sky130_fd_pr__res_xhigh_po w=10 l=49.614382
XRinv6ibp0s3 Rinv6ibt0s2 Rinv6ibt0s3 0 sky130_fd_pr__res_xhigh_po w=10 l=49.614382
XRinv6ibp0s4 Rinv6ibt0s3 Rinv6ibt0s4 0 sky130_fd_pr__res_xhigh_po w=10 l=49.614382
XRinv6ibp0s5 Rinv6ibt0s4 Rinv6ibt0s5 0 sky130_fd_pr__res_xhigh_po w=10 l=49.614382
XRinv6ibp0s6 Rinv6ibt0s5 Rinv6ibt0s6 0 sky130_fd_pr__res_xhigh_po w=10 l=49.614382
XRinv6ibp0s7 Rinv6ibt0s6 inv6m 0 sky130_fd_pr__res_xhigh_po w=10 l=49.614382
XRinv6ibp1s0 in6n Rinv6ibt1s0 0 sky130_fd_pr__res_xhigh_po w=10 l=49.614382
XRinv6ibp1s1 Rinv6ibt1s0 Rinv6ibt1s1 0 sky130_fd_pr__res_xhigh_po w=10 l=49.614382
XRinv6ibp1s2 Rinv6ibt1s1 Rinv6ibt1s2 0 sky130_fd_pr__res_xhigh_po w=10 l=49.614382
XRinv6ibp1s3 Rinv6ibt1s2 Rinv6ibt1s3 0 sky130_fd_pr__res_xhigh_po w=10 l=49.614382
XRinv6ibp1s4 Rinv6ibt1s3 Rinv6ibt1s4 0 sky130_fd_pr__res_xhigh_po w=10 l=49.614382
XRinv6ibp1s5 Rinv6ibt1s4 Rinv6ibt1s5 0 sky130_fd_pr__res_xhigh_po w=10 l=49.614382
XRinv6ibp1s6 Rinv6ibt1s5 Rinv6ibt1s6 0 sky130_fd_pr__res_xhigh_po w=10 l=49.614382
XRinv6ibp1s7 Rinv6ibt1s6 inv6m 0 sky130_fd_pr__res_xhigh_po w=10 l=49.614382
XRinv6ibp2s0 in6n Rinv6ibt2s0 0 sky130_fd_pr__res_xhigh_po w=10 l=49.614382
XRinv6ibp2s1 Rinv6ibt2s0 Rinv6ibt2s1 0 sky130_fd_pr__res_xhigh_po w=10 l=49.614382
XRinv6ibp2s2 Rinv6ibt2s1 Rinv6ibt2s2 0 sky130_fd_pr__res_xhigh_po w=10 l=49.614382
XRinv6ibp2s3 Rinv6ibt2s2 Rinv6ibt2s3 0 sky130_fd_pr__res_xhigh_po w=10 l=49.614382
XRinv6ibp2s4 Rinv6ibt2s3 Rinv6ibt2s4 0 sky130_fd_pr__res_xhigh_po w=10 l=49.614382
XRinv6ibp2s5 Rinv6ibt2s4 Rinv6ibt2s5 0 sky130_fd_pr__res_xhigh_po w=10 l=49.614382
XRinv6ibp2s6 Rinv6ibt2s5 Rinv6ibt2s6 0 sky130_fd_pr__res_xhigh_po w=10 l=49.614382
XRinv6ibp2s7 Rinv6ibt2s6 inv6m 0 sky130_fd_pr__res_xhigh_po w=10 l=49.614382
XRinv6ibp3s0 in6n Rinv6ibt3s0 0 sky130_fd_pr__res_xhigh_po w=10 l=49.614382
XRinv6ibp3s1 Rinv6ibt3s0 Rinv6ibt3s1 0 sky130_fd_pr__res_xhigh_po w=10 l=49.614382
XRinv6ibp3s2 Rinv6ibt3s1 Rinv6ibt3s2 0 sky130_fd_pr__res_xhigh_po w=10 l=49.614382
XRinv6ibp3s3 Rinv6ibt3s2 Rinv6ibt3s3 0 sky130_fd_pr__res_xhigh_po w=10 l=49.614382
XRinv6ibp3s4 Rinv6ibt3s3 Rinv6ibt3s4 0 sky130_fd_pr__res_xhigh_po w=10 l=49.614382
XRinv6ibp3s5 Rinv6ibt3s4 Rinv6ibt3s5 0 sky130_fd_pr__res_xhigh_po w=10 l=49.614382
XRinv6ibp3s6 Rinv6ibt3s5 Rinv6ibt3s6 0 sky130_fd_pr__res_xhigh_po w=10 l=49.614382
XRinv6ibp3s7 Rinv6ibt3s6 inv6m 0 sky130_fd_pr__res_xhigh_po w=10 l=49.614382
XRinv6ibp4s0 in6n Rinv6ibt4s0 0 sky130_fd_pr__res_xhigh_po w=10 l=49.614382
XRinv6ibp4s1 Rinv6ibt4s0 Rinv6ibt4s1 0 sky130_fd_pr__res_xhigh_po w=10 l=49.614382
XRinv6ibp4s2 Rinv6ibt4s1 Rinv6ibt4s2 0 sky130_fd_pr__res_xhigh_po w=10 l=49.614382
XRinv6ibp4s3 Rinv6ibt4s2 Rinv6ibt4s3 0 sky130_fd_pr__res_xhigh_po w=10 l=49.614382
XRinv6ibp4s4 Rinv6ibt4s3 Rinv6ibt4s4 0 sky130_fd_pr__res_xhigh_po w=10 l=49.614382
XRinv6ibp4s5 Rinv6ibt4s4 Rinv6ibt4s5 0 sky130_fd_pr__res_xhigh_po w=10 l=49.614382
XRinv6ibp4s6 Rinv6ibt4s5 Rinv6ibt4s6 0 sky130_fd_pr__res_xhigh_po w=10 l=49.614382
XRinv6ibp4s7 Rinv6ibt4s6 inv6m 0 sky130_fd_pr__res_xhigh_po w=10 l=49.614382
XRinv6ibp5s0 in6n Rinv6ibt5s0 0 sky130_fd_pr__res_xhigh_po w=10 l=49.614382
XRinv6ibp5s1 Rinv6ibt5s0 Rinv6ibt5s1 0 sky130_fd_pr__res_xhigh_po w=10 l=49.614382
XRinv6ibp5s2 Rinv6ibt5s1 Rinv6ibt5s2 0 sky130_fd_pr__res_xhigh_po w=10 l=49.614382
XRinv6ibp5s3 Rinv6ibt5s2 Rinv6ibt5s3 0 sky130_fd_pr__res_xhigh_po w=10 l=49.614382
XRinv6ibp5s4 Rinv6ibt5s3 Rinv6ibt5s4 0 sky130_fd_pr__res_xhigh_po w=10 l=49.614382
XRinv6ibp5s5 Rinv6ibt5s4 Rinv6ibt5s5 0 sky130_fd_pr__res_xhigh_po w=10 l=49.614382
XRinv6ibp5s6 Rinv6ibt5s5 Rinv6ibt5s6 0 sky130_fd_pr__res_xhigh_po w=10 l=49.614382
XRinv6ibp5s7 Rinv6ibt5s6 inv6m 0 sky130_fd_pr__res_xhigh_po w=10 l=49.614382
XRinv6ibp6s0 in6n Rinv6ibt6s0 0 sky130_fd_pr__res_xhigh_po w=10 l=49.614382
XRinv6ibp6s1 Rinv6ibt6s0 Rinv6ibt6s1 0 sky130_fd_pr__res_xhigh_po w=10 l=49.614382
XRinv6ibp6s2 Rinv6ibt6s1 Rinv6ibt6s2 0 sky130_fd_pr__res_xhigh_po w=10 l=49.614382
XRinv6ibp6s3 Rinv6ibt6s2 Rinv6ibt6s3 0 sky130_fd_pr__res_xhigh_po w=10 l=49.614382
XRinv6ibp6s4 Rinv6ibt6s3 Rinv6ibt6s4 0 sky130_fd_pr__res_xhigh_po w=10 l=49.614382
XRinv6ibp6s5 Rinv6ibt6s4 Rinv6ibt6s5 0 sky130_fd_pr__res_xhigh_po w=10 l=49.614382
XRinv6ibp6s6 Rinv6ibt6s5 Rinv6ibt6s6 0 sky130_fd_pr__res_xhigh_po w=10 l=49.614382
XRinv6ibp6s7 Rinv6ibt6s6 inv6m 0 sky130_fd_pr__res_xhigh_po w=10 l=49.614382
XRinv6ibp7s0 in6n Rinv6ibt7s0 0 sky130_fd_pr__res_xhigh_po w=10 l=49.614382
XRinv6ibp7s1 Rinv6ibt7s0 Rinv6ibt7s1 0 sky130_fd_pr__res_xhigh_po w=10 l=49.614382
XRinv6ibp7s2 Rinv6ibt7s1 Rinv6ibt7s2 0 sky130_fd_pr__res_xhigh_po w=10 l=49.614382
XRinv6ibp7s3 Rinv6ibt7s2 Rinv6ibt7s3 0 sky130_fd_pr__res_xhigh_po w=10 l=49.614382
XRinv6ibp7s4 Rinv6ibt7s3 Rinv6ibt7s4 0 sky130_fd_pr__res_xhigh_po w=10 l=49.614382
XRinv6ibp7s5 Rinv6ibt7s4 Rinv6ibt7s5 0 sky130_fd_pr__res_xhigh_po w=10 l=49.614382
XRinv6ibp7s6 Rinv6ibt7s5 Rinv6ibt7s6 0 sky130_fd_pr__res_xhigh_po w=10 l=49.614382
XRinv6ibp7s7 Rinv6ibt7s6 inv6m 0 sky130_fd_pr__res_xhigh_po w=10 l=49.614382
Einv6amp in6n 0 0 inv6m 10000000
Vin7 in7 0 DC 0
Vin8 in8 0 DC 0.317097301363568
Vin9 in9 0 DC 0
* passive invert in9 -> in9n: R2/R1=1.0000002 closed-loop -1 at A=1e+07
* PDK sky130_fd_pr__res_xhigh_po Rinv9ia W=10 L=49.614372
* tile Rinv9ia 8s x 8p same W=10 L=49.614372
XRinv9iap0s0 in9 Rinv9iat0s0 0 sky130_fd_pr__res_xhigh_po w=10 l=49.614372
XRinv9iap0s1 Rinv9iat0s0 Rinv9iat0s1 0 sky130_fd_pr__res_xhigh_po w=10 l=49.614372
XRinv9iap0s2 Rinv9iat0s1 Rinv9iat0s2 0 sky130_fd_pr__res_xhigh_po w=10 l=49.614372
XRinv9iap0s3 Rinv9iat0s2 Rinv9iat0s3 0 sky130_fd_pr__res_xhigh_po w=10 l=49.614372
XRinv9iap0s4 Rinv9iat0s3 Rinv9iat0s4 0 sky130_fd_pr__res_xhigh_po w=10 l=49.614372
XRinv9iap0s5 Rinv9iat0s4 Rinv9iat0s5 0 sky130_fd_pr__res_xhigh_po w=10 l=49.614372
XRinv9iap0s6 Rinv9iat0s5 Rinv9iat0s6 0 sky130_fd_pr__res_xhigh_po w=10 l=49.614372
XRinv9iap0s7 Rinv9iat0s6 inv9m 0 sky130_fd_pr__res_xhigh_po w=10 l=49.614372
XRinv9iap1s0 in9 Rinv9iat1s0 0 sky130_fd_pr__res_xhigh_po w=10 l=49.614372
XRinv9iap1s1 Rinv9iat1s0 Rinv9iat1s1 0 sky130_fd_pr__res_xhigh_po w=10 l=49.614372
XRinv9iap1s2 Rinv9iat1s1 Rinv9iat1s2 0 sky130_fd_pr__res_xhigh_po w=10 l=49.614372
XRinv9iap1s3 Rinv9iat1s2 Rinv9iat1s3 0 sky130_fd_pr__res_xhigh_po w=10 l=49.614372
XRinv9iap1s4 Rinv9iat1s3 Rinv9iat1s4 0 sky130_fd_pr__res_xhigh_po w=10 l=49.614372
XRinv9iap1s5 Rinv9iat1s4 Rinv9iat1s5 0 sky130_fd_pr__res_xhigh_po w=10 l=49.614372
XRinv9iap1s6 Rinv9iat1s5 Rinv9iat1s6 0 sky130_fd_pr__res_xhigh_po w=10 l=49.614372
XRinv9iap1s7 Rinv9iat1s6 inv9m 0 sky130_fd_pr__res_xhigh_po w=10 l=49.614372
XRinv9iap2s0 in9 Rinv9iat2s0 0 sky130_fd_pr__res_xhigh_po w=10 l=49.614372
XRinv9iap2s1 Rinv9iat2s0 Rinv9iat2s1 0 sky130_fd_pr__res_xhigh_po w=10 l=49.614372
XRinv9iap2s2 Rinv9iat2s1 Rinv9iat2s2 0 sky130_fd_pr__res_xhigh_po w=10 l=49.614372
XRinv9iap2s3 Rinv9iat2s2 Rinv9iat2s3 0 sky130_fd_pr__res_xhigh_po w=10 l=49.614372
XRinv9iap2s4 Rinv9iat2s3 Rinv9iat2s4 0 sky130_fd_pr__res_xhigh_po w=10 l=49.614372
XRinv9iap2s5 Rinv9iat2s4 Rinv9iat2s5 0 sky130_fd_pr__res_xhigh_po w=10 l=49.614372
XRinv9iap2s6 Rinv9iat2s5 Rinv9iat2s6 0 sky130_fd_pr__res_xhigh_po w=10 l=49.614372
XRinv9iap2s7 Rinv9iat2s6 inv9m 0 sky130_fd_pr__res_xhigh_po w=10 l=49.614372
XRinv9iap3s0 in9 Rinv9iat3s0 0 sky130_fd_pr__res_xhigh_po w=10 l=49.614372
XRinv9iap3s1 Rinv9iat3s0 Rinv9iat3s1 0 sky130_fd_pr__res_xhigh_po w=10 l=49.614372
XRinv9iap3s2 Rinv9iat3s1 Rinv9iat3s2 0 sky130_fd_pr__res_xhigh_po w=10 l=49.614372
XRinv9iap3s3 Rinv9iat3s2 Rinv9iat3s3 0 sky130_fd_pr__res_xhigh_po w=10 l=49.614372
XRinv9iap3s4 Rinv9iat3s3 Rinv9iat3s4 0 sky130_fd_pr__res_xhigh_po w=10 l=49.614372
XRinv9iap3s5 Rinv9iat3s4 Rinv9iat3s5 0 sky130_fd_pr__res_xhigh_po w=10 l=49.614372
XRinv9iap3s6 Rinv9iat3s5 Rinv9iat3s6 0 sky130_fd_pr__res_xhigh_po w=10 l=49.614372
XRinv9iap3s7 Rinv9iat3s6 inv9m 0 sky130_fd_pr__res_xhigh_po w=10 l=49.614372
XRinv9iap4s0 in9 Rinv9iat4s0 0 sky130_fd_pr__res_xhigh_po w=10 l=49.614372
XRinv9iap4s1 Rinv9iat4s0 Rinv9iat4s1 0 sky130_fd_pr__res_xhigh_po w=10 l=49.614372
XRinv9iap4s2 Rinv9iat4s1 Rinv9iat4s2 0 sky130_fd_pr__res_xhigh_po w=10 l=49.614372
XRinv9iap4s3 Rinv9iat4s2 Rinv9iat4s3 0 sky130_fd_pr__res_xhigh_po w=10 l=49.614372
XRinv9iap4s4 Rinv9iat4s3 Rinv9iat4s4 0 sky130_fd_pr__res_xhigh_po w=10 l=49.614372
XRinv9iap4s5 Rinv9iat4s4 Rinv9iat4s5 0 sky130_fd_pr__res_xhigh_po w=10 l=49.614372
XRinv9iap4s6 Rinv9iat4s5 Rinv9iat4s6 0 sky130_fd_pr__res_xhigh_po w=10 l=49.614372
XRinv9iap4s7 Rinv9iat4s6 inv9m 0 sky130_fd_pr__res_xhigh_po w=10 l=49.614372
XRinv9iap5s0 in9 Rinv9iat5s0 0 sky130_fd_pr__res_xhigh_po w=10 l=49.614372
XRinv9iap5s1 Rinv9iat5s0 Rinv9iat5s1 0 sky130_fd_pr__res_xhigh_po w=10 l=49.614372
XRinv9iap5s2 Rinv9iat5s1 Rinv9iat5s2 0 sky130_fd_pr__res_xhigh_po w=10 l=49.614372
XRinv9iap5s3 Rinv9iat5s2 Rinv9iat5s3 0 sky130_fd_pr__res_xhigh_po w=10 l=49.614372
XRinv9iap5s4 Rinv9iat5s3 Rinv9iat5s4 0 sky130_fd_pr__res_xhigh_po w=10 l=49.614372
XRinv9iap5s5 Rinv9iat5s4 Rinv9iat5s5 0 sky130_fd_pr__res_xhigh_po w=10 l=49.614372
XRinv9iap5s6 Rinv9iat5s5 Rinv9iat5s6 0 sky130_fd_pr__res_xhigh_po w=10 l=49.614372
XRinv9iap5s7 Rinv9iat5s6 inv9m 0 sky130_fd_pr__res_xhigh_po w=10 l=49.614372
XRinv9iap6s0 in9 Rinv9iat6s0 0 sky130_fd_pr__res_xhigh_po w=10 l=49.614372
XRinv9iap6s1 Rinv9iat6s0 Rinv9iat6s1 0 sky130_fd_pr__res_xhigh_po w=10 l=49.614372
XRinv9iap6s2 Rinv9iat6s1 Rinv9iat6s2 0 sky130_fd_pr__res_xhigh_po w=10 l=49.614372
XRinv9iap6s3 Rinv9iat6s2 Rinv9iat6s3 0 sky130_fd_pr__res_xhigh_po w=10 l=49.614372
XRinv9iap6s4 Rinv9iat6s3 Rinv9iat6s4 0 sky130_fd_pr__res_xhigh_po w=10 l=49.614372
XRinv9iap6s5 Rinv9iat6s4 Rinv9iat6s5 0 sky130_fd_pr__res_xhigh_po w=10 l=49.614372
XRinv9iap6s6 Rinv9iat6s5 Rinv9iat6s6 0 sky130_fd_pr__res_xhigh_po w=10 l=49.614372
XRinv9iap6s7 Rinv9iat6s6 inv9m 0 sky130_fd_pr__res_xhigh_po w=10 l=49.614372
XRinv9iap7s0 in9 Rinv9iat7s0 0 sky130_fd_pr__res_xhigh_po w=10 l=49.614372
XRinv9iap7s1 Rinv9iat7s0 Rinv9iat7s1 0 sky130_fd_pr__res_xhigh_po w=10 l=49.614372
XRinv9iap7s2 Rinv9iat7s1 Rinv9iat7s2 0 sky130_fd_pr__res_xhigh_po w=10 l=49.614372
XRinv9iap7s3 Rinv9iat7s2 Rinv9iat7s3 0 sky130_fd_pr__res_xhigh_po w=10 l=49.614372
XRinv9iap7s4 Rinv9iat7s3 Rinv9iat7s4 0 sky130_fd_pr__res_xhigh_po w=10 l=49.614372
XRinv9iap7s5 Rinv9iat7s4 Rinv9iat7s5 0 sky130_fd_pr__res_xhigh_po w=10 l=49.614372
XRinv9iap7s6 Rinv9iat7s5 Rinv9iat7s6 0 sky130_fd_pr__res_xhigh_po w=10 l=49.614372
XRinv9iap7s7 Rinv9iat7s6 inv9m 0 sky130_fd_pr__res_xhigh_po w=10 l=49.614372
* PDK sky130_fd_pr__res_xhigh_po Rinv9ib W=10 L=49.614382
* tile Rinv9ib 8s x 8p same W=10 L=49.614382
XRinv9ibp0s0 in9n Rinv9ibt0s0 0 sky130_fd_pr__res_xhigh_po w=10 l=49.614382
XRinv9ibp0s1 Rinv9ibt0s0 Rinv9ibt0s1 0 sky130_fd_pr__res_xhigh_po w=10 l=49.614382
XRinv9ibp0s2 Rinv9ibt0s1 Rinv9ibt0s2 0 sky130_fd_pr__res_xhigh_po w=10 l=49.614382
XRinv9ibp0s3 Rinv9ibt0s2 Rinv9ibt0s3 0 sky130_fd_pr__res_xhigh_po w=10 l=49.614382
XRinv9ibp0s4 Rinv9ibt0s3 Rinv9ibt0s4 0 sky130_fd_pr__res_xhigh_po w=10 l=49.614382
XRinv9ibp0s5 Rinv9ibt0s4 Rinv9ibt0s5 0 sky130_fd_pr__res_xhigh_po w=10 l=49.614382
XRinv9ibp0s6 Rinv9ibt0s5 Rinv9ibt0s6 0 sky130_fd_pr__res_xhigh_po w=10 l=49.614382
XRinv9ibp0s7 Rinv9ibt0s6 inv9m 0 sky130_fd_pr__res_xhigh_po w=10 l=49.614382
XRinv9ibp1s0 in9n Rinv9ibt1s0 0 sky130_fd_pr__res_xhigh_po w=10 l=49.614382
XRinv9ibp1s1 Rinv9ibt1s0 Rinv9ibt1s1 0 sky130_fd_pr__res_xhigh_po w=10 l=49.614382
XRinv9ibp1s2 Rinv9ibt1s1 Rinv9ibt1s2 0 sky130_fd_pr__res_xhigh_po w=10 l=49.614382
XRinv9ibp1s3 Rinv9ibt1s2 Rinv9ibt1s3 0 sky130_fd_pr__res_xhigh_po w=10 l=49.614382
XRinv9ibp1s4 Rinv9ibt1s3 Rinv9ibt1s4 0 sky130_fd_pr__res_xhigh_po w=10 l=49.614382
XRinv9ibp1s5 Rinv9ibt1s4 Rinv9ibt1s5 0 sky130_fd_pr__res_xhigh_po w=10 l=49.614382
XRinv9ibp1s6 Rinv9ibt1s5 Rinv9ibt1s6 0 sky130_fd_pr__res_xhigh_po w=10 l=49.614382
XRinv9ibp1s7 Rinv9ibt1s6 inv9m 0 sky130_fd_pr__res_xhigh_po w=10 l=49.614382
XRinv9ibp2s0 in9n Rinv9ibt2s0 0 sky130_fd_pr__res_xhigh_po w=10 l=49.614382
XRinv9ibp2s1 Rinv9ibt2s0 Rinv9ibt2s1 0 sky130_fd_pr__res_xhigh_po w=10 l=49.614382
XRinv9ibp2s2 Rinv9ibt2s1 Rinv9ibt2s2 0 sky130_fd_pr__res_xhigh_po w=10 l=49.614382
XRinv9ibp2s3 Rinv9ibt2s2 Rinv9ibt2s3 0 sky130_fd_pr__res_xhigh_po w=10 l=49.614382
XRinv9ibp2s4 Rinv9ibt2s3 Rinv9ibt2s4 0 sky130_fd_pr__res_xhigh_po w=10 l=49.614382
XRinv9ibp2s5 Rinv9ibt2s4 Rinv9ibt2s5 0 sky130_fd_pr__res_xhigh_po w=10 l=49.614382
XRinv9ibp2s6 Rinv9ibt2s5 Rinv9ibt2s6 0 sky130_fd_pr__res_xhigh_po w=10 l=49.614382
XRinv9ibp2s7 Rinv9ibt2s6 inv9m 0 sky130_fd_pr__res_xhigh_po w=10 l=49.614382
XRinv9ibp3s0 in9n Rinv9ibt3s0 0 sky130_fd_pr__res_xhigh_po w=10 l=49.614382
XRinv9ibp3s1 Rinv9ibt3s0 Rinv9ibt3s1 0 sky130_fd_pr__res_xhigh_po w=10 l=49.614382
XRinv9ibp3s2 Rinv9ibt3s1 Rinv9ibt3s2 0 sky130_fd_pr__res_xhigh_po w=10 l=49.614382
XRinv9ibp3s3 Rinv9ibt3s2 Rinv9ibt3s3 0 sky130_fd_pr__res_xhigh_po w=10 l=49.614382
XRinv9ibp3s4 Rinv9ibt3s3 Rinv9ibt3s4 0 sky130_fd_pr__res_xhigh_po w=10 l=49.614382
XRinv9ibp3s5 Rinv9ibt3s4 Rinv9ibt3s5 0 sky130_fd_pr__res_xhigh_po w=10 l=49.614382
XRinv9ibp3s6 Rinv9ibt3s5 Rinv9ibt3s6 0 sky130_fd_pr__res_xhigh_po w=10 l=49.614382
XRinv9ibp3s7 Rinv9ibt3s6 inv9m 0 sky130_fd_pr__res_xhigh_po w=10 l=49.614382
XRinv9ibp4s0 in9n Rinv9ibt4s0 0 sky130_fd_pr__res_xhigh_po w=10 l=49.614382
XRinv9ibp4s1 Rinv9ibt4s0 Rinv9ibt4s1 0 sky130_fd_pr__res_xhigh_po w=10 l=49.614382
XRinv9ibp4s2 Rinv9ibt4s1 Rinv9ibt4s2 0 sky130_fd_pr__res_xhigh_po w=10 l=49.614382
XRinv9ibp4s3 Rinv9ibt4s2 Rinv9ibt4s3 0 sky130_fd_pr__res_xhigh_po w=10 l=49.614382
XRinv9ibp4s4 Rinv9ibt4s3 Rinv9ibt4s4 0 sky130_fd_pr__res_xhigh_po w=10 l=49.614382
XRinv9ibp4s5 Rinv9ibt4s4 Rinv9ibt4s5 0 sky130_fd_pr__res_xhigh_po w=10 l=49.614382
XRinv9ibp4s6 Rinv9ibt4s5 Rinv9ibt4s6 0 sky130_fd_pr__res_xhigh_po w=10 l=49.614382
XRinv9ibp4s7 Rinv9ibt4s6 inv9m 0 sky130_fd_pr__res_xhigh_po w=10 l=49.614382
XRinv9ibp5s0 in9n Rinv9ibt5s0 0 sky130_fd_pr__res_xhigh_po w=10 l=49.614382
XRinv9ibp5s1 Rinv9ibt5s0 Rinv9ibt5s1 0 sky130_fd_pr__res_xhigh_po w=10 l=49.614382
XRinv9ibp5s2 Rinv9ibt5s1 Rinv9ibt5s2 0 sky130_fd_pr__res_xhigh_po w=10 l=49.614382
XRinv9ibp5s3 Rinv9ibt5s2 Rinv9ibt5s3 0 sky130_fd_pr__res_xhigh_po w=10 l=49.614382
XRinv9ibp5s4 Rinv9ibt5s3 Rinv9ibt5s4 0 sky130_fd_pr__res_xhigh_po w=10 l=49.614382
XRinv9ibp5s5 Rinv9ibt5s4 Rinv9ibt5s5 0 sky130_fd_pr__res_xhigh_po w=10 l=49.614382
XRinv9ibp5s6 Rinv9ibt5s5 Rinv9ibt5s6 0 sky130_fd_pr__res_xhigh_po w=10 l=49.614382
XRinv9ibp5s7 Rinv9ibt5s6 inv9m 0 sky130_fd_pr__res_xhigh_po w=10 l=49.614382
XRinv9ibp6s0 in9n Rinv9ibt6s0 0 sky130_fd_pr__res_xhigh_po w=10 l=49.614382
XRinv9ibp6s1 Rinv9ibt6s0 Rinv9ibt6s1 0 sky130_fd_pr__res_xhigh_po w=10 l=49.614382
XRinv9ibp6s2 Rinv9ibt6s1 Rinv9ibt6s2 0 sky130_fd_pr__res_xhigh_po w=10 l=49.614382
XRinv9ibp6s3 Rinv9ibt6s2 Rinv9ibt6s3 0 sky130_fd_pr__res_xhigh_po w=10 l=49.614382
XRinv9ibp6s4 Rinv9ibt6s3 Rinv9ibt6s4 0 sky130_fd_pr__res_xhigh_po w=10 l=49.614382
XRinv9ibp6s5 Rinv9ibt6s4 Rinv9ibt6s5 0 sky130_fd_pr__res_xhigh_po w=10 l=49.614382
XRinv9ibp6s6 Rinv9ibt6s5 Rinv9ibt6s6 0 sky130_fd_pr__res_xhigh_po w=10 l=49.614382
XRinv9ibp6s7 Rinv9ibt6s6 inv9m 0 sky130_fd_pr__res_xhigh_po w=10 l=49.614382
XRinv9ibp7s0 in9n Rinv9ibt7s0 0 sky130_fd_pr__res_xhigh_po w=10 l=49.614382
XRinv9ibp7s1 Rinv9ibt7s0 Rinv9ibt7s1 0 sky130_fd_pr__res_xhigh_po w=10 l=49.614382
XRinv9ibp7s2 Rinv9ibt7s1 Rinv9ibt7s2 0 sky130_fd_pr__res_xhigh_po w=10 l=49.614382
XRinv9ibp7s3 Rinv9ibt7s2 Rinv9ibt7s3 0 sky130_fd_pr__res_xhigh_po w=10 l=49.614382
XRinv9ibp7s4 Rinv9ibt7s3 Rinv9ibt7s4 0 sky130_fd_pr__res_xhigh_po w=10 l=49.614382
XRinv9ibp7s5 Rinv9ibt7s4 Rinv9ibt7s5 0 sky130_fd_pr__res_xhigh_po w=10 l=49.614382
XRinv9ibp7s6 Rinv9ibt7s5 Rinv9ibt7s6 0 sky130_fd_pr__res_xhigh_po w=10 l=49.614382
XRinv9ibp7s7 Rinv9ibt7s6 inv9m 0 sky130_fd_pr__res_xhigh_po w=10 l=49.614382
Einv9amp in9n 0 0 inv9m 10000000
Vin10 in10 0 DC 0.827257420094178
* passive invert in10 -> in10n: R2/R1=1.0000002 closed-loop -1 at A=1e+07
* PDK sky130_fd_pr__res_xhigh_po Rinv10ia W=10 L=49.614372
* tile Rinv10ia 8s x 8p same W=10 L=49.614372
XRinv10iap0s0 in10 Rinv10iat0s0 0 sky130_fd_pr__res_xhigh_po w=10 l=49.614372
XRinv10iap0s1 Rinv10iat0s0 Rinv10iat0s1 0 sky130_fd_pr__res_xhigh_po w=10 l=49.614372
XRinv10iap0s2 Rinv10iat0s1 Rinv10iat0s2 0 sky130_fd_pr__res_xhigh_po w=10 l=49.614372
XRinv10iap0s3 Rinv10iat0s2 Rinv10iat0s3 0 sky130_fd_pr__res_xhigh_po w=10 l=49.614372
XRinv10iap0s4 Rinv10iat0s3 Rinv10iat0s4 0 sky130_fd_pr__res_xhigh_po w=10 l=49.614372
XRinv10iap0s5 Rinv10iat0s4 Rinv10iat0s5 0 sky130_fd_pr__res_xhigh_po w=10 l=49.614372
XRinv10iap0s6 Rinv10iat0s5 Rinv10iat0s6 0 sky130_fd_pr__res_xhigh_po w=10 l=49.614372
XRinv10iap0s7 Rinv10iat0s6 inv10m 0 sky130_fd_pr__res_xhigh_po w=10 l=49.614372
XRinv10iap1s0 in10 Rinv10iat1s0 0 sky130_fd_pr__res_xhigh_po w=10 l=49.614372
XRinv10iap1s1 Rinv10iat1s0 Rinv10iat1s1 0 sky130_fd_pr__res_xhigh_po w=10 l=49.614372
XRinv10iap1s2 Rinv10iat1s1 Rinv10iat1s2 0 sky130_fd_pr__res_xhigh_po w=10 l=49.614372
XRinv10iap1s3 Rinv10iat1s2 Rinv10iat1s3 0 sky130_fd_pr__res_xhigh_po w=10 l=49.614372
XRinv10iap1s4 Rinv10iat1s3 Rinv10iat1s4 0 sky130_fd_pr__res_xhigh_po w=10 l=49.614372
XRinv10iap1s5 Rinv10iat1s4 Rinv10iat1s5 0 sky130_fd_pr__res_xhigh_po w=10 l=49.614372
XRinv10iap1s6 Rinv10iat1s5 Rinv10iat1s6 0 sky130_fd_pr__res_xhigh_po w=10 l=49.614372
XRinv10iap1s7 Rinv10iat1s6 inv10m 0 sky130_fd_pr__res_xhigh_po w=10 l=49.614372
XRinv10iap2s0 in10 Rinv10iat2s0 0 sky130_fd_pr__res_xhigh_po w=10 l=49.614372
XRinv10iap2s1 Rinv10iat2s0 Rinv10iat2s1 0 sky130_fd_pr__res_xhigh_po w=10 l=49.614372
XRinv10iap2s2 Rinv10iat2s1 Rinv10iat2s2 0 sky130_fd_pr__res_xhigh_po w=10 l=49.614372
XRinv10iap2s3 Rinv10iat2s2 Rinv10iat2s3 0 sky130_fd_pr__res_xhigh_po w=10 l=49.614372
XRinv10iap2s4 Rinv10iat2s3 Rinv10iat2s4 0 sky130_fd_pr__res_xhigh_po w=10 l=49.614372
XRinv10iap2s5 Rinv10iat2s4 Rinv10iat2s5 0 sky130_fd_pr__res_xhigh_po w=10 l=49.614372
XRinv10iap2s6 Rinv10iat2s5 Rinv10iat2s6 0 sky130_fd_pr__res_xhigh_po w=10 l=49.614372
XRinv10iap2s7 Rinv10iat2s6 inv10m 0 sky130_fd_pr__res_xhigh_po w=10 l=49.614372
XRinv10iap3s0 in10 Rinv10iat3s0 0 sky130_fd_pr__res_xhigh_po w=10 l=49.614372
XRinv10iap3s1 Rinv10iat3s0 Rinv10iat3s1 0 sky130_fd_pr__res_xhigh_po w=10 l=49.614372
XRinv10iap3s2 Rinv10iat3s1 Rinv10iat3s2 0 sky130_fd_pr__res_xhigh_po w=10 l=49.614372
XRinv10iap3s3 Rinv10iat3s2 Rinv10iat3s3 0 sky130_fd_pr__res_xhigh_po w=10 l=49.614372
XRinv10iap3s4 Rinv10iat3s3 Rinv10iat3s4 0 sky130_fd_pr__res_xhigh_po w=10 l=49.614372
XRinv10iap3s5 Rinv10iat3s4 Rinv10iat3s5 0 sky130_fd_pr__res_xhigh_po w=10 l=49.614372
XRinv10iap3s6 Rinv10iat3s5 Rinv10iat3s6 0 sky130_fd_pr__res_xhigh_po w=10 l=49.614372
XRinv10iap3s7 Rinv10iat3s6 inv10m 0 sky130_fd_pr__res_xhigh_po w=10 l=49.614372
XRinv10iap4s0 in10 Rinv10iat4s0 0 sky130_fd_pr__res_xhigh_po w=10 l=49.614372
XRinv10iap4s1 Rinv10iat4s0 Rinv10iat4s1 0 sky130_fd_pr__res_xhigh_po w=10 l=49.614372
XRinv10iap4s2 Rinv10iat4s1 Rinv10iat4s2 0 sky130_fd_pr__res_xhigh_po w=10 l=49.614372
XRinv10iap4s3 Rinv10iat4s2 Rinv10iat4s3 0 sky130_fd_pr__res_xhigh_po w=10 l=49.614372
XRinv10iap4s4 Rinv10iat4s3 Rinv10iat4s4 0 sky130_fd_pr__res_xhigh_po w=10 l=49.614372
XRinv10iap4s5 Rinv10iat4s4 Rinv10iat4s5 0 sky130_fd_pr__res_xhigh_po w=10 l=49.614372
XRinv10iap4s6 Rinv10iat4s5 Rinv10iat4s6 0 sky130_fd_pr__res_xhigh_po w=10 l=49.614372
XRinv10iap4s7 Rinv10iat4s6 inv10m 0 sky130_fd_pr__res_xhigh_po w=10 l=49.614372
XRinv10iap5s0 in10 Rinv10iat5s0 0 sky130_fd_pr__res_xhigh_po w=10 l=49.614372
XRinv10iap5s1 Rinv10iat5s0 Rinv10iat5s1 0 sky130_fd_pr__res_xhigh_po w=10 l=49.614372
XRinv10iap5s2 Rinv10iat5s1 Rinv10iat5s2 0 sky130_fd_pr__res_xhigh_po w=10 l=49.614372
XRinv10iap5s3 Rinv10iat5s2 Rinv10iat5s3 0 sky130_fd_pr__res_xhigh_po w=10 l=49.614372
XRinv10iap5s4 Rinv10iat5s3 Rinv10iat5s4 0 sky130_fd_pr__res_xhigh_po w=10 l=49.614372
XRinv10iap5s5 Rinv10iat5s4 Rinv10iat5s5 0 sky130_fd_pr__res_xhigh_po w=10 l=49.614372
XRinv10iap5s6 Rinv10iat5s5 Rinv10iat5s6 0 sky130_fd_pr__res_xhigh_po w=10 l=49.614372
XRinv10iap5s7 Rinv10iat5s6 inv10m 0 sky130_fd_pr__res_xhigh_po w=10 l=49.614372
XRinv10iap6s0 in10 Rinv10iat6s0 0 sky130_fd_pr__res_xhigh_po w=10 l=49.614372
XRinv10iap6s1 Rinv10iat6s0 Rinv10iat6s1 0 sky130_fd_pr__res_xhigh_po w=10 l=49.614372
XRinv10iap6s2 Rinv10iat6s1 Rinv10iat6s2 0 sky130_fd_pr__res_xhigh_po w=10 l=49.614372
XRinv10iap6s3 Rinv10iat6s2 Rinv10iat6s3 0 sky130_fd_pr__res_xhigh_po w=10 l=49.614372
XRinv10iap6s4 Rinv10iat6s3 Rinv10iat6s4 0 sky130_fd_pr__res_xhigh_po w=10 l=49.614372
XRinv10iap6s5 Rinv10iat6s4 Rinv10iat6s5 0 sky130_fd_pr__res_xhigh_po w=10 l=49.614372
XRinv10iap6s6 Rinv10iat6s5 Rinv10iat6s6 0 sky130_fd_pr__res_xhigh_po w=10 l=49.614372
XRinv10iap6s7 Rinv10iat6s6 inv10m 0 sky130_fd_pr__res_xhigh_po w=10 l=49.614372
XRinv10iap7s0 in10 Rinv10iat7s0 0 sky130_fd_pr__res_xhigh_po w=10 l=49.614372
XRinv10iap7s1 Rinv10iat7s0 Rinv10iat7s1 0 sky130_fd_pr__res_xhigh_po w=10 l=49.614372
XRinv10iap7s2 Rinv10iat7s1 Rinv10iat7s2 0 sky130_fd_pr__res_xhigh_po w=10 l=49.614372
XRinv10iap7s3 Rinv10iat7s2 Rinv10iat7s3 0 sky130_fd_pr__res_xhigh_po w=10 l=49.614372
XRinv10iap7s4 Rinv10iat7s3 Rinv10iat7s4 0 sky130_fd_pr__res_xhigh_po w=10 l=49.614372
XRinv10iap7s5 Rinv10iat7s4 Rinv10iat7s5 0 sky130_fd_pr__res_xhigh_po w=10 l=49.614372
XRinv10iap7s6 Rinv10iat7s5 Rinv10iat7s6 0 sky130_fd_pr__res_xhigh_po w=10 l=49.614372
XRinv10iap7s7 Rinv10iat7s6 inv10m 0 sky130_fd_pr__res_xhigh_po w=10 l=49.614372
* PDK sky130_fd_pr__res_xhigh_po Rinv10ib W=10 L=49.614382
* tile Rinv10ib 8s x 8p same W=10 L=49.614382
XRinv10ibp0s0 in10n Rinv10ibt0s0 0 sky130_fd_pr__res_xhigh_po w=10 l=49.614382
XRinv10ibp0s1 Rinv10ibt0s0 Rinv10ibt0s1 0 sky130_fd_pr__res_xhigh_po w=10 l=49.614382
XRinv10ibp0s2 Rinv10ibt0s1 Rinv10ibt0s2 0 sky130_fd_pr__res_xhigh_po w=10 l=49.614382
XRinv10ibp0s3 Rinv10ibt0s2 Rinv10ibt0s3 0 sky130_fd_pr__res_xhigh_po w=10 l=49.614382
XRinv10ibp0s4 Rinv10ibt0s3 Rinv10ibt0s4 0 sky130_fd_pr__res_xhigh_po w=10 l=49.614382
XRinv10ibp0s5 Rinv10ibt0s4 Rinv10ibt0s5 0 sky130_fd_pr__res_xhigh_po w=10 l=49.614382
XRinv10ibp0s6 Rinv10ibt0s5 Rinv10ibt0s6 0 sky130_fd_pr__res_xhigh_po w=10 l=49.614382
XRinv10ibp0s7 Rinv10ibt0s6 inv10m 0 sky130_fd_pr__res_xhigh_po w=10 l=49.614382
XRinv10ibp1s0 in10n Rinv10ibt1s0 0 sky130_fd_pr__res_xhigh_po w=10 l=49.614382
XRinv10ibp1s1 Rinv10ibt1s0 Rinv10ibt1s1 0 sky130_fd_pr__res_xhigh_po w=10 l=49.614382
XRinv10ibp1s2 Rinv10ibt1s1 Rinv10ibt1s2 0 sky130_fd_pr__res_xhigh_po w=10 l=49.614382
XRinv10ibp1s3 Rinv10ibt1s2 Rinv10ibt1s3 0 sky130_fd_pr__res_xhigh_po w=10 l=49.614382
XRinv10ibp1s4 Rinv10ibt1s3 Rinv10ibt1s4 0 sky130_fd_pr__res_xhigh_po w=10 l=49.614382
XRinv10ibp1s5 Rinv10ibt1s4 Rinv10ibt1s5 0 sky130_fd_pr__res_xhigh_po w=10 l=49.614382
XRinv10ibp1s6 Rinv10ibt1s5 Rinv10ibt1s6 0 sky130_fd_pr__res_xhigh_po w=10 l=49.614382
XRinv10ibp1s7 Rinv10ibt1s6 inv10m 0 sky130_fd_pr__res_xhigh_po w=10 l=49.614382
XRinv10ibp2s0 in10n Rinv10ibt2s0 0 sky130_fd_pr__res_xhigh_po w=10 l=49.614382
XRinv10ibp2s1 Rinv10ibt2s0 Rinv10ibt2s1 0 sky130_fd_pr__res_xhigh_po w=10 l=49.614382
XRinv10ibp2s2 Rinv10ibt2s1 Rinv10ibt2s2 0 sky130_fd_pr__res_xhigh_po w=10 l=49.614382
XRinv10ibp2s3 Rinv10ibt2s2 Rinv10ibt2s3 0 sky130_fd_pr__res_xhigh_po w=10 l=49.614382
XRinv10ibp2s4 Rinv10ibt2s3 Rinv10ibt2s4 0 sky130_fd_pr__res_xhigh_po w=10 l=49.614382
XRinv10ibp2s5 Rinv10ibt2s4 Rinv10ibt2s5 0 sky130_fd_pr__res_xhigh_po w=10 l=49.614382
XRinv10ibp2s6 Rinv10ibt2s5 Rinv10ibt2s6 0 sky130_fd_pr__res_xhigh_po w=10 l=49.614382
XRinv10ibp2s7 Rinv10ibt2s6 inv10m 0 sky130_fd_pr__res_xhigh_po w=10 l=49.614382
XRinv10ibp3s0 in10n Rinv10ibt3s0 0 sky130_fd_pr__res_xhigh_po w=10 l=49.614382
XRinv10ibp3s1 Rinv10ibt3s0 Rinv10ibt3s1 0 sky130_fd_pr__res_xhigh_po w=10 l=49.614382
XRinv10ibp3s2 Rinv10ibt3s1 Rinv10ibt3s2 0 sky130_fd_pr__res_xhigh_po w=10 l=49.614382
XRinv10ibp3s3 Rinv10ibt3s2 Rinv10ibt3s3 0 sky130_fd_pr__res_xhigh_po w=10 l=49.614382
XRinv10ibp3s4 Rinv10ibt3s3 Rinv10ibt3s4 0 sky130_fd_pr__res_xhigh_po w=10 l=49.614382
XRinv10ibp3s5 Rinv10ibt3s4 Rinv10ibt3s5 0 sky130_fd_pr__res_xhigh_po w=10 l=49.614382
XRinv10ibp3s6 Rinv10ibt3s5 Rinv10ibt3s6 0 sky130_fd_pr__res_xhigh_po w=10 l=49.614382
XRinv10ibp3s7 Rinv10ibt3s6 inv10m 0 sky130_fd_pr__res_xhigh_po w=10 l=49.614382
XRinv10ibp4s0 in10n Rinv10ibt4s0 0 sky130_fd_pr__res_xhigh_po w=10 l=49.614382
XRinv10ibp4s1 Rinv10ibt4s0 Rinv10ibt4s1 0 sky130_fd_pr__res_xhigh_po w=10 l=49.614382
XRinv10ibp4s2 Rinv10ibt4s1 Rinv10ibt4s2 0 sky130_fd_pr__res_xhigh_po w=10 l=49.614382
XRinv10ibp4s3 Rinv10ibt4s2 Rinv10ibt4s3 0 sky130_fd_pr__res_xhigh_po w=10 l=49.614382
XRinv10ibp4s4 Rinv10ibt4s3 Rinv10ibt4s4 0 sky130_fd_pr__res_xhigh_po w=10 l=49.614382
XRinv10ibp4s5 Rinv10ibt4s4 Rinv10ibt4s5 0 sky130_fd_pr__res_xhigh_po w=10 l=49.614382
XRinv10ibp4s6 Rinv10ibt4s5 Rinv10ibt4s6 0 sky130_fd_pr__res_xhigh_po w=10 l=49.614382
XRinv10ibp4s7 Rinv10ibt4s6 inv10m 0 sky130_fd_pr__res_xhigh_po w=10 l=49.614382
XRinv10ibp5s0 in10n Rinv10ibt5s0 0 sky130_fd_pr__res_xhigh_po w=10 l=49.614382
XRinv10ibp5s1 Rinv10ibt5s0 Rinv10ibt5s1 0 sky130_fd_pr__res_xhigh_po w=10 l=49.614382
XRinv10ibp5s2 Rinv10ibt5s1 Rinv10ibt5s2 0 sky130_fd_pr__res_xhigh_po w=10 l=49.614382
XRinv10ibp5s3 Rinv10ibt5s2 Rinv10ibt5s3 0 sky130_fd_pr__res_xhigh_po w=10 l=49.614382
XRinv10ibp5s4 Rinv10ibt5s3 Rinv10ibt5s4 0 sky130_fd_pr__res_xhigh_po w=10 l=49.614382
XRinv10ibp5s5 Rinv10ibt5s4 Rinv10ibt5s5 0 sky130_fd_pr__res_xhigh_po w=10 l=49.614382
XRinv10ibp5s6 Rinv10ibt5s5 Rinv10ibt5s6 0 sky130_fd_pr__res_xhigh_po w=10 l=49.614382
XRinv10ibp5s7 Rinv10ibt5s6 inv10m 0 sky130_fd_pr__res_xhigh_po w=10 l=49.614382
XRinv10ibp6s0 in10n Rinv10ibt6s0 0 sky130_fd_pr__res_xhigh_po w=10 l=49.614382
XRinv10ibp6s1 Rinv10ibt6s0 Rinv10ibt6s1 0 sky130_fd_pr__res_xhigh_po w=10 l=49.614382
XRinv10ibp6s2 Rinv10ibt6s1 Rinv10ibt6s2 0 sky130_fd_pr__res_xhigh_po w=10 l=49.614382
XRinv10ibp6s3 Rinv10ibt6s2 Rinv10ibt6s3 0 sky130_fd_pr__res_xhigh_po w=10 l=49.614382
XRinv10ibp6s4 Rinv10ibt6s3 Rinv10ibt6s4 0 sky130_fd_pr__res_xhigh_po w=10 l=49.614382
XRinv10ibp6s5 Rinv10ibt6s4 Rinv10ibt6s5 0 sky130_fd_pr__res_xhigh_po w=10 l=49.614382
XRinv10ibp6s6 Rinv10ibt6s5 Rinv10ibt6s6 0 sky130_fd_pr__res_xhigh_po w=10 l=49.614382
XRinv10ibp6s7 Rinv10ibt6s6 inv10m 0 sky130_fd_pr__res_xhigh_po w=10 l=49.614382
XRinv10ibp7s0 in10n Rinv10ibt7s0 0 sky130_fd_pr__res_xhigh_po w=10 l=49.614382
XRinv10ibp7s1 Rinv10ibt7s0 Rinv10ibt7s1 0 sky130_fd_pr__res_xhigh_po w=10 l=49.614382
XRinv10ibp7s2 Rinv10ibt7s1 Rinv10ibt7s2 0 sky130_fd_pr__res_xhigh_po w=10 l=49.614382
XRinv10ibp7s3 Rinv10ibt7s2 Rinv10ibt7s3 0 sky130_fd_pr__res_xhigh_po w=10 l=49.614382
XRinv10ibp7s4 Rinv10ibt7s3 Rinv10ibt7s4 0 sky130_fd_pr__res_xhigh_po w=10 l=49.614382
XRinv10ibp7s5 Rinv10ibt7s4 Rinv10ibt7s5 0 sky130_fd_pr__res_xhigh_po w=10 l=49.614382
XRinv10ibp7s6 Rinv10ibt7s5 Rinv10ibt7s6 0 sky130_fd_pr__res_xhigh_po w=10 l=49.614382
XRinv10ibp7s7 Rinv10ibt7s6 inv10m 0 sky130_fd_pr__res_xhigh_po w=10 l=49.614382
Einv10amp in10n 0 0 inv10m 10000000
Vin11 in11 0 DC 0
Vin12 in12 0 DC 0
Vin13 in13 0 DC 0
Vin14 in14 0 DC 1.25893915448753
* passive invert in14 -> in14n: R2/R1=1.0000002 closed-loop -1 at A=1e+07
* PDK sky130_fd_pr__res_xhigh_po Rinv14ia W=10 L=49.614372
* tile Rinv14ia 8s x 8p same W=10 L=49.614372
XRinv14iap0s0 in14 Rinv14iat0s0 0 sky130_fd_pr__res_xhigh_po w=10 l=49.614372
XRinv14iap0s1 Rinv14iat0s0 Rinv14iat0s1 0 sky130_fd_pr__res_xhigh_po w=10 l=49.614372
XRinv14iap0s2 Rinv14iat0s1 Rinv14iat0s2 0 sky130_fd_pr__res_xhigh_po w=10 l=49.614372
XRinv14iap0s3 Rinv14iat0s2 Rinv14iat0s3 0 sky130_fd_pr__res_xhigh_po w=10 l=49.614372
XRinv14iap0s4 Rinv14iat0s3 Rinv14iat0s4 0 sky130_fd_pr__res_xhigh_po w=10 l=49.614372
XRinv14iap0s5 Rinv14iat0s4 Rinv14iat0s5 0 sky130_fd_pr__res_xhigh_po w=10 l=49.614372
XRinv14iap0s6 Rinv14iat0s5 Rinv14iat0s6 0 sky130_fd_pr__res_xhigh_po w=10 l=49.614372
XRinv14iap0s7 Rinv14iat0s6 inv14m 0 sky130_fd_pr__res_xhigh_po w=10 l=49.614372
XRinv14iap1s0 in14 Rinv14iat1s0 0 sky130_fd_pr__res_xhigh_po w=10 l=49.614372
XRinv14iap1s1 Rinv14iat1s0 Rinv14iat1s1 0 sky130_fd_pr__res_xhigh_po w=10 l=49.614372
XRinv14iap1s2 Rinv14iat1s1 Rinv14iat1s2 0 sky130_fd_pr__res_xhigh_po w=10 l=49.614372
XRinv14iap1s3 Rinv14iat1s2 Rinv14iat1s3 0 sky130_fd_pr__res_xhigh_po w=10 l=49.614372
XRinv14iap1s4 Rinv14iat1s3 Rinv14iat1s4 0 sky130_fd_pr__res_xhigh_po w=10 l=49.614372
XRinv14iap1s5 Rinv14iat1s4 Rinv14iat1s5 0 sky130_fd_pr__res_xhigh_po w=10 l=49.614372
XRinv14iap1s6 Rinv14iat1s5 Rinv14iat1s6 0 sky130_fd_pr__res_xhigh_po w=10 l=49.614372
XRinv14iap1s7 Rinv14iat1s6 inv14m 0 sky130_fd_pr__res_xhigh_po w=10 l=49.614372
XRinv14iap2s0 in14 Rinv14iat2s0 0 sky130_fd_pr__res_xhigh_po w=10 l=49.614372
XRinv14iap2s1 Rinv14iat2s0 Rinv14iat2s1 0 sky130_fd_pr__res_xhigh_po w=10 l=49.614372
XRinv14iap2s2 Rinv14iat2s1 Rinv14iat2s2 0 sky130_fd_pr__res_xhigh_po w=10 l=49.614372
XRinv14iap2s3 Rinv14iat2s2 Rinv14iat2s3 0 sky130_fd_pr__res_xhigh_po w=10 l=49.614372
XRinv14iap2s4 Rinv14iat2s3 Rinv14iat2s4 0 sky130_fd_pr__res_xhigh_po w=10 l=49.614372
XRinv14iap2s5 Rinv14iat2s4 Rinv14iat2s5 0 sky130_fd_pr__res_xhigh_po w=10 l=49.614372
XRinv14iap2s6 Rinv14iat2s5 Rinv14iat2s6 0 sky130_fd_pr__res_xhigh_po w=10 l=49.614372
XRinv14iap2s7 Rinv14iat2s6 inv14m 0 sky130_fd_pr__res_xhigh_po w=10 l=49.614372
XRinv14iap3s0 in14 Rinv14iat3s0 0 sky130_fd_pr__res_xhigh_po w=10 l=49.614372
XRinv14iap3s1 Rinv14iat3s0 Rinv14iat3s1 0 sky130_fd_pr__res_xhigh_po w=10 l=49.614372
XRinv14iap3s2 Rinv14iat3s1 Rinv14iat3s2 0 sky130_fd_pr__res_xhigh_po w=10 l=49.614372
XRinv14iap3s3 Rinv14iat3s2 Rinv14iat3s3 0 sky130_fd_pr__res_xhigh_po w=10 l=49.614372
XRinv14iap3s4 Rinv14iat3s3 Rinv14iat3s4 0 sky130_fd_pr__res_xhigh_po w=10 l=49.614372
XRinv14iap3s5 Rinv14iat3s4 Rinv14iat3s5 0 sky130_fd_pr__res_xhigh_po w=10 l=49.614372
XRinv14iap3s6 Rinv14iat3s5 Rinv14iat3s6 0 sky130_fd_pr__res_xhigh_po w=10 l=49.614372
XRinv14iap3s7 Rinv14iat3s6 inv14m 0 sky130_fd_pr__res_xhigh_po w=10 l=49.614372
XRinv14iap4s0 in14 Rinv14iat4s0 0 sky130_fd_pr__res_xhigh_po w=10 l=49.614372
XRinv14iap4s1 Rinv14iat4s0 Rinv14iat4s1 0 sky130_fd_pr__res_xhigh_po w=10 l=49.614372
XRinv14iap4s2 Rinv14iat4s1 Rinv14iat4s2 0 sky130_fd_pr__res_xhigh_po w=10 l=49.614372
XRinv14iap4s3 Rinv14iat4s2 Rinv14iat4s3 0 sky130_fd_pr__res_xhigh_po w=10 l=49.614372
XRinv14iap4s4 Rinv14iat4s3 Rinv14iat4s4 0 sky130_fd_pr__res_xhigh_po w=10 l=49.614372
XRinv14iap4s5 Rinv14iat4s4 Rinv14iat4s5 0 sky130_fd_pr__res_xhigh_po w=10 l=49.614372
XRinv14iap4s6 Rinv14iat4s5 Rinv14iat4s6 0 sky130_fd_pr__res_xhigh_po w=10 l=49.614372
XRinv14iap4s7 Rinv14iat4s6 inv14m 0 sky130_fd_pr__res_xhigh_po w=10 l=49.614372
XRinv14iap5s0 in14 Rinv14iat5s0 0 sky130_fd_pr__res_xhigh_po w=10 l=49.614372
XRinv14iap5s1 Rinv14iat5s0 Rinv14iat5s1 0 sky130_fd_pr__res_xhigh_po w=10 l=49.614372
XRinv14iap5s2 Rinv14iat5s1 Rinv14iat5s2 0 sky130_fd_pr__res_xhigh_po w=10 l=49.614372
XRinv14iap5s3 Rinv14iat5s2 Rinv14iat5s3 0 sky130_fd_pr__res_xhigh_po w=10 l=49.614372
XRinv14iap5s4 Rinv14iat5s3 Rinv14iat5s4 0 sky130_fd_pr__res_xhigh_po w=10 l=49.614372
XRinv14iap5s5 Rinv14iat5s4 Rinv14iat5s5 0 sky130_fd_pr__res_xhigh_po w=10 l=49.614372
XRinv14iap5s6 Rinv14iat5s5 Rinv14iat5s6 0 sky130_fd_pr__res_xhigh_po w=10 l=49.614372
XRinv14iap5s7 Rinv14iat5s6 inv14m 0 sky130_fd_pr__res_xhigh_po w=10 l=49.614372
XRinv14iap6s0 in14 Rinv14iat6s0 0 sky130_fd_pr__res_xhigh_po w=10 l=49.614372
XRinv14iap6s1 Rinv14iat6s0 Rinv14iat6s1 0 sky130_fd_pr__res_xhigh_po w=10 l=49.614372
XRinv14iap6s2 Rinv14iat6s1 Rinv14iat6s2 0 sky130_fd_pr__res_xhigh_po w=10 l=49.614372
XRinv14iap6s3 Rinv14iat6s2 Rinv14iat6s3 0 sky130_fd_pr__res_xhigh_po w=10 l=49.614372
XRinv14iap6s4 Rinv14iat6s3 Rinv14iat6s4 0 sky130_fd_pr__res_xhigh_po w=10 l=49.614372
XRinv14iap6s5 Rinv14iat6s4 Rinv14iat6s5 0 sky130_fd_pr__res_xhigh_po w=10 l=49.614372
XRinv14iap6s6 Rinv14iat6s5 Rinv14iat6s6 0 sky130_fd_pr__res_xhigh_po w=10 l=49.614372
XRinv14iap6s7 Rinv14iat6s6 inv14m 0 sky130_fd_pr__res_xhigh_po w=10 l=49.614372
XRinv14iap7s0 in14 Rinv14iat7s0 0 sky130_fd_pr__res_xhigh_po w=10 l=49.614372
XRinv14iap7s1 Rinv14iat7s0 Rinv14iat7s1 0 sky130_fd_pr__res_xhigh_po w=10 l=49.614372
XRinv14iap7s2 Rinv14iat7s1 Rinv14iat7s2 0 sky130_fd_pr__res_xhigh_po w=10 l=49.614372
XRinv14iap7s3 Rinv14iat7s2 Rinv14iat7s3 0 sky130_fd_pr__res_xhigh_po w=10 l=49.614372
XRinv14iap7s4 Rinv14iat7s3 Rinv14iat7s4 0 sky130_fd_pr__res_xhigh_po w=10 l=49.614372
XRinv14iap7s5 Rinv14iat7s4 Rinv14iat7s5 0 sky130_fd_pr__res_xhigh_po w=10 l=49.614372
XRinv14iap7s6 Rinv14iat7s5 Rinv14iat7s6 0 sky130_fd_pr__res_xhigh_po w=10 l=49.614372
XRinv14iap7s7 Rinv14iat7s6 inv14m 0 sky130_fd_pr__res_xhigh_po w=10 l=49.614372
* PDK sky130_fd_pr__res_xhigh_po Rinv14ib W=10 L=49.614382
* tile Rinv14ib 8s x 8p same W=10 L=49.614382
XRinv14ibp0s0 in14n Rinv14ibt0s0 0 sky130_fd_pr__res_xhigh_po w=10 l=49.614382
XRinv14ibp0s1 Rinv14ibt0s0 Rinv14ibt0s1 0 sky130_fd_pr__res_xhigh_po w=10 l=49.614382
XRinv14ibp0s2 Rinv14ibt0s1 Rinv14ibt0s2 0 sky130_fd_pr__res_xhigh_po w=10 l=49.614382
XRinv14ibp0s3 Rinv14ibt0s2 Rinv14ibt0s3 0 sky130_fd_pr__res_xhigh_po w=10 l=49.614382
XRinv14ibp0s4 Rinv14ibt0s3 Rinv14ibt0s4 0 sky130_fd_pr__res_xhigh_po w=10 l=49.614382
XRinv14ibp0s5 Rinv14ibt0s4 Rinv14ibt0s5 0 sky130_fd_pr__res_xhigh_po w=10 l=49.614382
XRinv14ibp0s6 Rinv14ibt0s5 Rinv14ibt0s6 0 sky130_fd_pr__res_xhigh_po w=10 l=49.614382
XRinv14ibp0s7 Rinv14ibt0s6 inv14m 0 sky130_fd_pr__res_xhigh_po w=10 l=49.614382
XRinv14ibp1s0 in14n Rinv14ibt1s0 0 sky130_fd_pr__res_xhigh_po w=10 l=49.614382
XRinv14ibp1s1 Rinv14ibt1s0 Rinv14ibt1s1 0 sky130_fd_pr__res_xhigh_po w=10 l=49.614382
XRinv14ibp1s2 Rinv14ibt1s1 Rinv14ibt1s2 0 sky130_fd_pr__res_xhigh_po w=10 l=49.614382
XRinv14ibp1s3 Rinv14ibt1s2 Rinv14ibt1s3 0 sky130_fd_pr__res_xhigh_po w=10 l=49.614382
XRinv14ibp1s4 Rinv14ibt1s3 Rinv14ibt1s4 0 sky130_fd_pr__res_xhigh_po w=10 l=49.614382
XRinv14ibp1s5 Rinv14ibt1s4 Rinv14ibt1s5 0 sky130_fd_pr__res_xhigh_po w=10 l=49.614382
XRinv14ibp1s6 Rinv14ibt1s5 Rinv14ibt1s6 0 sky130_fd_pr__res_xhigh_po w=10 l=49.614382
XRinv14ibp1s7 Rinv14ibt1s6 inv14m 0 sky130_fd_pr__res_xhigh_po w=10 l=49.614382
XRinv14ibp2s0 in14n Rinv14ibt2s0 0 sky130_fd_pr__res_xhigh_po w=10 l=49.614382
XRinv14ibp2s1 Rinv14ibt2s0 Rinv14ibt2s1 0 sky130_fd_pr__res_xhigh_po w=10 l=49.614382
XRinv14ibp2s2 Rinv14ibt2s1 Rinv14ibt2s2 0 sky130_fd_pr__res_xhigh_po w=10 l=49.614382
XRinv14ibp2s3 Rinv14ibt2s2 Rinv14ibt2s3 0 sky130_fd_pr__res_xhigh_po w=10 l=49.614382
XRinv14ibp2s4 Rinv14ibt2s3 Rinv14ibt2s4 0 sky130_fd_pr__res_xhigh_po w=10 l=49.614382
XRinv14ibp2s5 Rinv14ibt2s4 Rinv14ibt2s5 0 sky130_fd_pr__res_xhigh_po w=10 l=49.614382
XRinv14ibp2s6 Rinv14ibt2s5 Rinv14ibt2s6 0 sky130_fd_pr__res_xhigh_po w=10 l=49.614382
XRinv14ibp2s7 Rinv14ibt2s6 inv14m 0 sky130_fd_pr__res_xhigh_po w=10 l=49.614382
XRinv14ibp3s0 in14n Rinv14ibt3s0 0 sky130_fd_pr__res_xhigh_po w=10 l=49.614382
XRinv14ibp3s1 Rinv14ibt3s0 Rinv14ibt3s1 0 sky130_fd_pr__res_xhigh_po w=10 l=49.614382
XRinv14ibp3s2 Rinv14ibt3s1 Rinv14ibt3s2 0 sky130_fd_pr__res_xhigh_po w=10 l=49.614382
XRinv14ibp3s3 Rinv14ibt3s2 Rinv14ibt3s3 0 sky130_fd_pr__res_xhigh_po w=10 l=49.614382
XRinv14ibp3s4 Rinv14ibt3s3 Rinv14ibt3s4 0 sky130_fd_pr__res_xhigh_po w=10 l=49.614382
XRinv14ibp3s5 Rinv14ibt3s4 Rinv14ibt3s5 0 sky130_fd_pr__res_xhigh_po w=10 l=49.614382
XRinv14ibp3s6 Rinv14ibt3s5 Rinv14ibt3s6 0 sky130_fd_pr__res_xhigh_po w=10 l=49.614382
XRinv14ibp3s7 Rinv14ibt3s6 inv14m 0 sky130_fd_pr__res_xhigh_po w=10 l=49.614382
XRinv14ibp4s0 in14n Rinv14ibt4s0 0 sky130_fd_pr__res_xhigh_po w=10 l=49.614382
XRinv14ibp4s1 Rinv14ibt4s0 Rinv14ibt4s1 0 sky130_fd_pr__res_xhigh_po w=10 l=49.614382
XRinv14ibp4s2 Rinv14ibt4s1 Rinv14ibt4s2 0 sky130_fd_pr__res_xhigh_po w=10 l=49.614382
XRinv14ibp4s3 Rinv14ibt4s2 Rinv14ibt4s3 0 sky130_fd_pr__res_xhigh_po w=10 l=49.614382
XRinv14ibp4s4 Rinv14ibt4s3 Rinv14ibt4s4 0 sky130_fd_pr__res_xhigh_po w=10 l=49.614382
XRinv14ibp4s5 Rinv14ibt4s4 Rinv14ibt4s5 0 sky130_fd_pr__res_xhigh_po w=10 l=49.614382
XRinv14ibp4s6 Rinv14ibt4s5 Rinv14ibt4s6 0 sky130_fd_pr__res_xhigh_po w=10 l=49.614382
XRinv14ibp4s7 Rinv14ibt4s6 inv14m 0 sky130_fd_pr__res_xhigh_po w=10 l=49.614382
XRinv14ibp5s0 in14n Rinv14ibt5s0 0 sky130_fd_pr__res_xhigh_po w=10 l=49.614382
XRinv14ibp5s1 Rinv14ibt5s0 Rinv14ibt5s1 0 sky130_fd_pr__res_xhigh_po w=10 l=49.614382
XRinv14ibp5s2 Rinv14ibt5s1 Rinv14ibt5s2 0 sky130_fd_pr__res_xhigh_po w=10 l=49.614382
XRinv14ibp5s3 Rinv14ibt5s2 Rinv14ibt5s3 0 sky130_fd_pr__res_xhigh_po w=10 l=49.614382
XRinv14ibp5s4 Rinv14ibt5s3 Rinv14ibt5s4 0 sky130_fd_pr__res_xhigh_po w=10 l=49.614382
XRinv14ibp5s5 Rinv14ibt5s4 Rinv14ibt5s5 0 sky130_fd_pr__res_xhigh_po w=10 l=49.614382
XRinv14ibp5s6 Rinv14ibt5s5 Rinv14ibt5s6 0 sky130_fd_pr__res_xhigh_po w=10 l=49.614382
XRinv14ibp5s7 Rinv14ibt5s6 inv14m 0 sky130_fd_pr__res_xhigh_po w=10 l=49.614382
XRinv14ibp6s0 in14n Rinv14ibt6s0 0 sky130_fd_pr__res_xhigh_po w=10 l=49.614382
XRinv14ibp6s1 Rinv14ibt6s0 Rinv14ibt6s1 0 sky130_fd_pr__res_xhigh_po w=10 l=49.614382
XRinv14ibp6s2 Rinv14ibt6s1 Rinv14ibt6s2 0 sky130_fd_pr__res_xhigh_po w=10 l=49.614382
XRinv14ibp6s3 Rinv14ibt6s2 Rinv14ibt6s3 0 sky130_fd_pr__res_xhigh_po w=10 l=49.614382
XRinv14ibp6s4 Rinv14ibt6s3 Rinv14ibt6s4 0 sky130_fd_pr__res_xhigh_po w=10 l=49.614382
XRinv14ibp6s5 Rinv14ibt6s4 Rinv14ibt6s5 0 sky130_fd_pr__res_xhigh_po w=10 l=49.614382
XRinv14ibp6s6 Rinv14ibt6s5 Rinv14ibt6s6 0 sky130_fd_pr__res_xhigh_po w=10 l=49.614382
XRinv14ibp6s7 Rinv14ibt6s6 inv14m 0 sky130_fd_pr__res_xhigh_po w=10 l=49.614382
XRinv14ibp7s0 in14n Rinv14ibt7s0 0 sky130_fd_pr__res_xhigh_po w=10 l=49.614382
XRinv14ibp7s1 Rinv14ibt7s0 Rinv14ibt7s1 0 sky130_fd_pr__res_xhigh_po w=10 l=49.614382
XRinv14ibp7s2 Rinv14ibt7s1 Rinv14ibt7s2 0 sky130_fd_pr__res_xhigh_po w=10 l=49.614382
XRinv14ibp7s3 Rinv14ibt7s2 Rinv14ibt7s3 0 sky130_fd_pr__res_xhigh_po w=10 l=49.614382
XRinv14ibp7s4 Rinv14ibt7s3 Rinv14ibt7s4 0 sky130_fd_pr__res_xhigh_po w=10 l=49.614382
XRinv14ibp7s5 Rinv14ibt7s4 Rinv14ibt7s5 0 sky130_fd_pr__res_xhigh_po w=10 l=49.614382
XRinv14ibp7s6 Rinv14ibt7s5 Rinv14ibt7s6 0 sky130_fd_pr__res_xhigh_po w=10 l=49.614382
XRinv14ibp7s7 Rinv14ibt7s6 inv14m 0 sky130_fd_pr__res_xhigh_po w=10 l=49.614382
Einv14amp in14n 0 0 inv14m 10000000
Vin15 in15 0 DC 0.398142284790337
Vin16 in16 0 DC 0
* load-compensated divider in16->tap16: G_load=0.000666445780473128 Ra=599479.450040294 Rb=1000 target beta=0.001 (no tap buffer)
* PDK sky130_fd_pr__res_xhigh_po Rdiv16a W=10 L=2980.5062
* tile Rdiv16a 8s x 8p same W=10 L=2980.5062
XRdiv16ap0s0 in16 Rdiv16at0s0 0 sky130_fd_pr__res_xhigh_po w=10 l=2980.5062
XRdiv16ap0s1 Rdiv16at0s0 Rdiv16at0s1 0 sky130_fd_pr__res_xhigh_po w=10 l=2980.5062
XRdiv16ap0s2 Rdiv16at0s1 Rdiv16at0s2 0 sky130_fd_pr__res_xhigh_po w=10 l=2980.5062
XRdiv16ap0s3 Rdiv16at0s2 Rdiv16at0s3 0 sky130_fd_pr__res_xhigh_po w=10 l=2980.5062
XRdiv16ap0s4 Rdiv16at0s3 Rdiv16at0s4 0 sky130_fd_pr__res_xhigh_po w=10 l=2980.5062
XRdiv16ap0s5 Rdiv16at0s4 Rdiv16at0s5 0 sky130_fd_pr__res_xhigh_po w=10 l=2980.5062
XRdiv16ap0s6 Rdiv16at0s5 Rdiv16at0s6 0 sky130_fd_pr__res_xhigh_po w=10 l=2980.5062
XRdiv16ap0s7 Rdiv16at0s6 tap16 0 sky130_fd_pr__res_xhigh_po w=10 l=2980.5062
XRdiv16ap1s0 in16 Rdiv16at1s0 0 sky130_fd_pr__res_xhigh_po w=10 l=2980.5062
XRdiv16ap1s1 Rdiv16at1s0 Rdiv16at1s1 0 sky130_fd_pr__res_xhigh_po w=10 l=2980.5062
XRdiv16ap1s2 Rdiv16at1s1 Rdiv16at1s2 0 sky130_fd_pr__res_xhigh_po w=10 l=2980.5062
XRdiv16ap1s3 Rdiv16at1s2 Rdiv16at1s3 0 sky130_fd_pr__res_xhigh_po w=10 l=2980.5062
XRdiv16ap1s4 Rdiv16at1s3 Rdiv16at1s4 0 sky130_fd_pr__res_xhigh_po w=10 l=2980.5062
XRdiv16ap1s5 Rdiv16at1s4 Rdiv16at1s5 0 sky130_fd_pr__res_xhigh_po w=10 l=2980.5062
XRdiv16ap1s6 Rdiv16at1s5 Rdiv16at1s6 0 sky130_fd_pr__res_xhigh_po w=10 l=2980.5062
XRdiv16ap1s7 Rdiv16at1s6 tap16 0 sky130_fd_pr__res_xhigh_po w=10 l=2980.5062
XRdiv16ap2s0 in16 Rdiv16at2s0 0 sky130_fd_pr__res_xhigh_po w=10 l=2980.5062
XRdiv16ap2s1 Rdiv16at2s0 Rdiv16at2s1 0 sky130_fd_pr__res_xhigh_po w=10 l=2980.5062
XRdiv16ap2s2 Rdiv16at2s1 Rdiv16at2s2 0 sky130_fd_pr__res_xhigh_po w=10 l=2980.5062
XRdiv16ap2s3 Rdiv16at2s2 Rdiv16at2s3 0 sky130_fd_pr__res_xhigh_po w=10 l=2980.5062
XRdiv16ap2s4 Rdiv16at2s3 Rdiv16at2s4 0 sky130_fd_pr__res_xhigh_po w=10 l=2980.5062
XRdiv16ap2s5 Rdiv16at2s4 Rdiv16at2s5 0 sky130_fd_pr__res_xhigh_po w=10 l=2980.5062
XRdiv16ap2s6 Rdiv16at2s5 Rdiv16at2s6 0 sky130_fd_pr__res_xhigh_po w=10 l=2980.5062
XRdiv16ap2s7 Rdiv16at2s6 tap16 0 sky130_fd_pr__res_xhigh_po w=10 l=2980.5062
XRdiv16ap3s0 in16 Rdiv16at3s0 0 sky130_fd_pr__res_xhigh_po w=10 l=2980.5062
XRdiv16ap3s1 Rdiv16at3s0 Rdiv16at3s1 0 sky130_fd_pr__res_xhigh_po w=10 l=2980.5062
XRdiv16ap3s2 Rdiv16at3s1 Rdiv16at3s2 0 sky130_fd_pr__res_xhigh_po w=10 l=2980.5062
XRdiv16ap3s3 Rdiv16at3s2 Rdiv16at3s3 0 sky130_fd_pr__res_xhigh_po w=10 l=2980.5062
XRdiv16ap3s4 Rdiv16at3s3 Rdiv16at3s4 0 sky130_fd_pr__res_xhigh_po w=10 l=2980.5062
XRdiv16ap3s5 Rdiv16at3s4 Rdiv16at3s5 0 sky130_fd_pr__res_xhigh_po w=10 l=2980.5062
XRdiv16ap3s6 Rdiv16at3s5 Rdiv16at3s6 0 sky130_fd_pr__res_xhigh_po w=10 l=2980.5062
XRdiv16ap3s7 Rdiv16at3s6 tap16 0 sky130_fd_pr__res_xhigh_po w=10 l=2980.5062
XRdiv16ap4s0 in16 Rdiv16at4s0 0 sky130_fd_pr__res_xhigh_po w=10 l=2980.5062
XRdiv16ap4s1 Rdiv16at4s0 Rdiv16at4s1 0 sky130_fd_pr__res_xhigh_po w=10 l=2980.5062
XRdiv16ap4s2 Rdiv16at4s1 Rdiv16at4s2 0 sky130_fd_pr__res_xhigh_po w=10 l=2980.5062
XRdiv16ap4s3 Rdiv16at4s2 Rdiv16at4s3 0 sky130_fd_pr__res_xhigh_po w=10 l=2980.5062
XRdiv16ap4s4 Rdiv16at4s3 Rdiv16at4s4 0 sky130_fd_pr__res_xhigh_po w=10 l=2980.5062
XRdiv16ap4s5 Rdiv16at4s4 Rdiv16at4s5 0 sky130_fd_pr__res_xhigh_po w=10 l=2980.5062
XRdiv16ap4s6 Rdiv16at4s5 Rdiv16at4s6 0 sky130_fd_pr__res_xhigh_po w=10 l=2980.5062
XRdiv16ap4s7 Rdiv16at4s6 tap16 0 sky130_fd_pr__res_xhigh_po w=10 l=2980.5062
XRdiv16ap5s0 in16 Rdiv16at5s0 0 sky130_fd_pr__res_xhigh_po w=10 l=2980.5062
XRdiv16ap5s1 Rdiv16at5s0 Rdiv16at5s1 0 sky130_fd_pr__res_xhigh_po w=10 l=2980.5062
XRdiv16ap5s2 Rdiv16at5s1 Rdiv16at5s2 0 sky130_fd_pr__res_xhigh_po w=10 l=2980.5062
XRdiv16ap5s3 Rdiv16at5s2 Rdiv16at5s3 0 sky130_fd_pr__res_xhigh_po w=10 l=2980.5062
XRdiv16ap5s4 Rdiv16at5s3 Rdiv16at5s4 0 sky130_fd_pr__res_xhigh_po w=10 l=2980.5062
XRdiv16ap5s5 Rdiv16at5s4 Rdiv16at5s5 0 sky130_fd_pr__res_xhigh_po w=10 l=2980.5062
XRdiv16ap5s6 Rdiv16at5s5 Rdiv16at5s6 0 sky130_fd_pr__res_xhigh_po w=10 l=2980.5062
XRdiv16ap5s7 Rdiv16at5s6 tap16 0 sky130_fd_pr__res_xhigh_po w=10 l=2980.5062
XRdiv16ap6s0 in16 Rdiv16at6s0 0 sky130_fd_pr__res_xhigh_po w=10 l=2980.5062
XRdiv16ap6s1 Rdiv16at6s0 Rdiv16at6s1 0 sky130_fd_pr__res_xhigh_po w=10 l=2980.5062
XRdiv16ap6s2 Rdiv16at6s1 Rdiv16at6s2 0 sky130_fd_pr__res_xhigh_po w=10 l=2980.5062
XRdiv16ap6s3 Rdiv16at6s2 Rdiv16at6s3 0 sky130_fd_pr__res_xhigh_po w=10 l=2980.5062
XRdiv16ap6s4 Rdiv16at6s3 Rdiv16at6s4 0 sky130_fd_pr__res_xhigh_po w=10 l=2980.5062
XRdiv16ap6s5 Rdiv16at6s4 Rdiv16at6s5 0 sky130_fd_pr__res_xhigh_po w=10 l=2980.5062
XRdiv16ap6s6 Rdiv16at6s5 Rdiv16at6s6 0 sky130_fd_pr__res_xhigh_po w=10 l=2980.5062
XRdiv16ap6s7 Rdiv16at6s6 tap16 0 sky130_fd_pr__res_xhigh_po w=10 l=2980.5062
XRdiv16ap7s0 in16 Rdiv16at7s0 0 sky130_fd_pr__res_xhigh_po w=10 l=2980.5062
XRdiv16ap7s1 Rdiv16at7s0 Rdiv16at7s1 0 sky130_fd_pr__res_xhigh_po w=10 l=2980.5062
XRdiv16ap7s2 Rdiv16at7s1 Rdiv16at7s2 0 sky130_fd_pr__res_xhigh_po w=10 l=2980.5062
XRdiv16ap7s3 Rdiv16at7s2 Rdiv16at7s3 0 sky130_fd_pr__res_xhigh_po w=10 l=2980.5062
XRdiv16ap7s4 Rdiv16at7s3 Rdiv16at7s4 0 sky130_fd_pr__res_xhigh_po w=10 l=2980.5062
XRdiv16ap7s5 Rdiv16at7s4 Rdiv16at7s5 0 sky130_fd_pr__res_xhigh_po w=10 l=2980.5062
XRdiv16ap7s6 Rdiv16at7s5 Rdiv16at7s6 0 sky130_fd_pr__res_xhigh_po w=10 l=2980.5062
XRdiv16ap7s7 Rdiv16at7s6 tap16 0 sky130_fd_pr__res_xhigh_po w=10 l=2980.5062
* PDK sky130_fd_pr__res_xhigh_po Rdiv16b W=10 L=4.8663717
* tile Rdiv16b 8s x 8p same W=10 L=4.8663717
XRdiv16bp0s0 tap16 Rdiv16bt0s0 0 sky130_fd_pr__res_xhigh_po w=10 l=4.8663717
XRdiv16bp0s1 Rdiv16bt0s0 Rdiv16bt0s1 0 sky130_fd_pr__res_xhigh_po w=10 l=4.8663717
XRdiv16bp0s2 Rdiv16bt0s1 Rdiv16bt0s2 0 sky130_fd_pr__res_xhigh_po w=10 l=4.8663717
XRdiv16bp0s3 Rdiv16bt0s2 Rdiv16bt0s3 0 sky130_fd_pr__res_xhigh_po w=10 l=4.8663717
XRdiv16bp0s4 Rdiv16bt0s3 Rdiv16bt0s4 0 sky130_fd_pr__res_xhigh_po w=10 l=4.8663717
XRdiv16bp0s5 Rdiv16bt0s4 Rdiv16bt0s5 0 sky130_fd_pr__res_xhigh_po w=10 l=4.8663717
XRdiv16bp0s6 Rdiv16bt0s5 Rdiv16bt0s6 0 sky130_fd_pr__res_xhigh_po w=10 l=4.8663717
XRdiv16bp0s7 Rdiv16bt0s6 0 0 sky130_fd_pr__res_xhigh_po w=10 l=4.8663717
XRdiv16bp1s0 tap16 Rdiv16bt1s0 0 sky130_fd_pr__res_xhigh_po w=10 l=4.8663717
XRdiv16bp1s1 Rdiv16bt1s0 Rdiv16bt1s1 0 sky130_fd_pr__res_xhigh_po w=10 l=4.8663717
XRdiv16bp1s2 Rdiv16bt1s1 Rdiv16bt1s2 0 sky130_fd_pr__res_xhigh_po w=10 l=4.8663717
XRdiv16bp1s3 Rdiv16bt1s2 Rdiv16bt1s3 0 sky130_fd_pr__res_xhigh_po w=10 l=4.8663717
XRdiv16bp1s4 Rdiv16bt1s3 Rdiv16bt1s4 0 sky130_fd_pr__res_xhigh_po w=10 l=4.8663717
XRdiv16bp1s5 Rdiv16bt1s4 Rdiv16bt1s5 0 sky130_fd_pr__res_xhigh_po w=10 l=4.8663717
XRdiv16bp1s6 Rdiv16bt1s5 Rdiv16bt1s6 0 sky130_fd_pr__res_xhigh_po w=10 l=4.8663717
XRdiv16bp1s7 Rdiv16bt1s6 0 0 sky130_fd_pr__res_xhigh_po w=10 l=4.8663717
XRdiv16bp2s0 tap16 Rdiv16bt2s0 0 sky130_fd_pr__res_xhigh_po w=10 l=4.8663717
XRdiv16bp2s1 Rdiv16bt2s0 Rdiv16bt2s1 0 sky130_fd_pr__res_xhigh_po w=10 l=4.8663717
XRdiv16bp2s2 Rdiv16bt2s1 Rdiv16bt2s2 0 sky130_fd_pr__res_xhigh_po w=10 l=4.8663717
XRdiv16bp2s3 Rdiv16bt2s2 Rdiv16bt2s3 0 sky130_fd_pr__res_xhigh_po w=10 l=4.8663717
XRdiv16bp2s4 Rdiv16bt2s3 Rdiv16bt2s4 0 sky130_fd_pr__res_xhigh_po w=10 l=4.8663717
XRdiv16bp2s5 Rdiv16bt2s4 Rdiv16bt2s5 0 sky130_fd_pr__res_xhigh_po w=10 l=4.8663717
XRdiv16bp2s6 Rdiv16bt2s5 Rdiv16bt2s6 0 sky130_fd_pr__res_xhigh_po w=10 l=4.8663717
XRdiv16bp2s7 Rdiv16bt2s6 0 0 sky130_fd_pr__res_xhigh_po w=10 l=4.8663717
XRdiv16bp3s0 tap16 Rdiv16bt3s0 0 sky130_fd_pr__res_xhigh_po w=10 l=4.8663717
XRdiv16bp3s1 Rdiv16bt3s0 Rdiv16bt3s1 0 sky130_fd_pr__res_xhigh_po w=10 l=4.8663717
XRdiv16bp3s2 Rdiv16bt3s1 Rdiv16bt3s2 0 sky130_fd_pr__res_xhigh_po w=10 l=4.8663717
XRdiv16bp3s3 Rdiv16bt3s2 Rdiv16bt3s3 0 sky130_fd_pr__res_xhigh_po w=10 l=4.8663717
XRdiv16bp3s4 Rdiv16bt3s3 Rdiv16bt3s4 0 sky130_fd_pr__res_xhigh_po w=10 l=4.8663717
XRdiv16bp3s5 Rdiv16bt3s4 Rdiv16bt3s5 0 sky130_fd_pr__res_xhigh_po w=10 l=4.8663717
XRdiv16bp3s6 Rdiv16bt3s5 Rdiv16bt3s6 0 sky130_fd_pr__res_xhigh_po w=10 l=4.8663717
XRdiv16bp3s7 Rdiv16bt3s6 0 0 sky130_fd_pr__res_xhigh_po w=10 l=4.8663717
XRdiv16bp4s0 tap16 Rdiv16bt4s0 0 sky130_fd_pr__res_xhigh_po w=10 l=4.8663717
XRdiv16bp4s1 Rdiv16bt4s0 Rdiv16bt4s1 0 sky130_fd_pr__res_xhigh_po w=10 l=4.8663717
XRdiv16bp4s2 Rdiv16bt4s1 Rdiv16bt4s2 0 sky130_fd_pr__res_xhigh_po w=10 l=4.8663717
XRdiv16bp4s3 Rdiv16bt4s2 Rdiv16bt4s3 0 sky130_fd_pr__res_xhigh_po w=10 l=4.8663717
XRdiv16bp4s4 Rdiv16bt4s3 Rdiv16bt4s4 0 sky130_fd_pr__res_xhigh_po w=10 l=4.8663717
XRdiv16bp4s5 Rdiv16bt4s4 Rdiv16bt4s5 0 sky130_fd_pr__res_xhigh_po w=10 l=4.8663717
XRdiv16bp4s6 Rdiv16bt4s5 Rdiv16bt4s6 0 sky130_fd_pr__res_xhigh_po w=10 l=4.8663717
XRdiv16bp4s7 Rdiv16bt4s6 0 0 sky130_fd_pr__res_xhigh_po w=10 l=4.8663717
XRdiv16bp5s0 tap16 Rdiv16bt5s0 0 sky130_fd_pr__res_xhigh_po w=10 l=4.8663717
XRdiv16bp5s1 Rdiv16bt5s0 Rdiv16bt5s1 0 sky130_fd_pr__res_xhigh_po w=10 l=4.8663717
XRdiv16bp5s2 Rdiv16bt5s1 Rdiv16bt5s2 0 sky130_fd_pr__res_xhigh_po w=10 l=4.8663717
XRdiv16bp5s3 Rdiv16bt5s2 Rdiv16bt5s3 0 sky130_fd_pr__res_xhigh_po w=10 l=4.8663717
XRdiv16bp5s4 Rdiv16bt5s3 Rdiv16bt5s4 0 sky130_fd_pr__res_xhigh_po w=10 l=4.8663717
XRdiv16bp5s5 Rdiv16bt5s4 Rdiv16bt5s5 0 sky130_fd_pr__res_xhigh_po w=10 l=4.8663717
XRdiv16bp5s6 Rdiv16bt5s5 Rdiv16bt5s6 0 sky130_fd_pr__res_xhigh_po w=10 l=4.8663717
XRdiv16bp5s7 Rdiv16bt5s6 0 0 sky130_fd_pr__res_xhigh_po w=10 l=4.8663717
XRdiv16bp6s0 tap16 Rdiv16bt6s0 0 sky130_fd_pr__res_xhigh_po w=10 l=4.8663717
XRdiv16bp6s1 Rdiv16bt6s0 Rdiv16bt6s1 0 sky130_fd_pr__res_xhigh_po w=10 l=4.8663717
XRdiv16bp6s2 Rdiv16bt6s1 Rdiv16bt6s2 0 sky130_fd_pr__res_xhigh_po w=10 l=4.8663717
XRdiv16bp6s3 Rdiv16bt6s2 Rdiv16bt6s3 0 sky130_fd_pr__res_xhigh_po w=10 l=4.8663717
XRdiv16bp6s4 Rdiv16bt6s3 Rdiv16bt6s4 0 sky130_fd_pr__res_xhigh_po w=10 l=4.8663717
XRdiv16bp6s5 Rdiv16bt6s4 Rdiv16bt6s5 0 sky130_fd_pr__res_xhigh_po w=10 l=4.8663717
XRdiv16bp6s6 Rdiv16bt6s5 Rdiv16bt6s6 0 sky130_fd_pr__res_xhigh_po w=10 l=4.8663717
XRdiv16bp6s7 Rdiv16bt6s6 0 0 sky130_fd_pr__res_xhigh_po w=10 l=4.8663717
XRdiv16bp7s0 tap16 Rdiv16bt7s0 0 sky130_fd_pr__res_xhigh_po w=10 l=4.8663717
XRdiv16bp7s1 Rdiv16bt7s0 Rdiv16bt7s1 0 sky130_fd_pr__res_xhigh_po w=10 l=4.8663717
XRdiv16bp7s2 Rdiv16bt7s1 Rdiv16bt7s2 0 sky130_fd_pr__res_xhigh_po w=10 l=4.8663717
XRdiv16bp7s3 Rdiv16bt7s2 Rdiv16bt7s3 0 sky130_fd_pr__res_xhigh_po w=10 l=4.8663717
XRdiv16bp7s4 Rdiv16bt7s3 Rdiv16bt7s4 0 sky130_fd_pr__res_xhigh_po w=10 l=4.8663717
XRdiv16bp7s5 Rdiv16bt7s4 Rdiv16bt7s5 0 sky130_fd_pr__res_xhigh_po w=10 l=4.8663717
XRdiv16bp7s6 Rdiv16bt7s5 Rdiv16bt7s6 0 sky130_fd_pr__res_xhigh_po w=10 l=4.8663717
XRdiv16bp7s7 Rdiv16bt7s6 0 0 sky130_fd_pr__res_xhigh_po w=10 l=4.8663717
Vin17 in17 0 DC 0
* passive invert in17 -> in17n: R2/R1=1.0000002 closed-loop -1 at A=1e+07
* PDK sky130_fd_pr__res_xhigh_po Rinv17ia W=10 L=49.614372
* tile Rinv17ia 8s x 8p same W=10 L=49.614372
XRinv17iap0s0 in17 Rinv17iat0s0 0 sky130_fd_pr__res_xhigh_po w=10 l=49.614372
XRinv17iap0s1 Rinv17iat0s0 Rinv17iat0s1 0 sky130_fd_pr__res_xhigh_po w=10 l=49.614372
XRinv17iap0s2 Rinv17iat0s1 Rinv17iat0s2 0 sky130_fd_pr__res_xhigh_po w=10 l=49.614372
XRinv17iap0s3 Rinv17iat0s2 Rinv17iat0s3 0 sky130_fd_pr__res_xhigh_po w=10 l=49.614372
XRinv17iap0s4 Rinv17iat0s3 Rinv17iat0s4 0 sky130_fd_pr__res_xhigh_po w=10 l=49.614372
XRinv17iap0s5 Rinv17iat0s4 Rinv17iat0s5 0 sky130_fd_pr__res_xhigh_po w=10 l=49.614372
XRinv17iap0s6 Rinv17iat0s5 Rinv17iat0s6 0 sky130_fd_pr__res_xhigh_po w=10 l=49.614372
XRinv17iap0s7 Rinv17iat0s6 inv17m 0 sky130_fd_pr__res_xhigh_po w=10 l=49.614372
XRinv17iap1s0 in17 Rinv17iat1s0 0 sky130_fd_pr__res_xhigh_po w=10 l=49.614372
XRinv17iap1s1 Rinv17iat1s0 Rinv17iat1s1 0 sky130_fd_pr__res_xhigh_po w=10 l=49.614372
XRinv17iap1s2 Rinv17iat1s1 Rinv17iat1s2 0 sky130_fd_pr__res_xhigh_po w=10 l=49.614372
XRinv17iap1s3 Rinv17iat1s2 Rinv17iat1s3 0 sky130_fd_pr__res_xhigh_po w=10 l=49.614372
XRinv17iap1s4 Rinv17iat1s3 Rinv17iat1s4 0 sky130_fd_pr__res_xhigh_po w=10 l=49.614372
XRinv17iap1s5 Rinv17iat1s4 Rinv17iat1s5 0 sky130_fd_pr__res_xhigh_po w=10 l=49.614372
XRinv17iap1s6 Rinv17iat1s5 Rinv17iat1s6 0 sky130_fd_pr__res_xhigh_po w=10 l=49.614372
XRinv17iap1s7 Rinv17iat1s6 inv17m 0 sky130_fd_pr__res_xhigh_po w=10 l=49.614372
XRinv17iap2s0 in17 Rinv17iat2s0 0 sky130_fd_pr__res_xhigh_po w=10 l=49.614372
XRinv17iap2s1 Rinv17iat2s0 Rinv17iat2s1 0 sky130_fd_pr__res_xhigh_po w=10 l=49.614372
XRinv17iap2s2 Rinv17iat2s1 Rinv17iat2s2 0 sky130_fd_pr__res_xhigh_po w=10 l=49.614372
XRinv17iap2s3 Rinv17iat2s2 Rinv17iat2s3 0 sky130_fd_pr__res_xhigh_po w=10 l=49.614372
XRinv17iap2s4 Rinv17iat2s3 Rinv17iat2s4 0 sky130_fd_pr__res_xhigh_po w=10 l=49.614372
XRinv17iap2s5 Rinv17iat2s4 Rinv17iat2s5 0 sky130_fd_pr__res_xhigh_po w=10 l=49.614372
XRinv17iap2s6 Rinv17iat2s5 Rinv17iat2s6 0 sky130_fd_pr__res_xhigh_po w=10 l=49.614372
XRinv17iap2s7 Rinv17iat2s6 inv17m 0 sky130_fd_pr__res_xhigh_po w=10 l=49.614372
XRinv17iap3s0 in17 Rinv17iat3s0 0 sky130_fd_pr__res_xhigh_po w=10 l=49.614372
XRinv17iap3s1 Rinv17iat3s0 Rinv17iat3s1 0 sky130_fd_pr__res_xhigh_po w=10 l=49.614372
XRinv17iap3s2 Rinv17iat3s1 Rinv17iat3s2 0 sky130_fd_pr__res_xhigh_po w=10 l=49.614372
XRinv17iap3s3 Rinv17iat3s2 Rinv17iat3s3 0 sky130_fd_pr__res_xhigh_po w=10 l=49.614372
XRinv17iap3s4 Rinv17iat3s3 Rinv17iat3s4 0 sky130_fd_pr__res_xhigh_po w=10 l=49.614372
XRinv17iap3s5 Rinv17iat3s4 Rinv17iat3s5 0 sky130_fd_pr__res_xhigh_po w=10 l=49.614372
XRinv17iap3s6 Rinv17iat3s5 Rinv17iat3s6 0 sky130_fd_pr__res_xhigh_po w=10 l=49.614372
XRinv17iap3s7 Rinv17iat3s6 inv17m 0 sky130_fd_pr__res_xhigh_po w=10 l=49.614372
XRinv17iap4s0 in17 Rinv17iat4s0 0 sky130_fd_pr__res_xhigh_po w=10 l=49.614372
XRinv17iap4s1 Rinv17iat4s0 Rinv17iat4s1 0 sky130_fd_pr__res_xhigh_po w=10 l=49.614372
XRinv17iap4s2 Rinv17iat4s1 Rinv17iat4s2 0 sky130_fd_pr__res_xhigh_po w=10 l=49.614372
XRinv17iap4s3 Rinv17iat4s2 Rinv17iat4s3 0 sky130_fd_pr__res_xhigh_po w=10 l=49.614372
XRinv17iap4s4 Rinv17iat4s3 Rinv17iat4s4 0 sky130_fd_pr__res_xhigh_po w=10 l=49.614372
XRinv17iap4s5 Rinv17iat4s4 Rinv17iat4s5 0 sky130_fd_pr__res_xhigh_po w=10 l=49.614372
XRinv17iap4s6 Rinv17iat4s5 Rinv17iat4s6 0 sky130_fd_pr__res_xhigh_po w=10 l=49.614372
XRinv17iap4s7 Rinv17iat4s6 inv17m 0 sky130_fd_pr__res_xhigh_po w=10 l=49.614372
XRinv17iap5s0 in17 Rinv17iat5s0 0 sky130_fd_pr__res_xhigh_po w=10 l=49.614372
XRinv17iap5s1 Rinv17iat5s0 Rinv17iat5s1 0 sky130_fd_pr__res_xhigh_po w=10 l=49.614372
XRinv17iap5s2 Rinv17iat5s1 Rinv17iat5s2 0 sky130_fd_pr__res_xhigh_po w=10 l=49.614372
XRinv17iap5s3 Rinv17iat5s2 Rinv17iat5s3 0 sky130_fd_pr__res_xhigh_po w=10 l=49.614372
XRinv17iap5s4 Rinv17iat5s3 Rinv17iat5s4 0 sky130_fd_pr__res_xhigh_po w=10 l=49.614372
XRinv17iap5s5 Rinv17iat5s4 Rinv17iat5s5 0 sky130_fd_pr__res_xhigh_po w=10 l=49.614372
XRinv17iap5s6 Rinv17iat5s5 Rinv17iat5s6 0 sky130_fd_pr__res_xhigh_po w=10 l=49.614372
XRinv17iap5s7 Rinv17iat5s6 inv17m 0 sky130_fd_pr__res_xhigh_po w=10 l=49.614372
XRinv17iap6s0 in17 Rinv17iat6s0 0 sky130_fd_pr__res_xhigh_po w=10 l=49.614372
XRinv17iap6s1 Rinv17iat6s0 Rinv17iat6s1 0 sky130_fd_pr__res_xhigh_po w=10 l=49.614372
XRinv17iap6s2 Rinv17iat6s1 Rinv17iat6s2 0 sky130_fd_pr__res_xhigh_po w=10 l=49.614372
XRinv17iap6s3 Rinv17iat6s2 Rinv17iat6s3 0 sky130_fd_pr__res_xhigh_po w=10 l=49.614372
XRinv17iap6s4 Rinv17iat6s3 Rinv17iat6s4 0 sky130_fd_pr__res_xhigh_po w=10 l=49.614372
XRinv17iap6s5 Rinv17iat6s4 Rinv17iat6s5 0 sky130_fd_pr__res_xhigh_po w=10 l=49.614372
XRinv17iap6s6 Rinv17iat6s5 Rinv17iat6s6 0 sky130_fd_pr__res_xhigh_po w=10 l=49.614372
XRinv17iap6s7 Rinv17iat6s6 inv17m 0 sky130_fd_pr__res_xhigh_po w=10 l=49.614372
XRinv17iap7s0 in17 Rinv17iat7s0 0 sky130_fd_pr__res_xhigh_po w=10 l=49.614372
XRinv17iap7s1 Rinv17iat7s0 Rinv17iat7s1 0 sky130_fd_pr__res_xhigh_po w=10 l=49.614372
XRinv17iap7s2 Rinv17iat7s1 Rinv17iat7s2 0 sky130_fd_pr__res_xhigh_po w=10 l=49.614372
XRinv17iap7s3 Rinv17iat7s2 Rinv17iat7s3 0 sky130_fd_pr__res_xhigh_po w=10 l=49.614372
XRinv17iap7s4 Rinv17iat7s3 Rinv17iat7s4 0 sky130_fd_pr__res_xhigh_po w=10 l=49.614372
XRinv17iap7s5 Rinv17iat7s4 Rinv17iat7s5 0 sky130_fd_pr__res_xhigh_po w=10 l=49.614372
XRinv17iap7s6 Rinv17iat7s5 Rinv17iat7s6 0 sky130_fd_pr__res_xhigh_po w=10 l=49.614372
XRinv17iap7s7 Rinv17iat7s6 inv17m 0 sky130_fd_pr__res_xhigh_po w=10 l=49.614372
* PDK sky130_fd_pr__res_xhigh_po Rinv17ib W=10 L=49.614382
* tile Rinv17ib 8s x 8p same W=10 L=49.614382
XRinv17ibp0s0 in17n Rinv17ibt0s0 0 sky130_fd_pr__res_xhigh_po w=10 l=49.614382
XRinv17ibp0s1 Rinv17ibt0s0 Rinv17ibt0s1 0 sky130_fd_pr__res_xhigh_po w=10 l=49.614382
XRinv17ibp0s2 Rinv17ibt0s1 Rinv17ibt0s2 0 sky130_fd_pr__res_xhigh_po w=10 l=49.614382
XRinv17ibp0s3 Rinv17ibt0s2 Rinv17ibt0s3 0 sky130_fd_pr__res_xhigh_po w=10 l=49.614382
XRinv17ibp0s4 Rinv17ibt0s3 Rinv17ibt0s4 0 sky130_fd_pr__res_xhigh_po w=10 l=49.614382
XRinv17ibp0s5 Rinv17ibt0s4 Rinv17ibt0s5 0 sky130_fd_pr__res_xhigh_po w=10 l=49.614382
XRinv17ibp0s6 Rinv17ibt0s5 Rinv17ibt0s6 0 sky130_fd_pr__res_xhigh_po w=10 l=49.614382
XRinv17ibp0s7 Rinv17ibt0s6 inv17m 0 sky130_fd_pr__res_xhigh_po w=10 l=49.614382
XRinv17ibp1s0 in17n Rinv17ibt1s0 0 sky130_fd_pr__res_xhigh_po w=10 l=49.614382
XRinv17ibp1s1 Rinv17ibt1s0 Rinv17ibt1s1 0 sky130_fd_pr__res_xhigh_po w=10 l=49.614382
XRinv17ibp1s2 Rinv17ibt1s1 Rinv17ibt1s2 0 sky130_fd_pr__res_xhigh_po w=10 l=49.614382
XRinv17ibp1s3 Rinv17ibt1s2 Rinv17ibt1s3 0 sky130_fd_pr__res_xhigh_po w=10 l=49.614382
XRinv17ibp1s4 Rinv17ibt1s3 Rinv17ibt1s4 0 sky130_fd_pr__res_xhigh_po w=10 l=49.614382
XRinv17ibp1s5 Rinv17ibt1s4 Rinv17ibt1s5 0 sky130_fd_pr__res_xhigh_po w=10 l=49.614382
XRinv17ibp1s6 Rinv17ibt1s5 Rinv17ibt1s6 0 sky130_fd_pr__res_xhigh_po w=10 l=49.614382
XRinv17ibp1s7 Rinv17ibt1s6 inv17m 0 sky130_fd_pr__res_xhigh_po w=10 l=49.614382
XRinv17ibp2s0 in17n Rinv17ibt2s0 0 sky130_fd_pr__res_xhigh_po w=10 l=49.614382
XRinv17ibp2s1 Rinv17ibt2s0 Rinv17ibt2s1 0 sky130_fd_pr__res_xhigh_po w=10 l=49.614382
XRinv17ibp2s2 Rinv17ibt2s1 Rinv17ibt2s2 0 sky130_fd_pr__res_xhigh_po w=10 l=49.614382
XRinv17ibp2s3 Rinv17ibt2s2 Rinv17ibt2s3 0 sky130_fd_pr__res_xhigh_po w=10 l=49.614382
XRinv17ibp2s4 Rinv17ibt2s3 Rinv17ibt2s4 0 sky130_fd_pr__res_xhigh_po w=10 l=49.614382
XRinv17ibp2s5 Rinv17ibt2s4 Rinv17ibt2s5 0 sky130_fd_pr__res_xhigh_po w=10 l=49.614382
XRinv17ibp2s6 Rinv17ibt2s5 Rinv17ibt2s6 0 sky130_fd_pr__res_xhigh_po w=10 l=49.614382
XRinv17ibp2s7 Rinv17ibt2s6 inv17m 0 sky130_fd_pr__res_xhigh_po w=10 l=49.614382
XRinv17ibp3s0 in17n Rinv17ibt3s0 0 sky130_fd_pr__res_xhigh_po w=10 l=49.614382
XRinv17ibp3s1 Rinv17ibt3s0 Rinv17ibt3s1 0 sky130_fd_pr__res_xhigh_po w=10 l=49.614382
XRinv17ibp3s2 Rinv17ibt3s1 Rinv17ibt3s2 0 sky130_fd_pr__res_xhigh_po w=10 l=49.614382
XRinv17ibp3s3 Rinv17ibt3s2 Rinv17ibt3s3 0 sky130_fd_pr__res_xhigh_po w=10 l=49.614382
XRinv17ibp3s4 Rinv17ibt3s3 Rinv17ibt3s4 0 sky130_fd_pr__res_xhigh_po w=10 l=49.614382
XRinv17ibp3s5 Rinv17ibt3s4 Rinv17ibt3s5 0 sky130_fd_pr__res_xhigh_po w=10 l=49.614382
XRinv17ibp3s6 Rinv17ibt3s5 Rinv17ibt3s6 0 sky130_fd_pr__res_xhigh_po w=10 l=49.614382
XRinv17ibp3s7 Rinv17ibt3s6 inv17m 0 sky130_fd_pr__res_xhigh_po w=10 l=49.614382
XRinv17ibp4s0 in17n Rinv17ibt4s0 0 sky130_fd_pr__res_xhigh_po w=10 l=49.614382
XRinv17ibp4s1 Rinv17ibt4s0 Rinv17ibt4s1 0 sky130_fd_pr__res_xhigh_po w=10 l=49.614382
XRinv17ibp4s2 Rinv17ibt4s1 Rinv17ibt4s2 0 sky130_fd_pr__res_xhigh_po w=10 l=49.614382
XRinv17ibp4s3 Rinv17ibt4s2 Rinv17ibt4s3 0 sky130_fd_pr__res_xhigh_po w=10 l=49.614382
XRinv17ibp4s4 Rinv17ibt4s3 Rinv17ibt4s4 0 sky130_fd_pr__res_xhigh_po w=10 l=49.614382
XRinv17ibp4s5 Rinv17ibt4s4 Rinv17ibt4s5 0 sky130_fd_pr__res_xhigh_po w=10 l=49.614382
XRinv17ibp4s6 Rinv17ibt4s5 Rinv17ibt4s6 0 sky130_fd_pr__res_xhigh_po w=10 l=49.614382
XRinv17ibp4s7 Rinv17ibt4s6 inv17m 0 sky130_fd_pr__res_xhigh_po w=10 l=49.614382
XRinv17ibp5s0 in17n Rinv17ibt5s0 0 sky130_fd_pr__res_xhigh_po w=10 l=49.614382
XRinv17ibp5s1 Rinv17ibt5s0 Rinv17ibt5s1 0 sky130_fd_pr__res_xhigh_po w=10 l=49.614382
XRinv17ibp5s2 Rinv17ibt5s1 Rinv17ibt5s2 0 sky130_fd_pr__res_xhigh_po w=10 l=49.614382
XRinv17ibp5s3 Rinv17ibt5s2 Rinv17ibt5s3 0 sky130_fd_pr__res_xhigh_po w=10 l=49.614382
XRinv17ibp5s4 Rinv17ibt5s3 Rinv17ibt5s4 0 sky130_fd_pr__res_xhigh_po w=10 l=49.614382
XRinv17ibp5s5 Rinv17ibt5s4 Rinv17ibt5s5 0 sky130_fd_pr__res_xhigh_po w=10 l=49.614382
XRinv17ibp5s6 Rinv17ibt5s5 Rinv17ibt5s6 0 sky130_fd_pr__res_xhigh_po w=10 l=49.614382
XRinv17ibp5s7 Rinv17ibt5s6 inv17m 0 sky130_fd_pr__res_xhigh_po w=10 l=49.614382
XRinv17ibp6s0 in17n Rinv17ibt6s0 0 sky130_fd_pr__res_xhigh_po w=10 l=49.614382
XRinv17ibp6s1 Rinv17ibt6s0 Rinv17ibt6s1 0 sky130_fd_pr__res_xhigh_po w=10 l=49.614382
XRinv17ibp6s2 Rinv17ibt6s1 Rinv17ibt6s2 0 sky130_fd_pr__res_xhigh_po w=10 l=49.614382
XRinv17ibp6s3 Rinv17ibt6s2 Rinv17ibt6s3 0 sky130_fd_pr__res_xhigh_po w=10 l=49.614382
XRinv17ibp6s4 Rinv17ibt6s3 Rinv17ibt6s4 0 sky130_fd_pr__res_xhigh_po w=10 l=49.614382
XRinv17ibp6s5 Rinv17ibt6s4 Rinv17ibt6s5 0 sky130_fd_pr__res_xhigh_po w=10 l=49.614382
XRinv17ibp6s6 Rinv17ibt6s5 Rinv17ibt6s6 0 sky130_fd_pr__res_xhigh_po w=10 l=49.614382
XRinv17ibp6s7 Rinv17ibt6s6 inv17m 0 sky130_fd_pr__res_xhigh_po w=10 l=49.614382
XRinv17ibp7s0 in17n Rinv17ibt7s0 0 sky130_fd_pr__res_xhigh_po w=10 l=49.614382
XRinv17ibp7s1 Rinv17ibt7s0 Rinv17ibt7s1 0 sky130_fd_pr__res_xhigh_po w=10 l=49.614382
XRinv17ibp7s2 Rinv17ibt7s1 Rinv17ibt7s2 0 sky130_fd_pr__res_xhigh_po w=10 l=49.614382
XRinv17ibp7s3 Rinv17ibt7s2 Rinv17ibt7s3 0 sky130_fd_pr__res_xhigh_po w=10 l=49.614382
XRinv17ibp7s4 Rinv17ibt7s3 Rinv17ibt7s4 0 sky130_fd_pr__res_xhigh_po w=10 l=49.614382
XRinv17ibp7s5 Rinv17ibt7s4 Rinv17ibt7s5 0 sky130_fd_pr__res_xhigh_po w=10 l=49.614382
XRinv17ibp7s6 Rinv17ibt7s5 Rinv17ibt7s6 0 sky130_fd_pr__res_xhigh_po w=10 l=49.614382
XRinv17ibp7s7 Rinv17ibt7s6 inv17m 0 sky130_fd_pr__res_xhigh_po w=10 l=49.614382
Einv17amp in17n 0 0 inv17m 10000000
* load-compensated divider in17n->tap17n: G_load=0.000266255881165782 Ra=788940.067216326 Rb=1000 target beta=0.001 (no tap buffer)
* PDK sky130_fd_pr__res_xhigh_po Rdiv17na W=10 L=3922.5044
* tile Rdiv17na 8s x 8p same W=10 L=3922.5044
XRdiv17nap0s0 in17n Rdiv17nat0s0 0 sky130_fd_pr__res_xhigh_po w=10 l=3922.5044
XRdiv17nap0s1 Rdiv17nat0s0 Rdiv17nat0s1 0 sky130_fd_pr__res_xhigh_po w=10 l=3922.5044
XRdiv17nap0s2 Rdiv17nat0s1 Rdiv17nat0s2 0 sky130_fd_pr__res_xhigh_po w=10 l=3922.5044
XRdiv17nap0s3 Rdiv17nat0s2 Rdiv17nat0s3 0 sky130_fd_pr__res_xhigh_po w=10 l=3922.5044
XRdiv17nap0s4 Rdiv17nat0s3 Rdiv17nat0s4 0 sky130_fd_pr__res_xhigh_po w=10 l=3922.5044
XRdiv17nap0s5 Rdiv17nat0s4 Rdiv17nat0s5 0 sky130_fd_pr__res_xhigh_po w=10 l=3922.5044
XRdiv17nap0s6 Rdiv17nat0s5 Rdiv17nat0s6 0 sky130_fd_pr__res_xhigh_po w=10 l=3922.5044
XRdiv17nap0s7 Rdiv17nat0s6 tap17n 0 sky130_fd_pr__res_xhigh_po w=10 l=3922.5044
XRdiv17nap1s0 in17n Rdiv17nat1s0 0 sky130_fd_pr__res_xhigh_po w=10 l=3922.5044
XRdiv17nap1s1 Rdiv17nat1s0 Rdiv17nat1s1 0 sky130_fd_pr__res_xhigh_po w=10 l=3922.5044
XRdiv17nap1s2 Rdiv17nat1s1 Rdiv17nat1s2 0 sky130_fd_pr__res_xhigh_po w=10 l=3922.5044
XRdiv17nap1s3 Rdiv17nat1s2 Rdiv17nat1s3 0 sky130_fd_pr__res_xhigh_po w=10 l=3922.5044
XRdiv17nap1s4 Rdiv17nat1s3 Rdiv17nat1s4 0 sky130_fd_pr__res_xhigh_po w=10 l=3922.5044
XRdiv17nap1s5 Rdiv17nat1s4 Rdiv17nat1s5 0 sky130_fd_pr__res_xhigh_po w=10 l=3922.5044
XRdiv17nap1s6 Rdiv17nat1s5 Rdiv17nat1s6 0 sky130_fd_pr__res_xhigh_po w=10 l=3922.5044
XRdiv17nap1s7 Rdiv17nat1s6 tap17n 0 sky130_fd_pr__res_xhigh_po w=10 l=3922.5044
XRdiv17nap2s0 in17n Rdiv17nat2s0 0 sky130_fd_pr__res_xhigh_po w=10 l=3922.5044
XRdiv17nap2s1 Rdiv17nat2s0 Rdiv17nat2s1 0 sky130_fd_pr__res_xhigh_po w=10 l=3922.5044
XRdiv17nap2s2 Rdiv17nat2s1 Rdiv17nat2s2 0 sky130_fd_pr__res_xhigh_po w=10 l=3922.5044
XRdiv17nap2s3 Rdiv17nat2s2 Rdiv17nat2s3 0 sky130_fd_pr__res_xhigh_po w=10 l=3922.5044
XRdiv17nap2s4 Rdiv17nat2s3 Rdiv17nat2s4 0 sky130_fd_pr__res_xhigh_po w=10 l=3922.5044
XRdiv17nap2s5 Rdiv17nat2s4 Rdiv17nat2s5 0 sky130_fd_pr__res_xhigh_po w=10 l=3922.5044
XRdiv17nap2s6 Rdiv17nat2s5 Rdiv17nat2s6 0 sky130_fd_pr__res_xhigh_po w=10 l=3922.5044
XRdiv17nap2s7 Rdiv17nat2s6 tap17n 0 sky130_fd_pr__res_xhigh_po w=10 l=3922.5044
XRdiv17nap3s0 in17n Rdiv17nat3s0 0 sky130_fd_pr__res_xhigh_po w=10 l=3922.5044
XRdiv17nap3s1 Rdiv17nat3s0 Rdiv17nat3s1 0 sky130_fd_pr__res_xhigh_po w=10 l=3922.5044
XRdiv17nap3s2 Rdiv17nat3s1 Rdiv17nat3s2 0 sky130_fd_pr__res_xhigh_po w=10 l=3922.5044
XRdiv17nap3s3 Rdiv17nat3s2 Rdiv17nat3s3 0 sky130_fd_pr__res_xhigh_po w=10 l=3922.5044
XRdiv17nap3s4 Rdiv17nat3s3 Rdiv17nat3s4 0 sky130_fd_pr__res_xhigh_po w=10 l=3922.5044
XRdiv17nap3s5 Rdiv17nat3s4 Rdiv17nat3s5 0 sky130_fd_pr__res_xhigh_po w=10 l=3922.5044
XRdiv17nap3s6 Rdiv17nat3s5 Rdiv17nat3s6 0 sky130_fd_pr__res_xhigh_po w=10 l=3922.5044
XRdiv17nap3s7 Rdiv17nat3s6 tap17n 0 sky130_fd_pr__res_xhigh_po w=10 l=3922.5044
XRdiv17nap4s0 in17n Rdiv17nat4s0 0 sky130_fd_pr__res_xhigh_po w=10 l=3922.5044
XRdiv17nap4s1 Rdiv17nat4s0 Rdiv17nat4s1 0 sky130_fd_pr__res_xhigh_po w=10 l=3922.5044
XRdiv17nap4s2 Rdiv17nat4s1 Rdiv17nat4s2 0 sky130_fd_pr__res_xhigh_po w=10 l=3922.5044
XRdiv17nap4s3 Rdiv17nat4s2 Rdiv17nat4s3 0 sky130_fd_pr__res_xhigh_po w=10 l=3922.5044
XRdiv17nap4s4 Rdiv17nat4s3 Rdiv17nat4s4 0 sky130_fd_pr__res_xhigh_po w=10 l=3922.5044
XRdiv17nap4s5 Rdiv17nat4s4 Rdiv17nat4s5 0 sky130_fd_pr__res_xhigh_po w=10 l=3922.5044
XRdiv17nap4s6 Rdiv17nat4s5 Rdiv17nat4s6 0 sky130_fd_pr__res_xhigh_po w=10 l=3922.5044
XRdiv17nap4s7 Rdiv17nat4s6 tap17n 0 sky130_fd_pr__res_xhigh_po w=10 l=3922.5044
XRdiv17nap5s0 in17n Rdiv17nat5s0 0 sky130_fd_pr__res_xhigh_po w=10 l=3922.5044
XRdiv17nap5s1 Rdiv17nat5s0 Rdiv17nat5s1 0 sky130_fd_pr__res_xhigh_po w=10 l=3922.5044
XRdiv17nap5s2 Rdiv17nat5s1 Rdiv17nat5s2 0 sky130_fd_pr__res_xhigh_po w=10 l=3922.5044
XRdiv17nap5s3 Rdiv17nat5s2 Rdiv17nat5s3 0 sky130_fd_pr__res_xhigh_po w=10 l=3922.5044
XRdiv17nap5s4 Rdiv17nat5s3 Rdiv17nat5s4 0 sky130_fd_pr__res_xhigh_po w=10 l=3922.5044
XRdiv17nap5s5 Rdiv17nat5s4 Rdiv17nat5s5 0 sky130_fd_pr__res_xhigh_po w=10 l=3922.5044
XRdiv17nap5s6 Rdiv17nat5s5 Rdiv17nat5s6 0 sky130_fd_pr__res_xhigh_po w=10 l=3922.5044
XRdiv17nap5s7 Rdiv17nat5s6 tap17n 0 sky130_fd_pr__res_xhigh_po w=10 l=3922.5044
XRdiv17nap6s0 in17n Rdiv17nat6s0 0 sky130_fd_pr__res_xhigh_po w=10 l=3922.5044
XRdiv17nap6s1 Rdiv17nat6s0 Rdiv17nat6s1 0 sky130_fd_pr__res_xhigh_po w=10 l=3922.5044
XRdiv17nap6s2 Rdiv17nat6s1 Rdiv17nat6s2 0 sky130_fd_pr__res_xhigh_po w=10 l=3922.5044
XRdiv17nap6s3 Rdiv17nat6s2 Rdiv17nat6s3 0 sky130_fd_pr__res_xhigh_po w=10 l=3922.5044
XRdiv17nap6s4 Rdiv17nat6s3 Rdiv17nat6s4 0 sky130_fd_pr__res_xhigh_po w=10 l=3922.5044
XRdiv17nap6s5 Rdiv17nat6s4 Rdiv17nat6s5 0 sky130_fd_pr__res_xhigh_po w=10 l=3922.5044
XRdiv17nap6s6 Rdiv17nat6s5 Rdiv17nat6s6 0 sky130_fd_pr__res_xhigh_po w=10 l=3922.5044
XRdiv17nap6s7 Rdiv17nat6s6 tap17n 0 sky130_fd_pr__res_xhigh_po w=10 l=3922.5044
XRdiv17nap7s0 in17n Rdiv17nat7s0 0 sky130_fd_pr__res_xhigh_po w=10 l=3922.5044
XRdiv17nap7s1 Rdiv17nat7s0 Rdiv17nat7s1 0 sky130_fd_pr__res_xhigh_po w=10 l=3922.5044
XRdiv17nap7s2 Rdiv17nat7s1 Rdiv17nat7s2 0 sky130_fd_pr__res_xhigh_po w=10 l=3922.5044
XRdiv17nap7s3 Rdiv17nat7s2 Rdiv17nat7s3 0 sky130_fd_pr__res_xhigh_po w=10 l=3922.5044
XRdiv17nap7s4 Rdiv17nat7s3 Rdiv17nat7s4 0 sky130_fd_pr__res_xhigh_po w=10 l=3922.5044
XRdiv17nap7s5 Rdiv17nat7s4 Rdiv17nat7s5 0 sky130_fd_pr__res_xhigh_po w=10 l=3922.5044
XRdiv17nap7s6 Rdiv17nat7s5 Rdiv17nat7s6 0 sky130_fd_pr__res_xhigh_po w=10 l=3922.5044
XRdiv17nap7s7 Rdiv17nat7s6 tap17n 0 sky130_fd_pr__res_xhigh_po w=10 l=3922.5044
* PDK sky130_fd_pr__res_xhigh_po Rdiv17nb W=10 L=4.8663717
* tile Rdiv17nb 8s x 8p same W=10 L=4.8663717
XRdiv17nbp0s0 tap17n Rdiv17nbt0s0 0 sky130_fd_pr__res_xhigh_po w=10 l=4.8663717
XRdiv17nbp0s1 Rdiv17nbt0s0 Rdiv17nbt0s1 0 sky130_fd_pr__res_xhigh_po w=10 l=4.8663717
XRdiv17nbp0s2 Rdiv17nbt0s1 Rdiv17nbt0s2 0 sky130_fd_pr__res_xhigh_po w=10 l=4.8663717
XRdiv17nbp0s3 Rdiv17nbt0s2 Rdiv17nbt0s3 0 sky130_fd_pr__res_xhigh_po w=10 l=4.8663717
XRdiv17nbp0s4 Rdiv17nbt0s3 Rdiv17nbt0s4 0 sky130_fd_pr__res_xhigh_po w=10 l=4.8663717
XRdiv17nbp0s5 Rdiv17nbt0s4 Rdiv17nbt0s5 0 sky130_fd_pr__res_xhigh_po w=10 l=4.8663717
XRdiv17nbp0s6 Rdiv17nbt0s5 Rdiv17nbt0s6 0 sky130_fd_pr__res_xhigh_po w=10 l=4.8663717
XRdiv17nbp0s7 Rdiv17nbt0s6 0 0 sky130_fd_pr__res_xhigh_po w=10 l=4.8663717
XRdiv17nbp1s0 tap17n Rdiv17nbt1s0 0 sky130_fd_pr__res_xhigh_po w=10 l=4.8663717
XRdiv17nbp1s1 Rdiv17nbt1s0 Rdiv17nbt1s1 0 sky130_fd_pr__res_xhigh_po w=10 l=4.8663717
XRdiv17nbp1s2 Rdiv17nbt1s1 Rdiv17nbt1s2 0 sky130_fd_pr__res_xhigh_po w=10 l=4.8663717
XRdiv17nbp1s3 Rdiv17nbt1s2 Rdiv17nbt1s3 0 sky130_fd_pr__res_xhigh_po w=10 l=4.8663717
XRdiv17nbp1s4 Rdiv17nbt1s3 Rdiv17nbt1s4 0 sky130_fd_pr__res_xhigh_po w=10 l=4.8663717
XRdiv17nbp1s5 Rdiv17nbt1s4 Rdiv17nbt1s5 0 sky130_fd_pr__res_xhigh_po w=10 l=4.8663717
XRdiv17nbp1s6 Rdiv17nbt1s5 Rdiv17nbt1s6 0 sky130_fd_pr__res_xhigh_po w=10 l=4.8663717
XRdiv17nbp1s7 Rdiv17nbt1s6 0 0 sky130_fd_pr__res_xhigh_po w=10 l=4.8663717
XRdiv17nbp2s0 tap17n Rdiv17nbt2s0 0 sky130_fd_pr__res_xhigh_po w=10 l=4.8663717
XRdiv17nbp2s1 Rdiv17nbt2s0 Rdiv17nbt2s1 0 sky130_fd_pr__res_xhigh_po w=10 l=4.8663717
XRdiv17nbp2s2 Rdiv17nbt2s1 Rdiv17nbt2s2 0 sky130_fd_pr__res_xhigh_po w=10 l=4.8663717
XRdiv17nbp2s3 Rdiv17nbt2s2 Rdiv17nbt2s3 0 sky130_fd_pr__res_xhigh_po w=10 l=4.8663717
XRdiv17nbp2s4 Rdiv17nbt2s3 Rdiv17nbt2s4 0 sky130_fd_pr__res_xhigh_po w=10 l=4.8663717
XRdiv17nbp2s5 Rdiv17nbt2s4 Rdiv17nbt2s5 0 sky130_fd_pr__res_xhigh_po w=10 l=4.8663717
XRdiv17nbp2s6 Rdiv17nbt2s5 Rdiv17nbt2s6 0 sky130_fd_pr__res_xhigh_po w=10 l=4.8663717
XRdiv17nbp2s7 Rdiv17nbt2s6 0 0 sky130_fd_pr__res_xhigh_po w=10 l=4.8663717
XRdiv17nbp3s0 tap17n Rdiv17nbt3s0 0 sky130_fd_pr__res_xhigh_po w=10 l=4.8663717
XRdiv17nbp3s1 Rdiv17nbt3s0 Rdiv17nbt3s1 0 sky130_fd_pr__res_xhigh_po w=10 l=4.8663717
XRdiv17nbp3s2 Rdiv17nbt3s1 Rdiv17nbt3s2 0 sky130_fd_pr__res_xhigh_po w=10 l=4.8663717
XRdiv17nbp3s3 Rdiv17nbt3s2 Rdiv17nbt3s3 0 sky130_fd_pr__res_xhigh_po w=10 l=4.8663717
XRdiv17nbp3s4 Rdiv17nbt3s3 Rdiv17nbt3s4 0 sky130_fd_pr__res_xhigh_po w=10 l=4.8663717
XRdiv17nbp3s5 Rdiv17nbt3s4 Rdiv17nbt3s5 0 sky130_fd_pr__res_xhigh_po w=10 l=4.8663717
XRdiv17nbp3s6 Rdiv17nbt3s5 Rdiv17nbt3s6 0 sky130_fd_pr__res_xhigh_po w=10 l=4.8663717
XRdiv17nbp3s7 Rdiv17nbt3s6 0 0 sky130_fd_pr__res_xhigh_po w=10 l=4.8663717
XRdiv17nbp4s0 tap17n Rdiv17nbt4s0 0 sky130_fd_pr__res_xhigh_po w=10 l=4.8663717
XRdiv17nbp4s1 Rdiv17nbt4s0 Rdiv17nbt4s1 0 sky130_fd_pr__res_xhigh_po w=10 l=4.8663717
XRdiv17nbp4s2 Rdiv17nbt4s1 Rdiv17nbt4s2 0 sky130_fd_pr__res_xhigh_po w=10 l=4.8663717
XRdiv17nbp4s3 Rdiv17nbt4s2 Rdiv17nbt4s3 0 sky130_fd_pr__res_xhigh_po w=10 l=4.8663717
XRdiv17nbp4s4 Rdiv17nbt4s3 Rdiv17nbt4s4 0 sky130_fd_pr__res_xhigh_po w=10 l=4.8663717
XRdiv17nbp4s5 Rdiv17nbt4s4 Rdiv17nbt4s5 0 sky130_fd_pr__res_xhigh_po w=10 l=4.8663717
XRdiv17nbp4s6 Rdiv17nbt4s5 Rdiv17nbt4s6 0 sky130_fd_pr__res_xhigh_po w=10 l=4.8663717
XRdiv17nbp4s7 Rdiv17nbt4s6 0 0 sky130_fd_pr__res_xhigh_po w=10 l=4.8663717
XRdiv17nbp5s0 tap17n Rdiv17nbt5s0 0 sky130_fd_pr__res_xhigh_po w=10 l=4.8663717
XRdiv17nbp5s1 Rdiv17nbt5s0 Rdiv17nbt5s1 0 sky130_fd_pr__res_xhigh_po w=10 l=4.8663717
XRdiv17nbp5s2 Rdiv17nbt5s1 Rdiv17nbt5s2 0 sky130_fd_pr__res_xhigh_po w=10 l=4.8663717
XRdiv17nbp5s3 Rdiv17nbt5s2 Rdiv17nbt5s3 0 sky130_fd_pr__res_xhigh_po w=10 l=4.8663717
XRdiv17nbp5s4 Rdiv17nbt5s3 Rdiv17nbt5s4 0 sky130_fd_pr__res_xhigh_po w=10 l=4.8663717
XRdiv17nbp5s5 Rdiv17nbt5s4 Rdiv17nbt5s5 0 sky130_fd_pr__res_xhigh_po w=10 l=4.8663717
XRdiv17nbp5s6 Rdiv17nbt5s5 Rdiv17nbt5s6 0 sky130_fd_pr__res_xhigh_po w=10 l=4.8663717
XRdiv17nbp5s7 Rdiv17nbt5s6 0 0 sky130_fd_pr__res_xhigh_po w=10 l=4.8663717
XRdiv17nbp6s0 tap17n Rdiv17nbt6s0 0 sky130_fd_pr__res_xhigh_po w=10 l=4.8663717
XRdiv17nbp6s1 Rdiv17nbt6s0 Rdiv17nbt6s1 0 sky130_fd_pr__res_xhigh_po w=10 l=4.8663717
XRdiv17nbp6s2 Rdiv17nbt6s1 Rdiv17nbt6s2 0 sky130_fd_pr__res_xhigh_po w=10 l=4.8663717
XRdiv17nbp6s3 Rdiv17nbt6s2 Rdiv17nbt6s3 0 sky130_fd_pr__res_xhigh_po w=10 l=4.8663717
XRdiv17nbp6s4 Rdiv17nbt6s3 Rdiv17nbt6s4 0 sky130_fd_pr__res_xhigh_po w=10 l=4.8663717
XRdiv17nbp6s5 Rdiv17nbt6s4 Rdiv17nbt6s5 0 sky130_fd_pr__res_xhigh_po w=10 l=4.8663717
XRdiv17nbp6s6 Rdiv17nbt6s5 Rdiv17nbt6s6 0 sky130_fd_pr__res_xhigh_po w=10 l=4.8663717
XRdiv17nbp6s7 Rdiv17nbt6s6 0 0 sky130_fd_pr__res_xhigh_po w=10 l=4.8663717
XRdiv17nbp7s0 tap17n Rdiv17nbt7s0 0 sky130_fd_pr__res_xhigh_po w=10 l=4.8663717
XRdiv17nbp7s1 Rdiv17nbt7s0 Rdiv17nbt7s1 0 sky130_fd_pr__res_xhigh_po w=10 l=4.8663717
XRdiv17nbp7s2 Rdiv17nbt7s1 Rdiv17nbt7s2 0 sky130_fd_pr__res_xhigh_po w=10 l=4.8663717
XRdiv17nbp7s3 Rdiv17nbt7s2 Rdiv17nbt7s3 0 sky130_fd_pr__res_xhigh_po w=10 l=4.8663717
XRdiv17nbp7s4 Rdiv17nbt7s3 Rdiv17nbt7s4 0 sky130_fd_pr__res_xhigh_po w=10 l=4.8663717
XRdiv17nbp7s5 Rdiv17nbt7s4 Rdiv17nbt7s5 0 sky130_fd_pr__res_xhigh_po w=10 l=4.8663717
XRdiv17nbp7s6 Rdiv17nbt7s5 Rdiv17nbt7s6 0 sky130_fd_pr__res_xhigh_po w=10 l=4.8663717
XRdiv17nbp7s7 Rdiv17nbt7s6 0 0 sky130_fd_pr__res_xhigh_po w=10 l=4.8663717
Vin18 in18 0 DC 1.19134595226048
Vin19 in19 0 DC 0
* passive invert in19 -> in19n: R2/R1=1.0000002 closed-loop -1 at A=1e+07
* PDK sky130_fd_pr__res_xhigh_po Rinv19ia W=10 L=49.614372
* tile Rinv19ia 8s x 8p same W=10 L=49.614372
XRinv19iap0s0 in19 Rinv19iat0s0 0 sky130_fd_pr__res_xhigh_po w=10 l=49.614372
XRinv19iap0s1 Rinv19iat0s0 Rinv19iat0s1 0 sky130_fd_pr__res_xhigh_po w=10 l=49.614372
XRinv19iap0s2 Rinv19iat0s1 Rinv19iat0s2 0 sky130_fd_pr__res_xhigh_po w=10 l=49.614372
XRinv19iap0s3 Rinv19iat0s2 Rinv19iat0s3 0 sky130_fd_pr__res_xhigh_po w=10 l=49.614372
XRinv19iap0s4 Rinv19iat0s3 Rinv19iat0s4 0 sky130_fd_pr__res_xhigh_po w=10 l=49.614372
XRinv19iap0s5 Rinv19iat0s4 Rinv19iat0s5 0 sky130_fd_pr__res_xhigh_po w=10 l=49.614372
XRinv19iap0s6 Rinv19iat0s5 Rinv19iat0s6 0 sky130_fd_pr__res_xhigh_po w=10 l=49.614372
XRinv19iap0s7 Rinv19iat0s6 inv19m 0 sky130_fd_pr__res_xhigh_po w=10 l=49.614372
XRinv19iap1s0 in19 Rinv19iat1s0 0 sky130_fd_pr__res_xhigh_po w=10 l=49.614372
XRinv19iap1s1 Rinv19iat1s0 Rinv19iat1s1 0 sky130_fd_pr__res_xhigh_po w=10 l=49.614372
XRinv19iap1s2 Rinv19iat1s1 Rinv19iat1s2 0 sky130_fd_pr__res_xhigh_po w=10 l=49.614372
XRinv19iap1s3 Rinv19iat1s2 Rinv19iat1s3 0 sky130_fd_pr__res_xhigh_po w=10 l=49.614372
XRinv19iap1s4 Rinv19iat1s3 Rinv19iat1s4 0 sky130_fd_pr__res_xhigh_po w=10 l=49.614372
XRinv19iap1s5 Rinv19iat1s4 Rinv19iat1s5 0 sky130_fd_pr__res_xhigh_po w=10 l=49.614372
XRinv19iap1s6 Rinv19iat1s5 Rinv19iat1s6 0 sky130_fd_pr__res_xhigh_po w=10 l=49.614372
XRinv19iap1s7 Rinv19iat1s6 inv19m 0 sky130_fd_pr__res_xhigh_po w=10 l=49.614372
XRinv19iap2s0 in19 Rinv19iat2s0 0 sky130_fd_pr__res_xhigh_po w=10 l=49.614372
XRinv19iap2s1 Rinv19iat2s0 Rinv19iat2s1 0 sky130_fd_pr__res_xhigh_po w=10 l=49.614372
XRinv19iap2s2 Rinv19iat2s1 Rinv19iat2s2 0 sky130_fd_pr__res_xhigh_po w=10 l=49.614372
XRinv19iap2s3 Rinv19iat2s2 Rinv19iat2s3 0 sky130_fd_pr__res_xhigh_po w=10 l=49.614372
XRinv19iap2s4 Rinv19iat2s3 Rinv19iat2s4 0 sky130_fd_pr__res_xhigh_po w=10 l=49.614372
XRinv19iap2s5 Rinv19iat2s4 Rinv19iat2s5 0 sky130_fd_pr__res_xhigh_po w=10 l=49.614372
XRinv19iap2s6 Rinv19iat2s5 Rinv19iat2s6 0 sky130_fd_pr__res_xhigh_po w=10 l=49.614372
XRinv19iap2s7 Rinv19iat2s6 inv19m 0 sky130_fd_pr__res_xhigh_po w=10 l=49.614372
XRinv19iap3s0 in19 Rinv19iat3s0 0 sky130_fd_pr__res_xhigh_po w=10 l=49.614372
XRinv19iap3s1 Rinv19iat3s0 Rinv19iat3s1 0 sky130_fd_pr__res_xhigh_po w=10 l=49.614372
XRinv19iap3s2 Rinv19iat3s1 Rinv19iat3s2 0 sky130_fd_pr__res_xhigh_po w=10 l=49.614372
XRinv19iap3s3 Rinv19iat3s2 Rinv19iat3s3 0 sky130_fd_pr__res_xhigh_po w=10 l=49.614372
XRinv19iap3s4 Rinv19iat3s3 Rinv19iat3s4 0 sky130_fd_pr__res_xhigh_po w=10 l=49.614372
XRinv19iap3s5 Rinv19iat3s4 Rinv19iat3s5 0 sky130_fd_pr__res_xhigh_po w=10 l=49.614372
XRinv19iap3s6 Rinv19iat3s5 Rinv19iat3s6 0 sky130_fd_pr__res_xhigh_po w=10 l=49.614372
XRinv19iap3s7 Rinv19iat3s6 inv19m 0 sky130_fd_pr__res_xhigh_po w=10 l=49.614372
XRinv19iap4s0 in19 Rinv19iat4s0 0 sky130_fd_pr__res_xhigh_po w=10 l=49.614372
XRinv19iap4s1 Rinv19iat4s0 Rinv19iat4s1 0 sky130_fd_pr__res_xhigh_po w=10 l=49.614372
XRinv19iap4s2 Rinv19iat4s1 Rinv19iat4s2 0 sky130_fd_pr__res_xhigh_po w=10 l=49.614372
XRinv19iap4s3 Rinv19iat4s2 Rinv19iat4s3 0 sky130_fd_pr__res_xhigh_po w=10 l=49.614372
XRinv19iap4s4 Rinv19iat4s3 Rinv19iat4s4 0 sky130_fd_pr__res_xhigh_po w=10 l=49.614372
XRinv19iap4s5 Rinv19iat4s4 Rinv19iat4s5 0 sky130_fd_pr__res_xhigh_po w=10 l=49.614372
XRinv19iap4s6 Rinv19iat4s5 Rinv19iat4s6 0 sky130_fd_pr__res_xhigh_po w=10 l=49.614372
XRinv19iap4s7 Rinv19iat4s6 inv19m 0 sky130_fd_pr__res_xhigh_po w=10 l=49.614372
XRinv19iap5s0 in19 Rinv19iat5s0 0 sky130_fd_pr__res_xhigh_po w=10 l=49.614372
XRinv19iap5s1 Rinv19iat5s0 Rinv19iat5s1 0 sky130_fd_pr__res_xhigh_po w=10 l=49.614372
XRinv19iap5s2 Rinv19iat5s1 Rinv19iat5s2 0 sky130_fd_pr__res_xhigh_po w=10 l=49.614372
XRinv19iap5s3 Rinv19iat5s2 Rinv19iat5s3 0 sky130_fd_pr__res_xhigh_po w=10 l=49.614372
XRinv19iap5s4 Rinv19iat5s3 Rinv19iat5s4 0 sky130_fd_pr__res_xhigh_po w=10 l=49.614372
XRinv19iap5s5 Rinv19iat5s4 Rinv19iat5s5 0 sky130_fd_pr__res_xhigh_po w=10 l=49.614372
XRinv19iap5s6 Rinv19iat5s5 Rinv19iat5s6 0 sky130_fd_pr__res_xhigh_po w=10 l=49.614372
XRinv19iap5s7 Rinv19iat5s6 inv19m 0 sky130_fd_pr__res_xhigh_po w=10 l=49.614372
XRinv19iap6s0 in19 Rinv19iat6s0 0 sky130_fd_pr__res_xhigh_po w=10 l=49.614372
XRinv19iap6s1 Rinv19iat6s0 Rinv19iat6s1 0 sky130_fd_pr__res_xhigh_po w=10 l=49.614372
XRinv19iap6s2 Rinv19iat6s1 Rinv19iat6s2 0 sky130_fd_pr__res_xhigh_po w=10 l=49.614372
XRinv19iap6s3 Rinv19iat6s2 Rinv19iat6s3 0 sky130_fd_pr__res_xhigh_po w=10 l=49.614372
XRinv19iap6s4 Rinv19iat6s3 Rinv19iat6s4 0 sky130_fd_pr__res_xhigh_po w=10 l=49.614372
XRinv19iap6s5 Rinv19iat6s4 Rinv19iat6s5 0 sky130_fd_pr__res_xhigh_po w=10 l=49.614372
XRinv19iap6s6 Rinv19iat6s5 Rinv19iat6s6 0 sky130_fd_pr__res_xhigh_po w=10 l=49.614372
XRinv19iap6s7 Rinv19iat6s6 inv19m 0 sky130_fd_pr__res_xhigh_po w=10 l=49.614372
XRinv19iap7s0 in19 Rinv19iat7s0 0 sky130_fd_pr__res_xhigh_po w=10 l=49.614372
XRinv19iap7s1 Rinv19iat7s0 Rinv19iat7s1 0 sky130_fd_pr__res_xhigh_po w=10 l=49.614372
XRinv19iap7s2 Rinv19iat7s1 Rinv19iat7s2 0 sky130_fd_pr__res_xhigh_po w=10 l=49.614372
XRinv19iap7s3 Rinv19iat7s2 Rinv19iat7s3 0 sky130_fd_pr__res_xhigh_po w=10 l=49.614372
XRinv19iap7s4 Rinv19iat7s3 Rinv19iat7s4 0 sky130_fd_pr__res_xhigh_po w=10 l=49.614372
XRinv19iap7s5 Rinv19iat7s4 Rinv19iat7s5 0 sky130_fd_pr__res_xhigh_po w=10 l=49.614372
XRinv19iap7s6 Rinv19iat7s5 Rinv19iat7s6 0 sky130_fd_pr__res_xhigh_po w=10 l=49.614372
XRinv19iap7s7 Rinv19iat7s6 inv19m 0 sky130_fd_pr__res_xhigh_po w=10 l=49.614372
* PDK sky130_fd_pr__res_xhigh_po Rinv19ib W=10 L=49.614382
* tile Rinv19ib 8s x 8p same W=10 L=49.614382
XRinv19ibp0s0 in19n Rinv19ibt0s0 0 sky130_fd_pr__res_xhigh_po w=10 l=49.614382
XRinv19ibp0s1 Rinv19ibt0s0 Rinv19ibt0s1 0 sky130_fd_pr__res_xhigh_po w=10 l=49.614382
XRinv19ibp0s2 Rinv19ibt0s1 Rinv19ibt0s2 0 sky130_fd_pr__res_xhigh_po w=10 l=49.614382
XRinv19ibp0s3 Rinv19ibt0s2 Rinv19ibt0s3 0 sky130_fd_pr__res_xhigh_po w=10 l=49.614382
XRinv19ibp0s4 Rinv19ibt0s3 Rinv19ibt0s4 0 sky130_fd_pr__res_xhigh_po w=10 l=49.614382
XRinv19ibp0s5 Rinv19ibt0s4 Rinv19ibt0s5 0 sky130_fd_pr__res_xhigh_po w=10 l=49.614382
XRinv19ibp0s6 Rinv19ibt0s5 Rinv19ibt0s6 0 sky130_fd_pr__res_xhigh_po w=10 l=49.614382
XRinv19ibp0s7 Rinv19ibt0s6 inv19m 0 sky130_fd_pr__res_xhigh_po w=10 l=49.614382
XRinv19ibp1s0 in19n Rinv19ibt1s0 0 sky130_fd_pr__res_xhigh_po w=10 l=49.614382
XRinv19ibp1s1 Rinv19ibt1s0 Rinv19ibt1s1 0 sky130_fd_pr__res_xhigh_po w=10 l=49.614382
XRinv19ibp1s2 Rinv19ibt1s1 Rinv19ibt1s2 0 sky130_fd_pr__res_xhigh_po w=10 l=49.614382
XRinv19ibp1s3 Rinv19ibt1s2 Rinv19ibt1s3 0 sky130_fd_pr__res_xhigh_po w=10 l=49.614382
XRinv19ibp1s4 Rinv19ibt1s3 Rinv19ibt1s4 0 sky130_fd_pr__res_xhigh_po w=10 l=49.614382
XRinv19ibp1s5 Rinv19ibt1s4 Rinv19ibt1s5 0 sky130_fd_pr__res_xhigh_po w=10 l=49.614382
XRinv19ibp1s6 Rinv19ibt1s5 Rinv19ibt1s6 0 sky130_fd_pr__res_xhigh_po w=10 l=49.614382
XRinv19ibp1s7 Rinv19ibt1s6 inv19m 0 sky130_fd_pr__res_xhigh_po w=10 l=49.614382
XRinv19ibp2s0 in19n Rinv19ibt2s0 0 sky130_fd_pr__res_xhigh_po w=10 l=49.614382
XRinv19ibp2s1 Rinv19ibt2s0 Rinv19ibt2s1 0 sky130_fd_pr__res_xhigh_po w=10 l=49.614382
XRinv19ibp2s2 Rinv19ibt2s1 Rinv19ibt2s2 0 sky130_fd_pr__res_xhigh_po w=10 l=49.614382
XRinv19ibp2s3 Rinv19ibt2s2 Rinv19ibt2s3 0 sky130_fd_pr__res_xhigh_po w=10 l=49.614382
XRinv19ibp2s4 Rinv19ibt2s3 Rinv19ibt2s4 0 sky130_fd_pr__res_xhigh_po w=10 l=49.614382
XRinv19ibp2s5 Rinv19ibt2s4 Rinv19ibt2s5 0 sky130_fd_pr__res_xhigh_po w=10 l=49.614382
XRinv19ibp2s6 Rinv19ibt2s5 Rinv19ibt2s6 0 sky130_fd_pr__res_xhigh_po w=10 l=49.614382
XRinv19ibp2s7 Rinv19ibt2s6 inv19m 0 sky130_fd_pr__res_xhigh_po w=10 l=49.614382
XRinv19ibp3s0 in19n Rinv19ibt3s0 0 sky130_fd_pr__res_xhigh_po w=10 l=49.614382
XRinv19ibp3s1 Rinv19ibt3s0 Rinv19ibt3s1 0 sky130_fd_pr__res_xhigh_po w=10 l=49.614382
XRinv19ibp3s2 Rinv19ibt3s1 Rinv19ibt3s2 0 sky130_fd_pr__res_xhigh_po w=10 l=49.614382
XRinv19ibp3s3 Rinv19ibt3s2 Rinv19ibt3s3 0 sky130_fd_pr__res_xhigh_po w=10 l=49.614382
XRinv19ibp3s4 Rinv19ibt3s3 Rinv19ibt3s4 0 sky130_fd_pr__res_xhigh_po w=10 l=49.614382
XRinv19ibp3s5 Rinv19ibt3s4 Rinv19ibt3s5 0 sky130_fd_pr__res_xhigh_po w=10 l=49.614382
XRinv19ibp3s6 Rinv19ibt3s5 Rinv19ibt3s6 0 sky130_fd_pr__res_xhigh_po w=10 l=49.614382
XRinv19ibp3s7 Rinv19ibt3s6 inv19m 0 sky130_fd_pr__res_xhigh_po w=10 l=49.614382
XRinv19ibp4s0 in19n Rinv19ibt4s0 0 sky130_fd_pr__res_xhigh_po w=10 l=49.614382
XRinv19ibp4s1 Rinv19ibt4s0 Rinv19ibt4s1 0 sky130_fd_pr__res_xhigh_po w=10 l=49.614382
XRinv19ibp4s2 Rinv19ibt4s1 Rinv19ibt4s2 0 sky130_fd_pr__res_xhigh_po w=10 l=49.614382
XRinv19ibp4s3 Rinv19ibt4s2 Rinv19ibt4s3 0 sky130_fd_pr__res_xhigh_po w=10 l=49.614382
XRinv19ibp4s4 Rinv19ibt4s3 Rinv19ibt4s4 0 sky130_fd_pr__res_xhigh_po w=10 l=49.614382
XRinv19ibp4s5 Rinv19ibt4s4 Rinv19ibt4s5 0 sky130_fd_pr__res_xhigh_po w=10 l=49.614382
XRinv19ibp4s6 Rinv19ibt4s5 Rinv19ibt4s6 0 sky130_fd_pr__res_xhigh_po w=10 l=49.614382
XRinv19ibp4s7 Rinv19ibt4s6 inv19m 0 sky130_fd_pr__res_xhigh_po w=10 l=49.614382
XRinv19ibp5s0 in19n Rinv19ibt5s0 0 sky130_fd_pr__res_xhigh_po w=10 l=49.614382
XRinv19ibp5s1 Rinv19ibt5s0 Rinv19ibt5s1 0 sky130_fd_pr__res_xhigh_po w=10 l=49.614382
XRinv19ibp5s2 Rinv19ibt5s1 Rinv19ibt5s2 0 sky130_fd_pr__res_xhigh_po w=10 l=49.614382
XRinv19ibp5s3 Rinv19ibt5s2 Rinv19ibt5s3 0 sky130_fd_pr__res_xhigh_po w=10 l=49.614382
XRinv19ibp5s4 Rinv19ibt5s3 Rinv19ibt5s4 0 sky130_fd_pr__res_xhigh_po w=10 l=49.614382
XRinv19ibp5s5 Rinv19ibt5s4 Rinv19ibt5s5 0 sky130_fd_pr__res_xhigh_po w=10 l=49.614382
XRinv19ibp5s6 Rinv19ibt5s5 Rinv19ibt5s6 0 sky130_fd_pr__res_xhigh_po w=10 l=49.614382
XRinv19ibp5s7 Rinv19ibt5s6 inv19m 0 sky130_fd_pr__res_xhigh_po w=10 l=49.614382
XRinv19ibp6s0 in19n Rinv19ibt6s0 0 sky130_fd_pr__res_xhigh_po w=10 l=49.614382
XRinv19ibp6s1 Rinv19ibt6s0 Rinv19ibt6s1 0 sky130_fd_pr__res_xhigh_po w=10 l=49.614382
XRinv19ibp6s2 Rinv19ibt6s1 Rinv19ibt6s2 0 sky130_fd_pr__res_xhigh_po w=10 l=49.614382
XRinv19ibp6s3 Rinv19ibt6s2 Rinv19ibt6s3 0 sky130_fd_pr__res_xhigh_po w=10 l=49.614382
XRinv19ibp6s4 Rinv19ibt6s3 Rinv19ibt6s4 0 sky130_fd_pr__res_xhigh_po w=10 l=49.614382
XRinv19ibp6s5 Rinv19ibt6s4 Rinv19ibt6s5 0 sky130_fd_pr__res_xhigh_po w=10 l=49.614382
XRinv19ibp6s6 Rinv19ibt6s5 Rinv19ibt6s6 0 sky130_fd_pr__res_xhigh_po w=10 l=49.614382
XRinv19ibp6s7 Rinv19ibt6s6 inv19m 0 sky130_fd_pr__res_xhigh_po w=10 l=49.614382
XRinv19ibp7s0 in19n Rinv19ibt7s0 0 sky130_fd_pr__res_xhigh_po w=10 l=49.614382
XRinv19ibp7s1 Rinv19ibt7s0 Rinv19ibt7s1 0 sky130_fd_pr__res_xhigh_po w=10 l=49.614382
XRinv19ibp7s2 Rinv19ibt7s1 Rinv19ibt7s2 0 sky130_fd_pr__res_xhigh_po w=10 l=49.614382
XRinv19ibp7s3 Rinv19ibt7s2 Rinv19ibt7s3 0 sky130_fd_pr__res_xhigh_po w=10 l=49.614382
XRinv19ibp7s4 Rinv19ibt7s3 Rinv19ibt7s4 0 sky130_fd_pr__res_xhigh_po w=10 l=49.614382
XRinv19ibp7s5 Rinv19ibt7s4 Rinv19ibt7s5 0 sky130_fd_pr__res_xhigh_po w=10 l=49.614382
XRinv19ibp7s6 Rinv19ibt7s5 Rinv19ibt7s6 0 sky130_fd_pr__res_xhigh_po w=10 l=49.614382
XRinv19ibp7s7 Rinv19ibt7s6 inv19m 0 sky130_fd_pr__res_xhigh_po w=10 l=49.614382
Einv19amp in19n 0 0 inv19m 10000000
Vin20 in20 0 DC 0
* load-compensated divider in20->tap20: G_load=0.000971610549965604 Ra=506692.358700063 Rb=1000 target beta=0.001 (no tap buffer)
* PDK sky130_fd_pr__res_xhigh_po Rdiv20a W=10 L=2519.1688
* tile Rdiv20a 8s x 8p same W=10 L=2519.1688
XRdiv20ap0s0 in20 Rdiv20at0s0 0 sky130_fd_pr__res_xhigh_po w=10 l=2519.1688
XRdiv20ap0s1 Rdiv20at0s0 Rdiv20at0s1 0 sky130_fd_pr__res_xhigh_po w=10 l=2519.1688
XRdiv20ap0s2 Rdiv20at0s1 Rdiv20at0s2 0 sky130_fd_pr__res_xhigh_po w=10 l=2519.1688
XRdiv20ap0s3 Rdiv20at0s2 Rdiv20at0s3 0 sky130_fd_pr__res_xhigh_po w=10 l=2519.1688
XRdiv20ap0s4 Rdiv20at0s3 Rdiv20at0s4 0 sky130_fd_pr__res_xhigh_po w=10 l=2519.1688
XRdiv20ap0s5 Rdiv20at0s4 Rdiv20at0s5 0 sky130_fd_pr__res_xhigh_po w=10 l=2519.1688
XRdiv20ap0s6 Rdiv20at0s5 Rdiv20at0s6 0 sky130_fd_pr__res_xhigh_po w=10 l=2519.1688
XRdiv20ap0s7 Rdiv20at0s6 tap20 0 sky130_fd_pr__res_xhigh_po w=10 l=2519.1688
XRdiv20ap1s0 in20 Rdiv20at1s0 0 sky130_fd_pr__res_xhigh_po w=10 l=2519.1688
XRdiv20ap1s1 Rdiv20at1s0 Rdiv20at1s1 0 sky130_fd_pr__res_xhigh_po w=10 l=2519.1688
XRdiv20ap1s2 Rdiv20at1s1 Rdiv20at1s2 0 sky130_fd_pr__res_xhigh_po w=10 l=2519.1688
XRdiv20ap1s3 Rdiv20at1s2 Rdiv20at1s3 0 sky130_fd_pr__res_xhigh_po w=10 l=2519.1688
XRdiv20ap1s4 Rdiv20at1s3 Rdiv20at1s4 0 sky130_fd_pr__res_xhigh_po w=10 l=2519.1688
XRdiv20ap1s5 Rdiv20at1s4 Rdiv20at1s5 0 sky130_fd_pr__res_xhigh_po w=10 l=2519.1688
XRdiv20ap1s6 Rdiv20at1s5 Rdiv20at1s6 0 sky130_fd_pr__res_xhigh_po w=10 l=2519.1688
XRdiv20ap1s7 Rdiv20at1s6 tap20 0 sky130_fd_pr__res_xhigh_po w=10 l=2519.1688
XRdiv20ap2s0 in20 Rdiv20at2s0 0 sky130_fd_pr__res_xhigh_po w=10 l=2519.1688
XRdiv20ap2s1 Rdiv20at2s0 Rdiv20at2s1 0 sky130_fd_pr__res_xhigh_po w=10 l=2519.1688
XRdiv20ap2s2 Rdiv20at2s1 Rdiv20at2s2 0 sky130_fd_pr__res_xhigh_po w=10 l=2519.1688
XRdiv20ap2s3 Rdiv20at2s2 Rdiv20at2s3 0 sky130_fd_pr__res_xhigh_po w=10 l=2519.1688
XRdiv20ap2s4 Rdiv20at2s3 Rdiv20at2s4 0 sky130_fd_pr__res_xhigh_po w=10 l=2519.1688
XRdiv20ap2s5 Rdiv20at2s4 Rdiv20at2s5 0 sky130_fd_pr__res_xhigh_po w=10 l=2519.1688
XRdiv20ap2s6 Rdiv20at2s5 Rdiv20at2s6 0 sky130_fd_pr__res_xhigh_po w=10 l=2519.1688
XRdiv20ap2s7 Rdiv20at2s6 tap20 0 sky130_fd_pr__res_xhigh_po w=10 l=2519.1688
XRdiv20ap3s0 in20 Rdiv20at3s0 0 sky130_fd_pr__res_xhigh_po w=10 l=2519.1688
XRdiv20ap3s1 Rdiv20at3s0 Rdiv20at3s1 0 sky130_fd_pr__res_xhigh_po w=10 l=2519.1688
XRdiv20ap3s2 Rdiv20at3s1 Rdiv20at3s2 0 sky130_fd_pr__res_xhigh_po w=10 l=2519.1688
XRdiv20ap3s3 Rdiv20at3s2 Rdiv20at3s3 0 sky130_fd_pr__res_xhigh_po w=10 l=2519.1688
XRdiv20ap3s4 Rdiv20at3s3 Rdiv20at3s4 0 sky130_fd_pr__res_xhigh_po w=10 l=2519.1688
XRdiv20ap3s5 Rdiv20at3s4 Rdiv20at3s5 0 sky130_fd_pr__res_xhigh_po w=10 l=2519.1688
XRdiv20ap3s6 Rdiv20at3s5 Rdiv20at3s6 0 sky130_fd_pr__res_xhigh_po w=10 l=2519.1688
XRdiv20ap3s7 Rdiv20at3s6 tap20 0 sky130_fd_pr__res_xhigh_po w=10 l=2519.1688
XRdiv20ap4s0 in20 Rdiv20at4s0 0 sky130_fd_pr__res_xhigh_po w=10 l=2519.1688
XRdiv20ap4s1 Rdiv20at4s0 Rdiv20at4s1 0 sky130_fd_pr__res_xhigh_po w=10 l=2519.1688
XRdiv20ap4s2 Rdiv20at4s1 Rdiv20at4s2 0 sky130_fd_pr__res_xhigh_po w=10 l=2519.1688
XRdiv20ap4s3 Rdiv20at4s2 Rdiv20at4s3 0 sky130_fd_pr__res_xhigh_po w=10 l=2519.1688
XRdiv20ap4s4 Rdiv20at4s3 Rdiv20at4s4 0 sky130_fd_pr__res_xhigh_po w=10 l=2519.1688
XRdiv20ap4s5 Rdiv20at4s4 Rdiv20at4s5 0 sky130_fd_pr__res_xhigh_po w=10 l=2519.1688
XRdiv20ap4s6 Rdiv20at4s5 Rdiv20at4s6 0 sky130_fd_pr__res_xhigh_po w=10 l=2519.1688
XRdiv20ap4s7 Rdiv20at4s6 tap20 0 sky130_fd_pr__res_xhigh_po w=10 l=2519.1688
XRdiv20ap5s0 in20 Rdiv20at5s0 0 sky130_fd_pr__res_xhigh_po w=10 l=2519.1688
XRdiv20ap5s1 Rdiv20at5s0 Rdiv20at5s1 0 sky130_fd_pr__res_xhigh_po w=10 l=2519.1688
XRdiv20ap5s2 Rdiv20at5s1 Rdiv20at5s2 0 sky130_fd_pr__res_xhigh_po w=10 l=2519.1688
XRdiv20ap5s3 Rdiv20at5s2 Rdiv20at5s3 0 sky130_fd_pr__res_xhigh_po w=10 l=2519.1688
XRdiv20ap5s4 Rdiv20at5s3 Rdiv20at5s4 0 sky130_fd_pr__res_xhigh_po w=10 l=2519.1688
XRdiv20ap5s5 Rdiv20at5s4 Rdiv20at5s5 0 sky130_fd_pr__res_xhigh_po w=10 l=2519.1688
XRdiv20ap5s6 Rdiv20at5s5 Rdiv20at5s6 0 sky130_fd_pr__res_xhigh_po w=10 l=2519.1688
XRdiv20ap5s7 Rdiv20at5s6 tap20 0 sky130_fd_pr__res_xhigh_po w=10 l=2519.1688
XRdiv20ap6s0 in20 Rdiv20at6s0 0 sky130_fd_pr__res_xhigh_po w=10 l=2519.1688
XRdiv20ap6s1 Rdiv20at6s0 Rdiv20at6s1 0 sky130_fd_pr__res_xhigh_po w=10 l=2519.1688
XRdiv20ap6s2 Rdiv20at6s1 Rdiv20at6s2 0 sky130_fd_pr__res_xhigh_po w=10 l=2519.1688
XRdiv20ap6s3 Rdiv20at6s2 Rdiv20at6s3 0 sky130_fd_pr__res_xhigh_po w=10 l=2519.1688
XRdiv20ap6s4 Rdiv20at6s3 Rdiv20at6s4 0 sky130_fd_pr__res_xhigh_po w=10 l=2519.1688
XRdiv20ap6s5 Rdiv20at6s4 Rdiv20at6s5 0 sky130_fd_pr__res_xhigh_po w=10 l=2519.1688
XRdiv20ap6s6 Rdiv20at6s5 Rdiv20at6s6 0 sky130_fd_pr__res_xhigh_po w=10 l=2519.1688
XRdiv20ap6s7 Rdiv20at6s6 tap20 0 sky130_fd_pr__res_xhigh_po w=10 l=2519.1688
XRdiv20ap7s0 in20 Rdiv20at7s0 0 sky130_fd_pr__res_xhigh_po w=10 l=2519.1688
XRdiv20ap7s1 Rdiv20at7s0 Rdiv20at7s1 0 sky130_fd_pr__res_xhigh_po w=10 l=2519.1688
XRdiv20ap7s2 Rdiv20at7s1 Rdiv20at7s2 0 sky130_fd_pr__res_xhigh_po w=10 l=2519.1688
XRdiv20ap7s3 Rdiv20at7s2 Rdiv20at7s3 0 sky130_fd_pr__res_xhigh_po w=10 l=2519.1688
XRdiv20ap7s4 Rdiv20at7s3 Rdiv20at7s4 0 sky130_fd_pr__res_xhigh_po w=10 l=2519.1688
XRdiv20ap7s5 Rdiv20at7s4 Rdiv20at7s5 0 sky130_fd_pr__res_xhigh_po w=10 l=2519.1688
XRdiv20ap7s6 Rdiv20at7s5 Rdiv20at7s6 0 sky130_fd_pr__res_xhigh_po w=10 l=2519.1688
XRdiv20ap7s7 Rdiv20at7s6 tap20 0 sky130_fd_pr__res_xhigh_po w=10 l=2519.1688
* PDK sky130_fd_pr__res_xhigh_po Rdiv20b W=10 L=4.8663717
* tile Rdiv20b 8s x 8p same W=10 L=4.8663717
XRdiv20bp0s0 tap20 Rdiv20bt0s0 0 sky130_fd_pr__res_xhigh_po w=10 l=4.8663717
XRdiv20bp0s1 Rdiv20bt0s0 Rdiv20bt0s1 0 sky130_fd_pr__res_xhigh_po w=10 l=4.8663717
XRdiv20bp0s2 Rdiv20bt0s1 Rdiv20bt0s2 0 sky130_fd_pr__res_xhigh_po w=10 l=4.8663717
XRdiv20bp0s3 Rdiv20bt0s2 Rdiv20bt0s3 0 sky130_fd_pr__res_xhigh_po w=10 l=4.8663717
XRdiv20bp0s4 Rdiv20bt0s3 Rdiv20bt0s4 0 sky130_fd_pr__res_xhigh_po w=10 l=4.8663717
XRdiv20bp0s5 Rdiv20bt0s4 Rdiv20bt0s5 0 sky130_fd_pr__res_xhigh_po w=10 l=4.8663717
XRdiv20bp0s6 Rdiv20bt0s5 Rdiv20bt0s6 0 sky130_fd_pr__res_xhigh_po w=10 l=4.8663717
XRdiv20bp0s7 Rdiv20bt0s6 0 0 sky130_fd_pr__res_xhigh_po w=10 l=4.8663717
XRdiv20bp1s0 tap20 Rdiv20bt1s0 0 sky130_fd_pr__res_xhigh_po w=10 l=4.8663717
XRdiv20bp1s1 Rdiv20bt1s0 Rdiv20bt1s1 0 sky130_fd_pr__res_xhigh_po w=10 l=4.8663717
XRdiv20bp1s2 Rdiv20bt1s1 Rdiv20bt1s2 0 sky130_fd_pr__res_xhigh_po w=10 l=4.8663717
XRdiv20bp1s3 Rdiv20bt1s2 Rdiv20bt1s3 0 sky130_fd_pr__res_xhigh_po w=10 l=4.8663717
XRdiv20bp1s4 Rdiv20bt1s3 Rdiv20bt1s4 0 sky130_fd_pr__res_xhigh_po w=10 l=4.8663717
XRdiv20bp1s5 Rdiv20bt1s4 Rdiv20bt1s5 0 sky130_fd_pr__res_xhigh_po w=10 l=4.8663717
XRdiv20bp1s6 Rdiv20bt1s5 Rdiv20bt1s6 0 sky130_fd_pr__res_xhigh_po w=10 l=4.8663717
XRdiv20bp1s7 Rdiv20bt1s6 0 0 sky130_fd_pr__res_xhigh_po w=10 l=4.8663717
XRdiv20bp2s0 tap20 Rdiv20bt2s0 0 sky130_fd_pr__res_xhigh_po w=10 l=4.8663717
XRdiv20bp2s1 Rdiv20bt2s0 Rdiv20bt2s1 0 sky130_fd_pr__res_xhigh_po w=10 l=4.8663717
XRdiv20bp2s2 Rdiv20bt2s1 Rdiv20bt2s2 0 sky130_fd_pr__res_xhigh_po w=10 l=4.8663717
XRdiv20bp2s3 Rdiv20bt2s2 Rdiv20bt2s3 0 sky130_fd_pr__res_xhigh_po w=10 l=4.8663717
XRdiv20bp2s4 Rdiv20bt2s3 Rdiv20bt2s4 0 sky130_fd_pr__res_xhigh_po w=10 l=4.8663717
XRdiv20bp2s5 Rdiv20bt2s4 Rdiv20bt2s5 0 sky130_fd_pr__res_xhigh_po w=10 l=4.8663717
XRdiv20bp2s6 Rdiv20bt2s5 Rdiv20bt2s6 0 sky130_fd_pr__res_xhigh_po w=10 l=4.8663717
XRdiv20bp2s7 Rdiv20bt2s6 0 0 sky130_fd_pr__res_xhigh_po w=10 l=4.8663717
XRdiv20bp3s0 tap20 Rdiv20bt3s0 0 sky130_fd_pr__res_xhigh_po w=10 l=4.8663717
XRdiv20bp3s1 Rdiv20bt3s0 Rdiv20bt3s1 0 sky130_fd_pr__res_xhigh_po w=10 l=4.8663717
XRdiv20bp3s2 Rdiv20bt3s1 Rdiv20bt3s2 0 sky130_fd_pr__res_xhigh_po w=10 l=4.8663717
XRdiv20bp3s3 Rdiv20bt3s2 Rdiv20bt3s3 0 sky130_fd_pr__res_xhigh_po w=10 l=4.8663717
XRdiv20bp3s4 Rdiv20bt3s3 Rdiv20bt3s4 0 sky130_fd_pr__res_xhigh_po w=10 l=4.8663717
XRdiv20bp3s5 Rdiv20bt3s4 Rdiv20bt3s5 0 sky130_fd_pr__res_xhigh_po w=10 l=4.8663717
XRdiv20bp3s6 Rdiv20bt3s5 Rdiv20bt3s6 0 sky130_fd_pr__res_xhigh_po w=10 l=4.8663717
XRdiv20bp3s7 Rdiv20bt3s6 0 0 sky130_fd_pr__res_xhigh_po w=10 l=4.8663717
XRdiv20bp4s0 tap20 Rdiv20bt4s0 0 sky130_fd_pr__res_xhigh_po w=10 l=4.8663717
XRdiv20bp4s1 Rdiv20bt4s0 Rdiv20bt4s1 0 sky130_fd_pr__res_xhigh_po w=10 l=4.8663717
XRdiv20bp4s2 Rdiv20bt4s1 Rdiv20bt4s2 0 sky130_fd_pr__res_xhigh_po w=10 l=4.8663717
XRdiv20bp4s3 Rdiv20bt4s2 Rdiv20bt4s3 0 sky130_fd_pr__res_xhigh_po w=10 l=4.8663717
XRdiv20bp4s4 Rdiv20bt4s3 Rdiv20bt4s4 0 sky130_fd_pr__res_xhigh_po w=10 l=4.8663717
XRdiv20bp4s5 Rdiv20bt4s4 Rdiv20bt4s5 0 sky130_fd_pr__res_xhigh_po w=10 l=4.8663717
XRdiv20bp4s6 Rdiv20bt4s5 Rdiv20bt4s6 0 sky130_fd_pr__res_xhigh_po w=10 l=4.8663717
XRdiv20bp4s7 Rdiv20bt4s6 0 0 sky130_fd_pr__res_xhigh_po w=10 l=4.8663717
XRdiv20bp5s0 tap20 Rdiv20bt5s0 0 sky130_fd_pr__res_xhigh_po w=10 l=4.8663717
XRdiv20bp5s1 Rdiv20bt5s0 Rdiv20bt5s1 0 sky130_fd_pr__res_xhigh_po w=10 l=4.8663717
XRdiv20bp5s2 Rdiv20bt5s1 Rdiv20bt5s2 0 sky130_fd_pr__res_xhigh_po w=10 l=4.8663717
XRdiv20bp5s3 Rdiv20bt5s2 Rdiv20bt5s3 0 sky130_fd_pr__res_xhigh_po w=10 l=4.8663717
XRdiv20bp5s4 Rdiv20bt5s3 Rdiv20bt5s4 0 sky130_fd_pr__res_xhigh_po w=10 l=4.8663717
XRdiv20bp5s5 Rdiv20bt5s4 Rdiv20bt5s5 0 sky130_fd_pr__res_xhigh_po w=10 l=4.8663717
XRdiv20bp5s6 Rdiv20bt5s5 Rdiv20bt5s6 0 sky130_fd_pr__res_xhigh_po w=10 l=4.8663717
XRdiv20bp5s7 Rdiv20bt5s6 0 0 sky130_fd_pr__res_xhigh_po w=10 l=4.8663717
XRdiv20bp6s0 tap20 Rdiv20bt6s0 0 sky130_fd_pr__res_xhigh_po w=10 l=4.8663717
XRdiv20bp6s1 Rdiv20bt6s0 Rdiv20bt6s1 0 sky130_fd_pr__res_xhigh_po w=10 l=4.8663717
XRdiv20bp6s2 Rdiv20bt6s1 Rdiv20bt6s2 0 sky130_fd_pr__res_xhigh_po w=10 l=4.8663717
XRdiv20bp6s3 Rdiv20bt6s2 Rdiv20bt6s3 0 sky130_fd_pr__res_xhigh_po w=10 l=4.8663717
XRdiv20bp6s4 Rdiv20bt6s3 Rdiv20bt6s4 0 sky130_fd_pr__res_xhigh_po w=10 l=4.8663717
XRdiv20bp6s5 Rdiv20bt6s4 Rdiv20bt6s5 0 sky130_fd_pr__res_xhigh_po w=10 l=4.8663717
XRdiv20bp6s6 Rdiv20bt6s5 Rdiv20bt6s6 0 sky130_fd_pr__res_xhigh_po w=10 l=4.8663717
XRdiv20bp6s7 Rdiv20bt6s6 0 0 sky130_fd_pr__res_xhigh_po w=10 l=4.8663717
XRdiv20bp7s0 tap20 Rdiv20bt7s0 0 sky130_fd_pr__res_xhigh_po w=10 l=4.8663717
XRdiv20bp7s1 Rdiv20bt7s0 Rdiv20bt7s1 0 sky130_fd_pr__res_xhigh_po w=10 l=4.8663717
XRdiv20bp7s2 Rdiv20bt7s1 Rdiv20bt7s2 0 sky130_fd_pr__res_xhigh_po w=10 l=4.8663717
XRdiv20bp7s3 Rdiv20bt7s2 Rdiv20bt7s3 0 sky130_fd_pr__res_xhigh_po w=10 l=4.8663717
XRdiv20bp7s4 Rdiv20bt7s3 Rdiv20bt7s4 0 sky130_fd_pr__res_xhigh_po w=10 l=4.8663717
XRdiv20bp7s5 Rdiv20bt7s4 Rdiv20bt7s5 0 sky130_fd_pr__res_xhigh_po w=10 l=4.8663717
XRdiv20bp7s6 Rdiv20bt7s5 Rdiv20bt7s6 0 sky130_fd_pr__res_xhigh_po w=10 l=4.8663717
XRdiv20bp7s7 Rdiv20bt7s6 0 0 sky130_fd_pr__res_xhigh_po w=10 l=4.8663717
Vin21 in21 0 DC 0
Vin22 in22 0 DC 0
* passive invert in22 -> in22n: R2/R1=1.0000002 closed-loop -1 at A=1e+07
* PDK sky130_fd_pr__res_xhigh_po Rinv22ia W=10 L=49.614372
* tile Rinv22ia 8s x 8p same W=10 L=49.614372
XRinv22iap0s0 in22 Rinv22iat0s0 0 sky130_fd_pr__res_xhigh_po w=10 l=49.614372
XRinv22iap0s1 Rinv22iat0s0 Rinv22iat0s1 0 sky130_fd_pr__res_xhigh_po w=10 l=49.614372
XRinv22iap0s2 Rinv22iat0s1 Rinv22iat0s2 0 sky130_fd_pr__res_xhigh_po w=10 l=49.614372
XRinv22iap0s3 Rinv22iat0s2 Rinv22iat0s3 0 sky130_fd_pr__res_xhigh_po w=10 l=49.614372
XRinv22iap0s4 Rinv22iat0s3 Rinv22iat0s4 0 sky130_fd_pr__res_xhigh_po w=10 l=49.614372
XRinv22iap0s5 Rinv22iat0s4 Rinv22iat0s5 0 sky130_fd_pr__res_xhigh_po w=10 l=49.614372
XRinv22iap0s6 Rinv22iat0s5 Rinv22iat0s6 0 sky130_fd_pr__res_xhigh_po w=10 l=49.614372
XRinv22iap0s7 Rinv22iat0s6 inv22m 0 sky130_fd_pr__res_xhigh_po w=10 l=49.614372
XRinv22iap1s0 in22 Rinv22iat1s0 0 sky130_fd_pr__res_xhigh_po w=10 l=49.614372
XRinv22iap1s1 Rinv22iat1s0 Rinv22iat1s1 0 sky130_fd_pr__res_xhigh_po w=10 l=49.614372
XRinv22iap1s2 Rinv22iat1s1 Rinv22iat1s2 0 sky130_fd_pr__res_xhigh_po w=10 l=49.614372
XRinv22iap1s3 Rinv22iat1s2 Rinv22iat1s3 0 sky130_fd_pr__res_xhigh_po w=10 l=49.614372
XRinv22iap1s4 Rinv22iat1s3 Rinv22iat1s4 0 sky130_fd_pr__res_xhigh_po w=10 l=49.614372
XRinv22iap1s5 Rinv22iat1s4 Rinv22iat1s5 0 sky130_fd_pr__res_xhigh_po w=10 l=49.614372
XRinv22iap1s6 Rinv22iat1s5 Rinv22iat1s6 0 sky130_fd_pr__res_xhigh_po w=10 l=49.614372
XRinv22iap1s7 Rinv22iat1s6 inv22m 0 sky130_fd_pr__res_xhigh_po w=10 l=49.614372
XRinv22iap2s0 in22 Rinv22iat2s0 0 sky130_fd_pr__res_xhigh_po w=10 l=49.614372
XRinv22iap2s1 Rinv22iat2s0 Rinv22iat2s1 0 sky130_fd_pr__res_xhigh_po w=10 l=49.614372
XRinv22iap2s2 Rinv22iat2s1 Rinv22iat2s2 0 sky130_fd_pr__res_xhigh_po w=10 l=49.614372
XRinv22iap2s3 Rinv22iat2s2 Rinv22iat2s3 0 sky130_fd_pr__res_xhigh_po w=10 l=49.614372
XRinv22iap2s4 Rinv22iat2s3 Rinv22iat2s4 0 sky130_fd_pr__res_xhigh_po w=10 l=49.614372
XRinv22iap2s5 Rinv22iat2s4 Rinv22iat2s5 0 sky130_fd_pr__res_xhigh_po w=10 l=49.614372
XRinv22iap2s6 Rinv22iat2s5 Rinv22iat2s6 0 sky130_fd_pr__res_xhigh_po w=10 l=49.614372
XRinv22iap2s7 Rinv22iat2s6 inv22m 0 sky130_fd_pr__res_xhigh_po w=10 l=49.614372
XRinv22iap3s0 in22 Rinv22iat3s0 0 sky130_fd_pr__res_xhigh_po w=10 l=49.614372
XRinv22iap3s1 Rinv22iat3s0 Rinv22iat3s1 0 sky130_fd_pr__res_xhigh_po w=10 l=49.614372
XRinv22iap3s2 Rinv22iat3s1 Rinv22iat3s2 0 sky130_fd_pr__res_xhigh_po w=10 l=49.614372
XRinv22iap3s3 Rinv22iat3s2 Rinv22iat3s3 0 sky130_fd_pr__res_xhigh_po w=10 l=49.614372
XRinv22iap3s4 Rinv22iat3s3 Rinv22iat3s4 0 sky130_fd_pr__res_xhigh_po w=10 l=49.614372
XRinv22iap3s5 Rinv22iat3s4 Rinv22iat3s5 0 sky130_fd_pr__res_xhigh_po w=10 l=49.614372
XRinv22iap3s6 Rinv22iat3s5 Rinv22iat3s6 0 sky130_fd_pr__res_xhigh_po w=10 l=49.614372
XRinv22iap3s7 Rinv22iat3s6 inv22m 0 sky130_fd_pr__res_xhigh_po w=10 l=49.614372
XRinv22iap4s0 in22 Rinv22iat4s0 0 sky130_fd_pr__res_xhigh_po w=10 l=49.614372
XRinv22iap4s1 Rinv22iat4s0 Rinv22iat4s1 0 sky130_fd_pr__res_xhigh_po w=10 l=49.614372
XRinv22iap4s2 Rinv22iat4s1 Rinv22iat4s2 0 sky130_fd_pr__res_xhigh_po w=10 l=49.614372
XRinv22iap4s3 Rinv22iat4s2 Rinv22iat4s3 0 sky130_fd_pr__res_xhigh_po w=10 l=49.614372
XRinv22iap4s4 Rinv22iat4s3 Rinv22iat4s4 0 sky130_fd_pr__res_xhigh_po w=10 l=49.614372
XRinv22iap4s5 Rinv22iat4s4 Rinv22iat4s5 0 sky130_fd_pr__res_xhigh_po w=10 l=49.614372
XRinv22iap4s6 Rinv22iat4s5 Rinv22iat4s6 0 sky130_fd_pr__res_xhigh_po w=10 l=49.614372
XRinv22iap4s7 Rinv22iat4s6 inv22m 0 sky130_fd_pr__res_xhigh_po w=10 l=49.614372
XRinv22iap5s0 in22 Rinv22iat5s0 0 sky130_fd_pr__res_xhigh_po w=10 l=49.614372
XRinv22iap5s1 Rinv22iat5s0 Rinv22iat5s1 0 sky130_fd_pr__res_xhigh_po w=10 l=49.614372
XRinv22iap5s2 Rinv22iat5s1 Rinv22iat5s2 0 sky130_fd_pr__res_xhigh_po w=10 l=49.614372
XRinv22iap5s3 Rinv22iat5s2 Rinv22iat5s3 0 sky130_fd_pr__res_xhigh_po w=10 l=49.614372
XRinv22iap5s4 Rinv22iat5s3 Rinv22iat5s4 0 sky130_fd_pr__res_xhigh_po w=10 l=49.614372
XRinv22iap5s5 Rinv22iat5s4 Rinv22iat5s5 0 sky130_fd_pr__res_xhigh_po w=10 l=49.614372
XRinv22iap5s6 Rinv22iat5s5 Rinv22iat5s6 0 sky130_fd_pr__res_xhigh_po w=10 l=49.614372
XRinv22iap5s7 Rinv22iat5s6 inv22m 0 sky130_fd_pr__res_xhigh_po w=10 l=49.614372
XRinv22iap6s0 in22 Rinv22iat6s0 0 sky130_fd_pr__res_xhigh_po w=10 l=49.614372
XRinv22iap6s1 Rinv22iat6s0 Rinv22iat6s1 0 sky130_fd_pr__res_xhigh_po w=10 l=49.614372
XRinv22iap6s2 Rinv22iat6s1 Rinv22iat6s2 0 sky130_fd_pr__res_xhigh_po w=10 l=49.614372
XRinv22iap6s3 Rinv22iat6s2 Rinv22iat6s3 0 sky130_fd_pr__res_xhigh_po w=10 l=49.614372
XRinv22iap6s4 Rinv22iat6s3 Rinv22iat6s4 0 sky130_fd_pr__res_xhigh_po w=10 l=49.614372
XRinv22iap6s5 Rinv22iat6s4 Rinv22iat6s5 0 sky130_fd_pr__res_xhigh_po w=10 l=49.614372
XRinv22iap6s6 Rinv22iat6s5 Rinv22iat6s6 0 sky130_fd_pr__res_xhigh_po w=10 l=49.614372
XRinv22iap6s7 Rinv22iat6s6 inv22m 0 sky130_fd_pr__res_xhigh_po w=10 l=49.614372
XRinv22iap7s0 in22 Rinv22iat7s0 0 sky130_fd_pr__res_xhigh_po w=10 l=49.614372
XRinv22iap7s1 Rinv22iat7s0 Rinv22iat7s1 0 sky130_fd_pr__res_xhigh_po w=10 l=49.614372
XRinv22iap7s2 Rinv22iat7s1 Rinv22iat7s2 0 sky130_fd_pr__res_xhigh_po w=10 l=49.614372
XRinv22iap7s3 Rinv22iat7s2 Rinv22iat7s3 0 sky130_fd_pr__res_xhigh_po w=10 l=49.614372
XRinv22iap7s4 Rinv22iat7s3 Rinv22iat7s4 0 sky130_fd_pr__res_xhigh_po w=10 l=49.614372
XRinv22iap7s5 Rinv22iat7s4 Rinv22iat7s5 0 sky130_fd_pr__res_xhigh_po w=10 l=49.614372
XRinv22iap7s6 Rinv22iat7s5 Rinv22iat7s6 0 sky130_fd_pr__res_xhigh_po w=10 l=49.614372
XRinv22iap7s7 Rinv22iat7s6 inv22m 0 sky130_fd_pr__res_xhigh_po w=10 l=49.614372
* PDK sky130_fd_pr__res_xhigh_po Rinv22ib W=10 L=49.614382
* tile Rinv22ib 8s x 8p same W=10 L=49.614382
XRinv22ibp0s0 in22n Rinv22ibt0s0 0 sky130_fd_pr__res_xhigh_po w=10 l=49.614382
XRinv22ibp0s1 Rinv22ibt0s0 Rinv22ibt0s1 0 sky130_fd_pr__res_xhigh_po w=10 l=49.614382
XRinv22ibp0s2 Rinv22ibt0s1 Rinv22ibt0s2 0 sky130_fd_pr__res_xhigh_po w=10 l=49.614382
XRinv22ibp0s3 Rinv22ibt0s2 Rinv22ibt0s3 0 sky130_fd_pr__res_xhigh_po w=10 l=49.614382
XRinv22ibp0s4 Rinv22ibt0s3 Rinv22ibt0s4 0 sky130_fd_pr__res_xhigh_po w=10 l=49.614382
XRinv22ibp0s5 Rinv22ibt0s4 Rinv22ibt0s5 0 sky130_fd_pr__res_xhigh_po w=10 l=49.614382
XRinv22ibp0s6 Rinv22ibt0s5 Rinv22ibt0s6 0 sky130_fd_pr__res_xhigh_po w=10 l=49.614382
XRinv22ibp0s7 Rinv22ibt0s6 inv22m 0 sky130_fd_pr__res_xhigh_po w=10 l=49.614382
XRinv22ibp1s0 in22n Rinv22ibt1s0 0 sky130_fd_pr__res_xhigh_po w=10 l=49.614382
XRinv22ibp1s1 Rinv22ibt1s0 Rinv22ibt1s1 0 sky130_fd_pr__res_xhigh_po w=10 l=49.614382
XRinv22ibp1s2 Rinv22ibt1s1 Rinv22ibt1s2 0 sky130_fd_pr__res_xhigh_po w=10 l=49.614382
XRinv22ibp1s3 Rinv22ibt1s2 Rinv22ibt1s3 0 sky130_fd_pr__res_xhigh_po w=10 l=49.614382
XRinv22ibp1s4 Rinv22ibt1s3 Rinv22ibt1s4 0 sky130_fd_pr__res_xhigh_po w=10 l=49.614382
XRinv22ibp1s5 Rinv22ibt1s4 Rinv22ibt1s5 0 sky130_fd_pr__res_xhigh_po w=10 l=49.614382
XRinv22ibp1s6 Rinv22ibt1s5 Rinv22ibt1s6 0 sky130_fd_pr__res_xhigh_po w=10 l=49.614382
XRinv22ibp1s7 Rinv22ibt1s6 inv22m 0 sky130_fd_pr__res_xhigh_po w=10 l=49.614382
XRinv22ibp2s0 in22n Rinv22ibt2s0 0 sky130_fd_pr__res_xhigh_po w=10 l=49.614382
XRinv22ibp2s1 Rinv22ibt2s0 Rinv22ibt2s1 0 sky130_fd_pr__res_xhigh_po w=10 l=49.614382
XRinv22ibp2s2 Rinv22ibt2s1 Rinv22ibt2s2 0 sky130_fd_pr__res_xhigh_po w=10 l=49.614382
XRinv22ibp2s3 Rinv22ibt2s2 Rinv22ibt2s3 0 sky130_fd_pr__res_xhigh_po w=10 l=49.614382
XRinv22ibp2s4 Rinv22ibt2s3 Rinv22ibt2s4 0 sky130_fd_pr__res_xhigh_po w=10 l=49.614382
XRinv22ibp2s5 Rinv22ibt2s4 Rinv22ibt2s5 0 sky130_fd_pr__res_xhigh_po w=10 l=49.614382
XRinv22ibp2s6 Rinv22ibt2s5 Rinv22ibt2s6 0 sky130_fd_pr__res_xhigh_po w=10 l=49.614382
XRinv22ibp2s7 Rinv22ibt2s6 inv22m 0 sky130_fd_pr__res_xhigh_po w=10 l=49.614382
XRinv22ibp3s0 in22n Rinv22ibt3s0 0 sky130_fd_pr__res_xhigh_po w=10 l=49.614382
XRinv22ibp3s1 Rinv22ibt3s0 Rinv22ibt3s1 0 sky130_fd_pr__res_xhigh_po w=10 l=49.614382
XRinv22ibp3s2 Rinv22ibt3s1 Rinv22ibt3s2 0 sky130_fd_pr__res_xhigh_po w=10 l=49.614382
XRinv22ibp3s3 Rinv22ibt3s2 Rinv22ibt3s3 0 sky130_fd_pr__res_xhigh_po w=10 l=49.614382
XRinv22ibp3s4 Rinv22ibt3s3 Rinv22ibt3s4 0 sky130_fd_pr__res_xhigh_po w=10 l=49.614382
XRinv22ibp3s5 Rinv22ibt3s4 Rinv22ibt3s5 0 sky130_fd_pr__res_xhigh_po w=10 l=49.614382
XRinv22ibp3s6 Rinv22ibt3s5 Rinv22ibt3s6 0 sky130_fd_pr__res_xhigh_po w=10 l=49.614382
XRinv22ibp3s7 Rinv22ibt3s6 inv22m 0 sky130_fd_pr__res_xhigh_po w=10 l=49.614382
XRinv22ibp4s0 in22n Rinv22ibt4s0 0 sky130_fd_pr__res_xhigh_po w=10 l=49.614382
XRinv22ibp4s1 Rinv22ibt4s0 Rinv22ibt4s1 0 sky130_fd_pr__res_xhigh_po w=10 l=49.614382
XRinv22ibp4s2 Rinv22ibt4s1 Rinv22ibt4s2 0 sky130_fd_pr__res_xhigh_po w=10 l=49.614382
XRinv22ibp4s3 Rinv22ibt4s2 Rinv22ibt4s3 0 sky130_fd_pr__res_xhigh_po w=10 l=49.614382
XRinv22ibp4s4 Rinv22ibt4s3 Rinv22ibt4s4 0 sky130_fd_pr__res_xhigh_po w=10 l=49.614382
XRinv22ibp4s5 Rinv22ibt4s4 Rinv22ibt4s5 0 sky130_fd_pr__res_xhigh_po w=10 l=49.614382
XRinv22ibp4s6 Rinv22ibt4s5 Rinv22ibt4s6 0 sky130_fd_pr__res_xhigh_po w=10 l=49.614382
XRinv22ibp4s7 Rinv22ibt4s6 inv22m 0 sky130_fd_pr__res_xhigh_po w=10 l=49.614382
XRinv22ibp5s0 in22n Rinv22ibt5s0 0 sky130_fd_pr__res_xhigh_po w=10 l=49.614382
XRinv22ibp5s1 Rinv22ibt5s0 Rinv22ibt5s1 0 sky130_fd_pr__res_xhigh_po w=10 l=49.614382
XRinv22ibp5s2 Rinv22ibt5s1 Rinv22ibt5s2 0 sky130_fd_pr__res_xhigh_po w=10 l=49.614382
XRinv22ibp5s3 Rinv22ibt5s2 Rinv22ibt5s3 0 sky130_fd_pr__res_xhigh_po w=10 l=49.614382
XRinv22ibp5s4 Rinv22ibt5s3 Rinv22ibt5s4 0 sky130_fd_pr__res_xhigh_po w=10 l=49.614382
XRinv22ibp5s5 Rinv22ibt5s4 Rinv22ibt5s5 0 sky130_fd_pr__res_xhigh_po w=10 l=49.614382
XRinv22ibp5s6 Rinv22ibt5s5 Rinv22ibt5s6 0 sky130_fd_pr__res_xhigh_po w=10 l=49.614382
XRinv22ibp5s7 Rinv22ibt5s6 inv22m 0 sky130_fd_pr__res_xhigh_po w=10 l=49.614382
XRinv22ibp6s0 in22n Rinv22ibt6s0 0 sky130_fd_pr__res_xhigh_po w=10 l=49.614382
XRinv22ibp6s1 Rinv22ibt6s0 Rinv22ibt6s1 0 sky130_fd_pr__res_xhigh_po w=10 l=49.614382
XRinv22ibp6s2 Rinv22ibt6s1 Rinv22ibt6s2 0 sky130_fd_pr__res_xhigh_po w=10 l=49.614382
XRinv22ibp6s3 Rinv22ibt6s2 Rinv22ibt6s3 0 sky130_fd_pr__res_xhigh_po w=10 l=49.614382
XRinv22ibp6s4 Rinv22ibt6s3 Rinv22ibt6s4 0 sky130_fd_pr__res_xhigh_po w=10 l=49.614382
XRinv22ibp6s5 Rinv22ibt6s4 Rinv22ibt6s5 0 sky130_fd_pr__res_xhigh_po w=10 l=49.614382
XRinv22ibp6s6 Rinv22ibt6s5 Rinv22ibt6s6 0 sky130_fd_pr__res_xhigh_po w=10 l=49.614382
XRinv22ibp6s7 Rinv22ibt6s6 inv22m 0 sky130_fd_pr__res_xhigh_po w=10 l=49.614382
XRinv22ibp7s0 in22n Rinv22ibt7s0 0 sky130_fd_pr__res_xhigh_po w=10 l=49.614382
XRinv22ibp7s1 Rinv22ibt7s0 Rinv22ibt7s1 0 sky130_fd_pr__res_xhigh_po w=10 l=49.614382
XRinv22ibp7s2 Rinv22ibt7s1 Rinv22ibt7s2 0 sky130_fd_pr__res_xhigh_po w=10 l=49.614382
XRinv22ibp7s3 Rinv22ibt7s2 Rinv22ibt7s3 0 sky130_fd_pr__res_xhigh_po w=10 l=49.614382
XRinv22ibp7s4 Rinv22ibt7s3 Rinv22ibt7s4 0 sky130_fd_pr__res_xhigh_po w=10 l=49.614382
XRinv22ibp7s5 Rinv22ibt7s4 Rinv22ibt7s5 0 sky130_fd_pr__res_xhigh_po w=10 l=49.614382
XRinv22ibp7s6 Rinv22ibt7s5 Rinv22ibt7s6 0 sky130_fd_pr__res_xhigh_po w=10 l=49.614382
XRinv22ibp7s7 Rinv22ibt7s6 inv22m 0 sky130_fd_pr__res_xhigh_po w=10 l=49.614382
Einv22amp in22n 0 0 inv22m 10000000
Vin23 in23 0 DC 0.370520947636909
* passive invert in23 -> in23n: R2/R1=1.0000002 closed-loop -1 at A=1e+07
* PDK sky130_fd_pr__res_xhigh_po Rinv23ia W=10 L=49.614372
* tile Rinv23ia 8s x 8p same W=10 L=49.614372
XRinv23iap0s0 in23 Rinv23iat0s0 0 sky130_fd_pr__res_xhigh_po w=10 l=49.614372
XRinv23iap0s1 Rinv23iat0s0 Rinv23iat0s1 0 sky130_fd_pr__res_xhigh_po w=10 l=49.614372
XRinv23iap0s2 Rinv23iat0s1 Rinv23iat0s2 0 sky130_fd_pr__res_xhigh_po w=10 l=49.614372
XRinv23iap0s3 Rinv23iat0s2 Rinv23iat0s3 0 sky130_fd_pr__res_xhigh_po w=10 l=49.614372
XRinv23iap0s4 Rinv23iat0s3 Rinv23iat0s4 0 sky130_fd_pr__res_xhigh_po w=10 l=49.614372
XRinv23iap0s5 Rinv23iat0s4 Rinv23iat0s5 0 sky130_fd_pr__res_xhigh_po w=10 l=49.614372
XRinv23iap0s6 Rinv23iat0s5 Rinv23iat0s6 0 sky130_fd_pr__res_xhigh_po w=10 l=49.614372
XRinv23iap0s7 Rinv23iat0s6 inv23m 0 sky130_fd_pr__res_xhigh_po w=10 l=49.614372
XRinv23iap1s0 in23 Rinv23iat1s0 0 sky130_fd_pr__res_xhigh_po w=10 l=49.614372
XRinv23iap1s1 Rinv23iat1s0 Rinv23iat1s1 0 sky130_fd_pr__res_xhigh_po w=10 l=49.614372
XRinv23iap1s2 Rinv23iat1s1 Rinv23iat1s2 0 sky130_fd_pr__res_xhigh_po w=10 l=49.614372
XRinv23iap1s3 Rinv23iat1s2 Rinv23iat1s3 0 sky130_fd_pr__res_xhigh_po w=10 l=49.614372
XRinv23iap1s4 Rinv23iat1s3 Rinv23iat1s4 0 sky130_fd_pr__res_xhigh_po w=10 l=49.614372
XRinv23iap1s5 Rinv23iat1s4 Rinv23iat1s5 0 sky130_fd_pr__res_xhigh_po w=10 l=49.614372
XRinv23iap1s6 Rinv23iat1s5 Rinv23iat1s6 0 sky130_fd_pr__res_xhigh_po w=10 l=49.614372
XRinv23iap1s7 Rinv23iat1s6 inv23m 0 sky130_fd_pr__res_xhigh_po w=10 l=49.614372
XRinv23iap2s0 in23 Rinv23iat2s0 0 sky130_fd_pr__res_xhigh_po w=10 l=49.614372
XRinv23iap2s1 Rinv23iat2s0 Rinv23iat2s1 0 sky130_fd_pr__res_xhigh_po w=10 l=49.614372
XRinv23iap2s2 Rinv23iat2s1 Rinv23iat2s2 0 sky130_fd_pr__res_xhigh_po w=10 l=49.614372
XRinv23iap2s3 Rinv23iat2s2 Rinv23iat2s3 0 sky130_fd_pr__res_xhigh_po w=10 l=49.614372
XRinv23iap2s4 Rinv23iat2s3 Rinv23iat2s4 0 sky130_fd_pr__res_xhigh_po w=10 l=49.614372
XRinv23iap2s5 Rinv23iat2s4 Rinv23iat2s5 0 sky130_fd_pr__res_xhigh_po w=10 l=49.614372
XRinv23iap2s6 Rinv23iat2s5 Rinv23iat2s6 0 sky130_fd_pr__res_xhigh_po w=10 l=49.614372
XRinv23iap2s7 Rinv23iat2s6 inv23m 0 sky130_fd_pr__res_xhigh_po w=10 l=49.614372
XRinv23iap3s0 in23 Rinv23iat3s0 0 sky130_fd_pr__res_xhigh_po w=10 l=49.614372
XRinv23iap3s1 Rinv23iat3s0 Rinv23iat3s1 0 sky130_fd_pr__res_xhigh_po w=10 l=49.614372
XRinv23iap3s2 Rinv23iat3s1 Rinv23iat3s2 0 sky130_fd_pr__res_xhigh_po w=10 l=49.614372
XRinv23iap3s3 Rinv23iat3s2 Rinv23iat3s3 0 sky130_fd_pr__res_xhigh_po w=10 l=49.614372
XRinv23iap3s4 Rinv23iat3s3 Rinv23iat3s4 0 sky130_fd_pr__res_xhigh_po w=10 l=49.614372
XRinv23iap3s5 Rinv23iat3s4 Rinv23iat3s5 0 sky130_fd_pr__res_xhigh_po w=10 l=49.614372
XRinv23iap3s6 Rinv23iat3s5 Rinv23iat3s6 0 sky130_fd_pr__res_xhigh_po w=10 l=49.614372
XRinv23iap3s7 Rinv23iat3s6 inv23m 0 sky130_fd_pr__res_xhigh_po w=10 l=49.614372
XRinv23iap4s0 in23 Rinv23iat4s0 0 sky130_fd_pr__res_xhigh_po w=10 l=49.614372
XRinv23iap4s1 Rinv23iat4s0 Rinv23iat4s1 0 sky130_fd_pr__res_xhigh_po w=10 l=49.614372
XRinv23iap4s2 Rinv23iat4s1 Rinv23iat4s2 0 sky130_fd_pr__res_xhigh_po w=10 l=49.614372
XRinv23iap4s3 Rinv23iat4s2 Rinv23iat4s3 0 sky130_fd_pr__res_xhigh_po w=10 l=49.614372
XRinv23iap4s4 Rinv23iat4s3 Rinv23iat4s4 0 sky130_fd_pr__res_xhigh_po w=10 l=49.614372
XRinv23iap4s5 Rinv23iat4s4 Rinv23iat4s5 0 sky130_fd_pr__res_xhigh_po w=10 l=49.614372
XRinv23iap4s6 Rinv23iat4s5 Rinv23iat4s6 0 sky130_fd_pr__res_xhigh_po w=10 l=49.614372
XRinv23iap4s7 Rinv23iat4s6 inv23m 0 sky130_fd_pr__res_xhigh_po w=10 l=49.614372
XRinv23iap5s0 in23 Rinv23iat5s0 0 sky130_fd_pr__res_xhigh_po w=10 l=49.614372
XRinv23iap5s1 Rinv23iat5s0 Rinv23iat5s1 0 sky130_fd_pr__res_xhigh_po w=10 l=49.614372
XRinv23iap5s2 Rinv23iat5s1 Rinv23iat5s2 0 sky130_fd_pr__res_xhigh_po w=10 l=49.614372
XRinv23iap5s3 Rinv23iat5s2 Rinv23iat5s3 0 sky130_fd_pr__res_xhigh_po w=10 l=49.614372
XRinv23iap5s4 Rinv23iat5s3 Rinv23iat5s4 0 sky130_fd_pr__res_xhigh_po w=10 l=49.614372
XRinv23iap5s5 Rinv23iat5s4 Rinv23iat5s5 0 sky130_fd_pr__res_xhigh_po w=10 l=49.614372
XRinv23iap5s6 Rinv23iat5s5 Rinv23iat5s6 0 sky130_fd_pr__res_xhigh_po w=10 l=49.614372
XRinv23iap5s7 Rinv23iat5s6 inv23m 0 sky130_fd_pr__res_xhigh_po w=10 l=49.614372
XRinv23iap6s0 in23 Rinv23iat6s0 0 sky130_fd_pr__res_xhigh_po w=10 l=49.614372
XRinv23iap6s1 Rinv23iat6s0 Rinv23iat6s1 0 sky130_fd_pr__res_xhigh_po w=10 l=49.614372
XRinv23iap6s2 Rinv23iat6s1 Rinv23iat6s2 0 sky130_fd_pr__res_xhigh_po w=10 l=49.614372
XRinv23iap6s3 Rinv23iat6s2 Rinv23iat6s3 0 sky130_fd_pr__res_xhigh_po w=10 l=49.614372
XRinv23iap6s4 Rinv23iat6s3 Rinv23iat6s4 0 sky130_fd_pr__res_xhigh_po w=10 l=49.614372
XRinv23iap6s5 Rinv23iat6s4 Rinv23iat6s5 0 sky130_fd_pr__res_xhigh_po w=10 l=49.614372
XRinv23iap6s6 Rinv23iat6s5 Rinv23iat6s6 0 sky130_fd_pr__res_xhigh_po w=10 l=49.614372
XRinv23iap6s7 Rinv23iat6s6 inv23m 0 sky130_fd_pr__res_xhigh_po w=10 l=49.614372
XRinv23iap7s0 in23 Rinv23iat7s0 0 sky130_fd_pr__res_xhigh_po w=10 l=49.614372
XRinv23iap7s1 Rinv23iat7s0 Rinv23iat7s1 0 sky130_fd_pr__res_xhigh_po w=10 l=49.614372
XRinv23iap7s2 Rinv23iat7s1 Rinv23iat7s2 0 sky130_fd_pr__res_xhigh_po w=10 l=49.614372
XRinv23iap7s3 Rinv23iat7s2 Rinv23iat7s3 0 sky130_fd_pr__res_xhigh_po w=10 l=49.614372
XRinv23iap7s4 Rinv23iat7s3 Rinv23iat7s4 0 sky130_fd_pr__res_xhigh_po w=10 l=49.614372
XRinv23iap7s5 Rinv23iat7s4 Rinv23iat7s5 0 sky130_fd_pr__res_xhigh_po w=10 l=49.614372
XRinv23iap7s6 Rinv23iat7s5 Rinv23iat7s6 0 sky130_fd_pr__res_xhigh_po w=10 l=49.614372
XRinv23iap7s7 Rinv23iat7s6 inv23m 0 sky130_fd_pr__res_xhigh_po w=10 l=49.614372
* PDK sky130_fd_pr__res_xhigh_po Rinv23ib W=10 L=49.614382
* tile Rinv23ib 8s x 8p same W=10 L=49.614382
XRinv23ibp0s0 in23n Rinv23ibt0s0 0 sky130_fd_pr__res_xhigh_po w=10 l=49.614382
XRinv23ibp0s1 Rinv23ibt0s0 Rinv23ibt0s1 0 sky130_fd_pr__res_xhigh_po w=10 l=49.614382
XRinv23ibp0s2 Rinv23ibt0s1 Rinv23ibt0s2 0 sky130_fd_pr__res_xhigh_po w=10 l=49.614382
XRinv23ibp0s3 Rinv23ibt0s2 Rinv23ibt0s3 0 sky130_fd_pr__res_xhigh_po w=10 l=49.614382
XRinv23ibp0s4 Rinv23ibt0s3 Rinv23ibt0s4 0 sky130_fd_pr__res_xhigh_po w=10 l=49.614382
XRinv23ibp0s5 Rinv23ibt0s4 Rinv23ibt0s5 0 sky130_fd_pr__res_xhigh_po w=10 l=49.614382
XRinv23ibp0s6 Rinv23ibt0s5 Rinv23ibt0s6 0 sky130_fd_pr__res_xhigh_po w=10 l=49.614382
XRinv23ibp0s7 Rinv23ibt0s6 inv23m 0 sky130_fd_pr__res_xhigh_po w=10 l=49.614382
XRinv23ibp1s0 in23n Rinv23ibt1s0 0 sky130_fd_pr__res_xhigh_po w=10 l=49.614382
XRinv23ibp1s1 Rinv23ibt1s0 Rinv23ibt1s1 0 sky130_fd_pr__res_xhigh_po w=10 l=49.614382
XRinv23ibp1s2 Rinv23ibt1s1 Rinv23ibt1s2 0 sky130_fd_pr__res_xhigh_po w=10 l=49.614382
XRinv23ibp1s3 Rinv23ibt1s2 Rinv23ibt1s3 0 sky130_fd_pr__res_xhigh_po w=10 l=49.614382
XRinv23ibp1s4 Rinv23ibt1s3 Rinv23ibt1s4 0 sky130_fd_pr__res_xhigh_po w=10 l=49.614382
XRinv23ibp1s5 Rinv23ibt1s4 Rinv23ibt1s5 0 sky130_fd_pr__res_xhigh_po w=10 l=49.614382
XRinv23ibp1s6 Rinv23ibt1s5 Rinv23ibt1s6 0 sky130_fd_pr__res_xhigh_po w=10 l=49.614382
XRinv23ibp1s7 Rinv23ibt1s6 inv23m 0 sky130_fd_pr__res_xhigh_po w=10 l=49.614382
XRinv23ibp2s0 in23n Rinv23ibt2s0 0 sky130_fd_pr__res_xhigh_po w=10 l=49.614382
XRinv23ibp2s1 Rinv23ibt2s0 Rinv23ibt2s1 0 sky130_fd_pr__res_xhigh_po w=10 l=49.614382
XRinv23ibp2s2 Rinv23ibt2s1 Rinv23ibt2s2 0 sky130_fd_pr__res_xhigh_po w=10 l=49.614382
XRinv23ibp2s3 Rinv23ibt2s2 Rinv23ibt2s3 0 sky130_fd_pr__res_xhigh_po w=10 l=49.614382
XRinv23ibp2s4 Rinv23ibt2s3 Rinv23ibt2s4 0 sky130_fd_pr__res_xhigh_po w=10 l=49.614382
XRinv23ibp2s5 Rinv23ibt2s4 Rinv23ibt2s5 0 sky130_fd_pr__res_xhigh_po w=10 l=49.614382
XRinv23ibp2s6 Rinv23ibt2s5 Rinv23ibt2s6 0 sky130_fd_pr__res_xhigh_po w=10 l=49.614382
XRinv23ibp2s7 Rinv23ibt2s6 inv23m 0 sky130_fd_pr__res_xhigh_po w=10 l=49.614382
XRinv23ibp3s0 in23n Rinv23ibt3s0 0 sky130_fd_pr__res_xhigh_po w=10 l=49.614382
XRinv23ibp3s1 Rinv23ibt3s0 Rinv23ibt3s1 0 sky130_fd_pr__res_xhigh_po w=10 l=49.614382
XRinv23ibp3s2 Rinv23ibt3s1 Rinv23ibt3s2 0 sky130_fd_pr__res_xhigh_po w=10 l=49.614382
XRinv23ibp3s3 Rinv23ibt3s2 Rinv23ibt3s3 0 sky130_fd_pr__res_xhigh_po w=10 l=49.614382
XRinv23ibp3s4 Rinv23ibt3s3 Rinv23ibt3s4 0 sky130_fd_pr__res_xhigh_po w=10 l=49.614382
XRinv23ibp3s5 Rinv23ibt3s4 Rinv23ibt3s5 0 sky130_fd_pr__res_xhigh_po w=10 l=49.614382
XRinv23ibp3s6 Rinv23ibt3s5 Rinv23ibt3s6 0 sky130_fd_pr__res_xhigh_po w=10 l=49.614382
XRinv23ibp3s7 Rinv23ibt3s6 inv23m 0 sky130_fd_pr__res_xhigh_po w=10 l=49.614382
XRinv23ibp4s0 in23n Rinv23ibt4s0 0 sky130_fd_pr__res_xhigh_po w=10 l=49.614382
XRinv23ibp4s1 Rinv23ibt4s0 Rinv23ibt4s1 0 sky130_fd_pr__res_xhigh_po w=10 l=49.614382
XRinv23ibp4s2 Rinv23ibt4s1 Rinv23ibt4s2 0 sky130_fd_pr__res_xhigh_po w=10 l=49.614382
XRinv23ibp4s3 Rinv23ibt4s2 Rinv23ibt4s3 0 sky130_fd_pr__res_xhigh_po w=10 l=49.614382
XRinv23ibp4s4 Rinv23ibt4s3 Rinv23ibt4s4 0 sky130_fd_pr__res_xhigh_po w=10 l=49.614382
XRinv23ibp4s5 Rinv23ibt4s4 Rinv23ibt4s5 0 sky130_fd_pr__res_xhigh_po w=10 l=49.614382
XRinv23ibp4s6 Rinv23ibt4s5 Rinv23ibt4s6 0 sky130_fd_pr__res_xhigh_po w=10 l=49.614382
XRinv23ibp4s7 Rinv23ibt4s6 inv23m 0 sky130_fd_pr__res_xhigh_po w=10 l=49.614382
XRinv23ibp5s0 in23n Rinv23ibt5s0 0 sky130_fd_pr__res_xhigh_po w=10 l=49.614382
XRinv23ibp5s1 Rinv23ibt5s0 Rinv23ibt5s1 0 sky130_fd_pr__res_xhigh_po w=10 l=49.614382
XRinv23ibp5s2 Rinv23ibt5s1 Rinv23ibt5s2 0 sky130_fd_pr__res_xhigh_po w=10 l=49.614382
XRinv23ibp5s3 Rinv23ibt5s2 Rinv23ibt5s3 0 sky130_fd_pr__res_xhigh_po w=10 l=49.614382
XRinv23ibp5s4 Rinv23ibt5s3 Rinv23ibt5s4 0 sky130_fd_pr__res_xhigh_po w=10 l=49.614382
XRinv23ibp5s5 Rinv23ibt5s4 Rinv23ibt5s5 0 sky130_fd_pr__res_xhigh_po w=10 l=49.614382
XRinv23ibp5s6 Rinv23ibt5s5 Rinv23ibt5s6 0 sky130_fd_pr__res_xhigh_po w=10 l=49.614382
XRinv23ibp5s7 Rinv23ibt5s6 inv23m 0 sky130_fd_pr__res_xhigh_po w=10 l=49.614382
XRinv23ibp6s0 in23n Rinv23ibt6s0 0 sky130_fd_pr__res_xhigh_po w=10 l=49.614382
XRinv23ibp6s1 Rinv23ibt6s0 Rinv23ibt6s1 0 sky130_fd_pr__res_xhigh_po w=10 l=49.614382
XRinv23ibp6s2 Rinv23ibt6s1 Rinv23ibt6s2 0 sky130_fd_pr__res_xhigh_po w=10 l=49.614382
XRinv23ibp6s3 Rinv23ibt6s2 Rinv23ibt6s3 0 sky130_fd_pr__res_xhigh_po w=10 l=49.614382
XRinv23ibp6s4 Rinv23ibt6s3 Rinv23ibt6s4 0 sky130_fd_pr__res_xhigh_po w=10 l=49.614382
XRinv23ibp6s5 Rinv23ibt6s4 Rinv23ibt6s5 0 sky130_fd_pr__res_xhigh_po w=10 l=49.614382
XRinv23ibp6s6 Rinv23ibt6s5 Rinv23ibt6s6 0 sky130_fd_pr__res_xhigh_po w=10 l=49.614382
XRinv23ibp6s7 Rinv23ibt6s6 inv23m 0 sky130_fd_pr__res_xhigh_po w=10 l=49.614382
XRinv23ibp7s0 in23n Rinv23ibt7s0 0 sky130_fd_pr__res_xhigh_po w=10 l=49.614382
XRinv23ibp7s1 Rinv23ibt7s0 Rinv23ibt7s1 0 sky130_fd_pr__res_xhigh_po w=10 l=49.614382
XRinv23ibp7s2 Rinv23ibt7s1 Rinv23ibt7s2 0 sky130_fd_pr__res_xhigh_po w=10 l=49.614382
XRinv23ibp7s3 Rinv23ibt7s2 Rinv23ibt7s3 0 sky130_fd_pr__res_xhigh_po w=10 l=49.614382
XRinv23ibp7s4 Rinv23ibt7s3 Rinv23ibt7s4 0 sky130_fd_pr__res_xhigh_po w=10 l=49.614382
XRinv23ibp7s5 Rinv23ibt7s4 Rinv23ibt7s5 0 sky130_fd_pr__res_xhigh_po w=10 l=49.614382
XRinv23ibp7s6 Rinv23ibt7s5 Rinv23ibt7s6 0 sky130_fd_pr__res_xhigh_po w=10 l=49.614382
XRinv23ibp7s7 Rinv23ibt7s6 inv23m 0 sky130_fd_pr__res_xhigh_po w=10 l=49.614382
Einv23amp in23n 0 0 inv23m 10000000
Vin24 in24 0 DC 0
* load-compensated divider in24->tap24: G_load=0.000881349510863982 Ra=531001.812385847 Rb=1000 target beta=0.001 (no tap buffer)
* PDK sky130_fd_pr__res_xhigh_po Rdiv24a W=10 L=2640.0354
* tile Rdiv24a 8s x 8p same W=10 L=2640.0354
XRdiv24ap0s0 in24 Rdiv24at0s0 0 sky130_fd_pr__res_xhigh_po w=10 l=2640.0354
XRdiv24ap0s1 Rdiv24at0s0 Rdiv24at0s1 0 sky130_fd_pr__res_xhigh_po w=10 l=2640.0354
XRdiv24ap0s2 Rdiv24at0s1 Rdiv24at0s2 0 sky130_fd_pr__res_xhigh_po w=10 l=2640.0354
XRdiv24ap0s3 Rdiv24at0s2 Rdiv24at0s3 0 sky130_fd_pr__res_xhigh_po w=10 l=2640.0354
XRdiv24ap0s4 Rdiv24at0s3 Rdiv24at0s4 0 sky130_fd_pr__res_xhigh_po w=10 l=2640.0354
XRdiv24ap0s5 Rdiv24at0s4 Rdiv24at0s5 0 sky130_fd_pr__res_xhigh_po w=10 l=2640.0354
XRdiv24ap0s6 Rdiv24at0s5 Rdiv24at0s6 0 sky130_fd_pr__res_xhigh_po w=10 l=2640.0354
XRdiv24ap0s7 Rdiv24at0s6 tap24 0 sky130_fd_pr__res_xhigh_po w=10 l=2640.0354
XRdiv24ap1s0 in24 Rdiv24at1s0 0 sky130_fd_pr__res_xhigh_po w=10 l=2640.0354
XRdiv24ap1s1 Rdiv24at1s0 Rdiv24at1s1 0 sky130_fd_pr__res_xhigh_po w=10 l=2640.0354
XRdiv24ap1s2 Rdiv24at1s1 Rdiv24at1s2 0 sky130_fd_pr__res_xhigh_po w=10 l=2640.0354
XRdiv24ap1s3 Rdiv24at1s2 Rdiv24at1s3 0 sky130_fd_pr__res_xhigh_po w=10 l=2640.0354
XRdiv24ap1s4 Rdiv24at1s3 Rdiv24at1s4 0 sky130_fd_pr__res_xhigh_po w=10 l=2640.0354
XRdiv24ap1s5 Rdiv24at1s4 Rdiv24at1s5 0 sky130_fd_pr__res_xhigh_po w=10 l=2640.0354
XRdiv24ap1s6 Rdiv24at1s5 Rdiv24at1s6 0 sky130_fd_pr__res_xhigh_po w=10 l=2640.0354
XRdiv24ap1s7 Rdiv24at1s6 tap24 0 sky130_fd_pr__res_xhigh_po w=10 l=2640.0354
XRdiv24ap2s0 in24 Rdiv24at2s0 0 sky130_fd_pr__res_xhigh_po w=10 l=2640.0354
XRdiv24ap2s1 Rdiv24at2s0 Rdiv24at2s1 0 sky130_fd_pr__res_xhigh_po w=10 l=2640.0354
XRdiv24ap2s2 Rdiv24at2s1 Rdiv24at2s2 0 sky130_fd_pr__res_xhigh_po w=10 l=2640.0354
XRdiv24ap2s3 Rdiv24at2s2 Rdiv24at2s3 0 sky130_fd_pr__res_xhigh_po w=10 l=2640.0354
XRdiv24ap2s4 Rdiv24at2s3 Rdiv24at2s4 0 sky130_fd_pr__res_xhigh_po w=10 l=2640.0354
XRdiv24ap2s5 Rdiv24at2s4 Rdiv24at2s5 0 sky130_fd_pr__res_xhigh_po w=10 l=2640.0354
XRdiv24ap2s6 Rdiv24at2s5 Rdiv24at2s6 0 sky130_fd_pr__res_xhigh_po w=10 l=2640.0354
XRdiv24ap2s7 Rdiv24at2s6 tap24 0 sky130_fd_pr__res_xhigh_po w=10 l=2640.0354
XRdiv24ap3s0 in24 Rdiv24at3s0 0 sky130_fd_pr__res_xhigh_po w=10 l=2640.0354
XRdiv24ap3s1 Rdiv24at3s0 Rdiv24at3s1 0 sky130_fd_pr__res_xhigh_po w=10 l=2640.0354
XRdiv24ap3s2 Rdiv24at3s1 Rdiv24at3s2 0 sky130_fd_pr__res_xhigh_po w=10 l=2640.0354
XRdiv24ap3s3 Rdiv24at3s2 Rdiv24at3s3 0 sky130_fd_pr__res_xhigh_po w=10 l=2640.0354
XRdiv24ap3s4 Rdiv24at3s3 Rdiv24at3s4 0 sky130_fd_pr__res_xhigh_po w=10 l=2640.0354
XRdiv24ap3s5 Rdiv24at3s4 Rdiv24at3s5 0 sky130_fd_pr__res_xhigh_po w=10 l=2640.0354
XRdiv24ap3s6 Rdiv24at3s5 Rdiv24at3s6 0 sky130_fd_pr__res_xhigh_po w=10 l=2640.0354
XRdiv24ap3s7 Rdiv24at3s6 tap24 0 sky130_fd_pr__res_xhigh_po w=10 l=2640.0354
XRdiv24ap4s0 in24 Rdiv24at4s0 0 sky130_fd_pr__res_xhigh_po w=10 l=2640.0354
XRdiv24ap4s1 Rdiv24at4s0 Rdiv24at4s1 0 sky130_fd_pr__res_xhigh_po w=10 l=2640.0354
XRdiv24ap4s2 Rdiv24at4s1 Rdiv24at4s2 0 sky130_fd_pr__res_xhigh_po w=10 l=2640.0354
XRdiv24ap4s3 Rdiv24at4s2 Rdiv24at4s3 0 sky130_fd_pr__res_xhigh_po w=10 l=2640.0354
XRdiv24ap4s4 Rdiv24at4s3 Rdiv24at4s4 0 sky130_fd_pr__res_xhigh_po w=10 l=2640.0354
XRdiv24ap4s5 Rdiv24at4s4 Rdiv24at4s5 0 sky130_fd_pr__res_xhigh_po w=10 l=2640.0354
XRdiv24ap4s6 Rdiv24at4s5 Rdiv24at4s6 0 sky130_fd_pr__res_xhigh_po w=10 l=2640.0354
XRdiv24ap4s7 Rdiv24at4s6 tap24 0 sky130_fd_pr__res_xhigh_po w=10 l=2640.0354
XRdiv24ap5s0 in24 Rdiv24at5s0 0 sky130_fd_pr__res_xhigh_po w=10 l=2640.0354
XRdiv24ap5s1 Rdiv24at5s0 Rdiv24at5s1 0 sky130_fd_pr__res_xhigh_po w=10 l=2640.0354
XRdiv24ap5s2 Rdiv24at5s1 Rdiv24at5s2 0 sky130_fd_pr__res_xhigh_po w=10 l=2640.0354
XRdiv24ap5s3 Rdiv24at5s2 Rdiv24at5s3 0 sky130_fd_pr__res_xhigh_po w=10 l=2640.0354
XRdiv24ap5s4 Rdiv24at5s3 Rdiv24at5s4 0 sky130_fd_pr__res_xhigh_po w=10 l=2640.0354
XRdiv24ap5s5 Rdiv24at5s4 Rdiv24at5s5 0 sky130_fd_pr__res_xhigh_po w=10 l=2640.0354
XRdiv24ap5s6 Rdiv24at5s5 Rdiv24at5s6 0 sky130_fd_pr__res_xhigh_po w=10 l=2640.0354
XRdiv24ap5s7 Rdiv24at5s6 tap24 0 sky130_fd_pr__res_xhigh_po w=10 l=2640.0354
XRdiv24ap6s0 in24 Rdiv24at6s0 0 sky130_fd_pr__res_xhigh_po w=10 l=2640.0354
XRdiv24ap6s1 Rdiv24at6s0 Rdiv24at6s1 0 sky130_fd_pr__res_xhigh_po w=10 l=2640.0354
XRdiv24ap6s2 Rdiv24at6s1 Rdiv24at6s2 0 sky130_fd_pr__res_xhigh_po w=10 l=2640.0354
XRdiv24ap6s3 Rdiv24at6s2 Rdiv24at6s3 0 sky130_fd_pr__res_xhigh_po w=10 l=2640.0354
XRdiv24ap6s4 Rdiv24at6s3 Rdiv24at6s4 0 sky130_fd_pr__res_xhigh_po w=10 l=2640.0354
XRdiv24ap6s5 Rdiv24at6s4 Rdiv24at6s5 0 sky130_fd_pr__res_xhigh_po w=10 l=2640.0354
XRdiv24ap6s6 Rdiv24at6s5 Rdiv24at6s6 0 sky130_fd_pr__res_xhigh_po w=10 l=2640.0354
XRdiv24ap6s7 Rdiv24at6s6 tap24 0 sky130_fd_pr__res_xhigh_po w=10 l=2640.0354
XRdiv24ap7s0 in24 Rdiv24at7s0 0 sky130_fd_pr__res_xhigh_po w=10 l=2640.0354
XRdiv24ap7s1 Rdiv24at7s0 Rdiv24at7s1 0 sky130_fd_pr__res_xhigh_po w=10 l=2640.0354
XRdiv24ap7s2 Rdiv24at7s1 Rdiv24at7s2 0 sky130_fd_pr__res_xhigh_po w=10 l=2640.0354
XRdiv24ap7s3 Rdiv24at7s2 Rdiv24at7s3 0 sky130_fd_pr__res_xhigh_po w=10 l=2640.0354
XRdiv24ap7s4 Rdiv24at7s3 Rdiv24at7s4 0 sky130_fd_pr__res_xhigh_po w=10 l=2640.0354
XRdiv24ap7s5 Rdiv24at7s4 Rdiv24at7s5 0 sky130_fd_pr__res_xhigh_po w=10 l=2640.0354
XRdiv24ap7s6 Rdiv24at7s5 Rdiv24at7s6 0 sky130_fd_pr__res_xhigh_po w=10 l=2640.0354
XRdiv24ap7s7 Rdiv24at7s6 tap24 0 sky130_fd_pr__res_xhigh_po w=10 l=2640.0354
* PDK sky130_fd_pr__res_xhigh_po Rdiv24b W=10 L=4.8663717
* tile Rdiv24b 8s x 8p same W=10 L=4.8663717
XRdiv24bp0s0 tap24 Rdiv24bt0s0 0 sky130_fd_pr__res_xhigh_po w=10 l=4.8663717
XRdiv24bp0s1 Rdiv24bt0s0 Rdiv24bt0s1 0 sky130_fd_pr__res_xhigh_po w=10 l=4.8663717
XRdiv24bp0s2 Rdiv24bt0s1 Rdiv24bt0s2 0 sky130_fd_pr__res_xhigh_po w=10 l=4.8663717
XRdiv24bp0s3 Rdiv24bt0s2 Rdiv24bt0s3 0 sky130_fd_pr__res_xhigh_po w=10 l=4.8663717
XRdiv24bp0s4 Rdiv24bt0s3 Rdiv24bt0s4 0 sky130_fd_pr__res_xhigh_po w=10 l=4.8663717
XRdiv24bp0s5 Rdiv24bt0s4 Rdiv24bt0s5 0 sky130_fd_pr__res_xhigh_po w=10 l=4.8663717
XRdiv24bp0s6 Rdiv24bt0s5 Rdiv24bt0s6 0 sky130_fd_pr__res_xhigh_po w=10 l=4.8663717
XRdiv24bp0s7 Rdiv24bt0s6 0 0 sky130_fd_pr__res_xhigh_po w=10 l=4.8663717
XRdiv24bp1s0 tap24 Rdiv24bt1s0 0 sky130_fd_pr__res_xhigh_po w=10 l=4.8663717
XRdiv24bp1s1 Rdiv24bt1s0 Rdiv24bt1s1 0 sky130_fd_pr__res_xhigh_po w=10 l=4.8663717
XRdiv24bp1s2 Rdiv24bt1s1 Rdiv24bt1s2 0 sky130_fd_pr__res_xhigh_po w=10 l=4.8663717
XRdiv24bp1s3 Rdiv24bt1s2 Rdiv24bt1s3 0 sky130_fd_pr__res_xhigh_po w=10 l=4.8663717
XRdiv24bp1s4 Rdiv24bt1s3 Rdiv24bt1s4 0 sky130_fd_pr__res_xhigh_po w=10 l=4.8663717
XRdiv24bp1s5 Rdiv24bt1s4 Rdiv24bt1s5 0 sky130_fd_pr__res_xhigh_po w=10 l=4.8663717
XRdiv24bp1s6 Rdiv24bt1s5 Rdiv24bt1s6 0 sky130_fd_pr__res_xhigh_po w=10 l=4.8663717
XRdiv24bp1s7 Rdiv24bt1s6 0 0 sky130_fd_pr__res_xhigh_po w=10 l=4.8663717
XRdiv24bp2s0 tap24 Rdiv24bt2s0 0 sky130_fd_pr__res_xhigh_po w=10 l=4.8663717
XRdiv24bp2s1 Rdiv24bt2s0 Rdiv24bt2s1 0 sky130_fd_pr__res_xhigh_po w=10 l=4.8663717
XRdiv24bp2s2 Rdiv24bt2s1 Rdiv24bt2s2 0 sky130_fd_pr__res_xhigh_po w=10 l=4.8663717
XRdiv24bp2s3 Rdiv24bt2s2 Rdiv24bt2s3 0 sky130_fd_pr__res_xhigh_po w=10 l=4.8663717
XRdiv24bp2s4 Rdiv24bt2s3 Rdiv24bt2s4 0 sky130_fd_pr__res_xhigh_po w=10 l=4.8663717
XRdiv24bp2s5 Rdiv24bt2s4 Rdiv24bt2s5 0 sky130_fd_pr__res_xhigh_po w=10 l=4.8663717
XRdiv24bp2s6 Rdiv24bt2s5 Rdiv24bt2s6 0 sky130_fd_pr__res_xhigh_po w=10 l=4.8663717
XRdiv24bp2s7 Rdiv24bt2s6 0 0 sky130_fd_pr__res_xhigh_po w=10 l=4.8663717
XRdiv24bp3s0 tap24 Rdiv24bt3s0 0 sky130_fd_pr__res_xhigh_po w=10 l=4.8663717
XRdiv24bp3s1 Rdiv24bt3s0 Rdiv24bt3s1 0 sky130_fd_pr__res_xhigh_po w=10 l=4.8663717
XRdiv24bp3s2 Rdiv24bt3s1 Rdiv24bt3s2 0 sky130_fd_pr__res_xhigh_po w=10 l=4.8663717
XRdiv24bp3s3 Rdiv24bt3s2 Rdiv24bt3s3 0 sky130_fd_pr__res_xhigh_po w=10 l=4.8663717
XRdiv24bp3s4 Rdiv24bt3s3 Rdiv24bt3s4 0 sky130_fd_pr__res_xhigh_po w=10 l=4.8663717
XRdiv24bp3s5 Rdiv24bt3s4 Rdiv24bt3s5 0 sky130_fd_pr__res_xhigh_po w=10 l=4.8663717
XRdiv24bp3s6 Rdiv24bt3s5 Rdiv24bt3s6 0 sky130_fd_pr__res_xhigh_po w=10 l=4.8663717
XRdiv24bp3s7 Rdiv24bt3s6 0 0 sky130_fd_pr__res_xhigh_po w=10 l=4.8663717
XRdiv24bp4s0 tap24 Rdiv24bt4s0 0 sky130_fd_pr__res_xhigh_po w=10 l=4.8663717
XRdiv24bp4s1 Rdiv24bt4s0 Rdiv24bt4s1 0 sky130_fd_pr__res_xhigh_po w=10 l=4.8663717
XRdiv24bp4s2 Rdiv24bt4s1 Rdiv24bt4s2 0 sky130_fd_pr__res_xhigh_po w=10 l=4.8663717
XRdiv24bp4s3 Rdiv24bt4s2 Rdiv24bt4s3 0 sky130_fd_pr__res_xhigh_po w=10 l=4.8663717
XRdiv24bp4s4 Rdiv24bt4s3 Rdiv24bt4s4 0 sky130_fd_pr__res_xhigh_po w=10 l=4.8663717
XRdiv24bp4s5 Rdiv24bt4s4 Rdiv24bt4s5 0 sky130_fd_pr__res_xhigh_po w=10 l=4.8663717
XRdiv24bp4s6 Rdiv24bt4s5 Rdiv24bt4s6 0 sky130_fd_pr__res_xhigh_po w=10 l=4.8663717
XRdiv24bp4s7 Rdiv24bt4s6 0 0 sky130_fd_pr__res_xhigh_po w=10 l=4.8663717
XRdiv24bp5s0 tap24 Rdiv24bt5s0 0 sky130_fd_pr__res_xhigh_po w=10 l=4.8663717
XRdiv24bp5s1 Rdiv24bt5s0 Rdiv24bt5s1 0 sky130_fd_pr__res_xhigh_po w=10 l=4.8663717
XRdiv24bp5s2 Rdiv24bt5s1 Rdiv24bt5s2 0 sky130_fd_pr__res_xhigh_po w=10 l=4.8663717
XRdiv24bp5s3 Rdiv24bt5s2 Rdiv24bt5s3 0 sky130_fd_pr__res_xhigh_po w=10 l=4.8663717
XRdiv24bp5s4 Rdiv24bt5s3 Rdiv24bt5s4 0 sky130_fd_pr__res_xhigh_po w=10 l=4.8663717
XRdiv24bp5s5 Rdiv24bt5s4 Rdiv24bt5s5 0 sky130_fd_pr__res_xhigh_po w=10 l=4.8663717
XRdiv24bp5s6 Rdiv24bt5s5 Rdiv24bt5s6 0 sky130_fd_pr__res_xhigh_po w=10 l=4.8663717
XRdiv24bp5s7 Rdiv24bt5s6 0 0 sky130_fd_pr__res_xhigh_po w=10 l=4.8663717
XRdiv24bp6s0 tap24 Rdiv24bt6s0 0 sky130_fd_pr__res_xhigh_po w=10 l=4.8663717
XRdiv24bp6s1 Rdiv24bt6s0 Rdiv24bt6s1 0 sky130_fd_pr__res_xhigh_po w=10 l=4.8663717
XRdiv24bp6s2 Rdiv24bt6s1 Rdiv24bt6s2 0 sky130_fd_pr__res_xhigh_po w=10 l=4.8663717
XRdiv24bp6s3 Rdiv24bt6s2 Rdiv24bt6s3 0 sky130_fd_pr__res_xhigh_po w=10 l=4.8663717
XRdiv24bp6s4 Rdiv24bt6s3 Rdiv24bt6s4 0 sky130_fd_pr__res_xhigh_po w=10 l=4.8663717
XRdiv24bp6s5 Rdiv24bt6s4 Rdiv24bt6s5 0 sky130_fd_pr__res_xhigh_po w=10 l=4.8663717
XRdiv24bp6s6 Rdiv24bt6s5 Rdiv24bt6s6 0 sky130_fd_pr__res_xhigh_po w=10 l=4.8663717
XRdiv24bp6s7 Rdiv24bt6s6 0 0 sky130_fd_pr__res_xhigh_po w=10 l=4.8663717
XRdiv24bp7s0 tap24 Rdiv24bt7s0 0 sky130_fd_pr__res_xhigh_po w=10 l=4.8663717
XRdiv24bp7s1 Rdiv24bt7s0 Rdiv24bt7s1 0 sky130_fd_pr__res_xhigh_po w=10 l=4.8663717
XRdiv24bp7s2 Rdiv24bt7s1 Rdiv24bt7s2 0 sky130_fd_pr__res_xhigh_po w=10 l=4.8663717
XRdiv24bp7s3 Rdiv24bt7s2 Rdiv24bt7s3 0 sky130_fd_pr__res_xhigh_po w=10 l=4.8663717
XRdiv24bp7s4 Rdiv24bt7s3 Rdiv24bt7s4 0 sky130_fd_pr__res_xhigh_po w=10 l=4.8663717
XRdiv24bp7s5 Rdiv24bt7s4 Rdiv24bt7s5 0 sky130_fd_pr__res_xhigh_po w=10 l=4.8663717
XRdiv24bp7s6 Rdiv24bt7s5 Rdiv24bt7s6 0 sky130_fd_pr__res_xhigh_po w=10 l=4.8663717
XRdiv24bp7s7 Rdiv24bt7s6 0 0 sky130_fd_pr__res_xhigh_po w=10 l=4.8663717
Vin25 in25 0 DC 0
* passive invert in25 -> in25n: R2/R1=1.0000002 closed-loop -1 at A=1e+07
* PDK sky130_fd_pr__res_xhigh_po Rinv25ia W=10 L=49.614372
* tile Rinv25ia 8s x 8p same W=10 L=49.614372
XRinv25iap0s0 in25 Rinv25iat0s0 0 sky130_fd_pr__res_xhigh_po w=10 l=49.614372
XRinv25iap0s1 Rinv25iat0s0 Rinv25iat0s1 0 sky130_fd_pr__res_xhigh_po w=10 l=49.614372
XRinv25iap0s2 Rinv25iat0s1 Rinv25iat0s2 0 sky130_fd_pr__res_xhigh_po w=10 l=49.614372
XRinv25iap0s3 Rinv25iat0s2 Rinv25iat0s3 0 sky130_fd_pr__res_xhigh_po w=10 l=49.614372
XRinv25iap0s4 Rinv25iat0s3 Rinv25iat0s4 0 sky130_fd_pr__res_xhigh_po w=10 l=49.614372
XRinv25iap0s5 Rinv25iat0s4 Rinv25iat0s5 0 sky130_fd_pr__res_xhigh_po w=10 l=49.614372
XRinv25iap0s6 Rinv25iat0s5 Rinv25iat0s6 0 sky130_fd_pr__res_xhigh_po w=10 l=49.614372
XRinv25iap0s7 Rinv25iat0s6 inv25m 0 sky130_fd_pr__res_xhigh_po w=10 l=49.614372
XRinv25iap1s0 in25 Rinv25iat1s0 0 sky130_fd_pr__res_xhigh_po w=10 l=49.614372
XRinv25iap1s1 Rinv25iat1s0 Rinv25iat1s1 0 sky130_fd_pr__res_xhigh_po w=10 l=49.614372
XRinv25iap1s2 Rinv25iat1s1 Rinv25iat1s2 0 sky130_fd_pr__res_xhigh_po w=10 l=49.614372
XRinv25iap1s3 Rinv25iat1s2 Rinv25iat1s3 0 sky130_fd_pr__res_xhigh_po w=10 l=49.614372
XRinv25iap1s4 Rinv25iat1s3 Rinv25iat1s4 0 sky130_fd_pr__res_xhigh_po w=10 l=49.614372
XRinv25iap1s5 Rinv25iat1s4 Rinv25iat1s5 0 sky130_fd_pr__res_xhigh_po w=10 l=49.614372
XRinv25iap1s6 Rinv25iat1s5 Rinv25iat1s6 0 sky130_fd_pr__res_xhigh_po w=10 l=49.614372
XRinv25iap1s7 Rinv25iat1s6 inv25m 0 sky130_fd_pr__res_xhigh_po w=10 l=49.614372
XRinv25iap2s0 in25 Rinv25iat2s0 0 sky130_fd_pr__res_xhigh_po w=10 l=49.614372
XRinv25iap2s1 Rinv25iat2s0 Rinv25iat2s1 0 sky130_fd_pr__res_xhigh_po w=10 l=49.614372
XRinv25iap2s2 Rinv25iat2s1 Rinv25iat2s2 0 sky130_fd_pr__res_xhigh_po w=10 l=49.614372
XRinv25iap2s3 Rinv25iat2s2 Rinv25iat2s3 0 sky130_fd_pr__res_xhigh_po w=10 l=49.614372
XRinv25iap2s4 Rinv25iat2s3 Rinv25iat2s4 0 sky130_fd_pr__res_xhigh_po w=10 l=49.614372
XRinv25iap2s5 Rinv25iat2s4 Rinv25iat2s5 0 sky130_fd_pr__res_xhigh_po w=10 l=49.614372
XRinv25iap2s6 Rinv25iat2s5 Rinv25iat2s6 0 sky130_fd_pr__res_xhigh_po w=10 l=49.614372
XRinv25iap2s7 Rinv25iat2s6 inv25m 0 sky130_fd_pr__res_xhigh_po w=10 l=49.614372
XRinv25iap3s0 in25 Rinv25iat3s0 0 sky130_fd_pr__res_xhigh_po w=10 l=49.614372
XRinv25iap3s1 Rinv25iat3s0 Rinv25iat3s1 0 sky130_fd_pr__res_xhigh_po w=10 l=49.614372
XRinv25iap3s2 Rinv25iat3s1 Rinv25iat3s2 0 sky130_fd_pr__res_xhigh_po w=10 l=49.614372
XRinv25iap3s3 Rinv25iat3s2 Rinv25iat3s3 0 sky130_fd_pr__res_xhigh_po w=10 l=49.614372
XRinv25iap3s4 Rinv25iat3s3 Rinv25iat3s4 0 sky130_fd_pr__res_xhigh_po w=10 l=49.614372
XRinv25iap3s5 Rinv25iat3s4 Rinv25iat3s5 0 sky130_fd_pr__res_xhigh_po w=10 l=49.614372
XRinv25iap3s6 Rinv25iat3s5 Rinv25iat3s6 0 sky130_fd_pr__res_xhigh_po w=10 l=49.614372
XRinv25iap3s7 Rinv25iat3s6 inv25m 0 sky130_fd_pr__res_xhigh_po w=10 l=49.614372
XRinv25iap4s0 in25 Rinv25iat4s0 0 sky130_fd_pr__res_xhigh_po w=10 l=49.614372
XRinv25iap4s1 Rinv25iat4s0 Rinv25iat4s1 0 sky130_fd_pr__res_xhigh_po w=10 l=49.614372
XRinv25iap4s2 Rinv25iat4s1 Rinv25iat4s2 0 sky130_fd_pr__res_xhigh_po w=10 l=49.614372
XRinv25iap4s3 Rinv25iat4s2 Rinv25iat4s3 0 sky130_fd_pr__res_xhigh_po w=10 l=49.614372
XRinv25iap4s4 Rinv25iat4s3 Rinv25iat4s4 0 sky130_fd_pr__res_xhigh_po w=10 l=49.614372
XRinv25iap4s5 Rinv25iat4s4 Rinv25iat4s5 0 sky130_fd_pr__res_xhigh_po w=10 l=49.614372
XRinv25iap4s6 Rinv25iat4s5 Rinv25iat4s6 0 sky130_fd_pr__res_xhigh_po w=10 l=49.614372
XRinv25iap4s7 Rinv25iat4s6 inv25m 0 sky130_fd_pr__res_xhigh_po w=10 l=49.614372
XRinv25iap5s0 in25 Rinv25iat5s0 0 sky130_fd_pr__res_xhigh_po w=10 l=49.614372
XRinv25iap5s1 Rinv25iat5s0 Rinv25iat5s1 0 sky130_fd_pr__res_xhigh_po w=10 l=49.614372
XRinv25iap5s2 Rinv25iat5s1 Rinv25iat5s2 0 sky130_fd_pr__res_xhigh_po w=10 l=49.614372
XRinv25iap5s3 Rinv25iat5s2 Rinv25iat5s3 0 sky130_fd_pr__res_xhigh_po w=10 l=49.614372
XRinv25iap5s4 Rinv25iat5s3 Rinv25iat5s4 0 sky130_fd_pr__res_xhigh_po w=10 l=49.614372
XRinv25iap5s5 Rinv25iat5s4 Rinv25iat5s5 0 sky130_fd_pr__res_xhigh_po w=10 l=49.614372
XRinv25iap5s6 Rinv25iat5s5 Rinv25iat5s6 0 sky130_fd_pr__res_xhigh_po w=10 l=49.614372
XRinv25iap5s7 Rinv25iat5s6 inv25m 0 sky130_fd_pr__res_xhigh_po w=10 l=49.614372
XRinv25iap6s0 in25 Rinv25iat6s0 0 sky130_fd_pr__res_xhigh_po w=10 l=49.614372
XRinv25iap6s1 Rinv25iat6s0 Rinv25iat6s1 0 sky130_fd_pr__res_xhigh_po w=10 l=49.614372
XRinv25iap6s2 Rinv25iat6s1 Rinv25iat6s2 0 sky130_fd_pr__res_xhigh_po w=10 l=49.614372
XRinv25iap6s3 Rinv25iat6s2 Rinv25iat6s3 0 sky130_fd_pr__res_xhigh_po w=10 l=49.614372
XRinv25iap6s4 Rinv25iat6s3 Rinv25iat6s4 0 sky130_fd_pr__res_xhigh_po w=10 l=49.614372
XRinv25iap6s5 Rinv25iat6s4 Rinv25iat6s5 0 sky130_fd_pr__res_xhigh_po w=10 l=49.614372
XRinv25iap6s6 Rinv25iat6s5 Rinv25iat6s6 0 sky130_fd_pr__res_xhigh_po w=10 l=49.614372
XRinv25iap6s7 Rinv25iat6s6 inv25m 0 sky130_fd_pr__res_xhigh_po w=10 l=49.614372
XRinv25iap7s0 in25 Rinv25iat7s0 0 sky130_fd_pr__res_xhigh_po w=10 l=49.614372
XRinv25iap7s1 Rinv25iat7s0 Rinv25iat7s1 0 sky130_fd_pr__res_xhigh_po w=10 l=49.614372
XRinv25iap7s2 Rinv25iat7s1 Rinv25iat7s2 0 sky130_fd_pr__res_xhigh_po w=10 l=49.614372
XRinv25iap7s3 Rinv25iat7s2 Rinv25iat7s3 0 sky130_fd_pr__res_xhigh_po w=10 l=49.614372
XRinv25iap7s4 Rinv25iat7s3 Rinv25iat7s4 0 sky130_fd_pr__res_xhigh_po w=10 l=49.614372
XRinv25iap7s5 Rinv25iat7s4 Rinv25iat7s5 0 sky130_fd_pr__res_xhigh_po w=10 l=49.614372
XRinv25iap7s6 Rinv25iat7s5 Rinv25iat7s6 0 sky130_fd_pr__res_xhigh_po w=10 l=49.614372
XRinv25iap7s7 Rinv25iat7s6 inv25m 0 sky130_fd_pr__res_xhigh_po w=10 l=49.614372
* PDK sky130_fd_pr__res_xhigh_po Rinv25ib W=10 L=49.614382
* tile Rinv25ib 8s x 8p same W=10 L=49.614382
XRinv25ibp0s0 in25n Rinv25ibt0s0 0 sky130_fd_pr__res_xhigh_po w=10 l=49.614382
XRinv25ibp0s1 Rinv25ibt0s0 Rinv25ibt0s1 0 sky130_fd_pr__res_xhigh_po w=10 l=49.614382
XRinv25ibp0s2 Rinv25ibt0s1 Rinv25ibt0s2 0 sky130_fd_pr__res_xhigh_po w=10 l=49.614382
XRinv25ibp0s3 Rinv25ibt0s2 Rinv25ibt0s3 0 sky130_fd_pr__res_xhigh_po w=10 l=49.614382
XRinv25ibp0s4 Rinv25ibt0s3 Rinv25ibt0s4 0 sky130_fd_pr__res_xhigh_po w=10 l=49.614382
XRinv25ibp0s5 Rinv25ibt0s4 Rinv25ibt0s5 0 sky130_fd_pr__res_xhigh_po w=10 l=49.614382
XRinv25ibp0s6 Rinv25ibt0s5 Rinv25ibt0s6 0 sky130_fd_pr__res_xhigh_po w=10 l=49.614382
XRinv25ibp0s7 Rinv25ibt0s6 inv25m 0 sky130_fd_pr__res_xhigh_po w=10 l=49.614382
XRinv25ibp1s0 in25n Rinv25ibt1s0 0 sky130_fd_pr__res_xhigh_po w=10 l=49.614382
XRinv25ibp1s1 Rinv25ibt1s0 Rinv25ibt1s1 0 sky130_fd_pr__res_xhigh_po w=10 l=49.614382
XRinv25ibp1s2 Rinv25ibt1s1 Rinv25ibt1s2 0 sky130_fd_pr__res_xhigh_po w=10 l=49.614382
XRinv25ibp1s3 Rinv25ibt1s2 Rinv25ibt1s3 0 sky130_fd_pr__res_xhigh_po w=10 l=49.614382
XRinv25ibp1s4 Rinv25ibt1s3 Rinv25ibt1s4 0 sky130_fd_pr__res_xhigh_po w=10 l=49.614382
XRinv25ibp1s5 Rinv25ibt1s4 Rinv25ibt1s5 0 sky130_fd_pr__res_xhigh_po w=10 l=49.614382
XRinv25ibp1s6 Rinv25ibt1s5 Rinv25ibt1s6 0 sky130_fd_pr__res_xhigh_po w=10 l=49.614382
XRinv25ibp1s7 Rinv25ibt1s6 inv25m 0 sky130_fd_pr__res_xhigh_po w=10 l=49.614382
XRinv25ibp2s0 in25n Rinv25ibt2s0 0 sky130_fd_pr__res_xhigh_po w=10 l=49.614382
XRinv25ibp2s1 Rinv25ibt2s0 Rinv25ibt2s1 0 sky130_fd_pr__res_xhigh_po w=10 l=49.614382
XRinv25ibp2s2 Rinv25ibt2s1 Rinv25ibt2s2 0 sky130_fd_pr__res_xhigh_po w=10 l=49.614382
XRinv25ibp2s3 Rinv25ibt2s2 Rinv25ibt2s3 0 sky130_fd_pr__res_xhigh_po w=10 l=49.614382
XRinv25ibp2s4 Rinv25ibt2s3 Rinv25ibt2s4 0 sky130_fd_pr__res_xhigh_po w=10 l=49.614382
XRinv25ibp2s5 Rinv25ibt2s4 Rinv25ibt2s5 0 sky130_fd_pr__res_xhigh_po w=10 l=49.614382
XRinv25ibp2s6 Rinv25ibt2s5 Rinv25ibt2s6 0 sky130_fd_pr__res_xhigh_po w=10 l=49.614382
XRinv25ibp2s7 Rinv25ibt2s6 inv25m 0 sky130_fd_pr__res_xhigh_po w=10 l=49.614382
XRinv25ibp3s0 in25n Rinv25ibt3s0 0 sky130_fd_pr__res_xhigh_po w=10 l=49.614382
XRinv25ibp3s1 Rinv25ibt3s0 Rinv25ibt3s1 0 sky130_fd_pr__res_xhigh_po w=10 l=49.614382
XRinv25ibp3s2 Rinv25ibt3s1 Rinv25ibt3s2 0 sky130_fd_pr__res_xhigh_po w=10 l=49.614382
XRinv25ibp3s3 Rinv25ibt3s2 Rinv25ibt3s3 0 sky130_fd_pr__res_xhigh_po w=10 l=49.614382
XRinv25ibp3s4 Rinv25ibt3s3 Rinv25ibt3s4 0 sky130_fd_pr__res_xhigh_po w=10 l=49.614382
XRinv25ibp3s5 Rinv25ibt3s4 Rinv25ibt3s5 0 sky130_fd_pr__res_xhigh_po w=10 l=49.614382
XRinv25ibp3s6 Rinv25ibt3s5 Rinv25ibt3s6 0 sky130_fd_pr__res_xhigh_po w=10 l=49.614382
XRinv25ibp3s7 Rinv25ibt3s6 inv25m 0 sky130_fd_pr__res_xhigh_po w=10 l=49.614382
XRinv25ibp4s0 in25n Rinv25ibt4s0 0 sky130_fd_pr__res_xhigh_po w=10 l=49.614382
XRinv25ibp4s1 Rinv25ibt4s0 Rinv25ibt4s1 0 sky130_fd_pr__res_xhigh_po w=10 l=49.614382
XRinv25ibp4s2 Rinv25ibt4s1 Rinv25ibt4s2 0 sky130_fd_pr__res_xhigh_po w=10 l=49.614382
XRinv25ibp4s3 Rinv25ibt4s2 Rinv25ibt4s3 0 sky130_fd_pr__res_xhigh_po w=10 l=49.614382
XRinv25ibp4s4 Rinv25ibt4s3 Rinv25ibt4s4 0 sky130_fd_pr__res_xhigh_po w=10 l=49.614382
XRinv25ibp4s5 Rinv25ibt4s4 Rinv25ibt4s5 0 sky130_fd_pr__res_xhigh_po w=10 l=49.614382
XRinv25ibp4s6 Rinv25ibt4s5 Rinv25ibt4s6 0 sky130_fd_pr__res_xhigh_po w=10 l=49.614382
XRinv25ibp4s7 Rinv25ibt4s6 inv25m 0 sky130_fd_pr__res_xhigh_po w=10 l=49.614382
XRinv25ibp5s0 in25n Rinv25ibt5s0 0 sky130_fd_pr__res_xhigh_po w=10 l=49.614382
XRinv25ibp5s1 Rinv25ibt5s0 Rinv25ibt5s1 0 sky130_fd_pr__res_xhigh_po w=10 l=49.614382
XRinv25ibp5s2 Rinv25ibt5s1 Rinv25ibt5s2 0 sky130_fd_pr__res_xhigh_po w=10 l=49.614382
XRinv25ibp5s3 Rinv25ibt5s2 Rinv25ibt5s3 0 sky130_fd_pr__res_xhigh_po w=10 l=49.614382
XRinv25ibp5s4 Rinv25ibt5s3 Rinv25ibt5s4 0 sky130_fd_pr__res_xhigh_po w=10 l=49.614382
XRinv25ibp5s5 Rinv25ibt5s4 Rinv25ibt5s5 0 sky130_fd_pr__res_xhigh_po w=10 l=49.614382
XRinv25ibp5s6 Rinv25ibt5s5 Rinv25ibt5s6 0 sky130_fd_pr__res_xhigh_po w=10 l=49.614382
XRinv25ibp5s7 Rinv25ibt5s6 inv25m 0 sky130_fd_pr__res_xhigh_po w=10 l=49.614382
XRinv25ibp6s0 in25n Rinv25ibt6s0 0 sky130_fd_pr__res_xhigh_po w=10 l=49.614382
XRinv25ibp6s1 Rinv25ibt6s0 Rinv25ibt6s1 0 sky130_fd_pr__res_xhigh_po w=10 l=49.614382
XRinv25ibp6s2 Rinv25ibt6s1 Rinv25ibt6s2 0 sky130_fd_pr__res_xhigh_po w=10 l=49.614382
XRinv25ibp6s3 Rinv25ibt6s2 Rinv25ibt6s3 0 sky130_fd_pr__res_xhigh_po w=10 l=49.614382
XRinv25ibp6s4 Rinv25ibt6s3 Rinv25ibt6s4 0 sky130_fd_pr__res_xhigh_po w=10 l=49.614382
XRinv25ibp6s5 Rinv25ibt6s4 Rinv25ibt6s5 0 sky130_fd_pr__res_xhigh_po w=10 l=49.614382
XRinv25ibp6s6 Rinv25ibt6s5 Rinv25ibt6s6 0 sky130_fd_pr__res_xhigh_po w=10 l=49.614382
XRinv25ibp6s7 Rinv25ibt6s6 inv25m 0 sky130_fd_pr__res_xhigh_po w=10 l=49.614382
XRinv25ibp7s0 in25n Rinv25ibt7s0 0 sky130_fd_pr__res_xhigh_po w=10 l=49.614382
XRinv25ibp7s1 Rinv25ibt7s0 Rinv25ibt7s1 0 sky130_fd_pr__res_xhigh_po w=10 l=49.614382
XRinv25ibp7s2 Rinv25ibt7s1 Rinv25ibt7s2 0 sky130_fd_pr__res_xhigh_po w=10 l=49.614382
XRinv25ibp7s3 Rinv25ibt7s2 Rinv25ibt7s3 0 sky130_fd_pr__res_xhigh_po w=10 l=49.614382
XRinv25ibp7s4 Rinv25ibt7s3 Rinv25ibt7s4 0 sky130_fd_pr__res_xhigh_po w=10 l=49.614382
XRinv25ibp7s5 Rinv25ibt7s4 Rinv25ibt7s5 0 sky130_fd_pr__res_xhigh_po w=10 l=49.614382
XRinv25ibp7s6 Rinv25ibt7s5 Rinv25ibt7s6 0 sky130_fd_pr__res_xhigh_po w=10 l=49.614382
XRinv25ibp7s7 Rinv25ibt7s6 inv25m 0 sky130_fd_pr__res_xhigh_po w=10 l=49.614382
Einv25amp in25n 0 0 inv25m 10000000
Vin26 in26 0 DC 0
Vin27 in27 0 DC 1.88293545008737
* passive invert in27 -> in27n: R2/R1=1.0000002 closed-loop -1 at A=1e+07
* PDK sky130_fd_pr__res_xhigh_po Rinv27ia W=10 L=49.614372
* tile Rinv27ia 8s x 8p same W=10 L=49.614372
XRinv27iap0s0 in27 Rinv27iat0s0 0 sky130_fd_pr__res_xhigh_po w=10 l=49.614372
XRinv27iap0s1 Rinv27iat0s0 Rinv27iat0s1 0 sky130_fd_pr__res_xhigh_po w=10 l=49.614372
XRinv27iap0s2 Rinv27iat0s1 Rinv27iat0s2 0 sky130_fd_pr__res_xhigh_po w=10 l=49.614372
XRinv27iap0s3 Rinv27iat0s2 Rinv27iat0s3 0 sky130_fd_pr__res_xhigh_po w=10 l=49.614372
XRinv27iap0s4 Rinv27iat0s3 Rinv27iat0s4 0 sky130_fd_pr__res_xhigh_po w=10 l=49.614372
XRinv27iap0s5 Rinv27iat0s4 Rinv27iat0s5 0 sky130_fd_pr__res_xhigh_po w=10 l=49.614372
XRinv27iap0s6 Rinv27iat0s5 Rinv27iat0s6 0 sky130_fd_pr__res_xhigh_po w=10 l=49.614372
XRinv27iap0s7 Rinv27iat0s6 inv27m 0 sky130_fd_pr__res_xhigh_po w=10 l=49.614372
XRinv27iap1s0 in27 Rinv27iat1s0 0 sky130_fd_pr__res_xhigh_po w=10 l=49.614372
XRinv27iap1s1 Rinv27iat1s0 Rinv27iat1s1 0 sky130_fd_pr__res_xhigh_po w=10 l=49.614372
XRinv27iap1s2 Rinv27iat1s1 Rinv27iat1s2 0 sky130_fd_pr__res_xhigh_po w=10 l=49.614372
XRinv27iap1s3 Rinv27iat1s2 Rinv27iat1s3 0 sky130_fd_pr__res_xhigh_po w=10 l=49.614372
XRinv27iap1s4 Rinv27iat1s3 Rinv27iat1s4 0 sky130_fd_pr__res_xhigh_po w=10 l=49.614372
XRinv27iap1s5 Rinv27iat1s4 Rinv27iat1s5 0 sky130_fd_pr__res_xhigh_po w=10 l=49.614372
XRinv27iap1s6 Rinv27iat1s5 Rinv27iat1s6 0 sky130_fd_pr__res_xhigh_po w=10 l=49.614372
XRinv27iap1s7 Rinv27iat1s6 inv27m 0 sky130_fd_pr__res_xhigh_po w=10 l=49.614372
XRinv27iap2s0 in27 Rinv27iat2s0 0 sky130_fd_pr__res_xhigh_po w=10 l=49.614372
XRinv27iap2s1 Rinv27iat2s0 Rinv27iat2s1 0 sky130_fd_pr__res_xhigh_po w=10 l=49.614372
XRinv27iap2s2 Rinv27iat2s1 Rinv27iat2s2 0 sky130_fd_pr__res_xhigh_po w=10 l=49.614372
XRinv27iap2s3 Rinv27iat2s2 Rinv27iat2s3 0 sky130_fd_pr__res_xhigh_po w=10 l=49.614372
XRinv27iap2s4 Rinv27iat2s3 Rinv27iat2s4 0 sky130_fd_pr__res_xhigh_po w=10 l=49.614372
XRinv27iap2s5 Rinv27iat2s4 Rinv27iat2s5 0 sky130_fd_pr__res_xhigh_po w=10 l=49.614372
XRinv27iap2s6 Rinv27iat2s5 Rinv27iat2s6 0 sky130_fd_pr__res_xhigh_po w=10 l=49.614372
XRinv27iap2s7 Rinv27iat2s6 inv27m 0 sky130_fd_pr__res_xhigh_po w=10 l=49.614372
XRinv27iap3s0 in27 Rinv27iat3s0 0 sky130_fd_pr__res_xhigh_po w=10 l=49.614372
XRinv27iap3s1 Rinv27iat3s0 Rinv27iat3s1 0 sky130_fd_pr__res_xhigh_po w=10 l=49.614372
XRinv27iap3s2 Rinv27iat3s1 Rinv27iat3s2 0 sky130_fd_pr__res_xhigh_po w=10 l=49.614372
XRinv27iap3s3 Rinv27iat3s2 Rinv27iat3s3 0 sky130_fd_pr__res_xhigh_po w=10 l=49.614372
XRinv27iap3s4 Rinv27iat3s3 Rinv27iat3s4 0 sky130_fd_pr__res_xhigh_po w=10 l=49.614372
XRinv27iap3s5 Rinv27iat3s4 Rinv27iat3s5 0 sky130_fd_pr__res_xhigh_po w=10 l=49.614372
XRinv27iap3s6 Rinv27iat3s5 Rinv27iat3s6 0 sky130_fd_pr__res_xhigh_po w=10 l=49.614372
XRinv27iap3s7 Rinv27iat3s6 inv27m 0 sky130_fd_pr__res_xhigh_po w=10 l=49.614372
XRinv27iap4s0 in27 Rinv27iat4s0 0 sky130_fd_pr__res_xhigh_po w=10 l=49.614372
XRinv27iap4s1 Rinv27iat4s0 Rinv27iat4s1 0 sky130_fd_pr__res_xhigh_po w=10 l=49.614372
XRinv27iap4s2 Rinv27iat4s1 Rinv27iat4s2 0 sky130_fd_pr__res_xhigh_po w=10 l=49.614372
XRinv27iap4s3 Rinv27iat4s2 Rinv27iat4s3 0 sky130_fd_pr__res_xhigh_po w=10 l=49.614372
XRinv27iap4s4 Rinv27iat4s3 Rinv27iat4s4 0 sky130_fd_pr__res_xhigh_po w=10 l=49.614372
XRinv27iap4s5 Rinv27iat4s4 Rinv27iat4s5 0 sky130_fd_pr__res_xhigh_po w=10 l=49.614372
XRinv27iap4s6 Rinv27iat4s5 Rinv27iat4s6 0 sky130_fd_pr__res_xhigh_po w=10 l=49.614372
XRinv27iap4s7 Rinv27iat4s6 inv27m 0 sky130_fd_pr__res_xhigh_po w=10 l=49.614372
XRinv27iap5s0 in27 Rinv27iat5s0 0 sky130_fd_pr__res_xhigh_po w=10 l=49.614372
XRinv27iap5s1 Rinv27iat5s0 Rinv27iat5s1 0 sky130_fd_pr__res_xhigh_po w=10 l=49.614372
XRinv27iap5s2 Rinv27iat5s1 Rinv27iat5s2 0 sky130_fd_pr__res_xhigh_po w=10 l=49.614372
XRinv27iap5s3 Rinv27iat5s2 Rinv27iat5s3 0 sky130_fd_pr__res_xhigh_po w=10 l=49.614372
XRinv27iap5s4 Rinv27iat5s3 Rinv27iat5s4 0 sky130_fd_pr__res_xhigh_po w=10 l=49.614372
XRinv27iap5s5 Rinv27iat5s4 Rinv27iat5s5 0 sky130_fd_pr__res_xhigh_po w=10 l=49.614372
XRinv27iap5s6 Rinv27iat5s5 Rinv27iat5s6 0 sky130_fd_pr__res_xhigh_po w=10 l=49.614372
XRinv27iap5s7 Rinv27iat5s6 inv27m 0 sky130_fd_pr__res_xhigh_po w=10 l=49.614372
XRinv27iap6s0 in27 Rinv27iat6s0 0 sky130_fd_pr__res_xhigh_po w=10 l=49.614372
XRinv27iap6s1 Rinv27iat6s0 Rinv27iat6s1 0 sky130_fd_pr__res_xhigh_po w=10 l=49.614372
XRinv27iap6s2 Rinv27iat6s1 Rinv27iat6s2 0 sky130_fd_pr__res_xhigh_po w=10 l=49.614372
XRinv27iap6s3 Rinv27iat6s2 Rinv27iat6s3 0 sky130_fd_pr__res_xhigh_po w=10 l=49.614372
XRinv27iap6s4 Rinv27iat6s3 Rinv27iat6s4 0 sky130_fd_pr__res_xhigh_po w=10 l=49.614372
XRinv27iap6s5 Rinv27iat6s4 Rinv27iat6s5 0 sky130_fd_pr__res_xhigh_po w=10 l=49.614372
XRinv27iap6s6 Rinv27iat6s5 Rinv27iat6s6 0 sky130_fd_pr__res_xhigh_po w=10 l=49.614372
XRinv27iap6s7 Rinv27iat6s6 inv27m 0 sky130_fd_pr__res_xhigh_po w=10 l=49.614372
XRinv27iap7s0 in27 Rinv27iat7s0 0 sky130_fd_pr__res_xhigh_po w=10 l=49.614372
XRinv27iap7s1 Rinv27iat7s0 Rinv27iat7s1 0 sky130_fd_pr__res_xhigh_po w=10 l=49.614372
XRinv27iap7s2 Rinv27iat7s1 Rinv27iat7s2 0 sky130_fd_pr__res_xhigh_po w=10 l=49.614372
XRinv27iap7s3 Rinv27iat7s2 Rinv27iat7s3 0 sky130_fd_pr__res_xhigh_po w=10 l=49.614372
XRinv27iap7s4 Rinv27iat7s3 Rinv27iat7s4 0 sky130_fd_pr__res_xhigh_po w=10 l=49.614372
XRinv27iap7s5 Rinv27iat7s4 Rinv27iat7s5 0 sky130_fd_pr__res_xhigh_po w=10 l=49.614372
XRinv27iap7s6 Rinv27iat7s5 Rinv27iat7s6 0 sky130_fd_pr__res_xhigh_po w=10 l=49.614372
XRinv27iap7s7 Rinv27iat7s6 inv27m 0 sky130_fd_pr__res_xhigh_po w=10 l=49.614372
* PDK sky130_fd_pr__res_xhigh_po Rinv27ib W=10 L=49.614382
* tile Rinv27ib 8s x 8p same W=10 L=49.614382
XRinv27ibp0s0 in27n Rinv27ibt0s0 0 sky130_fd_pr__res_xhigh_po w=10 l=49.614382
XRinv27ibp0s1 Rinv27ibt0s0 Rinv27ibt0s1 0 sky130_fd_pr__res_xhigh_po w=10 l=49.614382
XRinv27ibp0s2 Rinv27ibt0s1 Rinv27ibt0s2 0 sky130_fd_pr__res_xhigh_po w=10 l=49.614382
XRinv27ibp0s3 Rinv27ibt0s2 Rinv27ibt0s3 0 sky130_fd_pr__res_xhigh_po w=10 l=49.614382
XRinv27ibp0s4 Rinv27ibt0s3 Rinv27ibt0s4 0 sky130_fd_pr__res_xhigh_po w=10 l=49.614382
XRinv27ibp0s5 Rinv27ibt0s4 Rinv27ibt0s5 0 sky130_fd_pr__res_xhigh_po w=10 l=49.614382
XRinv27ibp0s6 Rinv27ibt0s5 Rinv27ibt0s6 0 sky130_fd_pr__res_xhigh_po w=10 l=49.614382
XRinv27ibp0s7 Rinv27ibt0s6 inv27m 0 sky130_fd_pr__res_xhigh_po w=10 l=49.614382
XRinv27ibp1s0 in27n Rinv27ibt1s0 0 sky130_fd_pr__res_xhigh_po w=10 l=49.614382
XRinv27ibp1s1 Rinv27ibt1s0 Rinv27ibt1s1 0 sky130_fd_pr__res_xhigh_po w=10 l=49.614382
XRinv27ibp1s2 Rinv27ibt1s1 Rinv27ibt1s2 0 sky130_fd_pr__res_xhigh_po w=10 l=49.614382
XRinv27ibp1s3 Rinv27ibt1s2 Rinv27ibt1s3 0 sky130_fd_pr__res_xhigh_po w=10 l=49.614382
XRinv27ibp1s4 Rinv27ibt1s3 Rinv27ibt1s4 0 sky130_fd_pr__res_xhigh_po w=10 l=49.614382
XRinv27ibp1s5 Rinv27ibt1s4 Rinv27ibt1s5 0 sky130_fd_pr__res_xhigh_po w=10 l=49.614382
XRinv27ibp1s6 Rinv27ibt1s5 Rinv27ibt1s6 0 sky130_fd_pr__res_xhigh_po w=10 l=49.614382
XRinv27ibp1s7 Rinv27ibt1s6 inv27m 0 sky130_fd_pr__res_xhigh_po w=10 l=49.614382
XRinv27ibp2s0 in27n Rinv27ibt2s0 0 sky130_fd_pr__res_xhigh_po w=10 l=49.614382
XRinv27ibp2s1 Rinv27ibt2s0 Rinv27ibt2s1 0 sky130_fd_pr__res_xhigh_po w=10 l=49.614382
XRinv27ibp2s2 Rinv27ibt2s1 Rinv27ibt2s2 0 sky130_fd_pr__res_xhigh_po w=10 l=49.614382
XRinv27ibp2s3 Rinv27ibt2s2 Rinv27ibt2s3 0 sky130_fd_pr__res_xhigh_po w=10 l=49.614382
XRinv27ibp2s4 Rinv27ibt2s3 Rinv27ibt2s4 0 sky130_fd_pr__res_xhigh_po w=10 l=49.614382
XRinv27ibp2s5 Rinv27ibt2s4 Rinv27ibt2s5 0 sky130_fd_pr__res_xhigh_po w=10 l=49.614382
XRinv27ibp2s6 Rinv27ibt2s5 Rinv27ibt2s6 0 sky130_fd_pr__res_xhigh_po w=10 l=49.614382
XRinv27ibp2s7 Rinv27ibt2s6 inv27m 0 sky130_fd_pr__res_xhigh_po w=10 l=49.614382
XRinv27ibp3s0 in27n Rinv27ibt3s0 0 sky130_fd_pr__res_xhigh_po w=10 l=49.614382
XRinv27ibp3s1 Rinv27ibt3s0 Rinv27ibt3s1 0 sky130_fd_pr__res_xhigh_po w=10 l=49.614382
XRinv27ibp3s2 Rinv27ibt3s1 Rinv27ibt3s2 0 sky130_fd_pr__res_xhigh_po w=10 l=49.614382
XRinv27ibp3s3 Rinv27ibt3s2 Rinv27ibt3s3 0 sky130_fd_pr__res_xhigh_po w=10 l=49.614382
XRinv27ibp3s4 Rinv27ibt3s3 Rinv27ibt3s4 0 sky130_fd_pr__res_xhigh_po w=10 l=49.614382
XRinv27ibp3s5 Rinv27ibt3s4 Rinv27ibt3s5 0 sky130_fd_pr__res_xhigh_po w=10 l=49.614382
XRinv27ibp3s6 Rinv27ibt3s5 Rinv27ibt3s6 0 sky130_fd_pr__res_xhigh_po w=10 l=49.614382
XRinv27ibp3s7 Rinv27ibt3s6 inv27m 0 sky130_fd_pr__res_xhigh_po w=10 l=49.614382
XRinv27ibp4s0 in27n Rinv27ibt4s0 0 sky130_fd_pr__res_xhigh_po w=10 l=49.614382
XRinv27ibp4s1 Rinv27ibt4s0 Rinv27ibt4s1 0 sky130_fd_pr__res_xhigh_po w=10 l=49.614382
XRinv27ibp4s2 Rinv27ibt4s1 Rinv27ibt4s2 0 sky130_fd_pr__res_xhigh_po w=10 l=49.614382
XRinv27ibp4s3 Rinv27ibt4s2 Rinv27ibt4s3 0 sky130_fd_pr__res_xhigh_po w=10 l=49.614382
XRinv27ibp4s4 Rinv27ibt4s3 Rinv27ibt4s4 0 sky130_fd_pr__res_xhigh_po w=10 l=49.614382
XRinv27ibp4s5 Rinv27ibt4s4 Rinv27ibt4s5 0 sky130_fd_pr__res_xhigh_po w=10 l=49.614382
XRinv27ibp4s6 Rinv27ibt4s5 Rinv27ibt4s6 0 sky130_fd_pr__res_xhigh_po w=10 l=49.614382
XRinv27ibp4s7 Rinv27ibt4s6 inv27m 0 sky130_fd_pr__res_xhigh_po w=10 l=49.614382
XRinv27ibp5s0 in27n Rinv27ibt5s0 0 sky130_fd_pr__res_xhigh_po w=10 l=49.614382
XRinv27ibp5s1 Rinv27ibt5s0 Rinv27ibt5s1 0 sky130_fd_pr__res_xhigh_po w=10 l=49.614382
XRinv27ibp5s2 Rinv27ibt5s1 Rinv27ibt5s2 0 sky130_fd_pr__res_xhigh_po w=10 l=49.614382
XRinv27ibp5s3 Rinv27ibt5s2 Rinv27ibt5s3 0 sky130_fd_pr__res_xhigh_po w=10 l=49.614382
XRinv27ibp5s4 Rinv27ibt5s3 Rinv27ibt5s4 0 sky130_fd_pr__res_xhigh_po w=10 l=49.614382
XRinv27ibp5s5 Rinv27ibt5s4 Rinv27ibt5s5 0 sky130_fd_pr__res_xhigh_po w=10 l=49.614382
XRinv27ibp5s6 Rinv27ibt5s5 Rinv27ibt5s6 0 sky130_fd_pr__res_xhigh_po w=10 l=49.614382
XRinv27ibp5s7 Rinv27ibt5s6 inv27m 0 sky130_fd_pr__res_xhigh_po w=10 l=49.614382
XRinv27ibp6s0 in27n Rinv27ibt6s0 0 sky130_fd_pr__res_xhigh_po w=10 l=49.614382
XRinv27ibp6s1 Rinv27ibt6s0 Rinv27ibt6s1 0 sky130_fd_pr__res_xhigh_po w=10 l=49.614382
XRinv27ibp6s2 Rinv27ibt6s1 Rinv27ibt6s2 0 sky130_fd_pr__res_xhigh_po w=10 l=49.614382
XRinv27ibp6s3 Rinv27ibt6s2 Rinv27ibt6s3 0 sky130_fd_pr__res_xhigh_po w=10 l=49.614382
XRinv27ibp6s4 Rinv27ibt6s3 Rinv27ibt6s4 0 sky130_fd_pr__res_xhigh_po w=10 l=49.614382
XRinv27ibp6s5 Rinv27ibt6s4 Rinv27ibt6s5 0 sky130_fd_pr__res_xhigh_po w=10 l=49.614382
XRinv27ibp6s6 Rinv27ibt6s5 Rinv27ibt6s6 0 sky130_fd_pr__res_xhigh_po w=10 l=49.614382
XRinv27ibp6s7 Rinv27ibt6s6 inv27m 0 sky130_fd_pr__res_xhigh_po w=10 l=49.614382
XRinv27ibp7s0 in27n Rinv27ibt7s0 0 sky130_fd_pr__res_xhigh_po w=10 l=49.614382
XRinv27ibp7s1 Rinv27ibt7s0 Rinv27ibt7s1 0 sky130_fd_pr__res_xhigh_po w=10 l=49.614382
XRinv27ibp7s2 Rinv27ibt7s1 Rinv27ibt7s2 0 sky130_fd_pr__res_xhigh_po w=10 l=49.614382
XRinv27ibp7s3 Rinv27ibt7s2 Rinv27ibt7s3 0 sky130_fd_pr__res_xhigh_po w=10 l=49.614382
XRinv27ibp7s4 Rinv27ibt7s3 Rinv27ibt7s4 0 sky130_fd_pr__res_xhigh_po w=10 l=49.614382
XRinv27ibp7s5 Rinv27ibt7s4 Rinv27ibt7s5 0 sky130_fd_pr__res_xhigh_po w=10 l=49.614382
XRinv27ibp7s6 Rinv27ibt7s5 Rinv27ibt7s6 0 sky130_fd_pr__res_xhigh_po w=10 l=49.614382
XRinv27ibp7s7 Rinv27ibt7s6 inv27m 0 sky130_fd_pr__res_xhigh_po w=10 l=49.614382
Einv27amp in27n 0 0 inv27m 10000000
Vin28 in28 0 DC 1.38172289531745
* passive invert in28 -> in28n: R2/R1=1.0000002 closed-loop -1 at A=1e+07
* PDK sky130_fd_pr__res_xhigh_po Rinv28ia W=10 L=49.614372
* tile Rinv28ia 8s x 8p same W=10 L=49.614372
XRinv28iap0s0 in28 Rinv28iat0s0 0 sky130_fd_pr__res_xhigh_po w=10 l=49.614372
XRinv28iap0s1 Rinv28iat0s0 Rinv28iat0s1 0 sky130_fd_pr__res_xhigh_po w=10 l=49.614372
XRinv28iap0s2 Rinv28iat0s1 Rinv28iat0s2 0 sky130_fd_pr__res_xhigh_po w=10 l=49.614372
XRinv28iap0s3 Rinv28iat0s2 Rinv28iat0s3 0 sky130_fd_pr__res_xhigh_po w=10 l=49.614372
XRinv28iap0s4 Rinv28iat0s3 Rinv28iat0s4 0 sky130_fd_pr__res_xhigh_po w=10 l=49.614372
XRinv28iap0s5 Rinv28iat0s4 Rinv28iat0s5 0 sky130_fd_pr__res_xhigh_po w=10 l=49.614372
XRinv28iap0s6 Rinv28iat0s5 Rinv28iat0s6 0 sky130_fd_pr__res_xhigh_po w=10 l=49.614372
XRinv28iap0s7 Rinv28iat0s6 inv28m 0 sky130_fd_pr__res_xhigh_po w=10 l=49.614372
XRinv28iap1s0 in28 Rinv28iat1s0 0 sky130_fd_pr__res_xhigh_po w=10 l=49.614372
XRinv28iap1s1 Rinv28iat1s0 Rinv28iat1s1 0 sky130_fd_pr__res_xhigh_po w=10 l=49.614372
XRinv28iap1s2 Rinv28iat1s1 Rinv28iat1s2 0 sky130_fd_pr__res_xhigh_po w=10 l=49.614372
XRinv28iap1s3 Rinv28iat1s2 Rinv28iat1s3 0 sky130_fd_pr__res_xhigh_po w=10 l=49.614372
XRinv28iap1s4 Rinv28iat1s3 Rinv28iat1s4 0 sky130_fd_pr__res_xhigh_po w=10 l=49.614372
XRinv28iap1s5 Rinv28iat1s4 Rinv28iat1s5 0 sky130_fd_pr__res_xhigh_po w=10 l=49.614372
XRinv28iap1s6 Rinv28iat1s5 Rinv28iat1s6 0 sky130_fd_pr__res_xhigh_po w=10 l=49.614372
XRinv28iap1s7 Rinv28iat1s6 inv28m 0 sky130_fd_pr__res_xhigh_po w=10 l=49.614372
XRinv28iap2s0 in28 Rinv28iat2s0 0 sky130_fd_pr__res_xhigh_po w=10 l=49.614372
XRinv28iap2s1 Rinv28iat2s0 Rinv28iat2s1 0 sky130_fd_pr__res_xhigh_po w=10 l=49.614372
XRinv28iap2s2 Rinv28iat2s1 Rinv28iat2s2 0 sky130_fd_pr__res_xhigh_po w=10 l=49.614372
XRinv28iap2s3 Rinv28iat2s2 Rinv28iat2s3 0 sky130_fd_pr__res_xhigh_po w=10 l=49.614372
XRinv28iap2s4 Rinv28iat2s3 Rinv28iat2s4 0 sky130_fd_pr__res_xhigh_po w=10 l=49.614372
XRinv28iap2s5 Rinv28iat2s4 Rinv28iat2s5 0 sky130_fd_pr__res_xhigh_po w=10 l=49.614372
XRinv28iap2s6 Rinv28iat2s5 Rinv28iat2s6 0 sky130_fd_pr__res_xhigh_po w=10 l=49.614372
XRinv28iap2s7 Rinv28iat2s6 inv28m 0 sky130_fd_pr__res_xhigh_po w=10 l=49.614372
XRinv28iap3s0 in28 Rinv28iat3s0 0 sky130_fd_pr__res_xhigh_po w=10 l=49.614372
XRinv28iap3s1 Rinv28iat3s0 Rinv28iat3s1 0 sky130_fd_pr__res_xhigh_po w=10 l=49.614372
XRinv28iap3s2 Rinv28iat3s1 Rinv28iat3s2 0 sky130_fd_pr__res_xhigh_po w=10 l=49.614372
XRinv28iap3s3 Rinv28iat3s2 Rinv28iat3s3 0 sky130_fd_pr__res_xhigh_po w=10 l=49.614372
XRinv28iap3s4 Rinv28iat3s3 Rinv28iat3s4 0 sky130_fd_pr__res_xhigh_po w=10 l=49.614372
XRinv28iap3s5 Rinv28iat3s4 Rinv28iat3s5 0 sky130_fd_pr__res_xhigh_po w=10 l=49.614372
XRinv28iap3s6 Rinv28iat3s5 Rinv28iat3s6 0 sky130_fd_pr__res_xhigh_po w=10 l=49.614372
XRinv28iap3s7 Rinv28iat3s6 inv28m 0 sky130_fd_pr__res_xhigh_po w=10 l=49.614372
XRinv28iap4s0 in28 Rinv28iat4s0 0 sky130_fd_pr__res_xhigh_po w=10 l=49.614372
XRinv28iap4s1 Rinv28iat4s0 Rinv28iat4s1 0 sky130_fd_pr__res_xhigh_po w=10 l=49.614372
XRinv28iap4s2 Rinv28iat4s1 Rinv28iat4s2 0 sky130_fd_pr__res_xhigh_po w=10 l=49.614372
XRinv28iap4s3 Rinv28iat4s2 Rinv28iat4s3 0 sky130_fd_pr__res_xhigh_po w=10 l=49.614372
XRinv28iap4s4 Rinv28iat4s3 Rinv28iat4s4 0 sky130_fd_pr__res_xhigh_po w=10 l=49.614372
XRinv28iap4s5 Rinv28iat4s4 Rinv28iat4s5 0 sky130_fd_pr__res_xhigh_po w=10 l=49.614372
XRinv28iap4s6 Rinv28iat4s5 Rinv28iat4s6 0 sky130_fd_pr__res_xhigh_po w=10 l=49.614372
XRinv28iap4s7 Rinv28iat4s6 inv28m 0 sky130_fd_pr__res_xhigh_po w=10 l=49.614372
XRinv28iap5s0 in28 Rinv28iat5s0 0 sky130_fd_pr__res_xhigh_po w=10 l=49.614372
XRinv28iap5s1 Rinv28iat5s0 Rinv28iat5s1 0 sky130_fd_pr__res_xhigh_po w=10 l=49.614372
XRinv28iap5s2 Rinv28iat5s1 Rinv28iat5s2 0 sky130_fd_pr__res_xhigh_po w=10 l=49.614372
XRinv28iap5s3 Rinv28iat5s2 Rinv28iat5s3 0 sky130_fd_pr__res_xhigh_po w=10 l=49.614372
XRinv28iap5s4 Rinv28iat5s3 Rinv28iat5s4 0 sky130_fd_pr__res_xhigh_po w=10 l=49.614372
XRinv28iap5s5 Rinv28iat5s4 Rinv28iat5s5 0 sky130_fd_pr__res_xhigh_po w=10 l=49.614372
XRinv28iap5s6 Rinv28iat5s5 Rinv28iat5s6 0 sky130_fd_pr__res_xhigh_po w=10 l=49.614372
XRinv28iap5s7 Rinv28iat5s6 inv28m 0 sky130_fd_pr__res_xhigh_po w=10 l=49.614372
XRinv28iap6s0 in28 Rinv28iat6s0 0 sky130_fd_pr__res_xhigh_po w=10 l=49.614372
XRinv28iap6s1 Rinv28iat6s0 Rinv28iat6s1 0 sky130_fd_pr__res_xhigh_po w=10 l=49.614372
XRinv28iap6s2 Rinv28iat6s1 Rinv28iat6s2 0 sky130_fd_pr__res_xhigh_po w=10 l=49.614372
XRinv28iap6s3 Rinv28iat6s2 Rinv28iat6s3 0 sky130_fd_pr__res_xhigh_po w=10 l=49.614372
XRinv28iap6s4 Rinv28iat6s3 Rinv28iat6s4 0 sky130_fd_pr__res_xhigh_po w=10 l=49.614372
XRinv28iap6s5 Rinv28iat6s4 Rinv28iat6s5 0 sky130_fd_pr__res_xhigh_po w=10 l=49.614372
XRinv28iap6s6 Rinv28iat6s5 Rinv28iat6s6 0 sky130_fd_pr__res_xhigh_po w=10 l=49.614372
XRinv28iap6s7 Rinv28iat6s6 inv28m 0 sky130_fd_pr__res_xhigh_po w=10 l=49.614372
XRinv28iap7s0 in28 Rinv28iat7s0 0 sky130_fd_pr__res_xhigh_po w=10 l=49.614372
XRinv28iap7s1 Rinv28iat7s0 Rinv28iat7s1 0 sky130_fd_pr__res_xhigh_po w=10 l=49.614372
XRinv28iap7s2 Rinv28iat7s1 Rinv28iat7s2 0 sky130_fd_pr__res_xhigh_po w=10 l=49.614372
XRinv28iap7s3 Rinv28iat7s2 Rinv28iat7s3 0 sky130_fd_pr__res_xhigh_po w=10 l=49.614372
XRinv28iap7s4 Rinv28iat7s3 Rinv28iat7s4 0 sky130_fd_pr__res_xhigh_po w=10 l=49.614372
XRinv28iap7s5 Rinv28iat7s4 Rinv28iat7s5 0 sky130_fd_pr__res_xhigh_po w=10 l=49.614372
XRinv28iap7s6 Rinv28iat7s5 Rinv28iat7s6 0 sky130_fd_pr__res_xhigh_po w=10 l=49.614372
XRinv28iap7s7 Rinv28iat7s6 inv28m 0 sky130_fd_pr__res_xhigh_po w=10 l=49.614372
* PDK sky130_fd_pr__res_xhigh_po Rinv28ib W=10 L=49.614382
* tile Rinv28ib 8s x 8p same W=10 L=49.614382
XRinv28ibp0s0 in28n Rinv28ibt0s0 0 sky130_fd_pr__res_xhigh_po w=10 l=49.614382
XRinv28ibp0s1 Rinv28ibt0s0 Rinv28ibt0s1 0 sky130_fd_pr__res_xhigh_po w=10 l=49.614382
XRinv28ibp0s2 Rinv28ibt0s1 Rinv28ibt0s2 0 sky130_fd_pr__res_xhigh_po w=10 l=49.614382
XRinv28ibp0s3 Rinv28ibt0s2 Rinv28ibt0s3 0 sky130_fd_pr__res_xhigh_po w=10 l=49.614382
XRinv28ibp0s4 Rinv28ibt0s3 Rinv28ibt0s4 0 sky130_fd_pr__res_xhigh_po w=10 l=49.614382
XRinv28ibp0s5 Rinv28ibt0s4 Rinv28ibt0s5 0 sky130_fd_pr__res_xhigh_po w=10 l=49.614382
XRinv28ibp0s6 Rinv28ibt0s5 Rinv28ibt0s6 0 sky130_fd_pr__res_xhigh_po w=10 l=49.614382
XRinv28ibp0s7 Rinv28ibt0s6 inv28m 0 sky130_fd_pr__res_xhigh_po w=10 l=49.614382
XRinv28ibp1s0 in28n Rinv28ibt1s0 0 sky130_fd_pr__res_xhigh_po w=10 l=49.614382
XRinv28ibp1s1 Rinv28ibt1s0 Rinv28ibt1s1 0 sky130_fd_pr__res_xhigh_po w=10 l=49.614382
XRinv28ibp1s2 Rinv28ibt1s1 Rinv28ibt1s2 0 sky130_fd_pr__res_xhigh_po w=10 l=49.614382
XRinv28ibp1s3 Rinv28ibt1s2 Rinv28ibt1s3 0 sky130_fd_pr__res_xhigh_po w=10 l=49.614382
XRinv28ibp1s4 Rinv28ibt1s3 Rinv28ibt1s4 0 sky130_fd_pr__res_xhigh_po w=10 l=49.614382
XRinv28ibp1s5 Rinv28ibt1s4 Rinv28ibt1s5 0 sky130_fd_pr__res_xhigh_po w=10 l=49.614382
XRinv28ibp1s6 Rinv28ibt1s5 Rinv28ibt1s6 0 sky130_fd_pr__res_xhigh_po w=10 l=49.614382
XRinv28ibp1s7 Rinv28ibt1s6 inv28m 0 sky130_fd_pr__res_xhigh_po w=10 l=49.614382
XRinv28ibp2s0 in28n Rinv28ibt2s0 0 sky130_fd_pr__res_xhigh_po w=10 l=49.614382
XRinv28ibp2s1 Rinv28ibt2s0 Rinv28ibt2s1 0 sky130_fd_pr__res_xhigh_po w=10 l=49.614382
XRinv28ibp2s2 Rinv28ibt2s1 Rinv28ibt2s2 0 sky130_fd_pr__res_xhigh_po w=10 l=49.614382
XRinv28ibp2s3 Rinv28ibt2s2 Rinv28ibt2s3 0 sky130_fd_pr__res_xhigh_po w=10 l=49.614382
XRinv28ibp2s4 Rinv28ibt2s3 Rinv28ibt2s4 0 sky130_fd_pr__res_xhigh_po w=10 l=49.614382
XRinv28ibp2s5 Rinv28ibt2s4 Rinv28ibt2s5 0 sky130_fd_pr__res_xhigh_po w=10 l=49.614382
XRinv28ibp2s6 Rinv28ibt2s5 Rinv28ibt2s6 0 sky130_fd_pr__res_xhigh_po w=10 l=49.614382
XRinv28ibp2s7 Rinv28ibt2s6 inv28m 0 sky130_fd_pr__res_xhigh_po w=10 l=49.614382
XRinv28ibp3s0 in28n Rinv28ibt3s0 0 sky130_fd_pr__res_xhigh_po w=10 l=49.614382
XRinv28ibp3s1 Rinv28ibt3s0 Rinv28ibt3s1 0 sky130_fd_pr__res_xhigh_po w=10 l=49.614382
XRinv28ibp3s2 Rinv28ibt3s1 Rinv28ibt3s2 0 sky130_fd_pr__res_xhigh_po w=10 l=49.614382
XRinv28ibp3s3 Rinv28ibt3s2 Rinv28ibt3s3 0 sky130_fd_pr__res_xhigh_po w=10 l=49.614382
XRinv28ibp3s4 Rinv28ibt3s3 Rinv28ibt3s4 0 sky130_fd_pr__res_xhigh_po w=10 l=49.614382
XRinv28ibp3s5 Rinv28ibt3s4 Rinv28ibt3s5 0 sky130_fd_pr__res_xhigh_po w=10 l=49.614382
XRinv28ibp3s6 Rinv28ibt3s5 Rinv28ibt3s6 0 sky130_fd_pr__res_xhigh_po w=10 l=49.614382
XRinv28ibp3s7 Rinv28ibt3s6 inv28m 0 sky130_fd_pr__res_xhigh_po w=10 l=49.614382
XRinv28ibp4s0 in28n Rinv28ibt4s0 0 sky130_fd_pr__res_xhigh_po w=10 l=49.614382
XRinv28ibp4s1 Rinv28ibt4s0 Rinv28ibt4s1 0 sky130_fd_pr__res_xhigh_po w=10 l=49.614382
XRinv28ibp4s2 Rinv28ibt4s1 Rinv28ibt4s2 0 sky130_fd_pr__res_xhigh_po w=10 l=49.614382
XRinv28ibp4s3 Rinv28ibt4s2 Rinv28ibt4s3 0 sky130_fd_pr__res_xhigh_po w=10 l=49.614382
XRinv28ibp4s4 Rinv28ibt4s3 Rinv28ibt4s4 0 sky130_fd_pr__res_xhigh_po w=10 l=49.614382
XRinv28ibp4s5 Rinv28ibt4s4 Rinv28ibt4s5 0 sky130_fd_pr__res_xhigh_po w=10 l=49.614382
XRinv28ibp4s6 Rinv28ibt4s5 Rinv28ibt4s6 0 sky130_fd_pr__res_xhigh_po w=10 l=49.614382
XRinv28ibp4s7 Rinv28ibt4s6 inv28m 0 sky130_fd_pr__res_xhigh_po w=10 l=49.614382
XRinv28ibp5s0 in28n Rinv28ibt5s0 0 sky130_fd_pr__res_xhigh_po w=10 l=49.614382
XRinv28ibp5s1 Rinv28ibt5s0 Rinv28ibt5s1 0 sky130_fd_pr__res_xhigh_po w=10 l=49.614382
XRinv28ibp5s2 Rinv28ibt5s1 Rinv28ibt5s2 0 sky130_fd_pr__res_xhigh_po w=10 l=49.614382
XRinv28ibp5s3 Rinv28ibt5s2 Rinv28ibt5s3 0 sky130_fd_pr__res_xhigh_po w=10 l=49.614382
XRinv28ibp5s4 Rinv28ibt5s3 Rinv28ibt5s4 0 sky130_fd_pr__res_xhigh_po w=10 l=49.614382
XRinv28ibp5s5 Rinv28ibt5s4 Rinv28ibt5s5 0 sky130_fd_pr__res_xhigh_po w=10 l=49.614382
XRinv28ibp5s6 Rinv28ibt5s5 Rinv28ibt5s6 0 sky130_fd_pr__res_xhigh_po w=10 l=49.614382
XRinv28ibp5s7 Rinv28ibt5s6 inv28m 0 sky130_fd_pr__res_xhigh_po w=10 l=49.614382
XRinv28ibp6s0 in28n Rinv28ibt6s0 0 sky130_fd_pr__res_xhigh_po w=10 l=49.614382
XRinv28ibp6s1 Rinv28ibt6s0 Rinv28ibt6s1 0 sky130_fd_pr__res_xhigh_po w=10 l=49.614382
XRinv28ibp6s2 Rinv28ibt6s1 Rinv28ibt6s2 0 sky130_fd_pr__res_xhigh_po w=10 l=49.614382
XRinv28ibp6s3 Rinv28ibt6s2 Rinv28ibt6s3 0 sky130_fd_pr__res_xhigh_po w=10 l=49.614382
XRinv28ibp6s4 Rinv28ibt6s3 Rinv28ibt6s4 0 sky130_fd_pr__res_xhigh_po w=10 l=49.614382
XRinv28ibp6s5 Rinv28ibt6s4 Rinv28ibt6s5 0 sky130_fd_pr__res_xhigh_po w=10 l=49.614382
XRinv28ibp6s6 Rinv28ibt6s5 Rinv28ibt6s6 0 sky130_fd_pr__res_xhigh_po w=10 l=49.614382
XRinv28ibp6s7 Rinv28ibt6s6 inv28m 0 sky130_fd_pr__res_xhigh_po w=10 l=49.614382
XRinv28ibp7s0 in28n Rinv28ibt7s0 0 sky130_fd_pr__res_xhigh_po w=10 l=49.614382
XRinv28ibp7s1 Rinv28ibt7s0 Rinv28ibt7s1 0 sky130_fd_pr__res_xhigh_po w=10 l=49.614382
XRinv28ibp7s2 Rinv28ibt7s1 Rinv28ibt7s2 0 sky130_fd_pr__res_xhigh_po w=10 l=49.614382
XRinv28ibp7s3 Rinv28ibt7s2 Rinv28ibt7s3 0 sky130_fd_pr__res_xhigh_po w=10 l=49.614382
XRinv28ibp7s4 Rinv28ibt7s3 Rinv28ibt7s4 0 sky130_fd_pr__res_xhigh_po w=10 l=49.614382
XRinv28ibp7s5 Rinv28ibt7s4 Rinv28ibt7s5 0 sky130_fd_pr__res_xhigh_po w=10 l=49.614382
XRinv28ibp7s6 Rinv28ibt7s5 Rinv28ibt7s6 0 sky130_fd_pr__res_xhigh_po w=10 l=49.614382
XRinv28ibp7s7 Rinv28ibt7s6 inv28m 0 sky130_fd_pr__res_xhigh_po w=10 l=49.614382
Einv28amp in28n 0 0 inv28m 10000000
Vin29 in29 0 DC 0
* passive invert in29 -> in29n: R2/R1=1.0000002 closed-loop -1 at A=1e+07
* PDK sky130_fd_pr__res_xhigh_po Rinv29ia W=10 L=49.614372
* tile Rinv29ia 8s x 8p same W=10 L=49.614372
XRinv29iap0s0 in29 Rinv29iat0s0 0 sky130_fd_pr__res_xhigh_po w=10 l=49.614372
XRinv29iap0s1 Rinv29iat0s0 Rinv29iat0s1 0 sky130_fd_pr__res_xhigh_po w=10 l=49.614372
XRinv29iap0s2 Rinv29iat0s1 Rinv29iat0s2 0 sky130_fd_pr__res_xhigh_po w=10 l=49.614372
XRinv29iap0s3 Rinv29iat0s2 Rinv29iat0s3 0 sky130_fd_pr__res_xhigh_po w=10 l=49.614372
XRinv29iap0s4 Rinv29iat0s3 Rinv29iat0s4 0 sky130_fd_pr__res_xhigh_po w=10 l=49.614372
XRinv29iap0s5 Rinv29iat0s4 Rinv29iat0s5 0 sky130_fd_pr__res_xhigh_po w=10 l=49.614372
XRinv29iap0s6 Rinv29iat0s5 Rinv29iat0s6 0 sky130_fd_pr__res_xhigh_po w=10 l=49.614372
XRinv29iap0s7 Rinv29iat0s6 inv29m 0 sky130_fd_pr__res_xhigh_po w=10 l=49.614372
XRinv29iap1s0 in29 Rinv29iat1s0 0 sky130_fd_pr__res_xhigh_po w=10 l=49.614372
XRinv29iap1s1 Rinv29iat1s0 Rinv29iat1s1 0 sky130_fd_pr__res_xhigh_po w=10 l=49.614372
XRinv29iap1s2 Rinv29iat1s1 Rinv29iat1s2 0 sky130_fd_pr__res_xhigh_po w=10 l=49.614372
XRinv29iap1s3 Rinv29iat1s2 Rinv29iat1s3 0 sky130_fd_pr__res_xhigh_po w=10 l=49.614372
XRinv29iap1s4 Rinv29iat1s3 Rinv29iat1s4 0 sky130_fd_pr__res_xhigh_po w=10 l=49.614372
XRinv29iap1s5 Rinv29iat1s4 Rinv29iat1s5 0 sky130_fd_pr__res_xhigh_po w=10 l=49.614372
XRinv29iap1s6 Rinv29iat1s5 Rinv29iat1s6 0 sky130_fd_pr__res_xhigh_po w=10 l=49.614372
XRinv29iap1s7 Rinv29iat1s6 inv29m 0 sky130_fd_pr__res_xhigh_po w=10 l=49.614372
XRinv29iap2s0 in29 Rinv29iat2s0 0 sky130_fd_pr__res_xhigh_po w=10 l=49.614372
XRinv29iap2s1 Rinv29iat2s0 Rinv29iat2s1 0 sky130_fd_pr__res_xhigh_po w=10 l=49.614372
XRinv29iap2s2 Rinv29iat2s1 Rinv29iat2s2 0 sky130_fd_pr__res_xhigh_po w=10 l=49.614372
XRinv29iap2s3 Rinv29iat2s2 Rinv29iat2s3 0 sky130_fd_pr__res_xhigh_po w=10 l=49.614372
XRinv29iap2s4 Rinv29iat2s3 Rinv29iat2s4 0 sky130_fd_pr__res_xhigh_po w=10 l=49.614372
XRinv29iap2s5 Rinv29iat2s4 Rinv29iat2s5 0 sky130_fd_pr__res_xhigh_po w=10 l=49.614372
XRinv29iap2s6 Rinv29iat2s5 Rinv29iat2s6 0 sky130_fd_pr__res_xhigh_po w=10 l=49.614372
XRinv29iap2s7 Rinv29iat2s6 inv29m 0 sky130_fd_pr__res_xhigh_po w=10 l=49.614372
XRinv29iap3s0 in29 Rinv29iat3s0 0 sky130_fd_pr__res_xhigh_po w=10 l=49.614372
XRinv29iap3s1 Rinv29iat3s0 Rinv29iat3s1 0 sky130_fd_pr__res_xhigh_po w=10 l=49.614372
XRinv29iap3s2 Rinv29iat3s1 Rinv29iat3s2 0 sky130_fd_pr__res_xhigh_po w=10 l=49.614372
XRinv29iap3s3 Rinv29iat3s2 Rinv29iat3s3 0 sky130_fd_pr__res_xhigh_po w=10 l=49.614372
XRinv29iap3s4 Rinv29iat3s3 Rinv29iat3s4 0 sky130_fd_pr__res_xhigh_po w=10 l=49.614372
XRinv29iap3s5 Rinv29iat3s4 Rinv29iat3s5 0 sky130_fd_pr__res_xhigh_po w=10 l=49.614372
XRinv29iap3s6 Rinv29iat3s5 Rinv29iat3s6 0 sky130_fd_pr__res_xhigh_po w=10 l=49.614372
XRinv29iap3s7 Rinv29iat3s6 inv29m 0 sky130_fd_pr__res_xhigh_po w=10 l=49.614372
XRinv29iap4s0 in29 Rinv29iat4s0 0 sky130_fd_pr__res_xhigh_po w=10 l=49.614372
XRinv29iap4s1 Rinv29iat4s0 Rinv29iat4s1 0 sky130_fd_pr__res_xhigh_po w=10 l=49.614372
XRinv29iap4s2 Rinv29iat4s1 Rinv29iat4s2 0 sky130_fd_pr__res_xhigh_po w=10 l=49.614372
XRinv29iap4s3 Rinv29iat4s2 Rinv29iat4s3 0 sky130_fd_pr__res_xhigh_po w=10 l=49.614372
XRinv29iap4s4 Rinv29iat4s3 Rinv29iat4s4 0 sky130_fd_pr__res_xhigh_po w=10 l=49.614372
XRinv29iap4s5 Rinv29iat4s4 Rinv29iat4s5 0 sky130_fd_pr__res_xhigh_po w=10 l=49.614372
XRinv29iap4s6 Rinv29iat4s5 Rinv29iat4s6 0 sky130_fd_pr__res_xhigh_po w=10 l=49.614372
XRinv29iap4s7 Rinv29iat4s6 inv29m 0 sky130_fd_pr__res_xhigh_po w=10 l=49.614372
XRinv29iap5s0 in29 Rinv29iat5s0 0 sky130_fd_pr__res_xhigh_po w=10 l=49.614372
XRinv29iap5s1 Rinv29iat5s0 Rinv29iat5s1 0 sky130_fd_pr__res_xhigh_po w=10 l=49.614372
XRinv29iap5s2 Rinv29iat5s1 Rinv29iat5s2 0 sky130_fd_pr__res_xhigh_po w=10 l=49.614372
XRinv29iap5s3 Rinv29iat5s2 Rinv29iat5s3 0 sky130_fd_pr__res_xhigh_po w=10 l=49.614372
XRinv29iap5s4 Rinv29iat5s3 Rinv29iat5s4 0 sky130_fd_pr__res_xhigh_po w=10 l=49.614372
XRinv29iap5s5 Rinv29iat5s4 Rinv29iat5s5 0 sky130_fd_pr__res_xhigh_po w=10 l=49.614372
XRinv29iap5s6 Rinv29iat5s5 Rinv29iat5s6 0 sky130_fd_pr__res_xhigh_po w=10 l=49.614372
XRinv29iap5s7 Rinv29iat5s6 inv29m 0 sky130_fd_pr__res_xhigh_po w=10 l=49.614372
XRinv29iap6s0 in29 Rinv29iat6s0 0 sky130_fd_pr__res_xhigh_po w=10 l=49.614372
XRinv29iap6s1 Rinv29iat6s0 Rinv29iat6s1 0 sky130_fd_pr__res_xhigh_po w=10 l=49.614372
XRinv29iap6s2 Rinv29iat6s1 Rinv29iat6s2 0 sky130_fd_pr__res_xhigh_po w=10 l=49.614372
XRinv29iap6s3 Rinv29iat6s2 Rinv29iat6s3 0 sky130_fd_pr__res_xhigh_po w=10 l=49.614372
XRinv29iap6s4 Rinv29iat6s3 Rinv29iat6s4 0 sky130_fd_pr__res_xhigh_po w=10 l=49.614372
XRinv29iap6s5 Rinv29iat6s4 Rinv29iat6s5 0 sky130_fd_pr__res_xhigh_po w=10 l=49.614372
XRinv29iap6s6 Rinv29iat6s5 Rinv29iat6s6 0 sky130_fd_pr__res_xhigh_po w=10 l=49.614372
XRinv29iap6s7 Rinv29iat6s6 inv29m 0 sky130_fd_pr__res_xhigh_po w=10 l=49.614372
XRinv29iap7s0 in29 Rinv29iat7s0 0 sky130_fd_pr__res_xhigh_po w=10 l=49.614372
XRinv29iap7s1 Rinv29iat7s0 Rinv29iat7s1 0 sky130_fd_pr__res_xhigh_po w=10 l=49.614372
XRinv29iap7s2 Rinv29iat7s1 Rinv29iat7s2 0 sky130_fd_pr__res_xhigh_po w=10 l=49.614372
XRinv29iap7s3 Rinv29iat7s2 Rinv29iat7s3 0 sky130_fd_pr__res_xhigh_po w=10 l=49.614372
XRinv29iap7s4 Rinv29iat7s3 Rinv29iat7s4 0 sky130_fd_pr__res_xhigh_po w=10 l=49.614372
XRinv29iap7s5 Rinv29iat7s4 Rinv29iat7s5 0 sky130_fd_pr__res_xhigh_po w=10 l=49.614372
XRinv29iap7s6 Rinv29iat7s5 Rinv29iat7s6 0 sky130_fd_pr__res_xhigh_po w=10 l=49.614372
XRinv29iap7s7 Rinv29iat7s6 inv29m 0 sky130_fd_pr__res_xhigh_po w=10 l=49.614372
* PDK sky130_fd_pr__res_xhigh_po Rinv29ib W=10 L=49.614382
* tile Rinv29ib 8s x 8p same W=10 L=49.614382
XRinv29ibp0s0 in29n Rinv29ibt0s0 0 sky130_fd_pr__res_xhigh_po w=10 l=49.614382
XRinv29ibp0s1 Rinv29ibt0s0 Rinv29ibt0s1 0 sky130_fd_pr__res_xhigh_po w=10 l=49.614382
XRinv29ibp0s2 Rinv29ibt0s1 Rinv29ibt0s2 0 sky130_fd_pr__res_xhigh_po w=10 l=49.614382
XRinv29ibp0s3 Rinv29ibt0s2 Rinv29ibt0s3 0 sky130_fd_pr__res_xhigh_po w=10 l=49.614382
XRinv29ibp0s4 Rinv29ibt0s3 Rinv29ibt0s4 0 sky130_fd_pr__res_xhigh_po w=10 l=49.614382
XRinv29ibp0s5 Rinv29ibt0s4 Rinv29ibt0s5 0 sky130_fd_pr__res_xhigh_po w=10 l=49.614382
XRinv29ibp0s6 Rinv29ibt0s5 Rinv29ibt0s6 0 sky130_fd_pr__res_xhigh_po w=10 l=49.614382
XRinv29ibp0s7 Rinv29ibt0s6 inv29m 0 sky130_fd_pr__res_xhigh_po w=10 l=49.614382
XRinv29ibp1s0 in29n Rinv29ibt1s0 0 sky130_fd_pr__res_xhigh_po w=10 l=49.614382
XRinv29ibp1s1 Rinv29ibt1s0 Rinv29ibt1s1 0 sky130_fd_pr__res_xhigh_po w=10 l=49.614382
XRinv29ibp1s2 Rinv29ibt1s1 Rinv29ibt1s2 0 sky130_fd_pr__res_xhigh_po w=10 l=49.614382
XRinv29ibp1s3 Rinv29ibt1s2 Rinv29ibt1s3 0 sky130_fd_pr__res_xhigh_po w=10 l=49.614382
XRinv29ibp1s4 Rinv29ibt1s3 Rinv29ibt1s4 0 sky130_fd_pr__res_xhigh_po w=10 l=49.614382
XRinv29ibp1s5 Rinv29ibt1s4 Rinv29ibt1s5 0 sky130_fd_pr__res_xhigh_po w=10 l=49.614382
XRinv29ibp1s6 Rinv29ibt1s5 Rinv29ibt1s6 0 sky130_fd_pr__res_xhigh_po w=10 l=49.614382
XRinv29ibp1s7 Rinv29ibt1s6 inv29m 0 sky130_fd_pr__res_xhigh_po w=10 l=49.614382
XRinv29ibp2s0 in29n Rinv29ibt2s0 0 sky130_fd_pr__res_xhigh_po w=10 l=49.614382
XRinv29ibp2s1 Rinv29ibt2s0 Rinv29ibt2s1 0 sky130_fd_pr__res_xhigh_po w=10 l=49.614382
XRinv29ibp2s2 Rinv29ibt2s1 Rinv29ibt2s2 0 sky130_fd_pr__res_xhigh_po w=10 l=49.614382
XRinv29ibp2s3 Rinv29ibt2s2 Rinv29ibt2s3 0 sky130_fd_pr__res_xhigh_po w=10 l=49.614382
XRinv29ibp2s4 Rinv29ibt2s3 Rinv29ibt2s4 0 sky130_fd_pr__res_xhigh_po w=10 l=49.614382
XRinv29ibp2s5 Rinv29ibt2s4 Rinv29ibt2s5 0 sky130_fd_pr__res_xhigh_po w=10 l=49.614382
XRinv29ibp2s6 Rinv29ibt2s5 Rinv29ibt2s6 0 sky130_fd_pr__res_xhigh_po w=10 l=49.614382
XRinv29ibp2s7 Rinv29ibt2s6 inv29m 0 sky130_fd_pr__res_xhigh_po w=10 l=49.614382
XRinv29ibp3s0 in29n Rinv29ibt3s0 0 sky130_fd_pr__res_xhigh_po w=10 l=49.614382
XRinv29ibp3s1 Rinv29ibt3s0 Rinv29ibt3s1 0 sky130_fd_pr__res_xhigh_po w=10 l=49.614382
XRinv29ibp3s2 Rinv29ibt3s1 Rinv29ibt3s2 0 sky130_fd_pr__res_xhigh_po w=10 l=49.614382
XRinv29ibp3s3 Rinv29ibt3s2 Rinv29ibt3s3 0 sky130_fd_pr__res_xhigh_po w=10 l=49.614382
XRinv29ibp3s4 Rinv29ibt3s3 Rinv29ibt3s4 0 sky130_fd_pr__res_xhigh_po w=10 l=49.614382
XRinv29ibp3s5 Rinv29ibt3s4 Rinv29ibt3s5 0 sky130_fd_pr__res_xhigh_po w=10 l=49.614382
XRinv29ibp3s6 Rinv29ibt3s5 Rinv29ibt3s6 0 sky130_fd_pr__res_xhigh_po w=10 l=49.614382
XRinv29ibp3s7 Rinv29ibt3s6 inv29m 0 sky130_fd_pr__res_xhigh_po w=10 l=49.614382
XRinv29ibp4s0 in29n Rinv29ibt4s0 0 sky130_fd_pr__res_xhigh_po w=10 l=49.614382
XRinv29ibp4s1 Rinv29ibt4s0 Rinv29ibt4s1 0 sky130_fd_pr__res_xhigh_po w=10 l=49.614382
XRinv29ibp4s2 Rinv29ibt4s1 Rinv29ibt4s2 0 sky130_fd_pr__res_xhigh_po w=10 l=49.614382
XRinv29ibp4s3 Rinv29ibt4s2 Rinv29ibt4s3 0 sky130_fd_pr__res_xhigh_po w=10 l=49.614382
XRinv29ibp4s4 Rinv29ibt4s3 Rinv29ibt4s4 0 sky130_fd_pr__res_xhigh_po w=10 l=49.614382
XRinv29ibp4s5 Rinv29ibt4s4 Rinv29ibt4s5 0 sky130_fd_pr__res_xhigh_po w=10 l=49.614382
XRinv29ibp4s6 Rinv29ibt4s5 Rinv29ibt4s6 0 sky130_fd_pr__res_xhigh_po w=10 l=49.614382
XRinv29ibp4s7 Rinv29ibt4s6 inv29m 0 sky130_fd_pr__res_xhigh_po w=10 l=49.614382
XRinv29ibp5s0 in29n Rinv29ibt5s0 0 sky130_fd_pr__res_xhigh_po w=10 l=49.614382
XRinv29ibp5s1 Rinv29ibt5s0 Rinv29ibt5s1 0 sky130_fd_pr__res_xhigh_po w=10 l=49.614382
XRinv29ibp5s2 Rinv29ibt5s1 Rinv29ibt5s2 0 sky130_fd_pr__res_xhigh_po w=10 l=49.614382
XRinv29ibp5s3 Rinv29ibt5s2 Rinv29ibt5s3 0 sky130_fd_pr__res_xhigh_po w=10 l=49.614382
XRinv29ibp5s4 Rinv29ibt5s3 Rinv29ibt5s4 0 sky130_fd_pr__res_xhigh_po w=10 l=49.614382
XRinv29ibp5s5 Rinv29ibt5s4 Rinv29ibt5s5 0 sky130_fd_pr__res_xhigh_po w=10 l=49.614382
XRinv29ibp5s6 Rinv29ibt5s5 Rinv29ibt5s6 0 sky130_fd_pr__res_xhigh_po w=10 l=49.614382
XRinv29ibp5s7 Rinv29ibt5s6 inv29m 0 sky130_fd_pr__res_xhigh_po w=10 l=49.614382
XRinv29ibp6s0 in29n Rinv29ibt6s0 0 sky130_fd_pr__res_xhigh_po w=10 l=49.614382
XRinv29ibp6s1 Rinv29ibt6s0 Rinv29ibt6s1 0 sky130_fd_pr__res_xhigh_po w=10 l=49.614382
XRinv29ibp6s2 Rinv29ibt6s1 Rinv29ibt6s2 0 sky130_fd_pr__res_xhigh_po w=10 l=49.614382
XRinv29ibp6s3 Rinv29ibt6s2 Rinv29ibt6s3 0 sky130_fd_pr__res_xhigh_po w=10 l=49.614382
XRinv29ibp6s4 Rinv29ibt6s3 Rinv29ibt6s4 0 sky130_fd_pr__res_xhigh_po w=10 l=49.614382
XRinv29ibp6s5 Rinv29ibt6s4 Rinv29ibt6s5 0 sky130_fd_pr__res_xhigh_po w=10 l=49.614382
XRinv29ibp6s6 Rinv29ibt6s5 Rinv29ibt6s6 0 sky130_fd_pr__res_xhigh_po w=10 l=49.614382
XRinv29ibp6s7 Rinv29ibt6s6 inv29m 0 sky130_fd_pr__res_xhigh_po w=10 l=49.614382
XRinv29ibp7s0 in29n Rinv29ibt7s0 0 sky130_fd_pr__res_xhigh_po w=10 l=49.614382
XRinv29ibp7s1 Rinv29ibt7s0 Rinv29ibt7s1 0 sky130_fd_pr__res_xhigh_po w=10 l=49.614382
XRinv29ibp7s2 Rinv29ibt7s1 Rinv29ibt7s2 0 sky130_fd_pr__res_xhigh_po w=10 l=49.614382
XRinv29ibp7s3 Rinv29ibt7s2 Rinv29ibt7s3 0 sky130_fd_pr__res_xhigh_po w=10 l=49.614382
XRinv29ibp7s4 Rinv29ibt7s3 Rinv29ibt7s4 0 sky130_fd_pr__res_xhigh_po w=10 l=49.614382
XRinv29ibp7s5 Rinv29ibt7s4 Rinv29ibt7s5 0 sky130_fd_pr__res_xhigh_po w=10 l=49.614382
XRinv29ibp7s6 Rinv29ibt7s5 Rinv29ibt7s6 0 sky130_fd_pr__res_xhigh_po w=10 l=49.614382
XRinv29ibp7s7 Rinv29ibt7s6 inv29m 0 sky130_fd_pr__res_xhigh_po w=10 l=49.614382
Einv29amp in29n 0 0 inv29m 10000000
* load-compensated divider in29n->tap29n: G_load=0.000275989040257845 Ra=782922.085128668 Rb=1000 target beta=0.001 (no tap buffer)
* PDK sky130_fd_pr__res_xhigh_po Rdiv29na W=10 L=3892.583
* tile Rdiv29na 8s x 8p same W=10 L=3892.583
XRdiv29nap0s0 in29n Rdiv29nat0s0 0 sky130_fd_pr__res_xhigh_po w=10 l=3892.583
XRdiv29nap0s1 Rdiv29nat0s0 Rdiv29nat0s1 0 sky130_fd_pr__res_xhigh_po w=10 l=3892.583
XRdiv29nap0s2 Rdiv29nat0s1 Rdiv29nat0s2 0 sky130_fd_pr__res_xhigh_po w=10 l=3892.583
XRdiv29nap0s3 Rdiv29nat0s2 Rdiv29nat0s3 0 sky130_fd_pr__res_xhigh_po w=10 l=3892.583
XRdiv29nap0s4 Rdiv29nat0s3 Rdiv29nat0s4 0 sky130_fd_pr__res_xhigh_po w=10 l=3892.583
XRdiv29nap0s5 Rdiv29nat0s4 Rdiv29nat0s5 0 sky130_fd_pr__res_xhigh_po w=10 l=3892.583
XRdiv29nap0s6 Rdiv29nat0s5 Rdiv29nat0s6 0 sky130_fd_pr__res_xhigh_po w=10 l=3892.583
XRdiv29nap0s7 Rdiv29nat0s6 tap29n 0 sky130_fd_pr__res_xhigh_po w=10 l=3892.583
XRdiv29nap1s0 in29n Rdiv29nat1s0 0 sky130_fd_pr__res_xhigh_po w=10 l=3892.583
XRdiv29nap1s1 Rdiv29nat1s0 Rdiv29nat1s1 0 sky130_fd_pr__res_xhigh_po w=10 l=3892.583
XRdiv29nap1s2 Rdiv29nat1s1 Rdiv29nat1s2 0 sky130_fd_pr__res_xhigh_po w=10 l=3892.583
XRdiv29nap1s3 Rdiv29nat1s2 Rdiv29nat1s3 0 sky130_fd_pr__res_xhigh_po w=10 l=3892.583
XRdiv29nap1s4 Rdiv29nat1s3 Rdiv29nat1s4 0 sky130_fd_pr__res_xhigh_po w=10 l=3892.583
XRdiv29nap1s5 Rdiv29nat1s4 Rdiv29nat1s5 0 sky130_fd_pr__res_xhigh_po w=10 l=3892.583
XRdiv29nap1s6 Rdiv29nat1s5 Rdiv29nat1s6 0 sky130_fd_pr__res_xhigh_po w=10 l=3892.583
XRdiv29nap1s7 Rdiv29nat1s6 tap29n 0 sky130_fd_pr__res_xhigh_po w=10 l=3892.583
XRdiv29nap2s0 in29n Rdiv29nat2s0 0 sky130_fd_pr__res_xhigh_po w=10 l=3892.583
XRdiv29nap2s1 Rdiv29nat2s0 Rdiv29nat2s1 0 sky130_fd_pr__res_xhigh_po w=10 l=3892.583
XRdiv29nap2s2 Rdiv29nat2s1 Rdiv29nat2s2 0 sky130_fd_pr__res_xhigh_po w=10 l=3892.583
XRdiv29nap2s3 Rdiv29nat2s2 Rdiv29nat2s3 0 sky130_fd_pr__res_xhigh_po w=10 l=3892.583
XRdiv29nap2s4 Rdiv29nat2s3 Rdiv29nat2s4 0 sky130_fd_pr__res_xhigh_po w=10 l=3892.583
XRdiv29nap2s5 Rdiv29nat2s4 Rdiv29nat2s5 0 sky130_fd_pr__res_xhigh_po w=10 l=3892.583
XRdiv29nap2s6 Rdiv29nat2s5 Rdiv29nat2s6 0 sky130_fd_pr__res_xhigh_po w=10 l=3892.583
XRdiv29nap2s7 Rdiv29nat2s6 tap29n 0 sky130_fd_pr__res_xhigh_po w=10 l=3892.583
XRdiv29nap3s0 in29n Rdiv29nat3s0 0 sky130_fd_pr__res_xhigh_po w=10 l=3892.583
XRdiv29nap3s1 Rdiv29nat3s0 Rdiv29nat3s1 0 sky130_fd_pr__res_xhigh_po w=10 l=3892.583
XRdiv29nap3s2 Rdiv29nat3s1 Rdiv29nat3s2 0 sky130_fd_pr__res_xhigh_po w=10 l=3892.583
XRdiv29nap3s3 Rdiv29nat3s2 Rdiv29nat3s3 0 sky130_fd_pr__res_xhigh_po w=10 l=3892.583
XRdiv29nap3s4 Rdiv29nat3s3 Rdiv29nat3s4 0 sky130_fd_pr__res_xhigh_po w=10 l=3892.583
XRdiv29nap3s5 Rdiv29nat3s4 Rdiv29nat3s5 0 sky130_fd_pr__res_xhigh_po w=10 l=3892.583
XRdiv29nap3s6 Rdiv29nat3s5 Rdiv29nat3s6 0 sky130_fd_pr__res_xhigh_po w=10 l=3892.583
XRdiv29nap3s7 Rdiv29nat3s6 tap29n 0 sky130_fd_pr__res_xhigh_po w=10 l=3892.583
XRdiv29nap4s0 in29n Rdiv29nat4s0 0 sky130_fd_pr__res_xhigh_po w=10 l=3892.583
XRdiv29nap4s1 Rdiv29nat4s0 Rdiv29nat4s1 0 sky130_fd_pr__res_xhigh_po w=10 l=3892.583
XRdiv29nap4s2 Rdiv29nat4s1 Rdiv29nat4s2 0 sky130_fd_pr__res_xhigh_po w=10 l=3892.583
XRdiv29nap4s3 Rdiv29nat4s2 Rdiv29nat4s3 0 sky130_fd_pr__res_xhigh_po w=10 l=3892.583
XRdiv29nap4s4 Rdiv29nat4s3 Rdiv29nat4s4 0 sky130_fd_pr__res_xhigh_po w=10 l=3892.583
XRdiv29nap4s5 Rdiv29nat4s4 Rdiv29nat4s5 0 sky130_fd_pr__res_xhigh_po w=10 l=3892.583
XRdiv29nap4s6 Rdiv29nat4s5 Rdiv29nat4s6 0 sky130_fd_pr__res_xhigh_po w=10 l=3892.583
XRdiv29nap4s7 Rdiv29nat4s6 tap29n 0 sky130_fd_pr__res_xhigh_po w=10 l=3892.583
XRdiv29nap5s0 in29n Rdiv29nat5s0 0 sky130_fd_pr__res_xhigh_po w=10 l=3892.583
XRdiv29nap5s1 Rdiv29nat5s0 Rdiv29nat5s1 0 sky130_fd_pr__res_xhigh_po w=10 l=3892.583
XRdiv29nap5s2 Rdiv29nat5s1 Rdiv29nat5s2 0 sky130_fd_pr__res_xhigh_po w=10 l=3892.583
XRdiv29nap5s3 Rdiv29nat5s2 Rdiv29nat5s3 0 sky130_fd_pr__res_xhigh_po w=10 l=3892.583
XRdiv29nap5s4 Rdiv29nat5s3 Rdiv29nat5s4 0 sky130_fd_pr__res_xhigh_po w=10 l=3892.583
XRdiv29nap5s5 Rdiv29nat5s4 Rdiv29nat5s5 0 sky130_fd_pr__res_xhigh_po w=10 l=3892.583
XRdiv29nap5s6 Rdiv29nat5s5 Rdiv29nat5s6 0 sky130_fd_pr__res_xhigh_po w=10 l=3892.583
XRdiv29nap5s7 Rdiv29nat5s6 tap29n 0 sky130_fd_pr__res_xhigh_po w=10 l=3892.583
XRdiv29nap6s0 in29n Rdiv29nat6s0 0 sky130_fd_pr__res_xhigh_po w=10 l=3892.583
XRdiv29nap6s1 Rdiv29nat6s0 Rdiv29nat6s1 0 sky130_fd_pr__res_xhigh_po w=10 l=3892.583
XRdiv29nap6s2 Rdiv29nat6s1 Rdiv29nat6s2 0 sky130_fd_pr__res_xhigh_po w=10 l=3892.583
XRdiv29nap6s3 Rdiv29nat6s2 Rdiv29nat6s3 0 sky130_fd_pr__res_xhigh_po w=10 l=3892.583
XRdiv29nap6s4 Rdiv29nat6s3 Rdiv29nat6s4 0 sky130_fd_pr__res_xhigh_po w=10 l=3892.583
XRdiv29nap6s5 Rdiv29nat6s4 Rdiv29nat6s5 0 sky130_fd_pr__res_xhigh_po w=10 l=3892.583
XRdiv29nap6s6 Rdiv29nat6s5 Rdiv29nat6s6 0 sky130_fd_pr__res_xhigh_po w=10 l=3892.583
XRdiv29nap6s7 Rdiv29nat6s6 tap29n 0 sky130_fd_pr__res_xhigh_po w=10 l=3892.583
XRdiv29nap7s0 in29n Rdiv29nat7s0 0 sky130_fd_pr__res_xhigh_po w=10 l=3892.583
XRdiv29nap7s1 Rdiv29nat7s0 Rdiv29nat7s1 0 sky130_fd_pr__res_xhigh_po w=10 l=3892.583
XRdiv29nap7s2 Rdiv29nat7s1 Rdiv29nat7s2 0 sky130_fd_pr__res_xhigh_po w=10 l=3892.583
XRdiv29nap7s3 Rdiv29nat7s2 Rdiv29nat7s3 0 sky130_fd_pr__res_xhigh_po w=10 l=3892.583
XRdiv29nap7s4 Rdiv29nat7s3 Rdiv29nat7s4 0 sky130_fd_pr__res_xhigh_po w=10 l=3892.583
XRdiv29nap7s5 Rdiv29nat7s4 Rdiv29nat7s5 0 sky130_fd_pr__res_xhigh_po w=10 l=3892.583
XRdiv29nap7s6 Rdiv29nat7s5 Rdiv29nat7s6 0 sky130_fd_pr__res_xhigh_po w=10 l=3892.583
XRdiv29nap7s7 Rdiv29nat7s6 tap29n 0 sky130_fd_pr__res_xhigh_po w=10 l=3892.583
* PDK sky130_fd_pr__res_xhigh_po Rdiv29nb W=10 L=4.8663717
* tile Rdiv29nb 8s x 8p same W=10 L=4.8663717
XRdiv29nbp0s0 tap29n Rdiv29nbt0s0 0 sky130_fd_pr__res_xhigh_po w=10 l=4.8663717
XRdiv29nbp0s1 Rdiv29nbt0s0 Rdiv29nbt0s1 0 sky130_fd_pr__res_xhigh_po w=10 l=4.8663717
XRdiv29nbp0s2 Rdiv29nbt0s1 Rdiv29nbt0s2 0 sky130_fd_pr__res_xhigh_po w=10 l=4.8663717
XRdiv29nbp0s3 Rdiv29nbt0s2 Rdiv29nbt0s3 0 sky130_fd_pr__res_xhigh_po w=10 l=4.8663717
XRdiv29nbp0s4 Rdiv29nbt0s3 Rdiv29nbt0s4 0 sky130_fd_pr__res_xhigh_po w=10 l=4.8663717
XRdiv29nbp0s5 Rdiv29nbt0s4 Rdiv29nbt0s5 0 sky130_fd_pr__res_xhigh_po w=10 l=4.8663717
XRdiv29nbp0s6 Rdiv29nbt0s5 Rdiv29nbt0s6 0 sky130_fd_pr__res_xhigh_po w=10 l=4.8663717
XRdiv29nbp0s7 Rdiv29nbt0s6 0 0 sky130_fd_pr__res_xhigh_po w=10 l=4.8663717
XRdiv29nbp1s0 tap29n Rdiv29nbt1s0 0 sky130_fd_pr__res_xhigh_po w=10 l=4.8663717
XRdiv29nbp1s1 Rdiv29nbt1s0 Rdiv29nbt1s1 0 sky130_fd_pr__res_xhigh_po w=10 l=4.8663717
XRdiv29nbp1s2 Rdiv29nbt1s1 Rdiv29nbt1s2 0 sky130_fd_pr__res_xhigh_po w=10 l=4.8663717
XRdiv29nbp1s3 Rdiv29nbt1s2 Rdiv29nbt1s3 0 sky130_fd_pr__res_xhigh_po w=10 l=4.8663717
XRdiv29nbp1s4 Rdiv29nbt1s3 Rdiv29nbt1s4 0 sky130_fd_pr__res_xhigh_po w=10 l=4.8663717
XRdiv29nbp1s5 Rdiv29nbt1s4 Rdiv29nbt1s5 0 sky130_fd_pr__res_xhigh_po w=10 l=4.8663717
XRdiv29nbp1s6 Rdiv29nbt1s5 Rdiv29nbt1s6 0 sky130_fd_pr__res_xhigh_po w=10 l=4.8663717
XRdiv29nbp1s7 Rdiv29nbt1s6 0 0 sky130_fd_pr__res_xhigh_po w=10 l=4.8663717
XRdiv29nbp2s0 tap29n Rdiv29nbt2s0 0 sky130_fd_pr__res_xhigh_po w=10 l=4.8663717
XRdiv29nbp2s1 Rdiv29nbt2s0 Rdiv29nbt2s1 0 sky130_fd_pr__res_xhigh_po w=10 l=4.8663717
XRdiv29nbp2s2 Rdiv29nbt2s1 Rdiv29nbt2s2 0 sky130_fd_pr__res_xhigh_po w=10 l=4.8663717
XRdiv29nbp2s3 Rdiv29nbt2s2 Rdiv29nbt2s3 0 sky130_fd_pr__res_xhigh_po w=10 l=4.8663717
XRdiv29nbp2s4 Rdiv29nbt2s3 Rdiv29nbt2s4 0 sky130_fd_pr__res_xhigh_po w=10 l=4.8663717
XRdiv29nbp2s5 Rdiv29nbt2s4 Rdiv29nbt2s5 0 sky130_fd_pr__res_xhigh_po w=10 l=4.8663717
XRdiv29nbp2s6 Rdiv29nbt2s5 Rdiv29nbt2s6 0 sky130_fd_pr__res_xhigh_po w=10 l=4.8663717
XRdiv29nbp2s7 Rdiv29nbt2s6 0 0 sky130_fd_pr__res_xhigh_po w=10 l=4.8663717
XRdiv29nbp3s0 tap29n Rdiv29nbt3s0 0 sky130_fd_pr__res_xhigh_po w=10 l=4.8663717
XRdiv29nbp3s1 Rdiv29nbt3s0 Rdiv29nbt3s1 0 sky130_fd_pr__res_xhigh_po w=10 l=4.8663717
XRdiv29nbp3s2 Rdiv29nbt3s1 Rdiv29nbt3s2 0 sky130_fd_pr__res_xhigh_po w=10 l=4.8663717
XRdiv29nbp3s3 Rdiv29nbt3s2 Rdiv29nbt3s3 0 sky130_fd_pr__res_xhigh_po w=10 l=4.8663717
XRdiv29nbp3s4 Rdiv29nbt3s3 Rdiv29nbt3s4 0 sky130_fd_pr__res_xhigh_po w=10 l=4.8663717
XRdiv29nbp3s5 Rdiv29nbt3s4 Rdiv29nbt3s5 0 sky130_fd_pr__res_xhigh_po w=10 l=4.8663717
XRdiv29nbp3s6 Rdiv29nbt3s5 Rdiv29nbt3s6 0 sky130_fd_pr__res_xhigh_po w=10 l=4.8663717
XRdiv29nbp3s7 Rdiv29nbt3s6 0 0 sky130_fd_pr__res_xhigh_po w=10 l=4.8663717
XRdiv29nbp4s0 tap29n Rdiv29nbt4s0 0 sky130_fd_pr__res_xhigh_po w=10 l=4.8663717
XRdiv29nbp4s1 Rdiv29nbt4s0 Rdiv29nbt4s1 0 sky130_fd_pr__res_xhigh_po w=10 l=4.8663717
XRdiv29nbp4s2 Rdiv29nbt4s1 Rdiv29nbt4s2 0 sky130_fd_pr__res_xhigh_po w=10 l=4.8663717
XRdiv29nbp4s3 Rdiv29nbt4s2 Rdiv29nbt4s3 0 sky130_fd_pr__res_xhigh_po w=10 l=4.8663717
XRdiv29nbp4s4 Rdiv29nbt4s3 Rdiv29nbt4s4 0 sky130_fd_pr__res_xhigh_po w=10 l=4.8663717
XRdiv29nbp4s5 Rdiv29nbt4s4 Rdiv29nbt4s5 0 sky130_fd_pr__res_xhigh_po w=10 l=4.8663717
XRdiv29nbp4s6 Rdiv29nbt4s5 Rdiv29nbt4s6 0 sky130_fd_pr__res_xhigh_po w=10 l=4.8663717
XRdiv29nbp4s7 Rdiv29nbt4s6 0 0 sky130_fd_pr__res_xhigh_po w=10 l=4.8663717
XRdiv29nbp5s0 tap29n Rdiv29nbt5s0 0 sky130_fd_pr__res_xhigh_po w=10 l=4.8663717
XRdiv29nbp5s1 Rdiv29nbt5s0 Rdiv29nbt5s1 0 sky130_fd_pr__res_xhigh_po w=10 l=4.8663717
XRdiv29nbp5s2 Rdiv29nbt5s1 Rdiv29nbt5s2 0 sky130_fd_pr__res_xhigh_po w=10 l=4.8663717
XRdiv29nbp5s3 Rdiv29nbt5s2 Rdiv29nbt5s3 0 sky130_fd_pr__res_xhigh_po w=10 l=4.8663717
XRdiv29nbp5s4 Rdiv29nbt5s3 Rdiv29nbt5s4 0 sky130_fd_pr__res_xhigh_po w=10 l=4.8663717
XRdiv29nbp5s5 Rdiv29nbt5s4 Rdiv29nbt5s5 0 sky130_fd_pr__res_xhigh_po w=10 l=4.8663717
XRdiv29nbp5s6 Rdiv29nbt5s5 Rdiv29nbt5s6 0 sky130_fd_pr__res_xhigh_po w=10 l=4.8663717
XRdiv29nbp5s7 Rdiv29nbt5s6 0 0 sky130_fd_pr__res_xhigh_po w=10 l=4.8663717
XRdiv29nbp6s0 tap29n Rdiv29nbt6s0 0 sky130_fd_pr__res_xhigh_po w=10 l=4.8663717
XRdiv29nbp6s1 Rdiv29nbt6s0 Rdiv29nbt6s1 0 sky130_fd_pr__res_xhigh_po w=10 l=4.8663717
XRdiv29nbp6s2 Rdiv29nbt6s1 Rdiv29nbt6s2 0 sky130_fd_pr__res_xhigh_po w=10 l=4.8663717
XRdiv29nbp6s3 Rdiv29nbt6s2 Rdiv29nbt6s3 0 sky130_fd_pr__res_xhigh_po w=10 l=4.8663717
XRdiv29nbp6s4 Rdiv29nbt6s3 Rdiv29nbt6s4 0 sky130_fd_pr__res_xhigh_po w=10 l=4.8663717
XRdiv29nbp6s5 Rdiv29nbt6s4 Rdiv29nbt6s5 0 sky130_fd_pr__res_xhigh_po w=10 l=4.8663717
XRdiv29nbp6s6 Rdiv29nbt6s5 Rdiv29nbt6s6 0 sky130_fd_pr__res_xhigh_po w=10 l=4.8663717
XRdiv29nbp6s7 Rdiv29nbt6s6 0 0 sky130_fd_pr__res_xhigh_po w=10 l=4.8663717
XRdiv29nbp7s0 tap29n Rdiv29nbt7s0 0 sky130_fd_pr__res_xhigh_po w=10 l=4.8663717
XRdiv29nbp7s1 Rdiv29nbt7s0 Rdiv29nbt7s1 0 sky130_fd_pr__res_xhigh_po w=10 l=4.8663717
XRdiv29nbp7s2 Rdiv29nbt7s1 Rdiv29nbt7s2 0 sky130_fd_pr__res_xhigh_po w=10 l=4.8663717
XRdiv29nbp7s3 Rdiv29nbt7s2 Rdiv29nbt7s3 0 sky130_fd_pr__res_xhigh_po w=10 l=4.8663717
XRdiv29nbp7s4 Rdiv29nbt7s3 Rdiv29nbt7s4 0 sky130_fd_pr__res_xhigh_po w=10 l=4.8663717
XRdiv29nbp7s5 Rdiv29nbt7s4 Rdiv29nbt7s5 0 sky130_fd_pr__res_xhigh_po w=10 l=4.8663717
XRdiv29nbp7s6 Rdiv29nbt7s5 Rdiv29nbt7s6 0 sky130_fd_pr__res_xhigh_po w=10 l=4.8663717
XRdiv29nbp7s7 Rdiv29nbt7s6 0 0 sky130_fd_pr__res_xhigh_po w=10 l=4.8663717
Vin30 in30 0 DC 0.0467434987671904
Vin31 in31 0 DC 0.376944739491497
Vin32 in32 0 DC 0.0618086911540602
* passive invert in32 -> in32n: R2/R1=1.0000002 closed-loop -1 at A=1e+07
* PDK sky130_fd_pr__res_xhigh_po Rinv32ia W=10 L=49.614372
* tile Rinv32ia 8s x 8p same W=10 L=49.614372
XRinv32iap0s0 in32 Rinv32iat0s0 0 sky130_fd_pr__res_xhigh_po w=10 l=49.614372
XRinv32iap0s1 Rinv32iat0s0 Rinv32iat0s1 0 sky130_fd_pr__res_xhigh_po w=10 l=49.614372
XRinv32iap0s2 Rinv32iat0s1 Rinv32iat0s2 0 sky130_fd_pr__res_xhigh_po w=10 l=49.614372
XRinv32iap0s3 Rinv32iat0s2 Rinv32iat0s3 0 sky130_fd_pr__res_xhigh_po w=10 l=49.614372
XRinv32iap0s4 Rinv32iat0s3 Rinv32iat0s4 0 sky130_fd_pr__res_xhigh_po w=10 l=49.614372
XRinv32iap0s5 Rinv32iat0s4 Rinv32iat0s5 0 sky130_fd_pr__res_xhigh_po w=10 l=49.614372
XRinv32iap0s6 Rinv32iat0s5 Rinv32iat0s6 0 sky130_fd_pr__res_xhigh_po w=10 l=49.614372
XRinv32iap0s7 Rinv32iat0s6 inv32m 0 sky130_fd_pr__res_xhigh_po w=10 l=49.614372
XRinv32iap1s0 in32 Rinv32iat1s0 0 sky130_fd_pr__res_xhigh_po w=10 l=49.614372
XRinv32iap1s1 Rinv32iat1s0 Rinv32iat1s1 0 sky130_fd_pr__res_xhigh_po w=10 l=49.614372
XRinv32iap1s2 Rinv32iat1s1 Rinv32iat1s2 0 sky130_fd_pr__res_xhigh_po w=10 l=49.614372
XRinv32iap1s3 Rinv32iat1s2 Rinv32iat1s3 0 sky130_fd_pr__res_xhigh_po w=10 l=49.614372
XRinv32iap1s4 Rinv32iat1s3 Rinv32iat1s4 0 sky130_fd_pr__res_xhigh_po w=10 l=49.614372
XRinv32iap1s5 Rinv32iat1s4 Rinv32iat1s5 0 sky130_fd_pr__res_xhigh_po w=10 l=49.614372
XRinv32iap1s6 Rinv32iat1s5 Rinv32iat1s6 0 sky130_fd_pr__res_xhigh_po w=10 l=49.614372
XRinv32iap1s7 Rinv32iat1s6 inv32m 0 sky130_fd_pr__res_xhigh_po w=10 l=49.614372
XRinv32iap2s0 in32 Rinv32iat2s0 0 sky130_fd_pr__res_xhigh_po w=10 l=49.614372
XRinv32iap2s1 Rinv32iat2s0 Rinv32iat2s1 0 sky130_fd_pr__res_xhigh_po w=10 l=49.614372
XRinv32iap2s2 Rinv32iat2s1 Rinv32iat2s2 0 sky130_fd_pr__res_xhigh_po w=10 l=49.614372
XRinv32iap2s3 Rinv32iat2s2 Rinv32iat2s3 0 sky130_fd_pr__res_xhigh_po w=10 l=49.614372
XRinv32iap2s4 Rinv32iat2s3 Rinv32iat2s4 0 sky130_fd_pr__res_xhigh_po w=10 l=49.614372
XRinv32iap2s5 Rinv32iat2s4 Rinv32iat2s5 0 sky130_fd_pr__res_xhigh_po w=10 l=49.614372
XRinv32iap2s6 Rinv32iat2s5 Rinv32iat2s6 0 sky130_fd_pr__res_xhigh_po w=10 l=49.614372
XRinv32iap2s7 Rinv32iat2s6 inv32m 0 sky130_fd_pr__res_xhigh_po w=10 l=49.614372
XRinv32iap3s0 in32 Rinv32iat3s0 0 sky130_fd_pr__res_xhigh_po w=10 l=49.614372
XRinv32iap3s1 Rinv32iat3s0 Rinv32iat3s1 0 sky130_fd_pr__res_xhigh_po w=10 l=49.614372
XRinv32iap3s2 Rinv32iat3s1 Rinv32iat3s2 0 sky130_fd_pr__res_xhigh_po w=10 l=49.614372
XRinv32iap3s3 Rinv32iat3s2 Rinv32iat3s3 0 sky130_fd_pr__res_xhigh_po w=10 l=49.614372
XRinv32iap3s4 Rinv32iat3s3 Rinv32iat3s4 0 sky130_fd_pr__res_xhigh_po w=10 l=49.614372
XRinv32iap3s5 Rinv32iat3s4 Rinv32iat3s5 0 sky130_fd_pr__res_xhigh_po w=10 l=49.614372
XRinv32iap3s6 Rinv32iat3s5 Rinv32iat3s6 0 sky130_fd_pr__res_xhigh_po w=10 l=49.614372
XRinv32iap3s7 Rinv32iat3s6 inv32m 0 sky130_fd_pr__res_xhigh_po w=10 l=49.614372
XRinv32iap4s0 in32 Rinv32iat4s0 0 sky130_fd_pr__res_xhigh_po w=10 l=49.614372
XRinv32iap4s1 Rinv32iat4s0 Rinv32iat4s1 0 sky130_fd_pr__res_xhigh_po w=10 l=49.614372
XRinv32iap4s2 Rinv32iat4s1 Rinv32iat4s2 0 sky130_fd_pr__res_xhigh_po w=10 l=49.614372
XRinv32iap4s3 Rinv32iat4s2 Rinv32iat4s3 0 sky130_fd_pr__res_xhigh_po w=10 l=49.614372
XRinv32iap4s4 Rinv32iat4s3 Rinv32iat4s4 0 sky130_fd_pr__res_xhigh_po w=10 l=49.614372
XRinv32iap4s5 Rinv32iat4s4 Rinv32iat4s5 0 sky130_fd_pr__res_xhigh_po w=10 l=49.614372
XRinv32iap4s6 Rinv32iat4s5 Rinv32iat4s6 0 sky130_fd_pr__res_xhigh_po w=10 l=49.614372
XRinv32iap4s7 Rinv32iat4s6 inv32m 0 sky130_fd_pr__res_xhigh_po w=10 l=49.614372
XRinv32iap5s0 in32 Rinv32iat5s0 0 sky130_fd_pr__res_xhigh_po w=10 l=49.614372
XRinv32iap5s1 Rinv32iat5s0 Rinv32iat5s1 0 sky130_fd_pr__res_xhigh_po w=10 l=49.614372
XRinv32iap5s2 Rinv32iat5s1 Rinv32iat5s2 0 sky130_fd_pr__res_xhigh_po w=10 l=49.614372
XRinv32iap5s3 Rinv32iat5s2 Rinv32iat5s3 0 sky130_fd_pr__res_xhigh_po w=10 l=49.614372
XRinv32iap5s4 Rinv32iat5s3 Rinv32iat5s4 0 sky130_fd_pr__res_xhigh_po w=10 l=49.614372
XRinv32iap5s5 Rinv32iat5s4 Rinv32iat5s5 0 sky130_fd_pr__res_xhigh_po w=10 l=49.614372
XRinv32iap5s6 Rinv32iat5s5 Rinv32iat5s6 0 sky130_fd_pr__res_xhigh_po w=10 l=49.614372
XRinv32iap5s7 Rinv32iat5s6 inv32m 0 sky130_fd_pr__res_xhigh_po w=10 l=49.614372
XRinv32iap6s0 in32 Rinv32iat6s0 0 sky130_fd_pr__res_xhigh_po w=10 l=49.614372
XRinv32iap6s1 Rinv32iat6s0 Rinv32iat6s1 0 sky130_fd_pr__res_xhigh_po w=10 l=49.614372
XRinv32iap6s2 Rinv32iat6s1 Rinv32iat6s2 0 sky130_fd_pr__res_xhigh_po w=10 l=49.614372
XRinv32iap6s3 Rinv32iat6s2 Rinv32iat6s3 0 sky130_fd_pr__res_xhigh_po w=10 l=49.614372
XRinv32iap6s4 Rinv32iat6s3 Rinv32iat6s4 0 sky130_fd_pr__res_xhigh_po w=10 l=49.614372
XRinv32iap6s5 Rinv32iat6s4 Rinv32iat6s5 0 sky130_fd_pr__res_xhigh_po w=10 l=49.614372
XRinv32iap6s6 Rinv32iat6s5 Rinv32iat6s6 0 sky130_fd_pr__res_xhigh_po w=10 l=49.614372
XRinv32iap6s7 Rinv32iat6s6 inv32m 0 sky130_fd_pr__res_xhigh_po w=10 l=49.614372
XRinv32iap7s0 in32 Rinv32iat7s0 0 sky130_fd_pr__res_xhigh_po w=10 l=49.614372
XRinv32iap7s1 Rinv32iat7s0 Rinv32iat7s1 0 sky130_fd_pr__res_xhigh_po w=10 l=49.614372
XRinv32iap7s2 Rinv32iat7s1 Rinv32iat7s2 0 sky130_fd_pr__res_xhigh_po w=10 l=49.614372
XRinv32iap7s3 Rinv32iat7s2 Rinv32iat7s3 0 sky130_fd_pr__res_xhigh_po w=10 l=49.614372
XRinv32iap7s4 Rinv32iat7s3 Rinv32iat7s4 0 sky130_fd_pr__res_xhigh_po w=10 l=49.614372
XRinv32iap7s5 Rinv32iat7s4 Rinv32iat7s5 0 sky130_fd_pr__res_xhigh_po w=10 l=49.614372
XRinv32iap7s6 Rinv32iat7s5 Rinv32iat7s6 0 sky130_fd_pr__res_xhigh_po w=10 l=49.614372
XRinv32iap7s7 Rinv32iat7s6 inv32m 0 sky130_fd_pr__res_xhigh_po w=10 l=49.614372
* PDK sky130_fd_pr__res_xhigh_po Rinv32ib W=10 L=49.614382
* tile Rinv32ib 8s x 8p same W=10 L=49.614382
XRinv32ibp0s0 in32n Rinv32ibt0s0 0 sky130_fd_pr__res_xhigh_po w=10 l=49.614382
XRinv32ibp0s1 Rinv32ibt0s0 Rinv32ibt0s1 0 sky130_fd_pr__res_xhigh_po w=10 l=49.614382
XRinv32ibp0s2 Rinv32ibt0s1 Rinv32ibt0s2 0 sky130_fd_pr__res_xhigh_po w=10 l=49.614382
XRinv32ibp0s3 Rinv32ibt0s2 Rinv32ibt0s3 0 sky130_fd_pr__res_xhigh_po w=10 l=49.614382
XRinv32ibp0s4 Rinv32ibt0s3 Rinv32ibt0s4 0 sky130_fd_pr__res_xhigh_po w=10 l=49.614382
XRinv32ibp0s5 Rinv32ibt0s4 Rinv32ibt0s5 0 sky130_fd_pr__res_xhigh_po w=10 l=49.614382
XRinv32ibp0s6 Rinv32ibt0s5 Rinv32ibt0s6 0 sky130_fd_pr__res_xhigh_po w=10 l=49.614382
XRinv32ibp0s7 Rinv32ibt0s6 inv32m 0 sky130_fd_pr__res_xhigh_po w=10 l=49.614382
XRinv32ibp1s0 in32n Rinv32ibt1s0 0 sky130_fd_pr__res_xhigh_po w=10 l=49.614382
XRinv32ibp1s1 Rinv32ibt1s0 Rinv32ibt1s1 0 sky130_fd_pr__res_xhigh_po w=10 l=49.614382
XRinv32ibp1s2 Rinv32ibt1s1 Rinv32ibt1s2 0 sky130_fd_pr__res_xhigh_po w=10 l=49.614382
XRinv32ibp1s3 Rinv32ibt1s2 Rinv32ibt1s3 0 sky130_fd_pr__res_xhigh_po w=10 l=49.614382
XRinv32ibp1s4 Rinv32ibt1s3 Rinv32ibt1s4 0 sky130_fd_pr__res_xhigh_po w=10 l=49.614382
XRinv32ibp1s5 Rinv32ibt1s4 Rinv32ibt1s5 0 sky130_fd_pr__res_xhigh_po w=10 l=49.614382
XRinv32ibp1s6 Rinv32ibt1s5 Rinv32ibt1s6 0 sky130_fd_pr__res_xhigh_po w=10 l=49.614382
XRinv32ibp1s7 Rinv32ibt1s6 inv32m 0 sky130_fd_pr__res_xhigh_po w=10 l=49.614382
XRinv32ibp2s0 in32n Rinv32ibt2s0 0 sky130_fd_pr__res_xhigh_po w=10 l=49.614382
XRinv32ibp2s1 Rinv32ibt2s0 Rinv32ibt2s1 0 sky130_fd_pr__res_xhigh_po w=10 l=49.614382
XRinv32ibp2s2 Rinv32ibt2s1 Rinv32ibt2s2 0 sky130_fd_pr__res_xhigh_po w=10 l=49.614382
XRinv32ibp2s3 Rinv32ibt2s2 Rinv32ibt2s3 0 sky130_fd_pr__res_xhigh_po w=10 l=49.614382
XRinv32ibp2s4 Rinv32ibt2s3 Rinv32ibt2s4 0 sky130_fd_pr__res_xhigh_po w=10 l=49.614382
XRinv32ibp2s5 Rinv32ibt2s4 Rinv32ibt2s5 0 sky130_fd_pr__res_xhigh_po w=10 l=49.614382
XRinv32ibp2s6 Rinv32ibt2s5 Rinv32ibt2s6 0 sky130_fd_pr__res_xhigh_po w=10 l=49.614382
XRinv32ibp2s7 Rinv32ibt2s6 inv32m 0 sky130_fd_pr__res_xhigh_po w=10 l=49.614382
XRinv32ibp3s0 in32n Rinv32ibt3s0 0 sky130_fd_pr__res_xhigh_po w=10 l=49.614382
XRinv32ibp3s1 Rinv32ibt3s0 Rinv32ibt3s1 0 sky130_fd_pr__res_xhigh_po w=10 l=49.614382
XRinv32ibp3s2 Rinv32ibt3s1 Rinv32ibt3s2 0 sky130_fd_pr__res_xhigh_po w=10 l=49.614382
XRinv32ibp3s3 Rinv32ibt3s2 Rinv32ibt3s3 0 sky130_fd_pr__res_xhigh_po w=10 l=49.614382
XRinv32ibp3s4 Rinv32ibt3s3 Rinv32ibt3s4 0 sky130_fd_pr__res_xhigh_po w=10 l=49.614382
XRinv32ibp3s5 Rinv32ibt3s4 Rinv32ibt3s5 0 sky130_fd_pr__res_xhigh_po w=10 l=49.614382
XRinv32ibp3s6 Rinv32ibt3s5 Rinv32ibt3s6 0 sky130_fd_pr__res_xhigh_po w=10 l=49.614382
XRinv32ibp3s7 Rinv32ibt3s6 inv32m 0 sky130_fd_pr__res_xhigh_po w=10 l=49.614382
XRinv32ibp4s0 in32n Rinv32ibt4s0 0 sky130_fd_pr__res_xhigh_po w=10 l=49.614382
XRinv32ibp4s1 Rinv32ibt4s0 Rinv32ibt4s1 0 sky130_fd_pr__res_xhigh_po w=10 l=49.614382
XRinv32ibp4s2 Rinv32ibt4s1 Rinv32ibt4s2 0 sky130_fd_pr__res_xhigh_po w=10 l=49.614382
XRinv32ibp4s3 Rinv32ibt4s2 Rinv32ibt4s3 0 sky130_fd_pr__res_xhigh_po w=10 l=49.614382
XRinv32ibp4s4 Rinv32ibt4s3 Rinv32ibt4s4 0 sky130_fd_pr__res_xhigh_po w=10 l=49.614382
XRinv32ibp4s5 Rinv32ibt4s4 Rinv32ibt4s5 0 sky130_fd_pr__res_xhigh_po w=10 l=49.614382
XRinv32ibp4s6 Rinv32ibt4s5 Rinv32ibt4s6 0 sky130_fd_pr__res_xhigh_po w=10 l=49.614382
XRinv32ibp4s7 Rinv32ibt4s6 inv32m 0 sky130_fd_pr__res_xhigh_po w=10 l=49.614382
XRinv32ibp5s0 in32n Rinv32ibt5s0 0 sky130_fd_pr__res_xhigh_po w=10 l=49.614382
XRinv32ibp5s1 Rinv32ibt5s0 Rinv32ibt5s1 0 sky130_fd_pr__res_xhigh_po w=10 l=49.614382
XRinv32ibp5s2 Rinv32ibt5s1 Rinv32ibt5s2 0 sky130_fd_pr__res_xhigh_po w=10 l=49.614382
XRinv32ibp5s3 Rinv32ibt5s2 Rinv32ibt5s3 0 sky130_fd_pr__res_xhigh_po w=10 l=49.614382
XRinv32ibp5s4 Rinv32ibt5s3 Rinv32ibt5s4 0 sky130_fd_pr__res_xhigh_po w=10 l=49.614382
XRinv32ibp5s5 Rinv32ibt5s4 Rinv32ibt5s5 0 sky130_fd_pr__res_xhigh_po w=10 l=49.614382
XRinv32ibp5s6 Rinv32ibt5s5 Rinv32ibt5s6 0 sky130_fd_pr__res_xhigh_po w=10 l=49.614382
XRinv32ibp5s7 Rinv32ibt5s6 inv32m 0 sky130_fd_pr__res_xhigh_po w=10 l=49.614382
XRinv32ibp6s0 in32n Rinv32ibt6s0 0 sky130_fd_pr__res_xhigh_po w=10 l=49.614382
XRinv32ibp6s1 Rinv32ibt6s0 Rinv32ibt6s1 0 sky130_fd_pr__res_xhigh_po w=10 l=49.614382
XRinv32ibp6s2 Rinv32ibt6s1 Rinv32ibt6s2 0 sky130_fd_pr__res_xhigh_po w=10 l=49.614382
XRinv32ibp6s3 Rinv32ibt6s2 Rinv32ibt6s3 0 sky130_fd_pr__res_xhigh_po w=10 l=49.614382
XRinv32ibp6s4 Rinv32ibt6s3 Rinv32ibt6s4 0 sky130_fd_pr__res_xhigh_po w=10 l=49.614382
XRinv32ibp6s5 Rinv32ibt6s4 Rinv32ibt6s5 0 sky130_fd_pr__res_xhigh_po w=10 l=49.614382
XRinv32ibp6s6 Rinv32ibt6s5 Rinv32ibt6s6 0 sky130_fd_pr__res_xhigh_po w=10 l=49.614382
XRinv32ibp6s7 Rinv32ibt6s6 inv32m 0 sky130_fd_pr__res_xhigh_po w=10 l=49.614382
XRinv32ibp7s0 in32n Rinv32ibt7s0 0 sky130_fd_pr__res_xhigh_po w=10 l=49.614382
XRinv32ibp7s1 Rinv32ibt7s0 Rinv32ibt7s1 0 sky130_fd_pr__res_xhigh_po w=10 l=49.614382
XRinv32ibp7s2 Rinv32ibt7s1 Rinv32ibt7s2 0 sky130_fd_pr__res_xhigh_po w=10 l=49.614382
XRinv32ibp7s3 Rinv32ibt7s2 Rinv32ibt7s3 0 sky130_fd_pr__res_xhigh_po w=10 l=49.614382
XRinv32ibp7s4 Rinv32ibt7s3 Rinv32ibt7s4 0 sky130_fd_pr__res_xhigh_po w=10 l=49.614382
XRinv32ibp7s5 Rinv32ibt7s4 Rinv32ibt7s5 0 sky130_fd_pr__res_xhigh_po w=10 l=49.614382
XRinv32ibp7s6 Rinv32ibt7s5 Rinv32ibt7s6 0 sky130_fd_pr__res_xhigh_po w=10 l=49.614382
XRinv32ibp7s7 Rinv32ibt7s6 inv32m 0 sky130_fd_pr__res_xhigh_po w=10 l=49.614382
Einv32amp in32n 0 0 inv32m 10000000
Vref vref 0 DC 1
* passive invert vref -> vrefn: R2/R1=1.0000002 closed-loop -1 at A=1e+07
* PDK sky130_fd_pr__res_xhigh_po Rinvrefia W=10 L=49.614372
* tile Rinvrefia 8s x 8p same W=10 L=49.614372
XRinvrefiap0s0 vref Rinvrefiat0s0 0 sky130_fd_pr__res_xhigh_po w=10 l=49.614372
XRinvrefiap0s1 Rinvrefiat0s0 Rinvrefiat0s1 0 sky130_fd_pr__res_xhigh_po w=10 l=49.614372
XRinvrefiap0s2 Rinvrefiat0s1 Rinvrefiat0s2 0 sky130_fd_pr__res_xhigh_po w=10 l=49.614372
XRinvrefiap0s3 Rinvrefiat0s2 Rinvrefiat0s3 0 sky130_fd_pr__res_xhigh_po w=10 l=49.614372
XRinvrefiap0s4 Rinvrefiat0s3 Rinvrefiat0s4 0 sky130_fd_pr__res_xhigh_po w=10 l=49.614372
XRinvrefiap0s5 Rinvrefiat0s4 Rinvrefiat0s5 0 sky130_fd_pr__res_xhigh_po w=10 l=49.614372
XRinvrefiap0s6 Rinvrefiat0s5 Rinvrefiat0s6 0 sky130_fd_pr__res_xhigh_po w=10 l=49.614372
XRinvrefiap0s7 Rinvrefiat0s6 invrefm 0 sky130_fd_pr__res_xhigh_po w=10 l=49.614372
XRinvrefiap1s0 vref Rinvrefiat1s0 0 sky130_fd_pr__res_xhigh_po w=10 l=49.614372
XRinvrefiap1s1 Rinvrefiat1s0 Rinvrefiat1s1 0 sky130_fd_pr__res_xhigh_po w=10 l=49.614372
XRinvrefiap1s2 Rinvrefiat1s1 Rinvrefiat1s2 0 sky130_fd_pr__res_xhigh_po w=10 l=49.614372
XRinvrefiap1s3 Rinvrefiat1s2 Rinvrefiat1s3 0 sky130_fd_pr__res_xhigh_po w=10 l=49.614372
XRinvrefiap1s4 Rinvrefiat1s3 Rinvrefiat1s4 0 sky130_fd_pr__res_xhigh_po w=10 l=49.614372
XRinvrefiap1s5 Rinvrefiat1s4 Rinvrefiat1s5 0 sky130_fd_pr__res_xhigh_po w=10 l=49.614372
XRinvrefiap1s6 Rinvrefiat1s5 Rinvrefiat1s6 0 sky130_fd_pr__res_xhigh_po w=10 l=49.614372
XRinvrefiap1s7 Rinvrefiat1s6 invrefm 0 sky130_fd_pr__res_xhigh_po w=10 l=49.614372
XRinvrefiap2s0 vref Rinvrefiat2s0 0 sky130_fd_pr__res_xhigh_po w=10 l=49.614372
XRinvrefiap2s1 Rinvrefiat2s0 Rinvrefiat2s1 0 sky130_fd_pr__res_xhigh_po w=10 l=49.614372
XRinvrefiap2s2 Rinvrefiat2s1 Rinvrefiat2s2 0 sky130_fd_pr__res_xhigh_po w=10 l=49.614372
XRinvrefiap2s3 Rinvrefiat2s2 Rinvrefiat2s3 0 sky130_fd_pr__res_xhigh_po w=10 l=49.614372
XRinvrefiap2s4 Rinvrefiat2s3 Rinvrefiat2s4 0 sky130_fd_pr__res_xhigh_po w=10 l=49.614372
XRinvrefiap2s5 Rinvrefiat2s4 Rinvrefiat2s5 0 sky130_fd_pr__res_xhigh_po w=10 l=49.614372
XRinvrefiap2s6 Rinvrefiat2s5 Rinvrefiat2s6 0 sky130_fd_pr__res_xhigh_po w=10 l=49.614372
XRinvrefiap2s7 Rinvrefiat2s6 invrefm 0 sky130_fd_pr__res_xhigh_po w=10 l=49.614372
XRinvrefiap3s0 vref Rinvrefiat3s0 0 sky130_fd_pr__res_xhigh_po w=10 l=49.614372
XRinvrefiap3s1 Rinvrefiat3s0 Rinvrefiat3s1 0 sky130_fd_pr__res_xhigh_po w=10 l=49.614372
XRinvrefiap3s2 Rinvrefiat3s1 Rinvrefiat3s2 0 sky130_fd_pr__res_xhigh_po w=10 l=49.614372
XRinvrefiap3s3 Rinvrefiat3s2 Rinvrefiat3s3 0 sky130_fd_pr__res_xhigh_po w=10 l=49.614372
XRinvrefiap3s4 Rinvrefiat3s3 Rinvrefiat3s4 0 sky130_fd_pr__res_xhigh_po w=10 l=49.614372
XRinvrefiap3s5 Rinvrefiat3s4 Rinvrefiat3s5 0 sky130_fd_pr__res_xhigh_po w=10 l=49.614372
XRinvrefiap3s6 Rinvrefiat3s5 Rinvrefiat3s6 0 sky130_fd_pr__res_xhigh_po w=10 l=49.614372
XRinvrefiap3s7 Rinvrefiat3s6 invrefm 0 sky130_fd_pr__res_xhigh_po w=10 l=49.614372
XRinvrefiap4s0 vref Rinvrefiat4s0 0 sky130_fd_pr__res_xhigh_po w=10 l=49.614372
XRinvrefiap4s1 Rinvrefiat4s0 Rinvrefiat4s1 0 sky130_fd_pr__res_xhigh_po w=10 l=49.614372
XRinvrefiap4s2 Rinvrefiat4s1 Rinvrefiat4s2 0 sky130_fd_pr__res_xhigh_po w=10 l=49.614372
XRinvrefiap4s3 Rinvrefiat4s2 Rinvrefiat4s3 0 sky130_fd_pr__res_xhigh_po w=10 l=49.614372
XRinvrefiap4s4 Rinvrefiat4s3 Rinvrefiat4s4 0 sky130_fd_pr__res_xhigh_po w=10 l=49.614372
XRinvrefiap4s5 Rinvrefiat4s4 Rinvrefiat4s5 0 sky130_fd_pr__res_xhigh_po w=10 l=49.614372
XRinvrefiap4s6 Rinvrefiat4s5 Rinvrefiat4s6 0 sky130_fd_pr__res_xhigh_po w=10 l=49.614372
XRinvrefiap4s7 Rinvrefiat4s6 invrefm 0 sky130_fd_pr__res_xhigh_po w=10 l=49.614372
XRinvrefiap5s0 vref Rinvrefiat5s0 0 sky130_fd_pr__res_xhigh_po w=10 l=49.614372
XRinvrefiap5s1 Rinvrefiat5s0 Rinvrefiat5s1 0 sky130_fd_pr__res_xhigh_po w=10 l=49.614372
XRinvrefiap5s2 Rinvrefiat5s1 Rinvrefiat5s2 0 sky130_fd_pr__res_xhigh_po w=10 l=49.614372
XRinvrefiap5s3 Rinvrefiat5s2 Rinvrefiat5s3 0 sky130_fd_pr__res_xhigh_po w=10 l=49.614372
XRinvrefiap5s4 Rinvrefiat5s3 Rinvrefiat5s4 0 sky130_fd_pr__res_xhigh_po w=10 l=49.614372
XRinvrefiap5s5 Rinvrefiat5s4 Rinvrefiat5s5 0 sky130_fd_pr__res_xhigh_po w=10 l=49.614372
XRinvrefiap5s6 Rinvrefiat5s5 Rinvrefiat5s6 0 sky130_fd_pr__res_xhigh_po w=10 l=49.614372
XRinvrefiap5s7 Rinvrefiat5s6 invrefm 0 sky130_fd_pr__res_xhigh_po w=10 l=49.614372
XRinvrefiap6s0 vref Rinvrefiat6s0 0 sky130_fd_pr__res_xhigh_po w=10 l=49.614372
XRinvrefiap6s1 Rinvrefiat6s0 Rinvrefiat6s1 0 sky130_fd_pr__res_xhigh_po w=10 l=49.614372
XRinvrefiap6s2 Rinvrefiat6s1 Rinvrefiat6s2 0 sky130_fd_pr__res_xhigh_po w=10 l=49.614372
XRinvrefiap6s3 Rinvrefiat6s2 Rinvrefiat6s3 0 sky130_fd_pr__res_xhigh_po w=10 l=49.614372
XRinvrefiap6s4 Rinvrefiat6s3 Rinvrefiat6s4 0 sky130_fd_pr__res_xhigh_po w=10 l=49.614372
XRinvrefiap6s5 Rinvrefiat6s4 Rinvrefiat6s5 0 sky130_fd_pr__res_xhigh_po w=10 l=49.614372
XRinvrefiap6s6 Rinvrefiat6s5 Rinvrefiat6s6 0 sky130_fd_pr__res_xhigh_po w=10 l=49.614372
XRinvrefiap6s7 Rinvrefiat6s6 invrefm 0 sky130_fd_pr__res_xhigh_po w=10 l=49.614372
XRinvrefiap7s0 vref Rinvrefiat7s0 0 sky130_fd_pr__res_xhigh_po w=10 l=49.614372
XRinvrefiap7s1 Rinvrefiat7s0 Rinvrefiat7s1 0 sky130_fd_pr__res_xhigh_po w=10 l=49.614372
XRinvrefiap7s2 Rinvrefiat7s1 Rinvrefiat7s2 0 sky130_fd_pr__res_xhigh_po w=10 l=49.614372
XRinvrefiap7s3 Rinvrefiat7s2 Rinvrefiat7s3 0 sky130_fd_pr__res_xhigh_po w=10 l=49.614372
XRinvrefiap7s4 Rinvrefiat7s3 Rinvrefiat7s4 0 sky130_fd_pr__res_xhigh_po w=10 l=49.614372
XRinvrefiap7s5 Rinvrefiat7s4 Rinvrefiat7s5 0 sky130_fd_pr__res_xhigh_po w=10 l=49.614372
XRinvrefiap7s6 Rinvrefiat7s5 Rinvrefiat7s6 0 sky130_fd_pr__res_xhigh_po w=10 l=49.614372
XRinvrefiap7s7 Rinvrefiat7s6 invrefm 0 sky130_fd_pr__res_xhigh_po w=10 l=49.614372
* PDK sky130_fd_pr__res_xhigh_po Rinvrefib W=10 L=49.614382
* tile Rinvrefib 8s x 8p same W=10 L=49.614382
XRinvrefibp0s0 vrefn Rinvrefibt0s0 0 sky130_fd_pr__res_xhigh_po w=10 l=49.614382
XRinvrefibp0s1 Rinvrefibt0s0 Rinvrefibt0s1 0 sky130_fd_pr__res_xhigh_po w=10 l=49.614382
XRinvrefibp0s2 Rinvrefibt0s1 Rinvrefibt0s2 0 sky130_fd_pr__res_xhigh_po w=10 l=49.614382
XRinvrefibp0s3 Rinvrefibt0s2 Rinvrefibt0s3 0 sky130_fd_pr__res_xhigh_po w=10 l=49.614382
XRinvrefibp0s4 Rinvrefibt0s3 Rinvrefibt0s4 0 sky130_fd_pr__res_xhigh_po w=10 l=49.614382
XRinvrefibp0s5 Rinvrefibt0s4 Rinvrefibt0s5 0 sky130_fd_pr__res_xhigh_po w=10 l=49.614382
XRinvrefibp0s6 Rinvrefibt0s5 Rinvrefibt0s6 0 sky130_fd_pr__res_xhigh_po w=10 l=49.614382
XRinvrefibp0s7 Rinvrefibt0s6 invrefm 0 sky130_fd_pr__res_xhigh_po w=10 l=49.614382
XRinvrefibp1s0 vrefn Rinvrefibt1s0 0 sky130_fd_pr__res_xhigh_po w=10 l=49.614382
XRinvrefibp1s1 Rinvrefibt1s0 Rinvrefibt1s1 0 sky130_fd_pr__res_xhigh_po w=10 l=49.614382
XRinvrefibp1s2 Rinvrefibt1s1 Rinvrefibt1s2 0 sky130_fd_pr__res_xhigh_po w=10 l=49.614382
XRinvrefibp1s3 Rinvrefibt1s2 Rinvrefibt1s3 0 sky130_fd_pr__res_xhigh_po w=10 l=49.614382
XRinvrefibp1s4 Rinvrefibt1s3 Rinvrefibt1s4 0 sky130_fd_pr__res_xhigh_po w=10 l=49.614382
XRinvrefibp1s5 Rinvrefibt1s4 Rinvrefibt1s5 0 sky130_fd_pr__res_xhigh_po w=10 l=49.614382
XRinvrefibp1s6 Rinvrefibt1s5 Rinvrefibt1s6 0 sky130_fd_pr__res_xhigh_po w=10 l=49.614382
XRinvrefibp1s7 Rinvrefibt1s6 invrefm 0 sky130_fd_pr__res_xhigh_po w=10 l=49.614382
XRinvrefibp2s0 vrefn Rinvrefibt2s0 0 sky130_fd_pr__res_xhigh_po w=10 l=49.614382
XRinvrefibp2s1 Rinvrefibt2s0 Rinvrefibt2s1 0 sky130_fd_pr__res_xhigh_po w=10 l=49.614382
XRinvrefibp2s2 Rinvrefibt2s1 Rinvrefibt2s2 0 sky130_fd_pr__res_xhigh_po w=10 l=49.614382
XRinvrefibp2s3 Rinvrefibt2s2 Rinvrefibt2s3 0 sky130_fd_pr__res_xhigh_po w=10 l=49.614382
XRinvrefibp2s4 Rinvrefibt2s3 Rinvrefibt2s4 0 sky130_fd_pr__res_xhigh_po w=10 l=49.614382
XRinvrefibp2s5 Rinvrefibt2s4 Rinvrefibt2s5 0 sky130_fd_pr__res_xhigh_po w=10 l=49.614382
XRinvrefibp2s6 Rinvrefibt2s5 Rinvrefibt2s6 0 sky130_fd_pr__res_xhigh_po w=10 l=49.614382
XRinvrefibp2s7 Rinvrefibt2s6 invrefm 0 sky130_fd_pr__res_xhigh_po w=10 l=49.614382
XRinvrefibp3s0 vrefn Rinvrefibt3s0 0 sky130_fd_pr__res_xhigh_po w=10 l=49.614382
XRinvrefibp3s1 Rinvrefibt3s0 Rinvrefibt3s1 0 sky130_fd_pr__res_xhigh_po w=10 l=49.614382
XRinvrefibp3s2 Rinvrefibt3s1 Rinvrefibt3s2 0 sky130_fd_pr__res_xhigh_po w=10 l=49.614382
XRinvrefibp3s3 Rinvrefibt3s2 Rinvrefibt3s3 0 sky130_fd_pr__res_xhigh_po w=10 l=49.614382
XRinvrefibp3s4 Rinvrefibt3s3 Rinvrefibt3s4 0 sky130_fd_pr__res_xhigh_po w=10 l=49.614382
XRinvrefibp3s5 Rinvrefibt3s4 Rinvrefibt3s5 0 sky130_fd_pr__res_xhigh_po w=10 l=49.614382
XRinvrefibp3s6 Rinvrefibt3s5 Rinvrefibt3s6 0 sky130_fd_pr__res_xhigh_po w=10 l=49.614382
XRinvrefibp3s7 Rinvrefibt3s6 invrefm 0 sky130_fd_pr__res_xhigh_po w=10 l=49.614382
XRinvrefibp4s0 vrefn Rinvrefibt4s0 0 sky130_fd_pr__res_xhigh_po w=10 l=49.614382
XRinvrefibp4s1 Rinvrefibt4s0 Rinvrefibt4s1 0 sky130_fd_pr__res_xhigh_po w=10 l=49.614382
XRinvrefibp4s2 Rinvrefibt4s1 Rinvrefibt4s2 0 sky130_fd_pr__res_xhigh_po w=10 l=49.614382
XRinvrefibp4s3 Rinvrefibt4s2 Rinvrefibt4s3 0 sky130_fd_pr__res_xhigh_po w=10 l=49.614382
XRinvrefibp4s4 Rinvrefibt4s3 Rinvrefibt4s4 0 sky130_fd_pr__res_xhigh_po w=10 l=49.614382
XRinvrefibp4s5 Rinvrefibt4s4 Rinvrefibt4s5 0 sky130_fd_pr__res_xhigh_po w=10 l=49.614382
XRinvrefibp4s6 Rinvrefibt4s5 Rinvrefibt4s6 0 sky130_fd_pr__res_xhigh_po w=10 l=49.614382
XRinvrefibp4s7 Rinvrefibt4s6 invrefm 0 sky130_fd_pr__res_xhigh_po w=10 l=49.614382
XRinvrefibp5s0 vrefn Rinvrefibt5s0 0 sky130_fd_pr__res_xhigh_po w=10 l=49.614382
XRinvrefibp5s1 Rinvrefibt5s0 Rinvrefibt5s1 0 sky130_fd_pr__res_xhigh_po w=10 l=49.614382
XRinvrefibp5s2 Rinvrefibt5s1 Rinvrefibt5s2 0 sky130_fd_pr__res_xhigh_po w=10 l=49.614382
XRinvrefibp5s3 Rinvrefibt5s2 Rinvrefibt5s3 0 sky130_fd_pr__res_xhigh_po w=10 l=49.614382
XRinvrefibp5s4 Rinvrefibt5s3 Rinvrefibt5s4 0 sky130_fd_pr__res_xhigh_po w=10 l=49.614382
XRinvrefibp5s5 Rinvrefibt5s4 Rinvrefibt5s5 0 sky130_fd_pr__res_xhigh_po w=10 l=49.614382
XRinvrefibp5s6 Rinvrefibt5s5 Rinvrefibt5s6 0 sky130_fd_pr__res_xhigh_po w=10 l=49.614382
XRinvrefibp5s7 Rinvrefibt5s6 invrefm 0 sky130_fd_pr__res_xhigh_po w=10 l=49.614382
XRinvrefibp6s0 vrefn Rinvrefibt6s0 0 sky130_fd_pr__res_xhigh_po w=10 l=49.614382
XRinvrefibp6s1 Rinvrefibt6s0 Rinvrefibt6s1 0 sky130_fd_pr__res_xhigh_po w=10 l=49.614382
XRinvrefibp6s2 Rinvrefibt6s1 Rinvrefibt6s2 0 sky130_fd_pr__res_xhigh_po w=10 l=49.614382
XRinvrefibp6s3 Rinvrefibt6s2 Rinvrefibt6s3 0 sky130_fd_pr__res_xhigh_po w=10 l=49.614382
XRinvrefibp6s4 Rinvrefibt6s3 Rinvrefibt6s4 0 sky130_fd_pr__res_xhigh_po w=10 l=49.614382
XRinvrefibp6s5 Rinvrefibt6s4 Rinvrefibt6s5 0 sky130_fd_pr__res_xhigh_po w=10 l=49.614382
XRinvrefibp6s6 Rinvrefibt6s5 Rinvrefibt6s6 0 sky130_fd_pr__res_xhigh_po w=10 l=49.614382
XRinvrefibp6s7 Rinvrefibt6s6 invrefm 0 sky130_fd_pr__res_xhigh_po w=10 l=49.614382
XRinvrefibp7s0 vrefn Rinvrefibt7s0 0 sky130_fd_pr__res_xhigh_po w=10 l=49.614382
XRinvrefibp7s1 Rinvrefibt7s0 Rinvrefibt7s1 0 sky130_fd_pr__res_xhigh_po w=10 l=49.614382
XRinvrefibp7s2 Rinvrefibt7s1 Rinvrefibt7s2 0 sky130_fd_pr__res_xhigh_po w=10 l=49.614382
XRinvrefibp7s3 Rinvrefibt7s2 Rinvrefibt7s3 0 sky130_fd_pr__res_xhigh_po w=10 l=49.614382
XRinvrefibp7s4 Rinvrefibt7s3 Rinvrefibt7s4 0 sky130_fd_pr__res_xhigh_po w=10 l=49.614382
XRinvrefibp7s5 Rinvrefibt7s4 Rinvrefibt7s5 0 sky130_fd_pr__res_xhigh_po w=10 l=49.614382
XRinvrefibp7s6 Rinvrefibt7s5 Rinvrefibt7s6 0 sky130_fd_pr__res_xhigh_po w=10 l=49.614382
XRinvrefibp7s7 Rinvrefibt7s6 invrefm 0 sky130_fd_pr__res_xhigh_po w=10 l=49.614382
Einvrefamp vrefn 0 0 invrefm 10000000
* load-compensated divider vrefn->taprefn: G_load=0.000966391595827364 Ra=508037.159088685 Rb=1000 target beta=0.001 (no tap buffer)
* PDK sky130_fd_pr__res_xhigh_po Rdivrefna W=10 L=2525.8551
* tile Rdivrefna 8s x 8p same W=10 L=2525.8551
XRdivrefnap0s0 vrefn Rdivrefnat0s0 0 sky130_fd_pr__res_xhigh_po w=10 l=2525.8551
XRdivrefnap0s1 Rdivrefnat0s0 Rdivrefnat0s1 0 sky130_fd_pr__res_xhigh_po w=10 l=2525.8551
XRdivrefnap0s2 Rdivrefnat0s1 Rdivrefnat0s2 0 sky130_fd_pr__res_xhigh_po w=10 l=2525.8551
XRdivrefnap0s3 Rdivrefnat0s2 Rdivrefnat0s3 0 sky130_fd_pr__res_xhigh_po w=10 l=2525.8551
XRdivrefnap0s4 Rdivrefnat0s3 Rdivrefnat0s4 0 sky130_fd_pr__res_xhigh_po w=10 l=2525.8551
XRdivrefnap0s5 Rdivrefnat0s4 Rdivrefnat0s5 0 sky130_fd_pr__res_xhigh_po w=10 l=2525.8551
XRdivrefnap0s6 Rdivrefnat0s5 Rdivrefnat0s6 0 sky130_fd_pr__res_xhigh_po w=10 l=2525.8551
XRdivrefnap0s7 Rdivrefnat0s6 taprefn 0 sky130_fd_pr__res_xhigh_po w=10 l=2525.8551
XRdivrefnap1s0 vrefn Rdivrefnat1s0 0 sky130_fd_pr__res_xhigh_po w=10 l=2525.8551
XRdivrefnap1s1 Rdivrefnat1s0 Rdivrefnat1s1 0 sky130_fd_pr__res_xhigh_po w=10 l=2525.8551
XRdivrefnap1s2 Rdivrefnat1s1 Rdivrefnat1s2 0 sky130_fd_pr__res_xhigh_po w=10 l=2525.8551
XRdivrefnap1s3 Rdivrefnat1s2 Rdivrefnat1s3 0 sky130_fd_pr__res_xhigh_po w=10 l=2525.8551
XRdivrefnap1s4 Rdivrefnat1s3 Rdivrefnat1s4 0 sky130_fd_pr__res_xhigh_po w=10 l=2525.8551
XRdivrefnap1s5 Rdivrefnat1s4 Rdivrefnat1s5 0 sky130_fd_pr__res_xhigh_po w=10 l=2525.8551
XRdivrefnap1s6 Rdivrefnat1s5 Rdivrefnat1s6 0 sky130_fd_pr__res_xhigh_po w=10 l=2525.8551
XRdivrefnap1s7 Rdivrefnat1s6 taprefn 0 sky130_fd_pr__res_xhigh_po w=10 l=2525.8551
XRdivrefnap2s0 vrefn Rdivrefnat2s0 0 sky130_fd_pr__res_xhigh_po w=10 l=2525.8551
XRdivrefnap2s1 Rdivrefnat2s0 Rdivrefnat2s1 0 sky130_fd_pr__res_xhigh_po w=10 l=2525.8551
XRdivrefnap2s2 Rdivrefnat2s1 Rdivrefnat2s2 0 sky130_fd_pr__res_xhigh_po w=10 l=2525.8551
XRdivrefnap2s3 Rdivrefnat2s2 Rdivrefnat2s3 0 sky130_fd_pr__res_xhigh_po w=10 l=2525.8551
XRdivrefnap2s4 Rdivrefnat2s3 Rdivrefnat2s4 0 sky130_fd_pr__res_xhigh_po w=10 l=2525.8551
XRdivrefnap2s5 Rdivrefnat2s4 Rdivrefnat2s5 0 sky130_fd_pr__res_xhigh_po w=10 l=2525.8551
XRdivrefnap2s6 Rdivrefnat2s5 Rdivrefnat2s6 0 sky130_fd_pr__res_xhigh_po w=10 l=2525.8551
XRdivrefnap2s7 Rdivrefnat2s6 taprefn 0 sky130_fd_pr__res_xhigh_po w=10 l=2525.8551
XRdivrefnap3s0 vrefn Rdivrefnat3s0 0 sky130_fd_pr__res_xhigh_po w=10 l=2525.8551
XRdivrefnap3s1 Rdivrefnat3s0 Rdivrefnat3s1 0 sky130_fd_pr__res_xhigh_po w=10 l=2525.8551
XRdivrefnap3s2 Rdivrefnat3s1 Rdivrefnat3s2 0 sky130_fd_pr__res_xhigh_po w=10 l=2525.8551
XRdivrefnap3s3 Rdivrefnat3s2 Rdivrefnat3s3 0 sky130_fd_pr__res_xhigh_po w=10 l=2525.8551
XRdivrefnap3s4 Rdivrefnat3s3 Rdivrefnat3s4 0 sky130_fd_pr__res_xhigh_po w=10 l=2525.8551
XRdivrefnap3s5 Rdivrefnat3s4 Rdivrefnat3s5 0 sky130_fd_pr__res_xhigh_po w=10 l=2525.8551
XRdivrefnap3s6 Rdivrefnat3s5 Rdivrefnat3s6 0 sky130_fd_pr__res_xhigh_po w=10 l=2525.8551
XRdivrefnap3s7 Rdivrefnat3s6 taprefn 0 sky130_fd_pr__res_xhigh_po w=10 l=2525.8551
XRdivrefnap4s0 vrefn Rdivrefnat4s0 0 sky130_fd_pr__res_xhigh_po w=10 l=2525.8551
XRdivrefnap4s1 Rdivrefnat4s0 Rdivrefnat4s1 0 sky130_fd_pr__res_xhigh_po w=10 l=2525.8551
XRdivrefnap4s2 Rdivrefnat4s1 Rdivrefnat4s2 0 sky130_fd_pr__res_xhigh_po w=10 l=2525.8551
XRdivrefnap4s3 Rdivrefnat4s2 Rdivrefnat4s3 0 sky130_fd_pr__res_xhigh_po w=10 l=2525.8551
XRdivrefnap4s4 Rdivrefnat4s3 Rdivrefnat4s4 0 sky130_fd_pr__res_xhigh_po w=10 l=2525.8551
XRdivrefnap4s5 Rdivrefnat4s4 Rdivrefnat4s5 0 sky130_fd_pr__res_xhigh_po w=10 l=2525.8551
XRdivrefnap4s6 Rdivrefnat4s5 Rdivrefnat4s6 0 sky130_fd_pr__res_xhigh_po w=10 l=2525.8551
XRdivrefnap4s7 Rdivrefnat4s6 taprefn 0 sky130_fd_pr__res_xhigh_po w=10 l=2525.8551
XRdivrefnap5s0 vrefn Rdivrefnat5s0 0 sky130_fd_pr__res_xhigh_po w=10 l=2525.8551
XRdivrefnap5s1 Rdivrefnat5s0 Rdivrefnat5s1 0 sky130_fd_pr__res_xhigh_po w=10 l=2525.8551
XRdivrefnap5s2 Rdivrefnat5s1 Rdivrefnat5s2 0 sky130_fd_pr__res_xhigh_po w=10 l=2525.8551
XRdivrefnap5s3 Rdivrefnat5s2 Rdivrefnat5s3 0 sky130_fd_pr__res_xhigh_po w=10 l=2525.8551
XRdivrefnap5s4 Rdivrefnat5s3 Rdivrefnat5s4 0 sky130_fd_pr__res_xhigh_po w=10 l=2525.8551
XRdivrefnap5s5 Rdivrefnat5s4 Rdivrefnat5s5 0 sky130_fd_pr__res_xhigh_po w=10 l=2525.8551
XRdivrefnap5s6 Rdivrefnat5s5 Rdivrefnat5s6 0 sky130_fd_pr__res_xhigh_po w=10 l=2525.8551
XRdivrefnap5s7 Rdivrefnat5s6 taprefn 0 sky130_fd_pr__res_xhigh_po w=10 l=2525.8551
XRdivrefnap6s0 vrefn Rdivrefnat6s0 0 sky130_fd_pr__res_xhigh_po w=10 l=2525.8551
XRdivrefnap6s1 Rdivrefnat6s0 Rdivrefnat6s1 0 sky130_fd_pr__res_xhigh_po w=10 l=2525.8551
XRdivrefnap6s2 Rdivrefnat6s1 Rdivrefnat6s2 0 sky130_fd_pr__res_xhigh_po w=10 l=2525.8551
XRdivrefnap6s3 Rdivrefnat6s2 Rdivrefnat6s3 0 sky130_fd_pr__res_xhigh_po w=10 l=2525.8551
XRdivrefnap6s4 Rdivrefnat6s3 Rdivrefnat6s4 0 sky130_fd_pr__res_xhigh_po w=10 l=2525.8551
XRdivrefnap6s5 Rdivrefnat6s4 Rdivrefnat6s5 0 sky130_fd_pr__res_xhigh_po w=10 l=2525.8551
XRdivrefnap6s6 Rdivrefnat6s5 Rdivrefnat6s6 0 sky130_fd_pr__res_xhigh_po w=10 l=2525.8551
XRdivrefnap6s7 Rdivrefnat6s6 taprefn 0 sky130_fd_pr__res_xhigh_po w=10 l=2525.8551
XRdivrefnap7s0 vrefn Rdivrefnat7s0 0 sky130_fd_pr__res_xhigh_po w=10 l=2525.8551
XRdivrefnap7s1 Rdivrefnat7s0 Rdivrefnat7s1 0 sky130_fd_pr__res_xhigh_po w=10 l=2525.8551
XRdivrefnap7s2 Rdivrefnat7s1 Rdivrefnat7s2 0 sky130_fd_pr__res_xhigh_po w=10 l=2525.8551
XRdivrefnap7s3 Rdivrefnat7s2 Rdivrefnat7s3 0 sky130_fd_pr__res_xhigh_po w=10 l=2525.8551
XRdivrefnap7s4 Rdivrefnat7s3 Rdivrefnat7s4 0 sky130_fd_pr__res_xhigh_po w=10 l=2525.8551
XRdivrefnap7s5 Rdivrefnat7s4 Rdivrefnat7s5 0 sky130_fd_pr__res_xhigh_po w=10 l=2525.8551
XRdivrefnap7s6 Rdivrefnat7s5 Rdivrefnat7s6 0 sky130_fd_pr__res_xhigh_po w=10 l=2525.8551
XRdivrefnap7s7 Rdivrefnat7s6 taprefn 0 sky130_fd_pr__res_xhigh_po w=10 l=2525.8551
* PDK sky130_fd_pr__res_xhigh_po Rdivrefnb W=10 L=4.8663717
* tile Rdivrefnb 8s x 8p same W=10 L=4.8663717
XRdivrefnbp0s0 taprefn Rdivrefnbt0s0 0 sky130_fd_pr__res_xhigh_po w=10 l=4.8663717
XRdivrefnbp0s1 Rdivrefnbt0s0 Rdivrefnbt0s1 0 sky130_fd_pr__res_xhigh_po w=10 l=4.8663717
XRdivrefnbp0s2 Rdivrefnbt0s1 Rdivrefnbt0s2 0 sky130_fd_pr__res_xhigh_po w=10 l=4.8663717
XRdivrefnbp0s3 Rdivrefnbt0s2 Rdivrefnbt0s3 0 sky130_fd_pr__res_xhigh_po w=10 l=4.8663717
XRdivrefnbp0s4 Rdivrefnbt0s3 Rdivrefnbt0s4 0 sky130_fd_pr__res_xhigh_po w=10 l=4.8663717
XRdivrefnbp0s5 Rdivrefnbt0s4 Rdivrefnbt0s5 0 sky130_fd_pr__res_xhigh_po w=10 l=4.8663717
XRdivrefnbp0s6 Rdivrefnbt0s5 Rdivrefnbt0s6 0 sky130_fd_pr__res_xhigh_po w=10 l=4.8663717
XRdivrefnbp0s7 Rdivrefnbt0s6 0 0 sky130_fd_pr__res_xhigh_po w=10 l=4.8663717
XRdivrefnbp1s0 taprefn Rdivrefnbt1s0 0 sky130_fd_pr__res_xhigh_po w=10 l=4.8663717
XRdivrefnbp1s1 Rdivrefnbt1s0 Rdivrefnbt1s1 0 sky130_fd_pr__res_xhigh_po w=10 l=4.8663717
XRdivrefnbp1s2 Rdivrefnbt1s1 Rdivrefnbt1s2 0 sky130_fd_pr__res_xhigh_po w=10 l=4.8663717
XRdivrefnbp1s3 Rdivrefnbt1s2 Rdivrefnbt1s3 0 sky130_fd_pr__res_xhigh_po w=10 l=4.8663717
XRdivrefnbp1s4 Rdivrefnbt1s3 Rdivrefnbt1s4 0 sky130_fd_pr__res_xhigh_po w=10 l=4.8663717
XRdivrefnbp1s5 Rdivrefnbt1s4 Rdivrefnbt1s5 0 sky130_fd_pr__res_xhigh_po w=10 l=4.8663717
XRdivrefnbp1s6 Rdivrefnbt1s5 Rdivrefnbt1s6 0 sky130_fd_pr__res_xhigh_po w=10 l=4.8663717
XRdivrefnbp1s7 Rdivrefnbt1s6 0 0 sky130_fd_pr__res_xhigh_po w=10 l=4.8663717
XRdivrefnbp2s0 taprefn Rdivrefnbt2s0 0 sky130_fd_pr__res_xhigh_po w=10 l=4.8663717
XRdivrefnbp2s1 Rdivrefnbt2s0 Rdivrefnbt2s1 0 sky130_fd_pr__res_xhigh_po w=10 l=4.8663717
XRdivrefnbp2s2 Rdivrefnbt2s1 Rdivrefnbt2s2 0 sky130_fd_pr__res_xhigh_po w=10 l=4.8663717
XRdivrefnbp2s3 Rdivrefnbt2s2 Rdivrefnbt2s3 0 sky130_fd_pr__res_xhigh_po w=10 l=4.8663717
XRdivrefnbp2s4 Rdivrefnbt2s3 Rdivrefnbt2s4 0 sky130_fd_pr__res_xhigh_po w=10 l=4.8663717
XRdivrefnbp2s5 Rdivrefnbt2s4 Rdivrefnbt2s5 0 sky130_fd_pr__res_xhigh_po w=10 l=4.8663717
XRdivrefnbp2s6 Rdivrefnbt2s5 Rdivrefnbt2s6 0 sky130_fd_pr__res_xhigh_po w=10 l=4.8663717
XRdivrefnbp2s7 Rdivrefnbt2s6 0 0 sky130_fd_pr__res_xhigh_po w=10 l=4.8663717
XRdivrefnbp3s0 taprefn Rdivrefnbt3s0 0 sky130_fd_pr__res_xhigh_po w=10 l=4.8663717
XRdivrefnbp3s1 Rdivrefnbt3s0 Rdivrefnbt3s1 0 sky130_fd_pr__res_xhigh_po w=10 l=4.8663717
XRdivrefnbp3s2 Rdivrefnbt3s1 Rdivrefnbt3s2 0 sky130_fd_pr__res_xhigh_po w=10 l=4.8663717
XRdivrefnbp3s3 Rdivrefnbt3s2 Rdivrefnbt3s3 0 sky130_fd_pr__res_xhigh_po w=10 l=4.8663717
XRdivrefnbp3s4 Rdivrefnbt3s3 Rdivrefnbt3s4 0 sky130_fd_pr__res_xhigh_po w=10 l=4.8663717
XRdivrefnbp3s5 Rdivrefnbt3s4 Rdivrefnbt3s5 0 sky130_fd_pr__res_xhigh_po w=10 l=4.8663717
XRdivrefnbp3s6 Rdivrefnbt3s5 Rdivrefnbt3s6 0 sky130_fd_pr__res_xhigh_po w=10 l=4.8663717
XRdivrefnbp3s7 Rdivrefnbt3s6 0 0 sky130_fd_pr__res_xhigh_po w=10 l=4.8663717
XRdivrefnbp4s0 taprefn Rdivrefnbt4s0 0 sky130_fd_pr__res_xhigh_po w=10 l=4.8663717
XRdivrefnbp4s1 Rdivrefnbt4s0 Rdivrefnbt4s1 0 sky130_fd_pr__res_xhigh_po w=10 l=4.8663717
XRdivrefnbp4s2 Rdivrefnbt4s1 Rdivrefnbt4s2 0 sky130_fd_pr__res_xhigh_po w=10 l=4.8663717
XRdivrefnbp4s3 Rdivrefnbt4s2 Rdivrefnbt4s3 0 sky130_fd_pr__res_xhigh_po w=10 l=4.8663717
XRdivrefnbp4s4 Rdivrefnbt4s3 Rdivrefnbt4s4 0 sky130_fd_pr__res_xhigh_po w=10 l=4.8663717
XRdivrefnbp4s5 Rdivrefnbt4s4 Rdivrefnbt4s5 0 sky130_fd_pr__res_xhigh_po w=10 l=4.8663717
XRdivrefnbp4s6 Rdivrefnbt4s5 Rdivrefnbt4s6 0 sky130_fd_pr__res_xhigh_po w=10 l=4.8663717
XRdivrefnbp4s7 Rdivrefnbt4s6 0 0 sky130_fd_pr__res_xhigh_po w=10 l=4.8663717
XRdivrefnbp5s0 taprefn Rdivrefnbt5s0 0 sky130_fd_pr__res_xhigh_po w=10 l=4.8663717
XRdivrefnbp5s1 Rdivrefnbt5s0 Rdivrefnbt5s1 0 sky130_fd_pr__res_xhigh_po w=10 l=4.8663717
XRdivrefnbp5s2 Rdivrefnbt5s1 Rdivrefnbt5s2 0 sky130_fd_pr__res_xhigh_po w=10 l=4.8663717
XRdivrefnbp5s3 Rdivrefnbt5s2 Rdivrefnbt5s3 0 sky130_fd_pr__res_xhigh_po w=10 l=4.8663717
XRdivrefnbp5s4 Rdivrefnbt5s3 Rdivrefnbt5s4 0 sky130_fd_pr__res_xhigh_po w=10 l=4.8663717
XRdivrefnbp5s5 Rdivrefnbt5s4 Rdivrefnbt5s5 0 sky130_fd_pr__res_xhigh_po w=10 l=4.8663717
XRdivrefnbp5s6 Rdivrefnbt5s5 Rdivrefnbt5s6 0 sky130_fd_pr__res_xhigh_po w=10 l=4.8663717
XRdivrefnbp5s7 Rdivrefnbt5s6 0 0 sky130_fd_pr__res_xhigh_po w=10 l=4.8663717
XRdivrefnbp6s0 taprefn Rdivrefnbt6s0 0 sky130_fd_pr__res_xhigh_po w=10 l=4.8663717
XRdivrefnbp6s1 Rdivrefnbt6s0 Rdivrefnbt6s1 0 sky130_fd_pr__res_xhigh_po w=10 l=4.8663717
XRdivrefnbp6s2 Rdivrefnbt6s1 Rdivrefnbt6s2 0 sky130_fd_pr__res_xhigh_po w=10 l=4.8663717
XRdivrefnbp6s3 Rdivrefnbt6s2 Rdivrefnbt6s3 0 sky130_fd_pr__res_xhigh_po w=10 l=4.8663717
XRdivrefnbp6s4 Rdivrefnbt6s3 Rdivrefnbt6s4 0 sky130_fd_pr__res_xhigh_po w=10 l=4.8663717
XRdivrefnbp6s5 Rdivrefnbt6s4 Rdivrefnbt6s5 0 sky130_fd_pr__res_xhigh_po w=10 l=4.8663717
XRdivrefnbp6s6 Rdivrefnbt6s5 Rdivrefnbt6s6 0 sky130_fd_pr__res_xhigh_po w=10 l=4.8663717
XRdivrefnbp6s7 Rdivrefnbt6s6 0 0 sky130_fd_pr__res_xhigh_po w=10 l=4.8663717
XRdivrefnbp7s0 taprefn Rdivrefnbt7s0 0 sky130_fd_pr__res_xhigh_po w=10 l=4.8663717
XRdivrefnbp7s1 Rdivrefnbt7s0 Rdivrefnbt7s1 0 sky130_fd_pr__res_xhigh_po w=10 l=4.8663717
XRdivrefnbp7s2 Rdivrefnbt7s1 Rdivrefnbt7s2 0 sky130_fd_pr__res_xhigh_po w=10 l=4.8663717
XRdivrefnbp7s3 Rdivrefnbt7s2 Rdivrefnbt7s3 0 sky130_fd_pr__res_xhigh_po w=10 l=4.8663717
XRdivrefnbp7s4 Rdivrefnbt7s3 Rdivrefnbt7s4 0 sky130_fd_pr__res_xhigh_po w=10 l=4.8663717
XRdivrefnbp7s5 Rdivrefnbt7s4 Rdivrefnbt7s5 0 sky130_fd_pr__res_xhigh_po w=10 l=4.8663717
XRdivrefnbp7s6 Rdivrefnbt7s5 Rdivrefnbt7s6 0 sky130_fd_pr__res_xhigh_po w=10 l=4.8663717
XRdivrefnbp7s7 Rdivrefnbt7s6 0 0 sky130_fd_pr__res_xhigh_po w=10 l=4.8663717

* n1 input 1 w=-0.195521390350609 w-  bank=n alpha=1 R=170484.330505015 G_phys=5.86564171051827e-06 G_eff=5.86564171051827e-06
* PDK sky130_fd_pr__res_xhigh_po Rn1n1n1 W=10 L=847.54246
* tile Rn1n1n1 8s x 8p same W=10 L=847.54246
XRn1n1n1p0s0 in1 Rn1n1n1t0s0 0 sky130_fd_pr__res_xhigh_po w=10 l=847.54246
XRn1n1n1p0s1 Rn1n1n1t0s0 Rn1n1n1t0s1 0 sky130_fd_pr__res_xhigh_po w=10 l=847.54246
XRn1n1n1p0s2 Rn1n1n1t0s1 Rn1n1n1t0s2 0 sky130_fd_pr__res_xhigh_po w=10 l=847.54246
XRn1n1n1p0s3 Rn1n1n1t0s2 Rn1n1n1t0s3 0 sky130_fd_pr__res_xhigh_po w=10 l=847.54246
XRn1n1n1p0s4 Rn1n1n1t0s3 Rn1n1n1t0s4 0 sky130_fd_pr__res_xhigh_po w=10 l=847.54246
XRn1n1n1p0s5 Rn1n1n1t0s4 Rn1n1n1t0s5 0 sky130_fd_pr__res_xhigh_po w=10 l=847.54246
XRn1n1n1p0s6 Rn1n1n1t0s5 Rn1n1n1t0s6 0 sky130_fd_pr__res_xhigh_po w=10 l=847.54246
XRn1n1n1p0s7 Rn1n1n1t0s6 n1p 0 sky130_fd_pr__res_xhigh_po w=10 l=847.54246
XRn1n1n1p1s0 in1 Rn1n1n1t1s0 0 sky130_fd_pr__res_xhigh_po w=10 l=847.54246
XRn1n1n1p1s1 Rn1n1n1t1s0 Rn1n1n1t1s1 0 sky130_fd_pr__res_xhigh_po w=10 l=847.54246
XRn1n1n1p1s2 Rn1n1n1t1s1 Rn1n1n1t1s2 0 sky130_fd_pr__res_xhigh_po w=10 l=847.54246
XRn1n1n1p1s3 Rn1n1n1t1s2 Rn1n1n1t1s3 0 sky130_fd_pr__res_xhigh_po w=10 l=847.54246
XRn1n1n1p1s4 Rn1n1n1t1s3 Rn1n1n1t1s4 0 sky130_fd_pr__res_xhigh_po w=10 l=847.54246
XRn1n1n1p1s5 Rn1n1n1t1s4 Rn1n1n1t1s5 0 sky130_fd_pr__res_xhigh_po w=10 l=847.54246
XRn1n1n1p1s6 Rn1n1n1t1s5 Rn1n1n1t1s6 0 sky130_fd_pr__res_xhigh_po w=10 l=847.54246
XRn1n1n1p1s7 Rn1n1n1t1s6 n1p 0 sky130_fd_pr__res_xhigh_po w=10 l=847.54246
XRn1n1n1p2s0 in1 Rn1n1n1t2s0 0 sky130_fd_pr__res_xhigh_po w=10 l=847.54246
XRn1n1n1p2s1 Rn1n1n1t2s0 Rn1n1n1t2s1 0 sky130_fd_pr__res_xhigh_po w=10 l=847.54246
XRn1n1n1p2s2 Rn1n1n1t2s1 Rn1n1n1t2s2 0 sky130_fd_pr__res_xhigh_po w=10 l=847.54246
XRn1n1n1p2s3 Rn1n1n1t2s2 Rn1n1n1t2s3 0 sky130_fd_pr__res_xhigh_po w=10 l=847.54246
XRn1n1n1p2s4 Rn1n1n1t2s3 Rn1n1n1t2s4 0 sky130_fd_pr__res_xhigh_po w=10 l=847.54246
XRn1n1n1p2s5 Rn1n1n1t2s4 Rn1n1n1t2s5 0 sky130_fd_pr__res_xhigh_po w=10 l=847.54246
XRn1n1n1p2s6 Rn1n1n1t2s5 Rn1n1n1t2s6 0 sky130_fd_pr__res_xhigh_po w=10 l=847.54246
XRn1n1n1p2s7 Rn1n1n1t2s6 n1p 0 sky130_fd_pr__res_xhigh_po w=10 l=847.54246
XRn1n1n1p3s0 in1 Rn1n1n1t3s0 0 sky130_fd_pr__res_xhigh_po w=10 l=847.54246
XRn1n1n1p3s1 Rn1n1n1t3s0 Rn1n1n1t3s1 0 sky130_fd_pr__res_xhigh_po w=10 l=847.54246
XRn1n1n1p3s2 Rn1n1n1t3s1 Rn1n1n1t3s2 0 sky130_fd_pr__res_xhigh_po w=10 l=847.54246
XRn1n1n1p3s3 Rn1n1n1t3s2 Rn1n1n1t3s3 0 sky130_fd_pr__res_xhigh_po w=10 l=847.54246
XRn1n1n1p3s4 Rn1n1n1t3s3 Rn1n1n1t3s4 0 sky130_fd_pr__res_xhigh_po w=10 l=847.54246
XRn1n1n1p3s5 Rn1n1n1t3s4 Rn1n1n1t3s5 0 sky130_fd_pr__res_xhigh_po w=10 l=847.54246
XRn1n1n1p3s6 Rn1n1n1t3s5 Rn1n1n1t3s6 0 sky130_fd_pr__res_xhigh_po w=10 l=847.54246
XRn1n1n1p3s7 Rn1n1n1t3s6 n1p 0 sky130_fd_pr__res_xhigh_po w=10 l=847.54246
XRn1n1n1p4s0 in1 Rn1n1n1t4s0 0 sky130_fd_pr__res_xhigh_po w=10 l=847.54246
XRn1n1n1p4s1 Rn1n1n1t4s0 Rn1n1n1t4s1 0 sky130_fd_pr__res_xhigh_po w=10 l=847.54246
XRn1n1n1p4s2 Rn1n1n1t4s1 Rn1n1n1t4s2 0 sky130_fd_pr__res_xhigh_po w=10 l=847.54246
XRn1n1n1p4s3 Rn1n1n1t4s2 Rn1n1n1t4s3 0 sky130_fd_pr__res_xhigh_po w=10 l=847.54246
XRn1n1n1p4s4 Rn1n1n1t4s3 Rn1n1n1t4s4 0 sky130_fd_pr__res_xhigh_po w=10 l=847.54246
XRn1n1n1p4s5 Rn1n1n1t4s4 Rn1n1n1t4s5 0 sky130_fd_pr__res_xhigh_po w=10 l=847.54246
XRn1n1n1p4s6 Rn1n1n1t4s5 Rn1n1n1t4s6 0 sky130_fd_pr__res_xhigh_po w=10 l=847.54246
XRn1n1n1p4s7 Rn1n1n1t4s6 n1p 0 sky130_fd_pr__res_xhigh_po w=10 l=847.54246
XRn1n1n1p5s0 in1 Rn1n1n1t5s0 0 sky130_fd_pr__res_xhigh_po w=10 l=847.54246
XRn1n1n1p5s1 Rn1n1n1t5s0 Rn1n1n1t5s1 0 sky130_fd_pr__res_xhigh_po w=10 l=847.54246
XRn1n1n1p5s2 Rn1n1n1t5s1 Rn1n1n1t5s2 0 sky130_fd_pr__res_xhigh_po w=10 l=847.54246
XRn1n1n1p5s3 Rn1n1n1t5s2 Rn1n1n1t5s3 0 sky130_fd_pr__res_xhigh_po w=10 l=847.54246
XRn1n1n1p5s4 Rn1n1n1t5s3 Rn1n1n1t5s4 0 sky130_fd_pr__res_xhigh_po w=10 l=847.54246
XRn1n1n1p5s5 Rn1n1n1t5s4 Rn1n1n1t5s5 0 sky130_fd_pr__res_xhigh_po w=10 l=847.54246
XRn1n1n1p5s6 Rn1n1n1t5s5 Rn1n1n1t5s6 0 sky130_fd_pr__res_xhigh_po w=10 l=847.54246
XRn1n1n1p5s7 Rn1n1n1t5s6 n1p 0 sky130_fd_pr__res_xhigh_po w=10 l=847.54246
XRn1n1n1p6s0 in1 Rn1n1n1t6s0 0 sky130_fd_pr__res_xhigh_po w=10 l=847.54246
XRn1n1n1p6s1 Rn1n1n1t6s0 Rn1n1n1t6s1 0 sky130_fd_pr__res_xhigh_po w=10 l=847.54246
XRn1n1n1p6s2 Rn1n1n1t6s1 Rn1n1n1t6s2 0 sky130_fd_pr__res_xhigh_po w=10 l=847.54246
XRn1n1n1p6s3 Rn1n1n1t6s2 Rn1n1n1t6s3 0 sky130_fd_pr__res_xhigh_po w=10 l=847.54246
XRn1n1n1p6s4 Rn1n1n1t6s3 Rn1n1n1t6s4 0 sky130_fd_pr__res_xhigh_po w=10 l=847.54246
XRn1n1n1p6s5 Rn1n1n1t6s4 Rn1n1n1t6s5 0 sky130_fd_pr__res_xhigh_po w=10 l=847.54246
XRn1n1n1p6s6 Rn1n1n1t6s5 Rn1n1n1t6s6 0 sky130_fd_pr__res_xhigh_po w=10 l=847.54246
XRn1n1n1p6s7 Rn1n1n1t6s6 n1p 0 sky130_fd_pr__res_xhigh_po w=10 l=847.54246
XRn1n1n1p7s0 in1 Rn1n1n1t7s0 0 sky130_fd_pr__res_xhigh_po w=10 l=847.54246
XRn1n1n1p7s1 Rn1n1n1t7s0 Rn1n1n1t7s1 0 sky130_fd_pr__res_xhigh_po w=10 l=847.54246
XRn1n1n1p7s2 Rn1n1n1t7s1 Rn1n1n1t7s2 0 sky130_fd_pr__res_xhigh_po w=10 l=847.54246
XRn1n1n1p7s3 Rn1n1n1t7s2 Rn1n1n1t7s3 0 sky130_fd_pr__res_xhigh_po w=10 l=847.54246
XRn1n1n1p7s4 Rn1n1n1t7s3 Rn1n1n1t7s4 0 sky130_fd_pr__res_xhigh_po w=10 l=847.54246
XRn1n1n1p7s5 Rn1n1n1t7s4 Rn1n1n1t7s5 0 sky130_fd_pr__res_xhigh_po w=10 l=847.54246
XRn1n1n1p7s6 Rn1n1n1t7s5 Rn1n1n1t7s6 0 sky130_fd_pr__res_xhigh_po w=10 l=847.54246
XRn1n1n1p7s7 Rn1n1n1t7s6 n1p 0 sky130_fd_pr__res_xhigh_po w=10 l=847.54246
* n1 input 2 w=+0.386445174905558 w+  bank=n alpha=1 R=86256.3061926689 G_phys=1.15933552471668e-05 G_eff=1.15933552471668e-05
* PDK sky130_fd_pr__res_xhigh_po Rn1p2n1 W=10 L=428.76073
* tile Rn1p2n1 8s x 8p same W=10 L=428.76073
XRn1p2n1p0s0 in2n Rn1p2n1t0s0 0 sky130_fd_pr__res_xhigh_po w=10 l=428.76073
XRn1p2n1p0s1 Rn1p2n1t0s0 Rn1p2n1t0s1 0 sky130_fd_pr__res_xhigh_po w=10 l=428.76073
XRn1p2n1p0s2 Rn1p2n1t0s1 Rn1p2n1t0s2 0 sky130_fd_pr__res_xhigh_po w=10 l=428.76073
XRn1p2n1p0s3 Rn1p2n1t0s2 Rn1p2n1t0s3 0 sky130_fd_pr__res_xhigh_po w=10 l=428.76073
XRn1p2n1p0s4 Rn1p2n1t0s3 Rn1p2n1t0s4 0 sky130_fd_pr__res_xhigh_po w=10 l=428.76073
XRn1p2n1p0s5 Rn1p2n1t0s4 Rn1p2n1t0s5 0 sky130_fd_pr__res_xhigh_po w=10 l=428.76073
XRn1p2n1p0s6 Rn1p2n1t0s5 Rn1p2n1t0s6 0 sky130_fd_pr__res_xhigh_po w=10 l=428.76073
XRn1p2n1p0s7 Rn1p2n1t0s6 n1p 0 sky130_fd_pr__res_xhigh_po w=10 l=428.76073
XRn1p2n1p1s0 in2n Rn1p2n1t1s0 0 sky130_fd_pr__res_xhigh_po w=10 l=428.76073
XRn1p2n1p1s1 Rn1p2n1t1s0 Rn1p2n1t1s1 0 sky130_fd_pr__res_xhigh_po w=10 l=428.76073
XRn1p2n1p1s2 Rn1p2n1t1s1 Rn1p2n1t1s2 0 sky130_fd_pr__res_xhigh_po w=10 l=428.76073
XRn1p2n1p1s3 Rn1p2n1t1s2 Rn1p2n1t1s3 0 sky130_fd_pr__res_xhigh_po w=10 l=428.76073
XRn1p2n1p1s4 Rn1p2n1t1s3 Rn1p2n1t1s4 0 sky130_fd_pr__res_xhigh_po w=10 l=428.76073
XRn1p2n1p1s5 Rn1p2n1t1s4 Rn1p2n1t1s5 0 sky130_fd_pr__res_xhigh_po w=10 l=428.76073
XRn1p2n1p1s6 Rn1p2n1t1s5 Rn1p2n1t1s6 0 sky130_fd_pr__res_xhigh_po w=10 l=428.76073
XRn1p2n1p1s7 Rn1p2n1t1s6 n1p 0 sky130_fd_pr__res_xhigh_po w=10 l=428.76073
XRn1p2n1p2s0 in2n Rn1p2n1t2s0 0 sky130_fd_pr__res_xhigh_po w=10 l=428.76073
XRn1p2n1p2s1 Rn1p2n1t2s0 Rn1p2n1t2s1 0 sky130_fd_pr__res_xhigh_po w=10 l=428.76073
XRn1p2n1p2s2 Rn1p2n1t2s1 Rn1p2n1t2s2 0 sky130_fd_pr__res_xhigh_po w=10 l=428.76073
XRn1p2n1p2s3 Rn1p2n1t2s2 Rn1p2n1t2s3 0 sky130_fd_pr__res_xhigh_po w=10 l=428.76073
XRn1p2n1p2s4 Rn1p2n1t2s3 Rn1p2n1t2s4 0 sky130_fd_pr__res_xhigh_po w=10 l=428.76073
XRn1p2n1p2s5 Rn1p2n1t2s4 Rn1p2n1t2s5 0 sky130_fd_pr__res_xhigh_po w=10 l=428.76073
XRn1p2n1p2s6 Rn1p2n1t2s5 Rn1p2n1t2s6 0 sky130_fd_pr__res_xhigh_po w=10 l=428.76073
XRn1p2n1p2s7 Rn1p2n1t2s6 n1p 0 sky130_fd_pr__res_xhigh_po w=10 l=428.76073
XRn1p2n1p3s0 in2n Rn1p2n1t3s0 0 sky130_fd_pr__res_xhigh_po w=10 l=428.76073
XRn1p2n1p3s1 Rn1p2n1t3s0 Rn1p2n1t3s1 0 sky130_fd_pr__res_xhigh_po w=10 l=428.76073
XRn1p2n1p3s2 Rn1p2n1t3s1 Rn1p2n1t3s2 0 sky130_fd_pr__res_xhigh_po w=10 l=428.76073
XRn1p2n1p3s3 Rn1p2n1t3s2 Rn1p2n1t3s3 0 sky130_fd_pr__res_xhigh_po w=10 l=428.76073
XRn1p2n1p3s4 Rn1p2n1t3s3 Rn1p2n1t3s4 0 sky130_fd_pr__res_xhigh_po w=10 l=428.76073
XRn1p2n1p3s5 Rn1p2n1t3s4 Rn1p2n1t3s5 0 sky130_fd_pr__res_xhigh_po w=10 l=428.76073
XRn1p2n1p3s6 Rn1p2n1t3s5 Rn1p2n1t3s6 0 sky130_fd_pr__res_xhigh_po w=10 l=428.76073
XRn1p2n1p3s7 Rn1p2n1t3s6 n1p 0 sky130_fd_pr__res_xhigh_po w=10 l=428.76073
XRn1p2n1p4s0 in2n Rn1p2n1t4s0 0 sky130_fd_pr__res_xhigh_po w=10 l=428.76073
XRn1p2n1p4s1 Rn1p2n1t4s0 Rn1p2n1t4s1 0 sky130_fd_pr__res_xhigh_po w=10 l=428.76073
XRn1p2n1p4s2 Rn1p2n1t4s1 Rn1p2n1t4s2 0 sky130_fd_pr__res_xhigh_po w=10 l=428.76073
XRn1p2n1p4s3 Rn1p2n1t4s2 Rn1p2n1t4s3 0 sky130_fd_pr__res_xhigh_po w=10 l=428.76073
XRn1p2n1p4s4 Rn1p2n1t4s3 Rn1p2n1t4s4 0 sky130_fd_pr__res_xhigh_po w=10 l=428.76073
XRn1p2n1p4s5 Rn1p2n1t4s4 Rn1p2n1t4s5 0 sky130_fd_pr__res_xhigh_po w=10 l=428.76073
XRn1p2n1p4s6 Rn1p2n1t4s5 Rn1p2n1t4s6 0 sky130_fd_pr__res_xhigh_po w=10 l=428.76073
XRn1p2n1p4s7 Rn1p2n1t4s6 n1p 0 sky130_fd_pr__res_xhigh_po w=10 l=428.76073
XRn1p2n1p5s0 in2n Rn1p2n1t5s0 0 sky130_fd_pr__res_xhigh_po w=10 l=428.76073
XRn1p2n1p5s1 Rn1p2n1t5s0 Rn1p2n1t5s1 0 sky130_fd_pr__res_xhigh_po w=10 l=428.76073
XRn1p2n1p5s2 Rn1p2n1t5s1 Rn1p2n1t5s2 0 sky130_fd_pr__res_xhigh_po w=10 l=428.76073
XRn1p2n1p5s3 Rn1p2n1t5s2 Rn1p2n1t5s3 0 sky130_fd_pr__res_xhigh_po w=10 l=428.76073
XRn1p2n1p5s4 Rn1p2n1t5s3 Rn1p2n1t5s4 0 sky130_fd_pr__res_xhigh_po w=10 l=428.76073
XRn1p2n1p5s5 Rn1p2n1t5s4 Rn1p2n1t5s5 0 sky130_fd_pr__res_xhigh_po w=10 l=428.76073
XRn1p2n1p5s6 Rn1p2n1t5s5 Rn1p2n1t5s6 0 sky130_fd_pr__res_xhigh_po w=10 l=428.76073
XRn1p2n1p5s7 Rn1p2n1t5s6 n1p 0 sky130_fd_pr__res_xhigh_po w=10 l=428.76073
XRn1p2n1p6s0 in2n Rn1p2n1t6s0 0 sky130_fd_pr__res_xhigh_po w=10 l=428.76073
XRn1p2n1p6s1 Rn1p2n1t6s0 Rn1p2n1t6s1 0 sky130_fd_pr__res_xhigh_po w=10 l=428.76073
XRn1p2n1p6s2 Rn1p2n1t6s1 Rn1p2n1t6s2 0 sky130_fd_pr__res_xhigh_po w=10 l=428.76073
XRn1p2n1p6s3 Rn1p2n1t6s2 Rn1p2n1t6s3 0 sky130_fd_pr__res_xhigh_po w=10 l=428.76073
XRn1p2n1p6s4 Rn1p2n1t6s3 Rn1p2n1t6s4 0 sky130_fd_pr__res_xhigh_po w=10 l=428.76073
XRn1p2n1p6s5 Rn1p2n1t6s4 Rn1p2n1t6s5 0 sky130_fd_pr__res_xhigh_po w=10 l=428.76073
XRn1p2n1p6s6 Rn1p2n1t6s5 Rn1p2n1t6s6 0 sky130_fd_pr__res_xhigh_po w=10 l=428.76073
XRn1p2n1p6s7 Rn1p2n1t6s6 n1p 0 sky130_fd_pr__res_xhigh_po w=10 l=428.76073
XRn1p2n1p7s0 in2n Rn1p2n1t7s0 0 sky130_fd_pr__res_xhigh_po w=10 l=428.76073
XRn1p2n1p7s1 Rn1p2n1t7s0 Rn1p2n1t7s1 0 sky130_fd_pr__res_xhigh_po w=10 l=428.76073
XRn1p2n1p7s2 Rn1p2n1t7s1 Rn1p2n1t7s2 0 sky130_fd_pr__res_xhigh_po w=10 l=428.76073
XRn1p2n1p7s3 Rn1p2n1t7s2 Rn1p2n1t7s3 0 sky130_fd_pr__res_xhigh_po w=10 l=428.76073
XRn1p2n1p7s4 Rn1p2n1t7s3 Rn1p2n1t7s4 0 sky130_fd_pr__res_xhigh_po w=10 l=428.76073
XRn1p2n1p7s5 Rn1p2n1t7s4 Rn1p2n1t7s5 0 sky130_fd_pr__res_xhigh_po w=10 l=428.76073
XRn1p2n1p7s6 Rn1p2n1t7s5 Rn1p2n1t7s6 0 sky130_fd_pr__res_xhigh_po w=10 l=428.76073
XRn1p2n1p7s7 Rn1p2n1t7s6 n1p 0 sky130_fd_pr__res_xhigh_po w=10 l=428.76073
* n1 input 3 w=+0.296294588630229 w+  bank=n alpha=1 R=112500.648383197 G_phys=8.88883765890688e-06 G_eff=8.88883765890688e-06
* PDK sky130_fd_pr__res_xhigh_po Rn1p3n1 W=10 L=559.2476
* tile Rn1p3n1 8s x 8p same W=10 L=559.2476
XRn1p3n1p0s0 in3n Rn1p3n1t0s0 0 sky130_fd_pr__res_xhigh_po w=10 l=559.2476
XRn1p3n1p0s1 Rn1p3n1t0s0 Rn1p3n1t0s1 0 sky130_fd_pr__res_xhigh_po w=10 l=559.2476
XRn1p3n1p0s2 Rn1p3n1t0s1 Rn1p3n1t0s2 0 sky130_fd_pr__res_xhigh_po w=10 l=559.2476
XRn1p3n1p0s3 Rn1p3n1t0s2 Rn1p3n1t0s3 0 sky130_fd_pr__res_xhigh_po w=10 l=559.2476
XRn1p3n1p0s4 Rn1p3n1t0s3 Rn1p3n1t0s4 0 sky130_fd_pr__res_xhigh_po w=10 l=559.2476
XRn1p3n1p0s5 Rn1p3n1t0s4 Rn1p3n1t0s5 0 sky130_fd_pr__res_xhigh_po w=10 l=559.2476
XRn1p3n1p0s6 Rn1p3n1t0s5 Rn1p3n1t0s6 0 sky130_fd_pr__res_xhigh_po w=10 l=559.2476
XRn1p3n1p0s7 Rn1p3n1t0s6 n1p 0 sky130_fd_pr__res_xhigh_po w=10 l=559.2476
XRn1p3n1p1s0 in3n Rn1p3n1t1s0 0 sky130_fd_pr__res_xhigh_po w=10 l=559.2476
XRn1p3n1p1s1 Rn1p3n1t1s0 Rn1p3n1t1s1 0 sky130_fd_pr__res_xhigh_po w=10 l=559.2476
XRn1p3n1p1s2 Rn1p3n1t1s1 Rn1p3n1t1s2 0 sky130_fd_pr__res_xhigh_po w=10 l=559.2476
XRn1p3n1p1s3 Rn1p3n1t1s2 Rn1p3n1t1s3 0 sky130_fd_pr__res_xhigh_po w=10 l=559.2476
XRn1p3n1p1s4 Rn1p3n1t1s3 Rn1p3n1t1s4 0 sky130_fd_pr__res_xhigh_po w=10 l=559.2476
XRn1p3n1p1s5 Rn1p3n1t1s4 Rn1p3n1t1s5 0 sky130_fd_pr__res_xhigh_po w=10 l=559.2476
XRn1p3n1p1s6 Rn1p3n1t1s5 Rn1p3n1t1s6 0 sky130_fd_pr__res_xhigh_po w=10 l=559.2476
XRn1p3n1p1s7 Rn1p3n1t1s6 n1p 0 sky130_fd_pr__res_xhigh_po w=10 l=559.2476
XRn1p3n1p2s0 in3n Rn1p3n1t2s0 0 sky130_fd_pr__res_xhigh_po w=10 l=559.2476
XRn1p3n1p2s1 Rn1p3n1t2s0 Rn1p3n1t2s1 0 sky130_fd_pr__res_xhigh_po w=10 l=559.2476
XRn1p3n1p2s2 Rn1p3n1t2s1 Rn1p3n1t2s2 0 sky130_fd_pr__res_xhigh_po w=10 l=559.2476
XRn1p3n1p2s3 Rn1p3n1t2s2 Rn1p3n1t2s3 0 sky130_fd_pr__res_xhigh_po w=10 l=559.2476
XRn1p3n1p2s4 Rn1p3n1t2s3 Rn1p3n1t2s4 0 sky130_fd_pr__res_xhigh_po w=10 l=559.2476
XRn1p3n1p2s5 Rn1p3n1t2s4 Rn1p3n1t2s5 0 sky130_fd_pr__res_xhigh_po w=10 l=559.2476
XRn1p3n1p2s6 Rn1p3n1t2s5 Rn1p3n1t2s6 0 sky130_fd_pr__res_xhigh_po w=10 l=559.2476
XRn1p3n1p2s7 Rn1p3n1t2s6 n1p 0 sky130_fd_pr__res_xhigh_po w=10 l=559.2476
XRn1p3n1p3s0 in3n Rn1p3n1t3s0 0 sky130_fd_pr__res_xhigh_po w=10 l=559.2476
XRn1p3n1p3s1 Rn1p3n1t3s0 Rn1p3n1t3s1 0 sky130_fd_pr__res_xhigh_po w=10 l=559.2476
XRn1p3n1p3s2 Rn1p3n1t3s1 Rn1p3n1t3s2 0 sky130_fd_pr__res_xhigh_po w=10 l=559.2476
XRn1p3n1p3s3 Rn1p3n1t3s2 Rn1p3n1t3s3 0 sky130_fd_pr__res_xhigh_po w=10 l=559.2476
XRn1p3n1p3s4 Rn1p3n1t3s3 Rn1p3n1t3s4 0 sky130_fd_pr__res_xhigh_po w=10 l=559.2476
XRn1p3n1p3s5 Rn1p3n1t3s4 Rn1p3n1t3s5 0 sky130_fd_pr__res_xhigh_po w=10 l=559.2476
XRn1p3n1p3s6 Rn1p3n1t3s5 Rn1p3n1t3s6 0 sky130_fd_pr__res_xhigh_po w=10 l=559.2476
XRn1p3n1p3s7 Rn1p3n1t3s6 n1p 0 sky130_fd_pr__res_xhigh_po w=10 l=559.2476
XRn1p3n1p4s0 in3n Rn1p3n1t4s0 0 sky130_fd_pr__res_xhigh_po w=10 l=559.2476
XRn1p3n1p4s1 Rn1p3n1t4s0 Rn1p3n1t4s1 0 sky130_fd_pr__res_xhigh_po w=10 l=559.2476
XRn1p3n1p4s2 Rn1p3n1t4s1 Rn1p3n1t4s2 0 sky130_fd_pr__res_xhigh_po w=10 l=559.2476
XRn1p3n1p4s3 Rn1p3n1t4s2 Rn1p3n1t4s3 0 sky130_fd_pr__res_xhigh_po w=10 l=559.2476
XRn1p3n1p4s4 Rn1p3n1t4s3 Rn1p3n1t4s4 0 sky130_fd_pr__res_xhigh_po w=10 l=559.2476
XRn1p3n1p4s5 Rn1p3n1t4s4 Rn1p3n1t4s5 0 sky130_fd_pr__res_xhigh_po w=10 l=559.2476
XRn1p3n1p4s6 Rn1p3n1t4s5 Rn1p3n1t4s6 0 sky130_fd_pr__res_xhigh_po w=10 l=559.2476
XRn1p3n1p4s7 Rn1p3n1t4s6 n1p 0 sky130_fd_pr__res_xhigh_po w=10 l=559.2476
XRn1p3n1p5s0 in3n Rn1p3n1t5s0 0 sky130_fd_pr__res_xhigh_po w=10 l=559.2476
XRn1p3n1p5s1 Rn1p3n1t5s0 Rn1p3n1t5s1 0 sky130_fd_pr__res_xhigh_po w=10 l=559.2476
XRn1p3n1p5s2 Rn1p3n1t5s1 Rn1p3n1t5s2 0 sky130_fd_pr__res_xhigh_po w=10 l=559.2476
XRn1p3n1p5s3 Rn1p3n1t5s2 Rn1p3n1t5s3 0 sky130_fd_pr__res_xhigh_po w=10 l=559.2476
XRn1p3n1p5s4 Rn1p3n1t5s3 Rn1p3n1t5s4 0 sky130_fd_pr__res_xhigh_po w=10 l=559.2476
XRn1p3n1p5s5 Rn1p3n1t5s4 Rn1p3n1t5s5 0 sky130_fd_pr__res_xhigh_po w=10 l=559.2476
XRn1p3n1p5s6 Rn1p3n1t5s5 Rn1p3n1t5s6 0 sky130_fd_pr__res_xhigh_po w=10 l=559.2476
XRn1p3n1p5s7 Rn1p3n1t5s6 n1p 0 sky130_fd_pr__res_xhigh_po w=10 l=559.2476
XRn1p3n1p6s0 in3n Rn1p3n1t6s0 0 sky130_fd_pr__res_xhigh_po w=10 l=559.2476
XRn1p3n1p6s1 Rn1p3n1t6s0 Rn1p3n1t6s1 0 sky130_fd_pr__res_xhigh_po w=10 l=559.2476
XRn1p3n1p6s2 Rn1p3n1t6s1 Rn1p3n1t6s2 0 sky130_fd_pr__res_xhigh_po w=10 l=559.2476
XRn1p3n1p6s3 Rn1p3n1t6s2 Rn1p3n1t6s3 0 sky130_fd_pr__res_xhigh_po w=10 l=559.2476
XRn1p3n1p6s4 Rn1p3n1t6s3 Rn1p3n1t6s4 0 sky130_fd_pr__res_xhigh_po w=10 l=559.2476
XRn1p3n1p6s5 Rn1p3n1t6s4 Rn1p3n1t6s5 0 sky130_fd_pr__res_xhigh_po w=10 l=559.2476
XRn1p3n1p6s6 Rn1p3n1t6s5 Rn1p3n1t6s6 0 sky130_fd_pr__res_xhigh_po w=10 l=559.2476
XRn1p3n1p6s7 Rn1p3n1t6s6 n1p 0 sky130_fd_pr__res_xhigh_po w=10 l=559.2476
XRn1p3n1p7s0 in3n Rn1p3n1t7s0 0 sky130_fd_pr__res_xhigh_po w=10 l=559.2476
XRn1p3n1p7s1 Rn1p3n1t7s0 Rn1p3n1t7s1 0 sky130_fd_pr__res_xhigh_po w=10 l=559.2476
XRn1p3n1p7s2 Rn1p3n1t7s1 Rn1p3n1t7s2 0 sky130_fd_pr__res_xhigh_po w=10 l=559.2476
XRn1p3n1p7s3 Rn1p3n1t7s2 Rn1p3n1t7s3 0 sky130_fd_pr__res_xhigh_po w=10 l=559.2476
XRn1p3n1p7s4 Rn1p3n1t7s3 Rn1p3n1t7s4 0 sky130_fd_pr__res_xhigh_po w=10 l=559.2476
XRn1p3n1p7s5 Rn1p3n1t7s4 Rn1p3n1t7s5 0 sky130_fd_pr__res_xhigh_po w=10 l=559.2476
XRn1p3n1p7s6 Rn1p3n1t7s5 Rn1p3n1t7s6 0 sky130_fd_pr__res_xhigh_po w=10 l=559.2476
XRn1p3n1p7s7 Rn1p3n1t7s6 n1p 0 sky130_fd_pr__res_xhigh_po w=10 l=559.2476
* n1 input 4 w=-0.299308681857295 w-  bank=n alpha=1 R=111367.746256108 G_phys=8.97926045571886e-06 G_eff=8.97926045571886e-06
* PDK sky130_fd_pr__res_xhigh_po Rn1n4n1 W=10 L=553.61481
* tile Rn1n4n1 8s x 8p same W=10 L=553.61481
XRn1n4n1p0s0 in4 Rn1n4n1t0s0 0 sky130_fd_pr__res_xhigh_po w=10 l=553.61481
XRn1n4n1p0s1 Rn1n4n1t0s0 Rn1n4n1t0s1 0 sky130_fd_pr__res_xhigh_po w=10 l=553.61481
XRn1n4n1p0s2 Rn1n4n1t0s1 Rn1n4n1t0s2 0 sky130_fd_pr__res_xhigh_po w=10 l=553.61481
XRn1n4n1p0s3 Rn1n4n1t0s2 Rn1n4n1t0s3 0 sky130_fd_pr__res_xhigh_po w=10 l=553.61481
XRn1n4n1p0s4 Rn1n4n1t0s3 Rn1n4n1t0s4 0 sky130_fd_pr__res_xhigh_po w=10 l=553.61481
XRn1n4n1p0s5 Rn1n4n1t0s4 Rn1n4n1t0s5 0 sky130_fd_pr__res_xhigh_po w=10 l=553.61481
XRn1n4n1p0s6 Rn1n4n1t0s5 Rn1n4n1t0s6 0 sky130_fd_pr__res_xhigh_po w=10 l=553.61481
XRn1n4n1p0s7 Rn1n4n1t0s6 n1p 0 sky130_fd_pr__res_xhigh_po w=10 l=553.61481
XRn1n4n1p1s0 in4 Rn1n4n1t1s0 0 sky130_fd_pr__res_xhigh_po w=10 l=553.61481
XRn1n4n1p1s1 Rn1n4n1t1s0 Rn1n4n1t1s1 0 sky130_fd_pr__res_xhigh_po w=10 l=553.61481
XRn1n4n1p1s2 Rn1n4n1t1s1 Rn1n4n1t1s2 0 sky130_fd_pr__res_xhigh_po w=10 l=553.61481
XRn1n4n1p1s3 Rn1n4n1t1s2 Rn1n4n1t1s3 0 sky130_fd_pr__res_xhigh_po w=10 l=553.61481
XRn1n4n1p1s4 Rn1n4n1t1s3 Rn1n4n1t1s4 0 sky130_fd_pr__res_xhigh_po w=10 l=553.61481
XRn1n4n1p1s5 Rn1n4n1t1s4 Rn1n4n1t1s5 0 sky130_fd_pr__res_xhigh_po w=10 l=553.61481
XRn1n4n1p1s6 Rn1n4n1t1s5 Rn1n4n1t1s6 0 sky130_fd_pr__res_xhigh_po w=10 l=553.61481
XRn1n4n1p1s7 Rn1n4n1t1s6 n1p 0 sky130_fd_pr__res_xhigh_po w=10 l=553.61481
XRn1n4n1p2s0 in4 Rn1n4n1t2s0 0 sky130_fd_pr__res_xhigh_po w=10 l=553.61481
XRn1n4n1p2s1 Rn1n4n1t2s0 Rn1n4n1t2s1 0 sky130_fd_pr__res_xhigh_po w=10 l=553.61481
XRn1n4n1p2s2 Rn1n4n1t2s1 Rn1n4n1t2s2 0 sky130_fd_pr__res_xhigh_po w=10 l=553.61481
XRn1n4n1p2s3 Rn1n4n1t2s2 Rn1n4n1t2s3 0 sky130_fd_pr__res_xhigh_po w=10 l=553.61481
XRn1n4n1p2s4 Rn1n4n1t2s3 Rn1n4n1t2s4 0 sky130_fd_pr__res_xhigh_po w=10 l=553.61481
XRn1n4n1p2s5 Rn1n4n1t2s4 Rn1n4n1t2s5 0 sky130_fd_pr__res_xhigh_po w=10 l=553.61481
XRn1n4n1p2s6 Rn1n4n1t2s5 Rn1n4n1t2s6 0 sky130_fd_pr__res_xhigh_po w=10 l=553.61481
XRn1n4n1p2s7 Rn1n4n1t2s6 n1p 0 sky130_fd_pr__res_xhigh_po w=10 l=553.61481
XRn1n4n1p3s0 in4 Rn1n4n1t3s0 0 sky130_fd_pr__res_xhigh_po w=10 l=553.61481
XRn1n4n1p3s1 Rn1n4n1t3s0 Rn1n4n1t3s1 0 sky130_fd_pr__res_xhigh_po w=10 l=553.61481
XRn1n4n1p3s2 Rn1n4n1t3s1 Rn1n4n1t3s2 0 sky130_fd_pr__res_xhigh_po w=10 l=553.61481
XRn1n4n1p3s3 Rn1n4n1t3s2 Rn1n4n1t3s3 0 sky130_fd_pr__res_xhigh_po w=10 l=553.61481
XRn1n4n1p3s4 Rn1n4n1t3s3 Rn1n4n1t3s4 0 sky130_fd_pr__res_xhigh_po w=10 l=553.61481
XRn1n4n1p3s5 Rn1n4n1t3s4 Rn1n4n1t3s5 0 sky130_fd_pr__res_xhigh_po w=10 l=553.61481
XRn1n4n1p3s6 Rn1n4n1t3s5 Rn1n4n1t3s6 0 sky130_fd_pr__res_xhigh_po w=10 l=553.61481
XRn1n4n1p3s7 Rn1n4n1t3s6 n1p 0 sky130_fd_pr__res_xhigh_po w=10 l=553.61481
XRn1n4n1p4s0 in4 Rn1n4n1t4s0 0 sky130_fd_pr__res_xhigh_po w=10 l=553.61481
XRn1n4n1p4s1 Rn1n4n1t4s0 Rn1n4n1t4s1 0 sky130_fd_pr__res_xhigh_po w=10 l=553.61481
XRn1n4n1p4s2 Rn1n4n1t4s1 Rn1n4n1t4s2 0 sky130_fd_pr__res_xhigh_po w=10 l=553.61481
XRn1n4n1p4s3 Rn1n4n1t4s2 Rn1n4n1t4s3 0 sky130_fd_pr__res_xhigh_po w=10 l=553.61481
XRn1n4n1p4s4 Rn1n4n1t4s3 Rn1n4n1t4s4 0 sky130_fd_pr__res_xhigh_po w=10 l=553.61481
XRn1n4n1p4s5 Rn1n4n1t4s4 Rn1n4n1t4s5 0 sky130_fd_pr__res_xhigh_po w=10 l=553.61481
XRn1n4n1p4s6 Rn1n4n1t4s5 Rn1n4n1t4s6 0 sky130_fd_pr__res_xhigh_po w=10 l=553.61481
XRn1n4n1p4s7 Rn1n4n1t4s6 n1p 0 sky130_fd_pr__res_xhigh_po w=10 l=553.61481
XRn1n4n1p5s0 in4 Rn1n4n1t5s0 0 sky130_fd_pr__res_xhigh_po w=10 l=553.61481
XRn1n4n1p5s1 Rn1n4n1t5s0 Rn1n4n1t5s1 0 sky130_fd_pr__res_xhigh_po w=10 l=553.61481
XRn1n4n1p5s2 Rn1n4n1t5s1 Rn1n4n1t5s2 0 sky130_fd_pr__res_xhigh_po w=10 l=553.61481
XRn1n4n1p5s3 Rn1n4n1t5s2 Rn1n4n1t5s3 0 sky130_fd_pr__res_xhigh_po w=10 l=553.61481
XRn1n4n1p5s4 Rn1n4n1t5s3 Rn1n4n1t5s4 0 sky130_fd_pr__res_xhigh_po w=10 l=553.61481
XRn1n4n1p5s5 Rn1n4n1t5s4 Rn1n4n1t5s5 0 sky130_fd_pr__res_xhigh_po w=10 l=553.61481
XRn1n4n1p5s6 Rn1n4n1t5s5 Rn1n4n1t5s6 0 sky130_fd_pr__res_xhigh_po w=10 l=553.61481
XRn1n4n1p5s7 Rn1n4n1t5s6 n1p 0 sky130_fd_pr__res_xhigh_po w=10 l=553.61481
XRn1n4n1p6s0 in4 Rn1n4n1t6s0 0 sky130_fd_pr__res_xhigh_po w=10 l=553.61481
XRn1n4n1p6s1 Rn1n4n1t6s0 Rn1n4n1t6s1 0 sky130_fd_pr__res_xhigh_po w=10 l=553.61481
XRn1n4n1p6s2 Rn1n4n1t6s1 Rn1n4n1t6s2 0 sky130_fd_pr__res_xhigh_po w=10 l=553.61481
XRn1n4n1p6s3 Rn1n4n1t6s2 Rn1n4n1t6s3 0 sky130_fd_pr__res_xhigh_po w=10 l=553.61481
XRn1n4n1p6s4 Rn1n4n1t6s3 Rn1n4n1t6s4 0 sky130_fd_pr__res_xhigh_po w=10 l=553.61481
XRn1n4n1p6s5 Rn1n4n1t6s4 Rn1n4n1t6s5 0 sky130_fd_pr__res_xhigh_po w=10 l=553.61481
XRn1n4n1p6s6 Rn1n4n1t6s5 Rn1n4n1t6s6 0 sky130_fd_pr__res_xhigh_po w=10 l=553.61481
XRn1n4n1p6s7 Rn1n4n1t6s6 n1p 0 sky130_fd_pr__res_xhigh_po w=10 l=553.61481
XRn1n4n1p7s0 in4 Rn1n4n1t7s0 0 sky130_fd_pr__res_xhigh_po w=10 l=553.61481
XRn1n4n1p7s1 Rn1n4n1t7s0 Rn1n4n1t7s1 0 sky130_fd_pr__res_xhigh_po w=10 l=553.61481
XRn1n4n1p7s2 Rn1n4n1t7s1 Rn1n4n1t7s2 0 sky130_fd_pr__res_xhigh_po w=10 l=553.61481
XRn1n4n1p7s3 Rn1n4n1t7s2 Rn1n4n1t7s3 0 sky130_fd_pr__res_xhigh_po w=10 l=553.61481
XRn1n4n1p7s4 Rn1n4n1t7s3 Rn1n4n1t7s4 0 sky130_fd_pr__res_xhigh_po w=10 l=553.61481
XRn1n4n1p7s5 Rn1n4n1t7s4 Rn1n4n1t7s5 0 sky130_fd_pr__res_xhigh_po w=10 l=553.61481
XRn1n4n1p7s6 Rn1n4n1t7s5 Rn1n4n1t7s6 0 sky130_fd_pr__res_xhigh_po w=10 l=553.61481
XRn1n4n1p7s7 Rn1n4n1t7s6 n1p 0 sky130_fd_pr__res_xhigh_po w=10 l=553.61481
* n1 input 5 w=+0.732671792857329 w+  bank=n alpha=1 R=45495.5870531571 G_phys=2.19801537857199e-05 G_eff=2.19801537857199e-05
* PDK sky130_fd_pr__res_xhigh_po Rn1p5n1 W=10 L=226.09843
* tile Rn1p5n1 8s x 8p same W=10 L=226.09843
XRn1p5n1p0s0 in5n Rn1p5n1t0s0 0 sky130_fd_pr__res_xhigh_po w=10 l=226.09843
XRn1p5n1p0s1 Rn1p5n1t0s0 Rn1p5n1t0s1 0 sky130_fd_pr__res_xhigh_po w=10 l=226.09843
XRn1p5n1p0s2 Rn1p5n1t0s1 Rn1p5n1t0s2 0 sky130_fd_pr__res_xhigh_po w=10 l=226.09843
XRn1p5n1p0s3 Rn1p5n1t0s2 Rn1p5n1t0s3 0 sky130_fd_pr__res_xhigh_po w=10 l=226.09843
XRn1p5n1p0s4 Rn1p5n1t0s3 Rn1p5n1t0s4 0 sky130_fd_pr__res_xhigh_po w=10 l=226.09843
XRn1p5n1p0s5 Rn1p5n1t0s4 Rn1p5n1t0s5 0 sky130_fd_pr__res_xhigh_po w=10 l=226.09843
XRn1p5n1p0s6 Rn1p5n1t0s5 Rn1p5n1t0s6 0 sky130_fd_pr__res_xhigh_po w=10 l=226.09843
XRn1p5n1p0s7 Rn1p5n1t0s6 n1p 0 sky130_fd_pr__res_xhigh_po w=10 l=226.09843
XRn1p5n1p1s0 in5n Rn1p5n1t1s0 0 sky130_fd_pr__res_xhigh_po w=10 l=226.09843
XRn1p5n1p1s1 Rn1p5n1t1s0 Rn1p5n1t1s1 0 sky130_fd_pr__res_xhigh_po w=10 l=226.09843
XRn1p5n1p1s2 Rn1p5n1t1s1 Rn1p5n1t1s2 0 sky130_fd_pr__res_xhigh_po w=10 l=226.09843
XRn1p5n1p1s3 Rn1p5n1t1s2 Rn1p5n1t1s3 0 sky130_fd_pr__res_xhigh_po w=10 l=226.09843
XRn1p5n1p1s4 Rn1p5n1t1s3 Rn1p5n1t1s4 0 sky130_fd_pr__res_xhigh_po w=10 l=226.09843
XRn1p5n1p1s5 Rn1p5n1t1s4 Rn1p5n1t1s5 0 sky130_fd_pr__res_xhigh_po w=10 l=226.09843
XRn1p5n1p1s6 Rn1p5n1t1s5 Rn1p5n1t1s6 0 sky130_fd_pr__res_xhigh_po w=10 l=226.09843
XRn1p5n1p1s7 Rn1p5n1t1s6 n1p 0 sky130_fd_pr__res_xhigh_po w=10 l=226.09843
XRn1p5n1p2s0 in5n Rn1p5n1t2s0 0 sky130_fd_pr__res_xhigh_po w=10 l=226.09843
XRn1p5n1p2s1 Rn1p5n1t2s0 Rn1p5n1t2s1 0 sky130_fd_pr__res_xhigh_po w=10 l=226.09843
XRn1p5n1p2s2 Rn1p5n1t2s1 Rn1p5n1t2s2 0 sky130_fd_pr__res_xhigh_po w=10 l=226.09843
XRn1p5n1p2s3 Rn1p5n1t2s2 Rn1p5n1t2s3 0 sky130_fd_pr__res_xhigh_po w=10 l=226.09843
XRn1p5n1p2s4 Rn1p5n1t2s3 Rn1p5n1t2s4 0 sky130_fd_pr__res_xhigh_po w=10 l=226.09843
XRn1p5n1p2s5 Rn1p5n1t2s4 Rn1p5n1t2s5 0 sky130_fd_pr__res_xhigh_po w=10 l=226.09843
XRn1p5n1p2s6 Rn1p5n1t2s5 Rn1p5n1t2s6 0 sky130_fd_pr__res_xhigh_po w=10 l=226.09843
XRn1p5n1p2s7 Rn1p5n1t2s6 n1p 0 sky130_fd_pr__res_xhigh_po w=10 l=226.09843
XRn1p5n1p3s0 in5n Rn1p5n1t3s0 0 sky130_fd_pr__res_xhigh_po w=10 l=226.09843
XRn1p5n1p3s1 Rn1p5n1t3s0 Rn1p5n1t3s1 0 sky130_fd_pr__res_xhigh_po w=10 l=226.09843
XRn1p5n1p3s2 Rn1p5n1t3s1 Rn1p5n1t3s2 0 sky130_fd_pr__res_xhigh_po w=10 l=226.09843
XRn1p5n1p3s3 Rn1p5n1t3s2 Rn1p5n1t3s3 0 sky130_fd_pr__res_xhigh_po w=10 l=226.09843
XRn1p5n1p3s4 Rn1p5n1t3s3 Rn1p5n1t3s4 0 sky130_fd_pr__res_xhigh_po w=10 l=226.09843
XRn1p5n1p3s5 Rn1p5n1t3s4 Rn1p5n1t3s5 0 sky130_fd_pr__res_xhigh_po w=10 l=226.09843
XRn1p5n1p3s6 Rn1p5n1t3s5 Rn1p5n1t3s6 0 sky130_fd_pr__res_xhigh_po w=10 l=226.09843
XRn1p5n1p3s7 Rn1p5n1t3s6 n1p 0 sky130_fd_pr__res_xhigh_po w=10 l=226.09843
XRn1p5n1p4s0 in5n Rn1p5n1t4s0 0 sky130_fd_pr__res_xhigh_po w=10 l=226.09843
XRn1p5n1p4s1 Rn1p5n1t4s0 Rn1p5n1t4s1 0 sky130_fd_pr__res_xhigh_po w=10 l=226.09843
XRn1p5n1p4s2 Rn1p5n1t4s1 Rn1p5n1t4s2 0 sky130_fd_pr__res_xhigh_po w=10 l=226.09843
XRn1p5n1p4s3 Rn1p5n1t4s2 Rn1p5n1t4s3 0 sky130_fd_pr__res_xhigh_po w=10 l=226.09843
XRn1p5n1p4s4 Rn1p5n1t4s3 Rn1p5n1t4s4 0 sky130_fd_pr__res_xhigh_po w=10 l=226.09843
XRn1p5n1p4s5 Rn1p5n1t4s4 Rn1p5n1t4s5 0 sky130_fd_pr__res_xhigh_po w=10 l=226.09843
XRn1p5n1p4s6 Rn1p5n1t4s5 Rn1p5n1t4s6 0 sky130_fd_pr__res_xhigh_po w=10 l=226.09843
XRn1p5n1p4s7 Rn1p5n1t4s6 n1p 0 sky130_fd_pr__res_xhigh_po w=10 l=226.09843
XRn1p5n1p5s0 in5n Rn1p5n1t5s0 0 sky130_fd_pr__res_xhigh_po w=10 l=226.09843
XRn1p5n1p5s1 Rn1p5n1t5s0 Rn1p5n1t5s1 0 sky130_fd_pr__res_xhigh_po w=10 l=226.09843
XRn1p5n1p5s2 Rn1p5n1t5s1 Rn1p5n1t5s2 0 sky130_fd_pr__res_xhigh_po w=10 l=226.09843
XRn1p5n1p5s3 Rn1p5n1t5s2 Rn1p5n1t5s3 0 sky130_fd_pr__res_xhigh_po w=10 l=226.09843
XRn1p5n1p5s4 Rn1p5n1t5s3 Rn1p5n1t5s4 0 sky130_fd_pr__res_xhigh_po w=10 l=226.09843
XRn1p5n1p5s5 Rn1p5n1t5s4 Rn1p5n1t5s5 0 sky130_fd_pr__res_xhigh_po w=10 l=226.09843
XRn1p5n1p5s6 Rn1p5n1t5s5 Rn1p5n1t5s6 0 sky130_fd_pr__res_xhigh_po w=10 l=226.09843
XRn1p5n1p5s7 Rn1p5n1t5s6 n1p 0 sky130_fd_pr__res_xhigh_po w=10 l=226.09843
XRn1p5n1p6s0 in5n Rn1p5n1t6s0 0 sky130_fd_pr__res_xhigh_po w=10 l=226.09843
XRn1p5n1p6s1 Rn1p5n1t6s0 Rn1p5n1t6s1 0 sky130_fd_pr__res_xhigh_po w=10 l=226.09843
XRn1p5n1p6s2 Rn1p5n1t6s1 Rn1p5n1t6s2 0 sky130_fd_pr__res_xhigh_po w=10 l=226.09843
XRn1p5n1p6s3 Rn1p5n1t6s2 Rn1p5n1t6s3 0 sky130_fd_pr__res_xhigh_po w=10 l=226.09843
XRn1p5n1p6s4 Rn1p5n1t6s3 Rn1p5n1t6s4 0 sky130_fd_pr__res_xhigh_po w=10 l=226.09843
XRn1p5n1p6s5 Rn1p5n1t6s4 Rn1p5n1t6s5 0 sky130_fd_pr__res_xhigh_po w=10 l=226.09843
XRn1p5n1p6s6 Rn1p5n1t6s5 Rn1p5n1t6s6 0 sky130_fd_pr__res_xhigh_po w=10 l=226.09843
XRn1p5n1p6s7 Rn1p5n1t6s6 n1p 0 sky130_fd_pr__res_xhigh_po w=10 l=226.09843
XRn1p5n1p7s0 in5n Rn1p5n1t7s0 0 sky130_fd_pr__res_xhigh_po w=10 l=226.09843
XRn1p5n1p7s1 Rn1p5n1t7s0 Rn1p5n1t7s1 0 sky130_fd_pr__res_xhigh_po w=10 l=226.09843
XRn1p5n1p7s2 Rn1p5n1t7s1 Rn1p5n1t7s2 0 sky130_fd_pr__res_xhigh_po w=10 l=226.09843
XRn1p5n1p7s3 Rn1p5n1t7s2 Rn1p5n1t7s3 0 sky130_fd_pr__res_xhigh_po w=10 l=226.09843
XRn1p5n1p7s4 Rn1p5n1t7s3 Rn1p5n1t7s4 0 sky130_fd_pr__res_xhigh_po w=10 l=226.09843
XRn1p5n1p7s5 Rn1p5n1t7s4 Rn1p5n1t7s5 0 sky130_fd_pr__res_xhigh_po w=10 l=226.09843
XRn1p5n1p7s6 Rn1p5n1t7s5 Rn1p5n1t7s6 0 sky130_fd_pr__res_xhigh_po w=10 l=226.09843
XRn1p5n1p7s7 Rn1p5n1t7s6 n1p 0 sky130_fd_pr__res_xhigh_po w=10 l=226.09843
* n1 input 6 w=+0.124925987288217 w+  bank=n alpha=1 R=266824.65399637 G_phys=3.7477796186465e-06 G_eff=3.7477796186465e-06
* PDK sky130_fd_pr__res_xhigh_po Rn1p6n1 W=10 L=1326.5466
* tile Rn1p6n1 8s x 8p same W=10 L=1326.5466
XRn1p6n1p0s0 in6n Rn1p6n1t0s0 0 sky130_fd_pr__res_xhigh_po w=10 l=1326.5466
XRn1p6n1p0s1 Rn1p6n1t0s0 Rn1p6n1t0s1 0 sky130_fd_pr__res_xhigh_po w=10 l=1326.5466
XRn1p6n1p0s2 Rn1p6n1t0s1 Rn1p6n1t0s2 0 sky130_fd_pr__res_xhigh_po w=10 l=1326.5466
XRn1p6n1p0s3 Rn1p6n1t0s2 Rn1p6n1t0s3 0 sky130_fd_pr__res_xhigh_po w=10 l=1326.5466
XRn1p6n1p0s4 Rn1p6n1t0s3 Rn1p6n1t0s4 0 sky130_fd_pr__res_xhigh_po w=10 l=1326.5466
XRn1p6n1p0s5 Rn1p6n1t0s4 Rn1p6n1t0s5 0 sky130_fd_pr__res_xhigh_po w=10 l=1326.5466
XRn1p6n1p0s6 Rn1p6n1t0s5 Rn1p6n1t0s6 0 sky130_fd_pr__res_xhigh_po w=10 l=1326.5466
XRn1p6n1p0s7 Rn1p6n1t0s6 n1p 0 sky130_fd_pr__res_xhigh_po w=10 l=1326.5466
XRn1p6n1p1s0 in6n Rn1p6n1t1s0 0 sky130_fd_pr__res_xhigh_po w=10 l=1326.5466
XRn1p6n1p1s1 Rn1p6n1t1s0 Rn1p6n1t1s1 0 sky130_fd_pr__res_xhigh_po w=10 l=1326.5466
XRn1p6n1p1s2 Rn1p6n1t1s1 Rn1p6n1t1s2 0 sky130_fd_pr__res_xhigh_po w=10 l=1326.5466
XRn1p6n1p1s3 Rn1p6n1t1s2 Rn1p6n1t1s3 0 sky130_fd_pr__res_xhigh_po w=10 l=1326.5466
XRn1p6n1p1s4 Rn1p6n1t1s3 Rn1p6n1t1s4 0 sky130_fd_pr__res_xhigh_po w=10 l=1326.5466
XRn1p6n1p1s5 Rn1p6n1t1s4 Rn1p6n1t1s5 0 sky130_fd_pr__res_xhigh_po w=10 l=1326.5466
XRn1p6n1p1s6 Rn1p6n1t1s5 Rn1p6n1t1s6 0 sky130_fd_pr__res_xhigh_po w=10 l=1326.5466
XRn1p6n1p1s7 Rn1p6n1t1s6 n1p 0 sky130_fd_pr__res_xhigh_po w=10 l=1326.5466
XRn1p6n1p2s0 in6n Rn1p6n1t2s0 0 sky130_fd_pr__res_xhigh_po w=10 l=1326.5466
XRn1p6n1p2s1 Rn1p6n1t2s0 Rn1p6n1t2s1 0 sky130_fd_pr__res_xhigh_po w=10 l=1326.5466
XRn1p6n1p2s2 Rn1p6n1t2s1 Rn1p6n1t2s2 0 sky130_fd_pr__res_xhigh_po w=10 l=1326.5466
XRn1p6n1p2s3 Rn1p6n1t2s2 Rn1p6n1t2s3 0 sky130_fd_pr__res_xhigh_po w=10 l=1326.5466
XRn1p6n1p2s4 Rn1p6n1t2s3 Rn1p6n1t2s4 0 sky130_fd_pr__res_xhigh_po w=10 l=1326.5466
XRn1p6n1p2s5 Rn1p6n1t2s4 Rn1p6n1t2s5 0 sky130_fd_pr__res_xhigh_po w=10 l=1326.5466
XRn1p6n1p2s6 Rn1p6n1t2s5 Rn1p6n1t2s6 0 sky130_fd_pr__res_xhigh_po w=10 l=1326.5466
XRn1p6n1p2s7 Rn1p6n1t2s6 n1p 0 sky130_fd_pr__res_xhigh_po w=10 l=1326.5466
XRn1p6n1p3s0 in6n Rn1p6n1t3s0 0 sky130_fd_pr__res_xhigh_po w=10 l=1326.5466
XRn1p6n1p3s1 Rn1p6n1t3s0 Rn1p6n1t3s1 0 sky130_fd_pr__res_xhigh_po w=10 l=1326.5466
XRn1p6n1p3s2 Rn1p6n1t3s1 Rn1p6n1t3s2 0 sky130_fd_pr__res_xhigh_po w=10 l=1326.5466
XRn1p6n1p3s3 Rn1p6n1t3s2 Rn1p6n1t3s3 0 sky130_fd_pr__res_xhigh_po w=10 l=1326.5466
XRn1p6n1p3s4 Rn1p6n1t3s3 Rn1p6n1t3s4 0 sky130_fd_pr__res_xhigh_po w=10 l=1326.5466
XRn1p6n1p3s5 Rn1p6n1t3s4 Rn1p6n1t3s5 0 sky130_fd_pr__res_xhigh_po w=10 l=1326.5466
XRn1p6n1p3s6 Rn1p6n1t3s5 Rn1p6n1t3s6 0 sky130_fd_pr__res_xhigh_po w=10 l=1326.5466
XRn1p6n1p3s7 Rn1p6n1t3s6 n1p 0 sky130_fd_pr__res_xhigh_po w=10 l=1326.5466
XRn1p6n1p4s0 in6n Rn1p6n1t4s0 0 sky130_fd_pr__res_xhigh_po w=10 l=1326.5466
XRn1p6n1p4s1 Rn1p6n1t4s0 Rn1p6n1t4s1 0 sky130_fd_pr__res_xhigh_po w=10 l=1326.5466
XRn1p6n1p4s2 Rn1p6n1t4s1 Rn1p6n1t4s2 0 sky130_fd_pr__res_xhigh_po w=10 l=1326.5466
XRn1p6n1p4s3 Rn1p6n1t4s2 Rn1p6n1t4s3 0 sky130_fd_pr__res_xhigh_po w=10 l=1326.5466
XRn1p6n1p4s4 Rn1p6n1t4s3 Rn1p6n1t4s4 0 sky130_fd_pr__res_xhigh_po w=10 l=1326.5466
XRn1p6n1p4s5 Rn1p6n1t4s4 Rn1p6n1t4s5 0 sky130_fd_pr__res_xhigh_po w=10 l=1326.5466
XRn1p6n1p4s6 Rn1p6n1t4s5 Rn1p6n1t4s6 0 sky130_fd_pr__res_xhigh_po w=10 l=1326.5466
XRn1p6n1p4s7 Rn1p6n1t4s6 n1p 0 sky130_fd_pr__res_xhigh_po w=10 l=1326.5466
XRn1p6n1p5s0 in6n Rn1p6n1t5s0 0 sky130_fd_pr__res_xhigh_po w=10 l=1326.5466
XRn1p6n1p5s1 Rn1p6n1t5s0 Rn1p6n1t5s1 0 sky130_fd_pr__res_xhigh_po w=10 l=1326.5466
XRn1p6n1p5s2 Rn1p6n1t5s1 Rn1p6n1t5s2 0 sky130_fd_pr__res_xhigh_po w=10 l=1326.5466
XRn1p6n1p5s3 Rn1p6n1t5s2 Rn1p6n1t5s3 0 sky130_fd_pr__res_xhigh_po w=10 l=1326.5466
XRn1p6n1p5s4 Rn1p6n1t5s3 Rn1p6n1t5s4 0 sky130_fd_pr__res_xhigh_po w=10 l=1326.5466
XRn1p6n1p5s5 Rn1p6n1t5s4 Rn1p6n1t5s5 0 sky130_fd_pr__res_xhigh_po w=10 l=1326.5466
XRn1p6n1p5s6 Rn1p6n1t5s5 Rn1p6n1t5s6 0 sky130_fd_pr__res_xhigh_po w=10 l=1326.5466
XRn1p6n1p5s7 Rn1p6n1t5s6 n1p 0 sky130_fd_pr__res_xhigh_po w=10 l=1326.5466
XRn1p6n1p6s0 in6n Rn1p6n1t6s0 0 sky130_fd_pr__res_xhigh_po w=10 l=1326.5466
XRn1p6n1p6s1 Rn1p6n1t6s0 Rn1p6n1t6s1 0 sky130_fd_pr__res_xhigh_po w=10 l=1326.5466
XRn1p6n1p6s2 Rn1p6n1t6s1 Rn1p6n1t6s2 0 sky130_fd_pr__res_xhigh_po w=10 l=1326.5466
XRn1p6n1p6s3 Rn1p6n1t6s2 Rn1p6n1t6s3 0 sky130_fd_pr__res_xhigh_po w=10 l=1326.5466
XRn1p6n1p6s4 Rn1p6n1t6s3 Rn1p6n1t6s4 0 sky130_fd_pr__res_xhigh_po w=10 l=1326.5466
XRn1p6n1p6s5 Rn1p6n1t6s4 Rn1p6n1t6s5 0 sky130_fd_pr__res_xhigh_po w=10 l=1326.5466
XRn1p6n1p6s6 Rn1p6n1t6s5 Rn1p6n1t6s6 0 sky130_fd_pr__res_xhigh_po w=10 l=1326.5466
XRn1p6n1p6s7 Rn1p6n1t6s6 n1p 0 sky130_fd_pr__res_xhigh_po w=10 l=1326.5466
XRn1p6n1p7s0 in6n Rn1p6n1t7s0 0 sky130_fd_pr__res_xhigh_po w=10 l=1326.5466
XRn1p6n1p7s1 Rn1p6n1t7s0 Rn1p6n1t7s1 0 sky130_fd_pr__res_xhigh_po w=10 l=1326.5466
XRn1p6n1p7s2 Rn1p6n1t7s1 Rn1p6n1t7s2 0 sky130_fd_pr__res_xhigh_po w=10 l=1326.5466
XRn1p6n1p7s3 Rn1p6n1t7s2 Rn1p6n1t7s3 0 sky130_fd_pr__res_xhigh_po w=10 l=1326.5466
XRn1p6n1p7s4 Rn1p6n1t7s3 Rn1p6n1t7s4 0 sky130_fd_pr__res_xhigh_po w=10 l=1326.5466
XRn1p6n1p7s5 Rn1p6n1t7s4 Rn1p6n1t7s5 0 sky130_fd_pr__res_xhigh_po w=10 l=1326.5466
XRn1p6n1p7s6 Rn1p6n1t7s5 Rn1p6n1t7s6 0 sky130_fd_pr__res_xhigh_po w=10 l=1326.5466
XRn1p6n1p7s7 Rn1p6n1t7s6 n1p 0 sky130_fd_pr__res_xhigh_po w=10 l=1326.5466
* n1 input 7 w=-0.0857938493267301 w-  bank=n alpha=1 R=388528.240601368 G_phys=2.5738154798019e-06 G_eff=2.5738154798019e-06
* PDK sky130_fd_pr__res_xhigh_po Rn1n7n1 W=10 L=1931.6568
* tile Rn1n7n1 8s x 8p same W=10 L=1931.6568
XRn1n7n1p0s0 in7 Rn1n7n1t0s0 0 sky130_fd_pr__res_xhigh_po w=10 l=1931.6568
XRn1n7n1p0s1 Rn1n7n1t0s0 Rn1n7n1t0s1 0 sky130_fd_pr__res_xhigh_po w=10 l=1931.6568
XRn1n7n1p0s2 Rn1n7n1t0s1 Rn1n7n1t0s2 0 sky130_fd_pr__res_xhigh_po w=10 l=1931.6568
XRn1n7n1p0s3 Rn1n7n1t0s2 Rn1n7n1t0s3 0 sky130_fd_pr__res_xhigh_po w=10 l=1931.6568
XRn1n7n1p0s4 Rn1n7n1t0s3 Rn1n7n1t0s4 0 sky130_fd_pr__res_xhigh_po w=10 l=1931.6568
XRn1n7n1p0s5 Rn1n7n1t0s4 Rn1n7n1t0s5 0 sky130_fd_pr__res_xhigh_po w=10 l=1931.6568
XRn1n7n1p0s6 Rn1n7n1t0s5 Rn1n7n1t0s6 0 sky130_fd_pr__res_xhigh_po w=10 l=1931.6568
XRn1n7n1p0s7 Rn1n7n1t0s6 n1p 0 sky130_fd_pr__res_xhigh_po w=10 l=1931.6568
XRn1n7n1p1s0 in7 Rn1n7n1t1s0 0 sky130_fd_pr__res_xhigh_po w=10 l=1931.6568
XRn1n7n1p1s1 Rn1n7n1t1s0 Rn1n7n1t1s1 0 sky130_fd_pr__res_xhigh_po w=10 l=1931.6568
XRn1n7n1p1s2 Rn1n7n1t1s1 Rn1n7n1t1s2 0 sky130_fd_pr__res_xhigh_po w=10 l=1931.6568
XRn1n7n1p1s3 Rn1n7n1t1s2 Rn1n7n1t1s3 0 sky130_fd_pr__res_xhigh_po w=10 l=1931.6568
XRn1n7n1p1s4 Rn1n7n1t1s3 Rn1n7n1t1s4 0 sky130_fd_pr__res_xhigh_po w=10 l=1931.6568
XRn1n7n1p1s5 Rn1n7n1t1s4 Rn1n7n1t1s5 0 sky130_fd_pr__res_xhigh_po w=10 l=1931.6568
XRn1n7n1p1s6 Rn1n7n1t1s5 Rn1n7n1t1s6 0 sky130_fd_pr__res_xhigh_po w=10 l=1931.6568
XRn1n7n1p1s7 Rn1n7n1t1s6 n1p 0 sky130_fd_pr__res_xhigh_po w=10 l=1931.6568
XRn1n7n1p2s0 in7 Rn1n7n1t2s0 0 sky130_fd_pr__res_xhigh_po w=10 l=1931.6568
XRn1n7n1p2s1 Rn1n7n1t2s0 Rn1n7n1t2s1 0 sky130_fd_pr__res_xhigh_po w=10 l=1931.6568
XRn1n7n1p2s2 Rn1n7n1t2s1 Rn1n7n1t2s2 0 sky130_fd_pr__res_xhigh_po w=10 l=1931.6568
XRn1n7n1p2s3 Rn1n7n1t2s2 Rn1n7n1t2s3 0 sky130_fd_pr__res_xhigh_po w=10 l=1931.6568
XRn1n7n1p2s4 Rn1n7n1t2s3 Rn1n7n1t2s4 0 sky130_fd_pr__res_xhigh_po w=10 l=1931.6568
XRn1n7n1p2s5 Rn1n7n1t2s4 Rn1n7n1t2s5 0 sky130_fd_pr__res_xhigh_po w=10 l=1931.6568
XRn1n7n1p2s6 Rn1n7n1t2s5 Rn1n7n1t2s6 0 sky130_fd_pr__res_xhigh_po w=10 l=1931.6568
XRn1n7n1p2s7 Rn1n7n1t2s6 n1p 0 sky130_fd_pr__res_xhigh_po w=10 l=1931.6568
XRn1n7n1p3s0 in7 Rn1n7n1t3s0 0 sky130_fd_pr__res_xhigh_po w=10 l=1931.6568
XRn1n7n1p3s1 Rn1n7n1t3s0 Rn1n7n1t3s1 0 sky130_fd_pr__res_xhigh_po w=10 l=1931.6568
XRn1n7n1p3s2 Rn1n7n1t3s1 Rn1n7n1t3s2 0 sky130_fd_pr__res_xhigh_po w=10 l=1931.6568
XRn1n7n1p3s3 Rn1n7n1t3s2 Rn1n7n1t3s3 0 sky130_fd_pr__res_xhigh_po w=10 l=1931.6568
XRn1n7n1p3s4 Rn1n7n1t3s3 Rn1n7n1t3s4 0 sky130_fd_pr__res_xhigh_po w=10 l=1931.6568
XRn1n7n1p3s5 Rn1n7n1t3s4 Rn1n7n1t3s5 0 sky130_fd_pr__res_xhigh_po w=10 l=1931.6568
XRn1n7n1p3s6 Rn1n7n1t3s5 Rn1n7n1t3s6 0 sky130_fd_pr__res_xhigh_po w=10 l=1931.6568
XRn1n7n1p3s7 Rn1n7n1t3s6 n1p 0 sky130_fd_pr__res_xhigh_po w=10 l=1931.6568
XRn1n7n1p4s0 in7 Rn1n7n1t4s0 0 sky130_fd_pr__res_xhigh_po w=10 l=1931.6568
XRn1n7n1p4s1 Rn1n7n1t4s0 Rn1n7n1t4s1 0 sky130_fd_pr__res_xhigh_po w=10 l=1931.6568
XRn1n7n1p4s2 Rn1n7n1t4s1 Rn1n7n1t4s2 0 sky130_fd_pr__res_xhigh_po w=10 l=1931.6568
XRn1n7n1p4s3 Rn1n7n1t4s2 Rn1n7n1t4s3 0 sky130_fd_pr__res_xhigh_po w=10 l=1931.6568
XRn1n7n1p4s4 Rn1n7n1t4s3 Rn1n7n1t4s4 0 sky130_fd_pr__res_xhigh_po w=10 l=1931.6568
XRn1n7n1p4s5 Rn1n7n1t4s4 Rn1n7n1t4s5 0 sky130_fd_pr__res_xhigh_po w=10 l=1931.6568
XRn1n7n1p4s6 Rn1n7n1t4s5 Rn1n7n1t4s6 0 sky130_fd_pr__res_xhigh_po w=10 l=1931.6568
XRn1n7n1p4s7 Rn1n7n1t4s6 n1p 0 sky130_fd_pr__res_xhigh_po w=10 l=1931.6568
XRn1n7n1p5s0 in7 Rn1n7n1t5s0 0 sky130_fd_pr__res_xhigh_po w=10 l=1931.6568
XRn1n7n1p5s1 Rn1n7n1t5s0 Rn1n7n1t5s1 0 sky130_fd_pr__res_xhigh_po w=10 l=1931.6568
XRn1n7n1p5s2 Rn1n7n1t5s1 Rn1n7n1t5s2 0 sky130_fd_pr__res_xhigh_po w=10 l=1931.6568
XRn1n7n1p5s3 Rn1n7n1t5s2 Rn1n7n1t5s3 0 sky130_fd_pr__res_xhigh_po w=10 l=1931.6568
XRn1n7n1p5s4 Rn1n7n1t5s3 Rn1n7n1t5s4 0 sky130_fd_pr__res_xhigh_po w=10 l=1931.6568
XRn1n7n1p5s5 Rn1n7n1t5s4 Rn1n7n1t5s5 0 sky130_fd_pr__res_xhigh_po w=10 l=1931.6568
XRn1n7n1p5s6 Rn1n7n1t5s5 Rn1n7n1t5s6 0 sky130_fd_pr__res_xhigh_po w=10 l=1931.6568
XRn1n7n1p5s7 Rn1n7n1t5s6 n1p 0 sky130_fd_pr__res_xhigh_po w=10 l=1931.6568
XRn1n7n1p6s0 in7 Rn1n7n1t6s0 0 sky130_fd_pr__res_xhigh_po w=10 l=1931.6568
XRn1n7n1p6s1 Rn1n7n1t6s0 Rn1n7n1t6s1 0 sky130_fd_pr__res_xhigh_po w=10 l=1931.6568
XRn1n7n1p6s2 Rn1n7n1t6s1 Rn1n7n1t6s2 0 sky130_fd_pr__res_xhigh_po w=10 l=1931.6568
XRn1n7n1p6s3 Rn1n7n1t6s2 Rn1n7n1t6s3 0 sky130_fd_pr__res_xhigh_po w=10 l=1931.6568
XRn1n7n1p6s4 Rn1n7n1t6s3 Rn1n7n1t6s4 0 sky130_fd_pr__res_xhigh_po w=10 l=1931.6568
XRn1n7n1p6s5 Rn1n7n1t6s4 Rn1n7n1t6s5 0 sky130_fd_pr__res_xhigh_po w=10 l=1931.6568
XRn1n7n1p6s6 Rn1n7n1t6s5 Rn1n7n1t6s6 0 sky130_fd_pr__res_xhigh_po w=10 l=1931.6568
XRn1n7n1p6s7 Rn1n7n1t6s6 n1p 0 sky130_fd_pr__res_xhigh_po w=10 l=1931.6568
XRn1n7n1p7s0 in7 Rn1n7n1t7s0 0 sky130_fd_pr__res_xhigh_po w=10 l=1931.6568
XRn1n7n1p7s1 Rn1n7n1t7s0 Rn1n7n1t7s1 0 sky130_fd_pr__res_xhigh_po w=10 l=1931.6568
XRn1n7n1p7s2 Rn1n7n1t7s1 Rn1n7n1t7s2 0 sky130_fd_pr__res_xhigh_po w=10 l=1931.6568
XRn1n7n1p7s3 Rn1n7n1t7s2 Rn1n7n1t7s3 0 sky130_fd_pr__res_xhigh_po w=10 l=1931.6568
XRn1n7n1p7s4 Rn1n7n1t7s3 Rn1n7n1t7s4 0 sky130_fd_pr__res_xhigh_po w=10 l=1931.6568
XRn1n7n1p7s5 Rn1n7n1t7s4 Rn1n7n1t7s5 0 sky130_fd_pr__res_xhigh_po w=10 l=1931.6568
XRn1n7n1p7s6 Rn1n7n1t7s5 Rn1n7n1t7s6 0 sky130_fd_pr__res_xhigh_po w=10 l=1931.6568
XRn1n7n1p7s7 Rn1n7n1t7s6 n1p 0 sky130_fd_pr__res_xhigh_po w=10 l=1931.6568
* n1 input 8 w=-0.0609936542707342 w-  bank=n alpha=1 R=546504.939438057 G_phys=1.82980962812202e-06 G_eff=1.82980962812202e-06
* PDK sky130_fd_pr__res_xhigh_po Rn1n8n1 W=10 L=2717.1169
* tile Rn1n8n1 8s x 8p same W=10 L=2717.1169
XRn1n8n1p0s0 in8 Rn1n8n1t0s0 0 sky130_fd_pr__res_xhigh_po w=10 l=2717.1169
XRn1n8n1p0s1 Rn1n8n1t0s0 Rn1n8n1t0s1 0 sky130_fd_pr__res_xhigh_po w=10 l=2717.1169
XRn1n8n1p0s2 Rn1n8n1t0s1 Rn1n8n1t0s2 0 sky130_fd_pr__res_xhigh_po w=10 l=2717.1169
XRn1n8n1p0s3 Rn1n8n1t0s2 Rn1n8n1t0s3 0 sky130_fd_pr__res_xhigh_po w=10 l=2717.1169
XRn1n8n1p0s4 Rn1n8n1t0s3 Rn1n8n1t0s4 0 sky130_fd_pr__res_xhigh_po w=10 l=2717.1169
XRn1n8n1p0s5 Rn1n8n1t0s4 Rn1n8n1t0s5 0 sky130_fd_pr__res_xhigh_po w=10 l=2717.1169
XRn1n8n1p0s6 Rn1n8n1t0s5 Rn1n8n1t0s6 0 sky130_fd_pr__res_xhigh_po w=10 l=2717.1169
XRn1n8n1p0s7 Rn1n8n1t0s6 n1p 0 sky130_fd_pr__res_xhigh_po w=10 l=2717.1169
XRn1n8n1p1s0 in8 Rn1n8n1t1s0 0 sky130_fd_pr__res_xhigh_po w=10 l=2717.1169
XRn1n8n1p1s1 Rn1n8n1t1s0 Rn1n8n1t1s1 0 sky130_fd_pr__res_xhigh_po w=10 l=2717.1169
XRn1n8n1p1s2 Rn1n8n1t1s1 Rn1n8n1t1s2 0 sky130_fd_pr__res_xhigh_po w=10 l=2717.1169
XRn1n8n1p1s3 Rn1n8n1t1s2 Rn1n8n1t1s3 0 sky130_fd_pr__res_xhigh_po w=10 l=2717.1169
XRn1n8n1p1s4 Rn1n8n1t1s3 Rn1n8n1t1s4 0 sky130_fd_pr__res_xhigh_po w=10 l=2717.1169
XRn1n8n1p1s5 Rn1n8n1t1s4 Rn1n8n1t1s5 0 sky130_fd_pr__res_xhigh_po w=10 l=2717.1169
XRn1n8n1p1s6 Rn1n8n1t1s5 Rn1n8n1t1s6 0 sky130_fd_pr__res_xhigh_po w=10 l=2717.1169
XRn1n8n1p1s7 Rn1n8n1t1s6 n1p 0 sky130_fd_pr__res_xhigh_po w=10 l=2717.1169
XRn1n8n1p2s0 in8 Rn1n8n1t2s0 0 sky130_fd_pr__res_xhigh_po w=10 l=2717.1169
XRn1n8n1p2s1 Rn1n8n1t2s0 Rn1n8n1t2s1 0 sky130_fd_pr__res_xhigh_po w=10 l=2717.1169
XRn1n8n1p2s2 Rn1n8n1t2s1 Rn1n8n1t2s2 0 sky130_fd_pr__res_xhigh_po w=10 l=2717.1169
XRn1n8n1p2s3 Rn1n8n1t2s2 Rn1n8n1t2s3 0 sky130_fd_pr__res_xhigh_po w=10 l=2717.1169
XRn1n8n1p2s4 Rn1n8n1t2s3 Rn1n8n1t2s4 0 sky130_fd_pr__res_xhigh_po w=10 l=2717.1169
XRn1n8n1p2s5 Rn1n8n1t2s4 Rn1n8n1t2s5 0 sky130_fd_pr__res_xhigh_po w=10 l=2717.1169
XRn1n8n1p2s6 Rn1n8n1t2s5 Rn1n8n1t2s6 0 sky130_fd_pr__res_xhigh_po w=10 l=2717.1169
XRn1n8n1p2s7 Rn1n8n1t2s6 n1p 0 sky130_fd_pr__res_xhigh_po w=10 l=2717.1169
XRn1n8n1p3s0 in8 Rn1n8n1t3s0 0 sky130_fd_pr__res_xhigh_po w=10 l=2717.1169
XRn1n8n1p3s1 Rn1n8n1t3s0 Rn1n8n1t3s1 0 sky130_fd_pr__res_xhigh_po w=10 l=2717.1169
XRn1n8n1p3s2 Rn1n8n1t3s1 Rn1n8n1t3s2 0 sky130_fd_pr__res_xhigh_po w=10 l=2717.1169
XRn1n8n1p3s3 Rn1n8n1t3s2 Rn1n8n1t3s3 0 sky130_fd_pr__res_xhigh_po w=10 l=2717.1169
XRn1n8n1p3s4 Rn1n8n1t3s3 Rn1n8n1t3s4 0 sky130_fd_pr__res_xhigh_po w=10 l=2717.1169
XRn1n8n1p3s5 Rn1n8n1t3s4 Rn1n8n1t3s5 0 sky130_fd_pr__res_xhigh_po w=10 l=2717.1169
XRn1n8n1p3s6 Rn1n8n1t3s5 Rn1n8n1t3s6 0 sky130_fd_pr__res_xhigh_po w=10 l=2717.1169
XRn1n8n1p3s7 Rn1n8n1t3s6 n1p 0 sky130_fd_pr__res_xhigh_po w=10 l=2717.1169
XRn1n8n1p4s0 in8 Rn1n8n1t4s0 0 sky130_fd_pr__res_xhigh_po w=10 l=2717.1169
XRn1n8n1p4s1 Rn1n8n1t4s0 Rn1n8n1t4s1 0 sky130_fd_pr__res_xhigh_po w=10 l=2717.1169
XRn1n8n1p4s2 Rn1n8n1t4s1 Rn1n8n1t4s2 0 sky130_fd_pr__res_xhigh_po w=10 l=2717.1169
XRn1n8n1p4s3 Rn1n8n1t4s2 Rn1n8n1t4s3 0 sky130_fd_pr__res_xhigh_po w=10 l=2717.1169
XRn1n8n1p4s4 Rn1n8n1t4s3 Rn1n8n1t4s4 0 sky130_fd_pr__res_xhigh_po w=10 l=2717.1169
XRn1n8n1p4s5 Rn1n8n1t4s4 Rn1n8n1t4s5 0 sky130_fd_pr__res_xhigh_po w=10 l=2717.1169
XRn1n8n1p4s6 Rn1n8n1t4s5 Rn1n8n1t4s6 0 sky130_fd_pr__res_xhigh_po w=10 l=2717.1169
XRn1n8n1p4s7 Rn1n8n1t4s6 n1p 0 sky130_fd_pr__res_xhigh_po w=10 l=2717.1169
XRn1n8n1p5s0 in8 Rn1n8n1t5s0 0 sky130_fd_pr__res_xhigh_po w=10 l=2717.1169
XRn1n8n1p5s1 Rn1n8n1t5s0 Rn1n8n1t5s1 0 sky130_fd_pr__res_xhigh_po w=10 l=2717.1169
XRn1n8n1p5s2 Rn1n8n1t5s1 Rn1n8n1t5s2 0 sky130_fd_pr__res_xhigh_po w=10 l=2717.1169
XRn1n8n1p5s3 Rn1n8n1t5s2 Rn1n8n1t5s3 0 sky130_fd_pr__res_xhigh_po w=10 l=2717.1169
XRn1n8n1p5s4 Rn1n8n1t5s3 Rn1n8n1t5s4 0 sky130_fd_pr__res_xhigh_po w=10 l=2717.1169
XRn1n8n1p5s5 Rn1n8n1t5s4 Rn1n8n1t5s5 0 sky130_fd_pr__res_xhigh_po w=10 l=2717.1169
XRn1n8n1p5s6 Rn1n8n1t5s5 Rn1n8n1t5s6 0 sky130_fd_pr__res_xhigh_po w=10 l=2717.1169
XRn1n8n1p5s7 Rn1n8n1t5s6 n1p 0 sky130_fd_pr__res_xhigh_po w=10 l=2717.1169
XRn1n8n1p6s0 in8 Rn1n8n1t6s0 0 sky130_fd_pr__res_xhigh_po w=10 l=2717.1169
XRn1n8n1p6s1 Rn1n8n1t6s0 Rn1n8n1t6s1 0 sky130_fd_pr__res_xhigh_po w=10 l=2717.1169
XRn1n8n1p6s2 Rn1n8n1t6s1 Rn1n8n1t6s2 0 sky130_fd_pr__res_xhigh_po w=10 l=2717.1169
XRn1n8n1p6s3 Rn1n8n1t6s2 Rn1n8n1t6s3 0 sky130_fd_pr__res_xhigh_po w=10 l=2717.1169
XRn1n8n1p6s4 Rn1n8n1t6s3 Rn1n8n1t6s4 0 sky130_fd_pr__res_xhigh_po w=10 l=2717.1169
XRn1n8n1p6s5 Rn1n8n1t6s4 Rn1n8n1t6s5 0 sky130_fd_pr__res_xhigh_po w=10 l=2717.1169
XRn1n8n1p6s6 Rn1n8n1t6s5 Rn1n8n1t6s6 0 sky130_fd_pr__res_xhigh_po w=10 l=2717.1169
XRn1n8n1p6s7 Rn1n8n1t6s6 n1p 0 sky130_fd_pr__res_xhigh_po w=10 l=2717.1169
XRn1n8n1p7s0 in8 Rn1n8n1t7s0 0 sky130_fd_pr__res_xhigh_po w=10 l=2717.1169
XRn1n8n1p7s1 Rn1n8n1t7s0 Rn1n8n1t7s1 0 sky130_fd_pr__res_xhigh_po w=10 l=2717.1169
XRn1n8n1p7s2 Rn1n8n1t7s1 Rn1n8n1t7s2 0 sky130_fd_pr__res_xhigh_po w=10 l=2717.1169
XRn1n8n1p7s3 Rn1n8n1t7s2 Rn1n8n1t7s3 0 sky130_fd_pr__res_xhigh_po w=10 l=2717.1169
XRn1n8n1p7s4 Rn1n8n1t7s3 Rn1n8n1t7s4 0 sky130_fd_pr__res_xhigh_po w=10 l=2717.1169
XRn1n8n1p7s5 Rn1n8n1t7s4 Rn1n8n1t7s5 0 sky130_fd_pr__res_xhigh_po w=10 l=2717.1169
XRn1n8n1p7s6 Rn1n8n1t7s5 Rn1n8n1t7s6 0 sky130_fd_pr__res_xhigh_po w=10 l=2717.1169
XRn1n8n1p7s7 Rn1n8n1t7s6 n1p 0 sky130_fd_pr__res_xhigh_po w=10 l=2717.1169
* n1 input 9 w=+0.256981204903229 w+  bank=n alpha=1 R=129711.172246568 G_phys=7.70943614709688e-06 G_eff=7.70943614709688e-06
* PDK sky130_fd_pr__res_xhigh_po Rn1p9n1 W=10 L=644.81832
* tile Rn1p9n1 8s x 8p same W=10 L=644.81832
XRn1p9n1p0s0 in9n Rn1p9n1t0s0 0 sky130_fd_pr__res_xhigh_po w=10 l=644.81832
XRn1p9n1p0s1 Rn1p9n1t0s0 Rn1p9n1t0s1 0 sky130_fd_pr__res_xhigh_po w=10 l=644.81832
XRn1p9n1p0s2 Rn1p9n1t0s1 Rn1p9n1t0s2 0 sky130_fd_pr__res_xhigh_po w=10 l=644.81832
XRn1p9n1p0s3 Rn1p9n1t0s2 Rn1p9n1t0s3 0 sky130_fd_pr__res_xhigh_po w=10 l=644.81832
XRn1p9n1p0s4 Rn1p9n1t0s3 Rn1p9n1t0s4 0 sky130_fd_pr__res_xhigh_po w=10 l=644.81832
XRn1p9n1p0s5 Rn1p9n1t0s4 Rn1p9n1t0s5 0 sky130_fd_pr__res_xhigh_po w=10 l=644.81832
XRn1p9n1p0s6 Rn1p9n1t0s5 Rn1p9n1t0s6 0 sky130_fd_pr__res_xhigh_po w=10 l=644.81832
XRn1p9n1p0s7 Rn1p9n1t0s6 n1p 0 sky130_fd_pr__res_xhigh_po w=10 l=644.81832
XRn1p9n1p1s0 in9n Rn1p9n1t1s0 0 sky130_fd_pr__res_xhigh_po w=10 l=644.81832
XRn1p9n1p1s1 Rn1p9n1t1s0 Rn1p9n1t1s1 0 sky130_fd_pr__res_xhigh_po w=10 l=644.81832
XRn1p9n1p1s2 Rn1p9n1t1s1 Rn1p9n1t1s2 0 sky130_fd_pr__res_xhigh_po w=10 l=644.81832
XRn1p9n1p1s3 Rn1p9n1t1s2 Rn1p9n1t1s3 0 sky130_fd_pr__res_xhigh_po w=10 l=644.81832
XRn1p9n1p1s4 Rn1p9n1t1s3 Rn1p9n1t1s4 0 sky130_fd_pr__res_xhigh_po w=10 l=644.81832
XRn1p9n1p1s5 Rn1p9n1t1s4 Rn1p9n1t1s5 0 sky130_fd_pr__res_xhigh_po w=10 l=644.81832
XRn1p9n1p1s6 Rn1p9n1t1s5 Rn1p9n1t1s6 0 sky130_fd_pr__res_xhigh_po w=10 l=644.81832
XRn1p9n1p1s7 Rn1p9n1t1s6 n1p 0 sky130_fd_pr__res_xhigh_po w=10 l=644.81832
XRn1p9n1p2s0 in9n Rn1p9n1t2s0 0 sky130_fd_pr__res_xhigh_po w=10 l=644.81832
XRn1p9n1p2s1 Rn1p9n1t2s0 Rn1p9n1t2s1 0 sky130_fd_pr__res_xhigh_po w=10 l=644.81832
XRn1p9n1p2s2 Rn1p9n1t2s1 Rn1p9n1t2s2 0 sky130_fd_pr__res_xhigh_po w=10 l=644.81832
XRn1p9n1p2s3 Rn1p9n1t2s2 Rn1p9n1t2s3 0 sky130_fd_pr__res_xhigh_po w=10 l=644.81832
XRn1p9n1p2s4 Rn1p9n1t2s3 Rn1p9n1t2s4 0 sky130_fd_pr__res_xhigh_po w=10 l=644.81832
XRn1p9n1p2s5 Rn1p9n1t2s4 Rn1p9n1t2s5 0 sky130_fd_pr__res_xhigh_po w=10 l=644.81832
XRn1p9n1p2s6 Rn1p9n1t2s5 Rn1p9n1t2s6 0 sky130_fd_pr__res_xhigh_po w=10 l=644.81832
XRn1p9n1p2s7 Rn1p9n1t2s6 n1p 0 sky130_fd_pr__res_xhigh_po w=10 l=644.81832
XRn1p9n1p3s0 in9n Rn1p9n1t3s0 0 sky130_fd_pr__res_xhigh_po w=10 l=644.81832
XRn1p9n1p3s1 Rn1p9n1t3s0 Rn1p9n1t3s1 0 sky130_fd_pr__res_xhigh_po w=10 l=644.81832
XRn1p9n1p3s2 Rn1p9n1t3s1 Rn1p9n1t3s2 0 sky130_fd_pr__res_xhigh_po w=10 l=644.81832
XRn1p9n1p3s3 Rn1p9n1t3s2 Rn1p9n1t3s3 0 sky130_fd_pr__res_xhigh_po w=10 l=644.81832
XRn1p9n1p3s4 Rn1p9n1t3s3 Rn1p9n1t3s4 0 sky130_fd_pr__res_xhigh_po w=10 l=644.81832
XRn1p9n1p3s5 Rn1p9n1t3s4 Rn1p9n1t3s5 0 sky130_fd_pr__res_xhigh_po w=10 l=644.81832
XRn1p9n1p3s6 Rn1p9n1t3s5 Rn1p9n1t3s6 0 sky130_fd_pr__res_xhigh_po w=10 l=644.81832
XRn1p9n1p3s7 Rn1p9n1t3s6 n1p 0 sky130_fd_pr__res_xhigh_po w=10 l=644.81832
XRn1p9n1p4s0 in9n Rn1p9n1t4s0 0 sky130_fd_pr__res_xhigh_po w=10 l=644.81832
XRn1p9n1p4s1 Rn1p9n1t4s0 Rn1p9n1t4s1 0 sky130_fd_pr__res_xhigh_po w=10 l=644.81832
XRn1p9n1p4s2 Rn1p9n1t4s1 Rn1p9n1t4s2 0 sky130_fd_pr__res_xhigh_po w=10 l=644.81832
XRn1p9n1p4s3 Rn1p9n1t4s2 Rn1p9n1t4s3 0 sky130_fd_pr__res_xhigh_po w=10 l=644.81832
XRn1p9n1p4s4 Rn1p9n1t4s3 Rn1p9n1t4s4 0 sky130_fd_pr__res_xhigh_po w=10 l=644.81832
XRn1p9n1p4s5 Rn1p9n1t4s4 Rn1p9n1t4s5 0 sky130_fd_pr__res_xhigh_po w=10 l=644.81832
XRn1p9n1p4s6 Rn1p9n1t4s5 Rn1p9n1t4s6 0 sky130_fd_pr__res_xhigh_po w=10 l=644.81832
XRn1p9n1p4s7 Rn1p9n1t4s6 n1p 0 sky130_fd_pr__res_xhigh_po w=10 l=644.81832
XRn1p9n1p5s0 in9n Rn1p9n1t5s0 0 sky130_fd_pr__res_xhigh_po w=10 l=644.81832
XRn1p9n1p5s1 Rn1p9n1t5s0 Rn1p9n1t5s1 0 sky130_fd_pr__res_xhigh_po w=10 l=644.81832
XRn1p9n1p5s2 Rn1p9n1t5s1 Rn1p9n1t5s2 0 sky130_fd_pr__res_xhigh_po w=10 l=644.81832
XRn1p9n1p5s3 Rn1p9n1t5s2 Rn1p9n1t5s3 0 sky130_fd_pr__res_xhigh_po w=10 l=644.81832
XRn1p9n1p5s4 Rn1p9n1t5s3 Rn1p9n1t5s4 0 sky130_fd_pr__res_xhigh_po w=10 l=644.81832
XRn1p9n1p5s5 Rn1p9n1t5s4 Rn1p9n1t5s5 0 sky130_fd_pr__res_xhigh_po w=10 l=644.81832
XRn1p9n1p5s6 Rn1p9n1t5s5 Rn1p9n1t5s6 0 sky130_fd_pr__res_xhigh_po w=10 l=644.81832
XRn1p9n1p5s7 Rn1p9n1t5s6 n1p 0 sky130_fd_pr__res_xhigh_po w=10 l=644.81832
XRn1p9n1p6s0 in9n Rn1p9n1t6s0 0 sky130_fd_pr__res_xhigh_po w=10 l=644.81832
XRn1p9n1p6s1 Rn1p9n1t6s0 Rn1p9n1t6s1 0 sky130_fd_pr__res_xhigh_po w=10 l=644.81832
XRn1p9n1p6s2 Rn1p9n1t6s1 Rn1p9n1t6s2 0 sky130_fd_pr__res_xhigh_po w=10 l=644.81832
XRn1p9n1p6s3 Rn1p9n1t6s2 Rn1p9n1t6s3 0 sky130_fd_pr__res_xhigh_po w=10 l=644.81832
XRn1p9n1p6s4 Rn1p9n1t6s3 Rn1p9n1t6s4 0 sky130_fd_pr__res_xhigh_po w=10 l=644.81832
XRn1p9n1p6s5 Rn1p9n1t6s4 Rn1p9n1t6s5 0 sky130_fd_pr__res_xhigh_po w=10 l=644.81832
XRn1p9n1p6s6 Rn1p9n1t6s5 Rn1p9n1t6s6 0 sky130_fd_pr__res_xhigh_po w=10 l=644.81832
XRn1p9n1p6s7 Rn1p9n1t6s6 n1p 0 sky130_fd_pr__res_xhigh_po w=10 l=644.81832
XRn1p9n1p7s0 in9n Rn1p9n1t7s0 0 sky130_fd_pr__res_xhigh_po w=10 l=644.81832
XRn1p9n1p7s1 Rn1p9n1t7s0 Rn1p9n1t7s1 0 sky130_fd_pr__res_xhigh_po w=10 l=644.81832
XRn1p9n1p7s2 Rn1p9n1t7s1 Rn1p9n1t7s2 0 sky130_fd_pr__res_xhigh_po w=10 l=644.81832
XRn1p9n1p7s3 Rn1p9n1t7s2 Rn1p9n1t7s3 0 sky130_fd_pr__res_xhigh_po w=10 l=644.81832
XRn1p9n1p7s4 Rn1p9n1t7s3 Rn1p9n1t7s4 0 sky130_fd_pr__res_xhigh_po w=10 l=644.81832
XRn1p9n1p7s5 Rn1p9n1t7s4 Rn1p9n1t7s5 0 sky130_fd_pr__res_xhigh_po w=10 l=644.81832
XRn1p9n1p7s6 Rn1p9n1t7s5 Rn1p9n1t7s6 0 sky130_fd_pr__res_xhigh_po w=10 l=644.81832
XRn1p9n1p7s7 Rn1p9n1t7s6 n1p 0 sky130_fd_pr__res_xhigh_po w=10 l=644.81832
* n1 input 10 w=+0.073638013162671 w+  bank=n alpha=1 R=452664.756987643 G_phys=2.20914039488013e-06 G_eff=2.20914039488013e-06
* PDK sky130_fd_pr__res_xhigh_po Rn1p10n1 W=10 L=2250.5435
* tile Rn1p10n1 8s x 8p same W=10 L=2250.5435
XRn1p10n1p0s0 in10n Rn1p10n1t0s0 0 sky130_fd_pr__res_xhigh_po w=10 l=2250.5435
XRn1p10n1p0s1 Rn1p10n1t0s0 Rn1p10n1t0s1 0 sky130_fd_pr__res_xhigh_po w=10 l=2250.5435
XRn1p10n1p0s2 Rn1p10n1t0s1 Rn1p10n1t0s2 0 sky130_fd_pr__res_xhigh_po w=10 l=2250.5435
XRn1p10n1p0s3 Rn1p10n1t0s2 Rn1p10n1t0s3 0 sky130_fd_pr__res_xhigh_po w=10 l=2250.5435
XRn1p10n1p0s4 Rn1p10n1t0s3 Rn1p10n1t0s4 0 sky130_fd_pr__res_xhigh_po w=10 l=2250.5435
XRn1p10n1p0s5 Rn1p10n1t0s4 Rn1p10n1t0s5 0 sky130_fd_pr__res_xhigh_po w=10 l=2250.5435
XRn1p10n1p0s6 Rn1p10n1t0s5 Rn1p10n1t0s6 0 sky130_fd_pr__res_xhigh_po w=10 l=2250.5435
XRn1p10n1p0s7 Rn1p10n1t0s6 n1p 0 sky130_fd_pr__res_xhigh_po w=10 l=2250.5435
XRn1p10n1p1s0 in10n Rn1p10n1t1s0 0 sky130_fd_pr__res_xhigh_po w=10 l=2250.5435
XRn1p10n1p1s1 Rn1p10n1t1s0 Rn1p10n1t1s1 0 sky130_fd_pr__res_xhigh_po w=10 l=2250.5435
XRn1p10n1p1s2 Rn1p10n1t1s1 Rn1p10n1t1s2 0 sky130_fd_pr__res_xhigh_po w=10 l=2250.5435
XRn1p10n1p1s3 Rn1p10n1t1s2 Rn1p10n1t1s3 0 sky130_fd_pr__res_xhigh_po w=10 l=2250.5435
XRn1p10n1p1s4 Rn1p10n1t1s3 Rn1p10n1t1s4 0 sky130_fd_pr__res_xhigh_po w=10 l=2250.5435
XRn1p10n1p1s5 Rn1p10n1t1s4 Rn1p10n1t1s5 0 sky130_fd_pr__res_xhigh_po w=10 l=2250.5435
XRn1p10n1p1s6 Rn1p10n1t1s5 Rn1p10n1t1s6 0 sky130_fd_pr__res_xhigh_po w=10 l=2250.5435
XRn1p10n1p1s7 Rn1p10n1t1s6 n1p 0 sky130_fd_pr__res_xhigh_po w=10 l=2250.5435
XRn1p10n1p2s0 in10n Rn1p10n1t2s0 0 sky130_fd_pr__res_xhigh_po w=10 l=2250.5435
XRn1p10n1p2s1 Rn1p10n1t2s0 Rn1p10n1t2s1 0 sky130_fd_pr__res_xhigh_po w=10 l=2250.5435
XRn1p10n1p2s2 Rn1p10n1t2s1 Rn1p10n1t2s2 0 sky130_fd_pr__res_xhigh_po w=10 l=2250.5435
XRn1p10n1p2s3 Rn1p10n1t2s2 Rn1p10n1t2s3 0 sky130_fd_pr__res_xhigh_po w=10 l=2250.5435
XRn1p10n1p2s4 Rn1p10n1t2s3 Rn1p10n1t2s4 0 sky130_fd_pr__res_xhigh_po w=10 l=2250.5435
XRn1p10n1p2s5 Rn1p10n1t2s4 Rn1p10n1t2s5 0 sky130_fd_pr__res_xhigh_po w=10 l=2250.5435
XRn1p10n1p2s6 Rn1p10n1t2s5 Rn1p10n1t2s6 0 sky130_fd_pr__res_xhigh_po w=10 l=2250.5435
XRn1p10n1p2s7 Rn1p10n1t2s6 n1p 0 sky130_fd_pr__res_xhigh_po w=10 l=2250.5435
XRn1p10n1p3s0 in10n Rn1p10n1t3s0 0 sky130_fd_pr__res_xhigh_po w=10 l=2250.5435
XRn1p10n1p3s1 Rn1p10n1t3s0 Rn1p10n1t3s1 0 sky130_fd_pr__res_xhigh_po w=10 l=2250.5435
XRn1p10n1p3s2 Rn1p10n1t3s1 Rn1p10n1t3s2 0 sky130_fd_pr__res_xhigh_po w=10 l=2250.5435
XRn1p10n1p3s3 Rn1p10n1t3s2 Rn1p10n1t3s3 0 sky130_fd_pr__res_xhigh_po w=10 l=2250.5435
XRn1p10n1p3s4 Rn1p10n1t3s3 Rn1p10n1t3s4 0 sky130_fd_pr__res_xhigh_po w=10 l=2250.5435
XRn1p10n1p3s5 Rn1p10n1t3s4 Rn1p10n1t3s5 0 sky130_fd_pr__res_xhigh_po w=10 l=2250.5435
XRn1p10n1p3s6 Rn1p10n1t3s5 Rn1p10n1t3s6 0 sky130_fd_pr__res_xhigh_po w=10 l=2250.5435
XRn1p10n1p3s7 Rn1p10n1t3s6 n1p 0 sky130_fd_pr__res_xhigh_po w=10 l=2250.5435
XRn1p10n1p4s0 in10n Rn1p10n1t4s0 0 sky130_fd_pr__res_xhigh_po w=10 l=2250.5435
XRn1p10n1p4s1 Rn1p10n1t4s0 Rn1p10n1t4s1 0 sky130_fd_pr__res_xhigh_po w=10 l=2250.5435
XRn1p10n1p4s2 Rn1p10n1t4s1 Rn1p10n1t4s2 0 sky130_fd_pr__res_xhigh_po w=10 l=2250.5435
XRn1p10n1p4s3 Rn1p10n1t4s2 Rn1p10n1t4s3 0 sky130_fd_pr__res_xhigh_po w=10 l=2250.5435
XRn1p10n1p4s4 Rn1p10n1t4s3 Rn1p10n1t4s4 0 sky130_fd_pr__res_xhigh_po w=10 l=2250.5435
XRn1p10n1p4s5 Rn1p10n1t4s4 Rn1p10n1t4s5 0 sky130_fd_pr__res_xhigh_po w=10 l=2250.5435
XRn1p10n1p4s6 Rn1p10n1t4s5 Rn1p10n1t4s6 0 sky130_fd_pr__res_xhigh_po w=10 l=2250.5435
XRn1p10n1p4s7 Rn1p10n1t4s6 n1p 0 sky130_fd_pr__res_xhigh_po w=10 l=2250.5435
XRn1p10n1p5s0 in10n Rn1p10n1t5s0 0 sky130_fd_pr__res_xhigh_po w=10 l=2250.5435
XRn1p10n1p5s1 Rn1p10n1t5s0 Rn1p10n1t5s1 0 sky130_fd_pr__res_xhigh_po w=10 l=2250.5435
XRn1p10n1p5s2 Rn1p10n1t5s1 Rn1p10n1t5s2 0 sky130_fd_pr__res_xhigh_po w=10 l=2250.5435
XRn1p10n1p5s3 Rn1p10n1t5s2 Rn1p10n1t5s3 0 sky130_fd_pr__res_xhigh_po w=10 l=2250.5435
XRn1p10n1p5s4 Rn1p10n1t5s3 Rn1p10n1t5s4 0 sky130_fd_pr__res_xhigh_po w=10 l=2250.5435
XRn1p10n1p5s5 Rn1p10n1t5s4 Rn1p10n1t5s5 0 sky130_fd_pr__res_xhigh_po w=10 l=2250.5435
XRn1p10n1p5s6 Rn1p10n1t5s5 Rn1p10n1t5s6 0 sky130_fd_pr__res_xhigh_po w=10 l=2250.5435
XRn1p10n1p5s7 Rn1p10n1t5s6 n1p 0 sky130_fd_pr__res_xhigh_po w=10 l=2250.5435
XRn1p10n1p6s0 in10n Rn1p10n1t6s0 0 sky130_fd_pr__res_xhigh_po w=10 l=2250.5435
XRn1p10n1p6s1 Rn1p10n1t6s0 Rn1p10n1t6s1 0 sky130_fd_pr__res_xhigh_po w=10 l=2250.5435
XRn1p10n1p6s2 Rn1p10n1t6s1 Rn1p10n1t6s2 0 sky130_fd_pr__res_xhigh_po w=10 l=2250.5435
XRn1p10n1p6s3 Rn1p10n1t6s2 Rn1p10n1t6s3 0 sky130_fd_pr__res_xhigh_po w=10 l=2250.5435
XRn1p10n1p6s4 Rn1p10n1t6s3 Rn1p10n1t6s4 0 sky130_fd_pr__res_xhigh_po w=10 l=2250.5435
XRn1p10n1p6s5 Rn1p10n1t6s4 Rn1p10n1t6s5 0 sky130_fd_pr__res_xhigh_po w=10 l=2250.5435
XRn1p10n1p6s6 Rn1p10n1t6s5 Rn1p10n1t6s6 0 sky130_fd_pr__res_xhigh_po w=10 l=2250.5435
XRn1p10n1p6s7 Rn1p10n1t6s6 n1p 0 sky130_fd_pr__res_xhigh_po w=10 l=2250.5435
XRn1p10n1p7s0 in10n Rn1p10n1t7s0 0 sky130_fd_pr__res_xhigh_po w=10 l=2250.5435
XRn1p10n1p7s1 Rn1p10n1t7s0 Rn1p10n1t7s1 0 sky130_fd_pr__res_xhigh_po w=10 l=2250.5435
XRn1p10n1p7s2 Rn1p10n1t7s1 Rn1p10n1t7s2 0 sky130_fd_pr__res_xhigh_po w=10 l=2250.5435
XRn1p10n1p7s3 Rn1p10n1t7s2 Rn1p10n1t7s3 0 sky130_fd_pr__res_xhigh_po w=10 l=2250.5435
XRn1p10n1p7s4 Rn1p10n1t7s3 Rn1p10n1t7s4 0 sky130_fd_pr__res_xhigh_po w=10 l=2250.5435
XRn1p10n1p7s5 Rn1p10n1t7s4 Rn1p10n1t7s5 0 sky130_fd_pr__res_xhigh_po w=10 l=2250.5435
XRn1p10n1p7s6 Rn1p10n1t7s5 Rn1p10n1t7s6 0 sky130_fd_pr__res_xhigh_po w=10 l=2250.5435
XRn1p10n1p7s7 Rn1p10n1t7s6 n1p 0 sky130_fd_pr__res_xhigh_po w=10 l=2250.5435
* n1 input 11 w=-0.149208279345328 w-  bank=n alpha=1 R=223401.365390634 G_phys=4.47624838035983e-06 G_eff=4.47624838035983e-06
* PDK sky130_fd_pr__res_xhigh_po Rn1n11n1 W=10 L=1110.646
* tile Rn1n11n1 8s x 8p same W=10 L=1110.646
XRn1n11n1p0s0 in11 Rn1n11n1t0s0 0 sky130_fd_pr__res_xhigh_po w=10 l=1110.646
XRn1n11n1p0s1 Rn1n11n1t0s0 Rn1n11n1t0s1 0 sky130_fd_pr__res_xhigh_po w=10 l=1110.646
XRn1n11n1p0s2 Rn1n11n1t0s1 Rn1n11n1t0s2 0 sky130_fd_pr__res_xhigh_po w=10 l=1110.646
XRn1n11n1p0s3 Rn1n11n1t0s2 Rn1n11n1t0s3 0 sky130_fd_pr__res_xhigh_po w=10 l=1110.646
XRn1n11n1p0s4 Rn1n11n1t0s3 Rn1n11n1t0s4 0 sky130_fd_pr__res_xhigh_po w=10 l=1110.646
XRn1n11n1p0s5 Rn1n11n1t0s4 Rn1n11n1t0s5 0 sky130_fd_pr__res_xhigh_po w=10 l=1110.646
XRn1n11n1p0s6 Rn1n11n1t0s5 Rn1n11n1t0s6 0 sky130_fd_pr__res_xhigh_po w=10 l=1110.646
XRn1n11n1p0s7 Rn1n11n1t0s6 n1p 0 sky130_fd_pr__res_xhigh_po w=10 l=1110.646
XRn1n11n1p1s0 in11 Rn1n11n1t1s0 0 sky130_fd_pr__res_xhigh_po w=10 l=1110.646
XRn1n11n1p1s1 Rn1n11n1t1s0 Rn1n11n1t1s1 0 sky130_fd_pr__res_xhigh_po w=10 l=1110.646
XRn1n11n1p1s2 Rn1n11n1t1s1 Rn1n11n1t1s2 0 sky130_fd_pr__res_xhigh_po w=10 l=1110.646
XRn1n11n1p1s3 Rn1n11n1t1s2 Rn1n11n1t1s3 0 sky130_fd_pr__res_xhigh_po w=10 l=1110.646
XRn1n11n1p1s4 Rn1n11n1t1s3 Rn1n11n1t1s4 0 sky130_fd_pr__res_xhigh_po w=10 l=1110.646
XRn1n11n1p1s5 Rn1n11n1t1s4 Rn1n11n1t1s5 0 sky130_fd_pr__res_xhigh_po w=10 l=1110.646
XRn1n11n1p1s6 Rn1n11n1t1s5 Rn1n11n1t1s6 0 sky130_fd_pr__res_xhigh_po w=10 l=1110.646
XRn1n11n1p1s7 Rn1n11n1t1s6 n1p 0 sky130_fd_pr__res_xhigh_po w=10 l=1110.646
XRn1n11n1p2s0 in11 Rn1n11n1t2s0 0 sky130_fd_pr__res_xhigh_po w=10 l=1110.646
XRn1n11n1p2s1 Rn1n11n1t2s0 Rn1n11n1t2s1 0 sky130_fd_pr__res_xhigh_po w=10 l=1110.646
XRn1n11n1p2s2 Rn1n11n1t2s1 Rn1n11n1t2s2 0 sky130_fd_pr__res_xhigh_po w=10 l=1110.646
XRn1n11n1p2s3 Rn1n11n1t2s2 Rn1n11n1t2s3 0 sky130_fd_pr__res_xhigh_po w=10 l=1110.646
XRn1n11n1p2s4 Rn1n11n1t2s3 Rn1n11n1t2s4 0 sky130_fd_pr__res_xhigh_po w=10 l=1110.646
XRn1n11n1p2s5 Rn1n11n1t2s4 Rn1n11n1t2s5 0 sky130_fd_pr__res_xhigh_po w=10 l=1110.646
XRn1n11n1p2s6 Rn1n11n1t2s5 Rn1n11n1t2s6 0 sky130_fd_pr__res_xhigh_po w=10 l=1110.646
XRn1n11n1p2s7 Rn1n11n1t2s6 n1p 0 sky130_fd_pr__res_xhigh_po w=10 l=1110.646
XRn1n11n1p3s0 in11 Rn1n11n1t3s0 0 sky130_fd_pr__res_xhigh_po w=10 l=1110.646
XRn1n11n1p3s1 Rn1n11n1t3s0 Rn1n11n1t3s1 0 sky130_fd_pr__res_xhigh_po w=10 l=1110.646
XRn1n11n1p3s2 Rn1n11n1t3s1 Rn1n11n1t3s2 0 sky130_fd_pr__res_xhigh_po w=10 l=1110.646
XRn1n11n1p3s3 Rn1n11n1t3s2 Rn1n11n1t3s3 0 sky130_fd_pr__res_xhigh_po w=10 l=1110.646
XRn1n11n1p3s4 Rn1n11n1t3s3 Rn1n11n1t3s4 0 sky130_fd_pr__res_xhigh_po w=10 l=1110.646
XRn1n11n1p3s5 Rn1n11n1t3s4 Rn1n11n1t3s5 0 sky130_fd_pr__res_xhigh_po w=10 l=1110.646
XRn1n11n1p3s6 Rn1n11n1t3s5 Rn1n11n1t3s6 0 sky130_fd_pr__res_xhigh_po w=10 l=1110.646
XRn1n11n1p3s7 Rn1n11n1t3s6 n1p 0 sky130_fd_pr__res_xhigh_po w=10 l=1110.646
XRn1n11n1p4s0 in11 Rn1n11n1t4s0 0 sky130_fd_pr__res_xhigh_po w=10 l=1110.646
XRn1n11n1p4s1 Rn1n11n1t4s0 Rn1n11n1t4s1 0 sky130_fd_pr__res_xhigh_po w=10 l=1110.646
XRn1n11n1p4s2 Rn1n11n1t4s1 Rn1n11n1t4s2 0 sky130_fd_pr__res_xhigh_po w=10 l=1110.646
XRn1n11n1p4s3 Rn1n11n1t4s2 Rn1n11n1t4s3 0 sky130_fd_pr__res_xhigh_po w=10 l=1110.646
XRn1n11n1p4s4 Rn1n11n1t4s3 Rn1n11n1t4s4 0 sky130_fd_pr__res_xhigh_po w=10 l=1110.646
XRn1n11n1p4s5 Rn1n11n1t4s4 Rn1n11n1t4s5 0 sky130_fd_pr__res_xhigh_po w=10 l=1110.646
XRn1n11n1p4s6 Rn1n11n1t4s5 Rn1n11n1t4s6 0 sky130_fd_pr__res_xhigh_po w=10 l=1110.646
XRn1n11n1p4s7 Rn1n11n1t4s6 n1p 0 sky130_fd_pr__res_xhigh_po w=10 l=1110.646
XRn1n11n1p5s0 in11 Rn1n11n1t5s0 0 sky130_fd_pr__res_xhigh_po w=10 l=1110.646
XRn1n11n1p5s1 Rn1n11n1t5s0 Rn1n11n1t5s1 0 sky130_fd_pr__res_xhigh_po w=10 l=1110.646
XRn1n11n1p5s2 Rn1n11n1t5s1 Rn1n11n1t5s2 0 sky130_fd_pr__res_xhigh_po w=10 l=1110.646
XRn1n11n1p5s3 Rn1n11n1t5s2 Rn1n11n1t5s3 0 sky130_fd_pr__res_xhigh_po w=10 l=1110.646
XRn1n11n1p5s4 Rn1n11n1t5s3 Rn1n11n1t5s4 0 sky130_fd_pr__res_xhigh_po w=10 l=1110.646
XRn1n11n1p5s5 Rn1n11n1t5s4 Rn1n11n1t5s5 0 sky130_fd_pr__res_xhigh_po w=10 l=1110.646
XRn1n11n1p5s6 Rn1n11n1t5s5 Rn1n11n1t5s6 0 sky130_fd_pr__res_xhigh_po w=10 l=1110.646
XRn1n11n1p5s7 Rn1n11n1t5s6 n1p 0 sky130_fd_pr__res_xhigh_po w=10 l=1110.646
XRn1n11n1p6s0 in11 Rn1n11n1t6s0 0 sky130_fd_pr__res_xhigh_po w=10 l=1110.646
XRn1n11n1p6s1 Rn1n11n1t6s0 Rn1n11n1t6s1 0 sky130_fd_pr__res_xhigh_po w=10 l=1110.646
XRn1n11n1p6s2 Rn1n11n1t6s1 Rn1n11n1t6s2 0 sky130_fd_pr__res_xhigh_po w=10 l=1110.646
XRn1n11n1p6s3 Rn1n11n1t6s2 Rn1n11n1t6s3 0 sky130_fd_pr__res_xhigh_po w=10 l=1110.646
XRn1n11n1p6s4 Rn1n11n1t6s3 Rn1n11n1t6s4 0 sky130_fd_pr__res_xhigh_po w=10 l=1110.646
XRn1n11n1p6s5 Rn1n11n1t6s4 Rn1n11n1t6s5 0 sky130_fd_pr__res_xhigh_po w=10 l=1110.646
XRn1n11n1p6s6 Rn1n11n1t6s5 Rn1n11n1t6s6 0 sky130_fd_pr__res_xhigh_po w=10 l=1110.646
XRn1n11n1p6s7 Rn1n11n1t6s6 n1p 0 sky130_fd_pr__res_xhigh_po w=10 l=1110.646
XRn1n11n1p7s0 in11 Rn1n11n1t7s0 0 sky130_fd_pr__res_xhigh_po w=10 l=1110.646
XRn1n11n1p7s1 Rn1n11n1t7s0 Rn1n11n1t7s1 0 sky130_fd_pr__res_xhigh_po w=10 l=1110.646
XRn1n11n1p7s2 Rn1n11n1t7s1 Rn1n11n1t7s2 0 sky130_fd_pr__res_xhigh_po w=10 l=1110.646
XRn1n11n1p7s3 Rn1n11n1t7s2 Rn1n11n1t7s3 0 sky130_fd_pr__res_xhigh_po w=10 l=1110.646
XRn1n11n1p7s4 Rn1n11n1t7s3 Rn1n11n1t7s4 0 sky130_fd_pr__res_xhigh_po w=10 l=1110.646
XRn1n11n1p7s5 Rn1n11n1t7s4 Rn1n11n1t7s5 0 sky130_fd_pr__res_xhigh_po w=10 l=1110.646
XRn1n11n1p7s6 Rn1n11n1t7s5 Rn1n11n1t7s6 0 sky130_fd_pr__res_xhigh_po w=10 l=1110.646
XRn1n11n1p7s7 Rn1n11n1t7s6 n1p 0 sky130_fd_pr__res_xhigh_po w=10 l=1110.646
* n1 input 12 w=-0.475362564845884 w-  bank=n alpha=1 R=70121.9149306388 G_phys=1.42608769453765e-05 G_eff=1.42608769453765e-05
* PDK sky130_fd_pr__res_xhigh_po Rn1n12n1 W=10 L=348.54053
* tile Rn1n12n1 8s x 8p same W=10 L=348.54053
XRn1n12n1p0s0 in12 Rn1n12n1t0s0 0 sky130_fd_pr__res_xhigh_po w=10 l=348.54053
XRn1n12n1p0s1 Rn1n12n1t0s0 Rn1n12n1t0s1 0 sky130_fd_pr__res_xhigh_po w=10 l=348.54053
XRn1n12n1p0s2 Rn1n12n1t0s1 Rn1n12n1t0s2 0 sky130_fd_pr__res_xhigh_po w=10 l=348.54053
XRn1n12n1p0s3 Rn1n12n1t0s2 Rn1n12n1t0s3 0 sky130_fd_pr__res_xhigh_po w=10 l=348.54053
XRn1n12n1p0s4 Rn1n12n1t0s3 Rn1n12n1t0s4 0 sky130_fd_pr__res_xhigh_po w=10 l=348.54053
XRn1n12n1p0s5 Rn1n12n1t0s4 Rn1n12n1t0s5 0 sky130_fd_pr__res_xhigh_po w=10 l=348.54053
XRn1n12n1p0s6 Rn1n12n1t0s5 Rn1n12n1t0s6 0 sky130_fd_pr__res_xhigh_po w=10 l=348.54053
XRn1n12n1p0s7 Rn1n12n1t0s6 n1p 0 sky130_fd_pr__res_xhigh_po w=10 l=348.54053
XRn1n12n1p1s0 in12 Rn1n12n1t1s0 0 sky130_fd_pr__res_xhigh_po w=10 l=348.54053
XRn1n12n1p1s1 Rn1n12n1t1s0 Rn1n12n1t1s1 0 sky130_fd_pr__res_xhigh_po w=10 l=348.54053
XRn1n12n1p1s2 Rn1n12n1t1s1 Rn1n12n1t1s2 0 sky130_fd_pr__res_xhigh_po w=10 l=348.54053
XRn1n12n1p1s3 Rn1n12n1t1s2 Rn1n12n1t1s3 0 sky130_fd_pr__res_xhigh_po w=10 l=348.54053
XRn1n12n1p1s4 Rn1n12n1t1s3 Rn1n12n1t1s4 0 sky130_fd_pr__res_xhigh_po w=10 l=348.54053
XRn1n12n1p1s5 Rn1n12n1t1s4 Rn1n12n1t1s5 0 sky130_fd_pr__res_xhigh_po w=10 l=348.54053
XRn1n12n1p1s6 Rn1n12n1t1s5 Rn1n12n1t1s6 0 sky130_fd_pr__res_xhigh_po w=10 l=348.54053
XRn1n12n1p1s7 Rn1n12n1t1s6 n1p 0 sky130_fd_pr__res_xhigh_po w=10 l=348.54053
XRn1n12n1p2s0 in12 Rn1n12n1t2s0 0 sky130_fd_pr__res_xhigh_po w=10 l=348.54053
XRn1n12n1p2s1 Rn1n12n1t2s0 Rn1n12n1t2s1 0 sky130_fd_pr__res_xhigh_po w=10 l=348.54053
XRn1n12n1p2s2 Rn1n12n1t2s1 Rn1n12n1t2s2 0 sky130_fd_pr__res_xhigh_po w=10 l=348.54053
XRn1n12n1p2s3 Rn1n12n1t2s2 Rn1n12n1t2s3 0 sky130_fd_pr__res_xhigh_po w=10 l=348.54053
XRn1n12n1p2s4 Rn1n12n1t2s3 Rn1n12n1t2s4 0 sky130_fd_pr__res_xhigh_po w=10 l=348.54053
XRn1n12n1p2s5 Rn1n12n1t2s4 Rn1n12n1t2s5 0 sky130_fd_pr__res_xhigh_po w=10 l=348.54053
XRn1n12n1p2s6 Rn1n12n1t2s5 Rn1n12n1t2s6 0 sky130_fd_pr__res_xhigh_po w=10 l=348.54053
XRn1n12n1p2s7 Rn1n12n1t2s6 n1p 0 sky130_fd_pr__res_xhigh_po w=10 l=348.54053
XRn1n12n1p3s0 in12 Rn1n12n1t3s0 0 sky130_fd_pr__res_xhigh_po w=10 l=348.54053
XRn1n12n1p3s1 Rn1n12n1t3s0 Rn1n12n1t3s1 0 sky130_fd_pr__res_xhigh_po w=10 l=348.54053
XRn1n12n1p3s2 Rn1n12n1t3s1 Rn1n12n1t3s2 0 sky130_fd_pr__res_xhigh_po w=10 l=348.54053
XRn1n12n1p3s3 Rn1n12n1t3s2 Rn1n12n1t3s3 0 sky130_fd_pr__res_xhigh_po w=10 l=348.54053
XRn1n12n1p3s4 Rn1n12n1t3s3 Rn1n12n1t3s4 0 sky130_fd_pr__res_xhigh_po w=10 l=348.54053
XRn1n12n1p3s5 Rn1n12n1t3s4 Rn1n12n1t3s5 0 sky130_fd_pr__res_xhigh_po w=10 l=348.54053
XRn1n12n1p3s6 Rn1n12n1t3s5 Rn1n12n1t3s6 0 sky130_fd_pr__res_xhigh_po w=10 l=348.54053
XRn1n12n1p3s7 Rn1n12n1t3s6 n1p 0 sky130_fd_pr__res_xhigh_po w=10 l=348.54053
XRn1n12n1p4s0 in12 Rn1n12n1t4s0 0 sky130_fd_pr__res_xhigh_po w=10 l=348.54053
XRn1n12n1p4s1 Rn1n12n1t4s0 Rn1n12n1t4s1 0 sky130_fd_pr__res_xhigh_po w=10 l=348.54053
XRn1n12n1p4s2 Rn1n12n1t4s1 Rn1n12n1t4s2 0 sky130_fd_pr__res_xhigh_po w=10 l=348.54053
XRn1n12n1p4s3 Rn1n12n1t4s2 Rn1n12n1t4s3 0 sky130_fd_pr__res_xhigh_po w=10 l=348.54053
XRn1n12n1p4s4 Rn1n12n1t4s3 Rn1n12n1t4s4 0 sky130_fd_pr__res_xhigh_po w=10 l=348.54053
XRn1n12n1p4s5 Rn1n12n1t4s4 Rn1n12n1t4s5 0 sky130_fd_pr__res_xhigh_po w=10 l=348.54053
XRn1n12n1p4s6 Rn1n12n1t4s5 Rn1n12n1t4s6 0 sky130_fd_pr__res_xhigh_po w=10 l=348.54053
XRn1n12n1p4s7 Rn1n12n1t4s6 n1p 0 sky130_fd_pr__res_xhigh_po w=10 l=348.54053
XRn1n12n1p5s0 in12 Rn1n12n1t5s0 0 sky130_fd_pr__res_xhigh_po w=10 l=348.54053
XRn1n12n1p5s1 Rn1n12n1t5s0 Rn1n12n1t5s1 0 sky130_fd_pr__res_xhigh_po w=10 l=348.54053
XRn1n12n1p5s2 Rn1n12n1t5s1 Rn1n12n1t5s2 0 sky130_fd_pr__res_xhigh_po w=10 l=348.54053
XRn1n12n1p5s3 Rn1n12n1t5s2 Rn1n12n1t5s3 0 sky130_fd_pr__res_xhigh_po w=10 l=348.54053
XRn1n12n1p5s4 Rn1n12n1t5s3 Rn1n12n1t5s4 0 sky130_fd_pr__res_xhigh_po w=10 l=348.54053
XRn1n12n1p5s5 Rn1n12n1t5s4 Rn1n12n1t5s5 0 sky130_fd_pr__res_xhigh_po w=10 l=348.54053
XRn1n12n1p5s6 Rn1n12n1t5s5 Rn1n12n1t5s6 0 sky130_fd_pr__res_xhigh_po w=10 l=348.54053
XRn1n12n1p5s7 Rn1n12n1t5s6 n1p 0 sky130_fd_pr__res_xhigh_po w=10 l=348.54053
XRn1n12n1p6s0 in12 Rn1n12n1t6s0 0 sky130_fd_pr__res_xhigh_po w=10 l=348.54053
XRn1n12n1p6s1 Rn1n12n1t6s0 Rn1n12n1t6s1 0 sky130_fd_pr__res_xhigh_po w=10 l=348.54053
XRn1n12n1p6s2 Rn1n12n1t6s1 Rn1n12n1t6s2 0 sky130_fd_pr__res_xhigh_po w=10 l=348.54053
XRn1n12n1p6s3 Rn1n12n1t6s2 Rn1n12n1t6s3 0 sky130_fd_pr__res_xhigh_po w=10 l=348.54053
XRn1n12n1p6s4 Rn1n12n1t6s3 Rn1n12n1t6s4 0 sky130_fd_pr__res_xhigh_po w=10 l=348.54053
XRn1n12n1p6s5 Rn1n12n1t6s4 Rn1n12n1t6s5 0 sky130_fd_pr__res_xhigh_po w=10 l=348.54053
XRn1n12n1p6s6 Rn1n12n1t6s5 Rn1n12n1t6s6 0 sky130_fd_pr__res_xhigh_po w=10 l=348.54053
XRn1n12n1p6s7 Rn1n12n1t6s6 n1p 0 sky130_fd_pr__res_xhigh_po w=10 l=348.54053
XRn1n12n1p7s0 in12 Rn1n12n1t7s0 0 sky130_fd_pr__res_xhigh_po w=10 l=348.54053
XRn1n12n1p7s1 Rn1n12n1t7s0 Rn1n12n1t7s1 0 sky130_fd_pr__res_xhigh_po w=10 l=348.54053
XRn1n12n1p7s2 Rn1n12n1t7s1 Rn1n12n1t7s2 0 sky130_fd_pr__res_xhigh_po w=10 l=348.54053
XRn1n12n1p7s3 Rn1n12n1t7s2 Rn1n12n1t7s3 0 sky130_fd_pr__res_xhigh_po w=10 l=348.54053
XRn1n12n1p7s4 Rn1n12n1t7s3 Rn1n12n1t7s4 0 sky130_fd_pr__res_xhigh_po w=10 l=348.54053
XRn1n12n1p7s5 Rn1n12n1t7s4 Rn1n12n1t7s5 0 sky130_fd_pr__res_xhigh_po w=10 l=348.54053
XRn1n12n1p7s6 Rn1n12n1t7s5 Rn1n12n1t7s6 0 sky130_fd_pr__res_xhigh_po w=10 l=348.54053
XRn1n12n1p7s7 Rn1n12n1t7s6 n1p 0 sky130_fd_pr__res_xhigh_po w=10 l=348.54053
* n1 input 13 w=-0.0533811781970356 w-  bank=n alpha=1 R=624439.820535554 G_phys=1.60143534591107e-06 G_eff=1.60143534591107e-06
* PDK sky130_fd_pr__res_xhigh_po Rn1n13n1 W=10 L=3104.6092
* tile Rn1n13n1 8s x 8p same W=10 L=3104.6092
XRn1n13n1p0s0 in13 Rn1n13n1t0s0 0 sky130_fd_pr__res_xhigh_po w=10 l=3104.6092
XRn1n13n1p0s1 Rn1n13n1t0s0 Rn1n13n1t0s1 0 sky130_fd_pr__res_xhigh_po w=10 l=3104.6092
XRn1n13n1p0s2 Rn1n13n1t0s1 Rn1n13n1t0s2 0 sky130_fd_pr__res_xhigh_po w=10 l=3104.6092
XRn1n13n1p0s3 Rn1n13n1t0s2 Rn1n13n1t0s3 0 sky130_fd_pr__res_xhigh_po w=10 l=3104.6092
XRn1n13n1p0s4 Rn1n13n1t0s3 Rn1n13n1t0s4 0 sky130_fd_pr__res_xhigh_po w=10 l=3104.6092
XRn1n13n1p0s5 Rn1n13n1t0s4 Rn1n13n1t0s5 0 sky130_fd_pr__res_xhigh_po w=10 l=3104.6092
XRn1n13n1p0s6 Rn1n13n1t0s5 Rn1n13n1t0s6 0 sky130_fd_pr__res_xhigh_po w=10 l=3104.6092
XRn1n13n1p0s7 Rn1n13n1t0s6 n1p 0 sky130_fd_pr__res_xhigh_po w=10 l=3104.6092
XRn1n13n1p1s0 in13 Rn1n13n1t1s0 0 sky130_fd_pr__res_xhigh_po w=10 l=3104.6092
XRn1n13n1p1s1 Rn1n13n1t1s0 Rn1n13n1t1s1 0 sky130_fd_pr__res_xhigh_po w=10 l=3104.6092
XRn1n13n1p1s2 Rn1n13n1t1s1 Rn1n13n1t1s2 0 sky130_fd_pr__res_xhigh_po w=10 l=3104.6092
XRn1n13n1p1s3 Rn1n13n1t1s2 Rn1n13n1t1s3 0 sky130_fd_pr__res_xhigh_po w=10 l=3104.6092
XRn1n13n1p1s4 Rn1n13n1t1s3 Rn1n13n1t1s4 0 sky130_fd_pr__res_xhigh_po w=10 l=3104.6092
XRn1n13n1p1s5 Rn1n13n1t1s4 Rn1n13n1t1s5 0 sky130_fd_pr__res_xhigh_po w=10 l=3104.6092
XRn1n13n1p1s6 Rn1n13n1t1s5 Rn1n13n1t1s6 0 sky130_fd_pr__res_xhigh_po w=10 l=3104.6092
XRn1n13n1p1s7 Rn1n13n1t1s6 n1p 0 sky130_fd_pr__res_xhigh_po w=10 l=3104.6092
XRn1n13n1p2s0 in13 Rn1n13n1t2s0 0 sky130_fd_pr__res_xhigh_po w=10 l=3104.6092
XRn1n13n1p2s1 Rn1n13n1t2s0 Rn1n13n1t2s1 0 sky130_fd_pr__res_xhigh_po w=10 l=3104.6092
XRn1n13n1p2s2 Rn1n13n1t2s1 Rn1n13n1t2s2 0 sky130_fd_pr__res_xhigh_po w=10 l=3104.6092
XRn1n13n1p2s3 Rn1n13n1t2s2 Rn1n13n1t2s3 0 sky130_fd_pr__res_xhigh_po w=10 l=3104.6092
XRn1n13n1p2s4 Rn1n13n1t2s3 Rn1n13n1t2s4 0 sky130_fd_pr__res_xhigh_po w=10 l=3104.6092
XRn1n13n1p2s5 Rn1n13n1t2s4 Rn1n13n1t2s5 0 sky130_fd_pr__res_xhigh_po w=10 l=3104.6092
XRn1n13n1p2s6 Rn1n13n1t2s5 Rn1n13n1t2s6 0 sky130_fd_pr__res_xhigh_po w=10 l=3104.6092
XRn1n13n1p2s7 Rn1n13n1t2s6 n1p 0 sky130_fd_pr__res_xhigh_po w=10 l=3104.6092
XRn1n13n1p3s0 in13 Rn1n13n1t3s0 0 sky130_fd_pr__res_xhigh_po w=10 l=3104.6092
XRn1n13n1p3s1 Rn1n13n1t3s0 Rn1n13n1t3s1 0 sky130_fd_pr__res_xhigh_po w=10 l=3104.6092
XRn1n13n1p3s2 Rn1n13n1t3s1 Rn1n13n1t3s2 0 sky130_fd_pr__res_xhigh_po w=10 l=3104.6092
XRn1n13n1p3s3 Rn1n13n1t3s2 Rn1n13n1t3s3 0 sky130_fd_pr__res_xhigh_po w=10 l=3104.6092
XRn1n13n1p3s4 Rn1n13n1t3s3 Rn1n13n1t3s4 0 sky130_fd_pr__res_xhigh_po w=10 l=3104.6092
XRn1n13n1p3s5 Rn1n13n1t3s4 Rn1n13n1t3s5 0 sky130_fd_pr__res_xhigh_po w=10 l=3104.6092
XRn1n13n1p3s6 Rn1n13n1t3s5 Rn1n13n1t3s6 0 sky130_fd_pr__res_xhigh_po w=10 l=3104.6092
XRn1n13n1p3s7 Rn1n13n1t3s6 n1p 0 sky130_fd_pr__res_xhigh_po w=10 l=3104.6092
XRn1n13n1p4s0 in13 Rn1n13n1t4s0 0 sky130_fd_pr__res_xhigh_po w=10 l=3104.6092
XRn1n13n1p4s1 Rn1n13n1t4s0 Rn1n13n1t4s1 0 sky130_fd_pr__res_xhigh_po w=10 l=3104.6092
XRn1n13n1p4s2 Rn1n13n1t4s1 Rn1n13n1t4s2 0 sky130_fd_pr__res_xhigh_po w=10 l=3104.6092
XRn1n13n1p4s3 Rn1n13n1t4s2 Rn1n13n1t4s3 0 sky130_fd_pr__res_xhigh_po w=10 l=3104.6092
XRn1n13n1p4s4 Rn1n13n1t4s3 Rn1n13n1t4s4 0 sky130_fd_pr__res_xhigh_po w=10 l=3104.6092
XRn1n13n1p4s5 Rn1n13n1t4s4 Rn1n13n1t4s5 0 sky130_fd_pr__res_xhigh_po w=10 l=3104.6092
XRn1n13n1p4s6 Rn1n13n1t4s5 Rn1n13n1t4s6 0 sky130_fd_pr__res_xhigh_po w=10 l=3104.6092
XRn1n13n1p4s7 Rn1n13n1t4s6 n1p 0 sky130_fd_pr__res_xhigh_po w=10 l=3104.6092
XRn1n13n1p5s0 in13 Rn1n13n1t5s0 0 sky130_fd_pr__res_xhigh_po w=10 l=3104.6092
XRn1n13n1p5s1 Rn1n13n1t5s0 Rn1n13n1t5s1 0 sky130_fd_pr__res_xhigh_po w=10 l=3104.6092
XRn1n13n1p5s2 Rn1n13n1t5s1 Rn1n13n1t5s2 0 sky130_fd_pr__res_xhigh_po w=10 l=3104.6092
XRn1n13n1p5s3 Rn1n13n1t5s2 Rn1n13n1t5s3 0 sky130_fd_pr__res_xhigh_po w=10 l=3104.6092
XRn1n13n1p5s4 Rn1n13n1t5s3 Rn1n13n1t5s4 0 sky130_fd_pr__res_xhigh_po w=10 l=3104.6092
XRn1n13n1p5s5 Rn1n13n1t5s4 Rn1n13n1t5s5 0 sky130_fd_pr__res_xhigh_po w=10 l=3104.6092
XRn1n13n1p5s6 Rn1n13n1t5s5 Rn1n13n1t5s6 0 sky130_fd_pr__res_xhigh_po w=10 l=3104.6092
XRn1n13n1p5s7 Rn1n13n1t5s6 n1p 0 sky130_fd_pr__res_xhigh_po w=10 l=3104.6092
XRn1n13n1p6s0 in13 Rn1n13n1t6s0 0 sky130_fd_pr__res_xhigh_po w=10 l=3104.6092
XRn1n13n1p6s1 Rn1n13n1t6s0 Rn1n13n1t6s1 0 sky130_fd_pr__res_xhigh_po w=10 l=3104.6092
XRn1n13n1p6s2 Rn1n13n1t6s1 Rn1n13n1t6s2 0 sky130_fd_pr__res_xhigh_po w=10 l=3104.6092
XRn1n13n1p6s3 Rn1n13n1t6s2 Rn1n13n1t6s3 0 sky130_fd_pr__res_xhigh_po w=10 l=3104.6092
XRn1n13n1p6s4 Rn1n13n1t6s3 Rn1n13n1t6s4 0 sky130_fd_pr__res_xhigh_po w=10 l=3104.6092
XRn1n13n1p6s5 Rn1n13n1t6s4 Rn1n13n1t6s5 0 sky130_fd_pr__res_xhigh_po w=10 l=3104.6092
XRn1n13n1p6s6 Rn1n13n1t6s5 Rn1n13n1t6s6 0 sky130_fd_pr__res_xhigh_po w=10 l=3104.6092
XRn1n13n1p6s7 Rn1n13n1t6s6 n1p 0 sky130_fd_pr__res_xhigh_po w=10 l=3104.6092
XRn1n13n1p7s0 in13 Rn1n13n1t7s0 0 sky130_fd_pr__res_xhigh_po w=10 l=3104.6092
XRn1n13n1p7s1 Rn1n13n1t7s0 Rn1n13n1t7s1 0 sky130_fd_pr__res_xhigh_po w=10 l=3104.6092
XRn1n13n1p7s2 Rn1n13n1t7s1 Rn1n13n1t7s2 0 sky130_fd_pr__res_xhigh_po w=10 l=3104.6092
XRn1n13n1p7s3 Rn1n13n1t7s2 Rn1n13n1t7s3 0 sky130_fd_pr__res_xhigh_po w=10 l=3104.6092
XRn1n13n1p7s4 Rn1n13n1t7s3 Rn1n13n1t7s4 0 sky130_fd_pr__res_xhigh_po w=10 l=3104.6092
XRn1n13n1p7s5 Rn1n13n1t7s4 Rn1n13n1t7s5 0 sky130_fd_pr__res_xhigh_po w=10 l=3104.6092
XRn1n13n1p7s6 Rn1n13n1t7s5 Rn1n13n1t7s6 0 sky130_fd_pr__res_xhigh_po w=10 l=3104.6092
XRn1n13n1p7s7 Rn1n13n1t7s6 n1p 0 sky130_fd_pr__res_xhigh_po w=10 l=3104.6092
* n1 input 14 w=+0.279456004632752 w+  bank=n alpha=1 R=119279.359830319 G_phys=8.38368013898257e-06 G_eff=8.38368013898257e-06
* PDK sky130_fd_pr__res_xhigh_po Rn1p14n1 W=10 L=592.95135
* tile Rn1p14n1 8s x 8p same W=10 L=592.95135
XRn1p14n1p0s0 in14n Rn1p14n1t0s0 0 sky130_fd_pr__res_xhigh_po w=10 l=592.95135
XRn1p14n1p0s1 Rn1p14n1t0s0 Rn1p14n1t0s1 0 sky130_fd_pr__res_xhigh_po w=10 l=592.95135
XRn1p14n1p0s2 Rn1p14n1t0s1 Rn1p14n1t0s2 0 sky130_fd_pr__res_xhigh_po w=10 l=592.95135
XRn1p14n1p0s3 Rn1p14n1t0s2 Rn1p14n1t0s3 0 sky130_fd_pr__res_xhigh_po w=10 l=592.95135
XRn1p14n1p0s4 Rn1p14n1t0s3 Rn1p14n1t0s4 0 sky130_fd_pr__res_xhigh_po w=10 l=592.95135
XRn1p14n1p0s5 Rn1p14n1t0s4 Rn1p14n1t0s5 0 sky130_fd_pr__res_xhigh_po w=10 l=592.95135
XRn1p14n1p0s6 Rn1p14n1t0s5 Rn1p14n1t0s6 0 sky130_fd_pr__res_xhigh_po w=10 l=592.95135
XRn1p14n1p0s7 Rn1p14n1t0s6 n1p 0 sky130_fd_pr__res_xhigh_po w=10 l=592.95135
XRn1p14n1p1s0 in14n Rn1p14n1t1s0 0 sky130_fd_pr__res_xhigh_po w=10 l=592.95135
XRn1p14n1p1s1 Rn1p14n1t1s0 Rn1p14n1t1s1 0 sky130_fd_pr__res_xhigh_po w=10 l=592.95135
XRn1p14n1p1s2 Rn1p14n1t1s1 Rn1p14n1t1s2 0 sky130_fd_pr__res_xhigh_po w=10 l=592.95135
XRn1p14n1p1s3 Rn1p14n1t1s2 Rn1p14n1t1s3 0 sky130_fd_pr__res_xhigh_po w=10 l=592.95135
XRn1p14n1p1s4 Rn1p14n1t1s3 Rn1p14n1t1s4 0 sky130_fd_pr__res_xhigh_po w=10 l=592.95135
XRn1p14n1p1s5 Rn1p14n1t1s4 Rn1p14n1t1s5 0 sky130_fd_pr__res_xhigh_po w=10 l=592.95135
XRn1p14n1p1s6 Rn1p14n1t1s5 Rn1p14n1t1s6 0 sky130_fd_pr__res_xhigh_po w=10 l=592.95135
XRn1p14n1p1s7 Rn1p14n1t1s6 n1p 0 sky130_fd_pr__res_xhigh_po w=10 l=592.95135
XRn1p14n1p2s0 in14n Rn1p14n1t2s0 0 sky130_fd_pr__res_xhigh_po w=10 l=592.95135
XRn1p14n1p2s1 Rn1p14n1t2s0 Rn1p14n1t2s1 0 sky130_fd_pr__res_xhigh_po w=10 l=592.95135
XRn1p14n1p2s2 Rn1p14n1t2s1 Rn1p14n1t2s2 0 sky130_fd_pr__res_xhigh_po w=10 l=592.95135
XRn1p14n1p2s3 Rn1p14n1t2s2 Rn1p14n1t2s3 0 sky130_fd_pr__res_xhigh_po w=10 l=592.95135
XRn1p14n1p2s4 Rn1p14n1t2s3 Rn1p14n1t2s4 0 sky130_fd_pr__res_xhigh_po w=10 l=592.95135
XRn1p14n1p2s5 Rn1p14n1t2s4 Rn1p14n1t2s5 0 sky130_fd_pr__res_xhigh_po w=10 l=592.95135
XRn1p14n1p2s6 Rn1p14n1t2s5 Rn1p14n1t2s6 0 sky130_fd_pr__res_xhigh_po w=10 l=592.95135
XRn1p14n1p2s7 Rn1p14n1t2s6 n1p 0 sky130_fd_pr__res_xhigh_po w=10 l=592.95135
XRn1p14n1p3s0 in14n Rn1p14n1t3s0 0 sky130_fd_pr__res_xhigh_po w=10 l=592.95135
XRn1p14n1p3s1 Rn1p14n1t3s0 Rn1p14n1t3s1 0 sky130_fd_pr__res_xhigh_po w=10 l=592.95135
XRn1p14n1p3s2 Rn1p14n1t3s1 Rn1p14n1t3s2 0 sky130_fd_pr__res_xhigh_po w=10 l=592.95135
XRn1p14n1p3s3 Rn1p14n1t3s2 Rn1p14n1t3s3 0 sky130_fd_pr__res_xhigh_po w=10 l=592.95135
XRn1p14n1p3s4 Rn1p14n1t3s3 Rn1p14n1t3s4 0 sky130_fd_pr__res_xhigh_po w=10 l=592.95135
XRn1p14n1p3s5 Rn1p14n1t3s4 Rn1p14n1t3s5 0 sky130_fd_pr__res_xhigh_po w=10 l=592.95135
XRn1p14n1p3s6 Rn1p14n1t3s5 Rn1p14n1t3s6 0 sky130_fd_pr__res_xhigh_po w=10 l=592.95135
XRn1p14n1p3s7 Rn1p14n1t3s6 n1p 0 sky130_fd_pr__res_xhigh_po w=10 l=592.95135
XRn1p14n1p4s0 in14n Rn1p14n1t4s0 0 sky130_fd_pr__res_xhigh_po w=10 l=592.95135
XRn1p14n1p4s1 Rn1p14n1t4s0 Rn1p14n1t4s1 0 sky130_fd_pr__res_xhigh_po w=10 l=592.95135
XRn1p14n1p4s2 Rn1p14n1t4s1 Rn1p14n1t4s2 0 sky130_fd_pr__res_xhigh_po w=10 l=592.95135
XRn1p14n1p4s3 Rn1p14n1t4s2 Rn1p14n1t4s3 0 sky130_fd_pr__res_xhigh_po w=10 l=592.95135
XRn1p14n1p4s4 Rn1p14n1t4s3 Rn1p14n1t4s4 0 sky130_fd_pr__res_xhigh_po w=10 l=592.95135
XRn1p14n1p4s5 Rn1p14n1t4s4 Rn1p14n1t4s5 0 sky130_fd_pr__res_xhigh_po w=10 l=592.95135
XRn1p14n1p4s6 Rn1p14n1t4s5 Rn1p14n1t4s6 0 sky130_fd_pr__res_xhigh_po w=10 l=592.95135
XRn1p14n1p4s7 Rn1p14n1t4s6 n1p 0 sky130_fd_pr__res_xhigh_po w=10 l=592.95135
XRn1p14n1p5s0 in14n Rn1p14n1t5s0 0 sky130_fd_pr__res_xhigh_po w=10 l=592.95135
XRn1p14n1p5s1 Rn1p14n1t5s0 Rn1p14n1t5s1 0 sky130_fd_pr__res_xhigh_po w=10 l=592.95135
XRn1p14n1p5s2 Rn1p14n1t5s1 Rn1p14n1t5s2 0 sky130_fd_pr__res_xhigh_po w=10 l=592.95135
XRn1p14n1p5s3 Rn1p14n1t5s2 Rn1p14n1t5s3 0 sky130_fd_pr__res_xhigh_po w=10 l=592.95135
XRn1p14n1p5s4 Rn1p14n1t5s3 Rn1p14n1t5s4 0 sky130_fd_pr__res_xhigh_po w=10 l=592.95135
XRn1p14n1p5s5 Rn1p14n1t5s4 Rn1p14n1t5s5 0 sky130_fd_pr__res_xhigh_po w=10 l=592.95135
XRn1p14n1p5s6 Rn1p14n1t5s5 Rn1p14n1t5s6 0 sky130_fd_pr__res_xhigh_po w=10 l=592.95135
XRn1p14n1p5s7 Rn1p14n1t5s6 n1p 0 sky130_fd_pr__res_xhigh_po w=10 l=592.95135
XRn1p14n1p6s0 in14n Rn1p14n1t6s0 0 sky130_fd_pr__res_xhigh_po w=10 l=592.95135
XRn1p14n1p6s1 Rn1p14n1t6s0 Rn1p14n1t6s1 0 sky130_fd_pr__res_xhigh_po w=10 l=592.95135
XRn1p14n1p6s2 Rn1p14n1t6s1 Rn1p14n1t6s2 0 sky130_fd_pr__res_xhigh_po w=10 l=592.95135
XRn1p14n1p6s3 Rn1p14n1t6s2 Rn1p14n1t6s3 0 sky130_fd_pr__res_xhigh_po w=10 l=592.95135
XRn1p14n1p6s4 Rn1p14n1t6s3 Rn1p14n1t6s4 0 sky130_fd_pr__res_xhigh_po w=10 l=592.95135
XRn1p14n1p6s5 Rn1p14n1t6s4 Rn1p14n1t6s5 0 sky130_fd_pr__res_xhigh_po w=10 l=592.95135
XRn1p14n1p6s6 Rn1p14n1t6s5 Rn1p14n1t6s6 0 sky130_fd_pr__res_xhigh_po w=10 l=592.95135
XRn1p14n1p6s7 Rn1p14n1t6s6 n1p 0 sky130_fd_pr__res_xhigh_po w=10 l=592.95135
XRn1p14n1p7s0 in14n Rn1p14n1t7s0 0 sky130_fd_pr__res_xhigh_po w=10 l=592.95135
XRn1p14n1p7s1 Rn1p14n1t7s0 Rn1p14n1t7s1 0 sky130_fd_pr__res_xhigh_po w=10 l=592.95135
XRn1p14n1p7s2 Rn1p14n1t7s1 Rn1p14n1t7s2 0 sky130_fd_pr__res_xhigh_po w=10 l=592.95135
XRn1p14n1p7s3 Rn1p14n1t7s2 Rn1p14n1t7s3 0 sky130_fd_pr__res_xhigh_po w=10 l=592.95135
XRn1p14n1p7s4 Rn1p14n1t7s3 Rn1p14n1t7s4 0 sky130_fd_pr__res_xhigh_po w=10 l=592.95135
XRn1p14n1p7s5 Rn1p14n1t7s4 Rn1p14n1t7s5 0 sky130_fd_pr__res_xhigh_po w=10 l=592.95135
XRn1p14n1p7s6 Rn1p14n1t7s5 Rn1p14n1t7s6 0 sky130_fd_pr__res_xhigh_po w=10 l=592.95135
XRn1p14n1p7s7 Rn1p14n1t7s6 n1p 0 sky130_fd_pr__res_xhigh_po w=10 l=592.95135
* n1 input 15 w=-0.0744870090943736 w-  bank=n alpha=1 R=447505.326614748 G_phys=2.23461027283121e-06 G_eff=2.23461027283121e-06
* PDK sky130_fd_pr__res_xhigh_po Rn1n15n1 W=10 L=2224.8909
* tile Rn1n15n1 8s x 8p same W=10 L=2224.8909
XRn1n15n1p0s0 in15 Rn1n15n1t0s0 0 sky130_fd_pr__res_xhigh_po w=10 l=2224.8909
XRn1n15n1p0s1 Rn1n15n1t0s0 Rn1n15n1t0s1 0 sky130_fd_pr__res_xhigh_po w=10 l=2224.8909
XRn1n15n1p0s2 Rn1n15n1t0s1 Rn1n15n1t0s2 0 sky130_fd_pr__res_xhigh_po w=10 l=2224.8909
XRn1n15n1p0s3 Rn1n15n1t0s2 Rn1n15n1t0s3 0 sky130_fd_pr__res_xhigh_po w=10 l=2224.8909
XRn1n15n1p0s4 Rn1n15n1t0s3 Rn1n15n1t0s4 0 sky130_fd_pr__res_xhigh_po w=10 l=2224.8909
XRn1n15n1p0s5 Rn1n15n1t0s4 Rn1n15n1t0s5 0 sky130_fd_pr__res_xhigh_po w=10 l=2224.8909
XRn1n15n1p0s6 Rn1n15n1t0s5 Rn1n15n1t0s6 0 sky130_fd_pr__res_xhigh_po w=10 l=2224.8909
XRn1n15n1p0s7 Rn1n15n1t0s6 n1p 0 sky130_fd_pr__res_xhigh_po w=10 l=2224.8909
XRn1n15n1p1s0 in15 Rn1n15n1t1s0 0 sky130_fd_pr__res_xhigh_po w=10 l=2224.8909
XRn1n15n1p1s1 Rn1n15n1t1s0 Rn1n15n1t1s1 0 sky130_fd_pr__res_xhigh_po w=10 l=2224.8909
XRn1n15n1p1s2 Rn1n15n1t1s1 Rn1n15n1t1s2 0 sky130_fd_pr__res_xhigh_po w=10 l=2224.8909
XRn1n15n1p1s3 Rn1n15n1t1s2 Rn1n15n1t1s3 0 sky130_fd_pr__res_xhigh_po w=10 l=2224.8909
XRn1n15n1p1s4 Rn1n15n1t1s3 Rn1n15n1t1s4 0 sky130_fd_pr__res_xhigh_po w=10 l=2224.8909
XRn1n15n1p1s5 Rn1n15n1t1s4 Rn1n15n1t1s5 0 sky130_fd_pr__res_xhigh_po w=10 l=2224.8909
XRn1n15n1p1s6 Rn1n15n1t1s5 Rn1n15n1t1s6 0 sky130_fd_pr__res_xhigh_po w=10 l=2224.8909
XRn1n15n1p1s7 Rn1n15n1t1s6 n1p 0 sky130_fd_pr__res_xhigh_po w=10 l=2224.8909
XRn1n15n1p2s0 in15 Rn1n15n1t2s0 0 sky130_fd_pr__res_xhigh_po w=10 l=2224.8909
XRn1n15n1p2s1 Rn1n15n1t2s0 Rn1n15n1t2s1 0 sky130_fd_pr__res_xhigh_po w=10 l=2224.8909
XRn1n15n1p2s2 Rn1n15n1t2s1 Rn1n15n1t2s2 0 sky130_fd_pr__res_xhigh_po w=10 l=2224.8909
XRn1n15n1p2s3 Rn1n15n1t2s2 Rn1n15n1t2s3 0 sky130_fd_pr__res_xhigh_po w=10 l=2224.8909
XRn1n15n1p2s4 Rn1n15n1t2s3 Rn1n15n1t2s4 0 sky130_fd_pr__res_xhigh_po w=10 l=2224.8909
XRn1n15n1p2s5 Rn1n15n1t2s4 Rn1n15n1t2s5 0 sky130_fd_pr__res_xhigh_po w=10 l=2224.8909
XRn1n15n1p2s6 Rn1n15n1t2s5 Rn1n15n1t2s6 0 sky130_fd_pr__res_xhigh_po w=10 l=2224.8909
XRn1n15n1p2s7 Rn1n15n1t2s6 n1p 0 sky130_fd_pr__res_xhigh_po w=10 l=2224.8909
XRn1n15n1p3s0 in15 Rn1n15n1t3s0 0 sky130_fd_pr__res_xhigh_po w=10 l=2224.8909
XRn1n15n1p3s1 Rn1n15n1t3s0 Rn1n15n1t3s1 0 sky130_fd_pr__res_xhigh_po w=10 l=2224.8909
XRn1n15n1p3s2 Rn1n15n1t3s1 Rn1n15n1t3s2 0 sky130_fd_pr__res_xhigh_po w=10 l=2224.8909
XRn1n15n1p3s3 Rn1n15n1t3s2 Rn1n15n1t3s3 0 sky130_fd_pr__res_xhigh_po w=10 l=2224.8909
XRn1n15n1p3s4 Rn1n15n1t3s3 Rn1n15n1t3s4 0 sky130_fd_pr__res_xhigh_po w=10 l=2224.8909
XRn1n15n1p3s5 Rn1n15n1t3s4 Rn1n15n1t3s5 0 sky130_fd_pr__res_xhigh_po w=10 l=2224.8909
XRn1n15n1p3s6 Rn1n15n1t3s5 Rn1n15n1t3s6 0 sky130_fd_pr__res_xhigh_po w=10 l=2224.8909
XRn1n15n1p3s7 Rn1n15n1t3s6 n1p 0 sky130_fd_pr__res_xhigh_po w=10 l=2224.8909
XRn1n15n1p4s0 in15 Rn1n15n1t4s0 0 sky130_fd_pr__res_xhigh_po w=10 l=2224.8909
XRn1n15n1p4s1 Rn1n15n1t4s0 Rn1n15n1t4s1 0 sky130_fd_pr__res_xhigh_po w=10 l=2224.8909
XRn1n15n1p4s2 Rn1n15n1t4s1 Rn1n15n1t4s2 0 sky130_fd_pr__res_xhigh_po w=10 l=2224.8909
XRn1n15n1p4s3 Rn1n15n1t4s2 Rn1n15n1t4s3 0 sky130_fd_pr__res_xhigh_po w=10 l=2224.8909
XRn1n15n1p4s4 Rn1n15n1t4s3 Rn1n15n1t4s4 0 sky130_fd_pr__res_xhigh_po w=10 l=2224.8909
XRn1n15n1p4s5 Rn1n15n1t4s4 Rn1n15n1t4s5 0 sky130_fd_pr__res_xhigh_po w=10 l=2224.8909
XRn1n15n1p4s6 Rn1n15n1t4s5 Rn1n15n1t4s6 0 sky130_fd_pr__res_xhigh_po w=10 l=2224.8909
XRn1n15n1p4s7 Rn1n15n1t4s6 n1p 0 sky130_fd_pr__res_xhigh_po w=10 l=2224.8909
XRn1n15n1p5s0 in15 Rn1n15n1t5s0 0 sky130_fd_pr__res_xhigh_po w=10 l=2224.8909
XRn1n15n1p5s1 Rn1n15n1t5s0 Rn1n15n1t5s1 0 sky130_fd_pr__res_xhigh_po w=10 l=2224.8909
XRn1n15n1p5s2 Rn1n15n1t5s1 Rn1n15n1t5s2 0 sky130_fd_pr__res_xhigh_po w=10 l=2224.8909
XRn1n15n1p5s3 Rn1n15n1t5s2 Rn1n15n1t5s3 0 sky130_fd_pr__res_xhigh_po w=10 l=2224.8909
XRn1n15n1p5s4 Rn1n15n1t5s3 Rn1n15n1t5s4 0 sky130_fd_pr__res_xhigh_po w=10 l=2224.8909
XRn1n15n1p5s5 Rn1n15n1t5s4 Rn1n15n1t5s5 0 sky130_fd_pr__res_xhigh_po w=10 l=2224.8909
XRn1n15n1p5s6 Rn1n15n1t5s5 Rn1n15n1t5s6 0 sky130_fd_pr__res_xhigh_po w=10 l=2224.8909
XRn1n15n1p5s7 Rn1n15n1t5s6 n1p 0 sky130_fd_pr__res_xhigh_po w=10 l=2224.8909
XRn1n15n1p6s0 in15 Rn1n15n1t6s0 0 sky130_fd_pr__res_xhigh_po w=10 l=2224.8909
XRn1n15n1p6s1 Rn1n15n1t6s0 Rn1n15n1t6s1 0 sky130_fd_pr__res_xhigh_po w=10 l=2224.8909
XRn1n15n1p6s2 Rn1n15n1t6s1 Rn1n15n1t6s2 0 sky130_fd_pr__res_xhigh_po w=10 l=2224.8909
XRn1n15n1p6s3 Rn1n15n1t6s2 Rn1n15n1t6s3 0 sky130_fd_pr__res_xhigh_po w=10 l=2224.8909
XRn1n15n1p6s4 Rn1n15n1t6s3 Rn1n15n1t6s4 0 sky130_fd_pr__res_xhigh_po w=10 l=2224.8909
XRn1n15n1p6s5 Rn1n15n1t6s4 Rn1n15n1t6s5 0 sky130_fd_pr__res_xhigh_po w=10 l=2224.8909
XRn1n15n1p6s6 Rn1n15n1t6s5 Rn1n15n1t6s6 0 sky130_fd_pr__res_xhigh_po w=10 l=2224.8909
XRn1n15n1p6s7 Rn1n15n1t6s6 n1p 0 sky130_fd_pr__res_xhigh_po w=10 l=2224.8909
XRn1n15n1p7s0 in15 Rn1n15n1t7s0 0 sky130_fd_pr__res_xhigh_po w=10 l=2224.8909
XRn1n15n1p7s1 Rn1n15n1t7s0 Rn1n15n1t7s1 0 sky130_fd_pr__res_xhigh_po w=10 l=2224.8909
XRn1n15n1p7s2 Rn1n15n1t7s1 Rn1n15n1t7s2 0 sky130_fd_pr__res_xhigh_po w=10 l=2224.8909
XRn1n15n1p7s3 Rn1n15n1t7s2 Rn1n15n1t7s3 0 sky130_fd_pr__res_xhigh_po w=10 l=2224.8909
XRn1n15n1p7s4 Rn1n15n1t7s3 Rn1n15n1t7s4 0 sky130_fd_pr__res_xhigh_po w=10 l=2224.8909
XRn1n15n1p7s5 Rn1n15n1t7s4 Rn1n15n1t7s5 0 sky130_fd_pr__res_xhigh_po w=10 l=2224.8909
XRn1n15n1p7s6 Rn1n15n1t7s5 Rn1n15n1t7s6 0 sky130_fd_pr__res_xhigh_po w=10 l=2224.8909
XRn1n15n1p7s7 Rn1n15n1t7s6 n1p 0 sky130_fd_pr__res_xhigh_po w=10 l=2224.8909
* n1 input 16 w=-0.0222148593491043 w-  bank=f alpha=0.001 R=1500.49715865869 G_phys=0.000666445780473128 G_eff=6.66445780473128e-07
* PDK sky130_fd_pr__res_xhigh_po Rn1n16f1 W=10 L=7.3548435
* tile Rn1n16f1 8s x 8p same W=10 L=7.3548435
XRn1n16f1p0s0 tap16 Rn1n16f1t0s0 0 sky130_fd_pr__res_xhigh_po w=10 l=7.3548435
XRn1n16f1p0s1 Rn1n16f1t0s0 Rn1n16f1t0s1 0 sky130_fd_pr__res_xhigh_po w=10 l=7.3548435
XRn1n16f1p0s2 Rn1n16f1t0s1 Rn1n16f1t0s2 0 sky130_fd_pr__res_xhigh_po w=10 l=7.3548435
XRn1n16f1p0s3 Rn1n16f1t0s2 Rn1n16f1t0s3 0 sky130_fd_pr__res_xhigh_po w=10 l=7.3548435
XRn1n16f1p0s4 Rn1n16f1t0s3 Rn1n16f1t0s4 0 sky130_fd_pr__res_xhigh_po w=10 l=7.3548435
XRn1n16f1p0s5 Rn1n16f1t0s4 Rn1n16f1t0s5 0 sky130_fd_pr__res_xhigh_po w=10 l=7.3548435
XRn1n16f1p0s6 Rn1n16f1t0s5 Rn1n16f1t0s6 0 sky130_fd_pr__res_xhigh_po w=10 l=7.3548435
XRn1n16f1p0s7 Rn1n16f1t0s6 n1p 0 sky130_fd_pr__res_xhigh_po w=10 l=7.3548435
XRn1n16f1p1s0 tap16 Rn1n16f1t1s0 0 sky130_fd_pr__res_xhigh_po w=10 l=7.3548435
XRn1n16f1p1s1 Rn1n16f1t1s0 Rn1n16f1t1s1 0 sky130_fd_pr__res_xhigh_po w=10 l=7.3548435
XRn1n16f1p1s2 Rn1n16f1t1s1 Rn1n16f1t1s2 0 sky130_fd_pr__res_xhigh_po w=10 l=7.3548435
XRn1n16f1p1s3 Rn1n16f1t1s2 Rn1n16f1t1s3 0 sky130_fd_pr__res_xhigh_po w=10 l=7.3548435
XRn1n16f1p1s4 Rn1n16f1t1s3 Rn1n16f1t1s4 0 sky130_fd_pr__res_xhigh_po w=10 l=7.3548435
XRn1n16f1p1s5 Rn1n16f1t1s4 Rn1n16f1t1s5 0 sky130_fd_pr__res_xhigh_po w=10 l=7.3548435
XRn1n16f1p1s6 Rn1n16f1t1s5 Rn1n16f1t1s6 0 sky130_fd_pr__res_xhigh_po w=10 l=7.3548435
XRn1n16f1p1s7 Rn1n16f1t1s6 n1p 0 sky130_fd_pr__res_xhigh_po w=10 l=7.3548435
XRn1n16f1p2s0 tap16 Rn1n16f1t2s0 0 sky130_fd_pr__res_xhigh_po w=10 l=7.3548435
XRn1n16f1p2s1 Rn1n16f1t2s0 Rn1n16f1t2s1 0 sky130_fd_pr__res_xhigh_po w=10 l=7.3548435
XRn1n16f1p2s2 Rn1n16f1t2s1 Rn1n16f1t2s2 0 sky130_fd_pr__res_xhigh_po w=10 l=7.3548435
XRn1n16f1p2s3 Rn1n16f1t2s2 Rn1n16f1t2s3 0 sky130_fd_pr__res_xhigh_po w=10 l=7.3548435
XRn1n16f1p2s4 Rn1n16f1t2s3 Rn1n16f1t2s4 0 sky130_fd_pr__res_xhigh_po w=10 l=7.3548435
XRn1n16f1p2s5 Rn1n16f1t2s4 Rn1n16f1t2s5 0 sky130_fd_pr__res_xhigh_po w=10 l=7.3548435
XRn1n16f1p2s6 Rn1n16f1t2s5 Rn1n16f1t2s6 0 sky130_fd_pr__res_xhigh_po w=10 l=7.3548435
XRn1n16f1p2s7 Rn1n16f1t2s6 n1p 0 sky130_fd_pr__res_xhigh_po w=10 l=7.3548435
XRn1n16f1p3s0 tap16 Rn1n16f1t3s0 0 sky130_fd_pr__res_xhigh_po w=10 l=7.3548435
XRn1n16f1p3s1 Rn1n16f1t3s0 Rn1n16f1t3s1 0 sky130_fd_pr__res_xhigh_po w=10 l=7.3548435
XRn1n16f1p3s2 Rn1n16f1t3s1 Rn1n16f1t3s2 0 sky130_fd_pr__res_xhigh_po w=10 l=7.3548435
XRn1n16f1p3s3 Rn1n16f1t3s2 Rn1n16f1t3s3 0 sky130_fd_pr__res_xhigh_po w=10 l=7.3548435
XRn1n16f1p3s4 Rn1n16f1t3s3 Rn1n16f1t3s4 0 sky130_fd_pr__res_xhigh_po w=10 l=7.3548435
XRn1n16f1p3s5 Rn1n16f1t3s4 Rn1n16f1t3s5 0 sky130_fd_pr__res_xhigh_po w=10 l=7.3548435
XRn1n16f1p3s6 Rn1n16f1t3s5 Rn1n16f1t3s6 0 sky130_fd_pr__res_xhigh_po w=10 l=7.3548435
XRn1n16f1p3s7 Rn1n16f1t3s6 n1p 0 sky130_fd_pr__res_xhigh_po w=10 l=7.3548435
XRn1n16f1p4s0 tap16 Rn1n16f1t4s0 0 sky130_fd_pr__res_xhigh_po w=10 l=7.3548435
XRn1n16f1p4s1 Rn1n16f1t4s0 Rn1n16f1t4s1 0 sky130_fd_pr__res_xhigh_po w=10 l=7.3548435
XRn1n16f1p4s2 Rn1n16f1t4s1 Rn1n16f1t4s2 0 sky130_fd_pr__res_xhigh_po w=10 l=7.3548435
XRn1n16f1p4s3 Rn1n16f1t4s2 Rn1n16f1t4s3 0 sky130_fd_pr__res_xhigh_po w=10 l=7.3548435
XRn1n16f1p4s4 Rn1n16f1t4s3 Rn1n16f1t4s4 0 sky130_fd_pr__res_xhigh_po w=10 l=7.3548435
XRn1n16f1p4s5 Rn1n16f1t4s4 Rn1n16f1t4s5 0 sky130_fd_pr__res_xhigh_po w=10 l=7.3548435
XRn1n16f1p4s6 Rn1n16f1t4s5 Rn1n16f1t4s6 0 sky130_fd_pr__res_xhigh_po w=10 l=7.3548435
XRn1n16f1p4s7 Rn1n16f1t4s6 n1p 0 sky130_fd_pr__res_xhigh_po w=10 l=7.3548435
XRn1n16f1p5s0 tap16 Rn1n16f1t5s0 0 sky130_fd_pr__res_xhigh_po w=10 l=7.3548435
XRn1n16f1p5s1 Rn1n16f1t5s0 Rn1n16f1t5s1 0 sky130_fd_pr__res_xhigh_po w=10 l=7.3548435
XRn1n16f1p5s2 Rn1n16f1t5s1 Rn1n16f1t5s2 0 sky130_fd_pr__res_xhigh_po w=10 l=7.3548435
XRn1n16f1p5s3 Rn1n16f1t5s2 Rn1n16f1t5s3 0 sky130_fd_pr__res_xhigh_po w=10 l=7.3548435
XRn1n16f1p5s4 Rn1n16f1t5s3 Rn1n16f1t5s4 0 sky130_fd_pr__res_xhigh_po w=10 l=7.3548435
XRn1n16f1p5s5 Rn1n16f1t5s4 Rn1n16f1t5s5 0 sky130_fd_pr__res_xhigh_po w=10 l=7.3548435
XRn1n16f1p5s6 Rn1n16f1t5s5 Rn1n16f1t5s6 0 sky130_fd_pr__res_xhigh_po w=10 l=7.3548435
XRn1n16f1p5s7 Rn1n16f1t5s6 n1p 0 sky130_fd_pr__res_xhigh_po w=10 l=7.3548435
XRn1n16f1p6s0 tap16 Rn1n16f1t6s0 0 sky130_fd_pr__res_xhigh_po w=10 l=7.3548435
XRn1n16f1p6s1 Rn1n16f1t6s0 Rn1n16f1t6s1 0 sky130_fd_pr__res_xhigh_po w=10 l=7.3548435
XRn1n16f1p6s2 Rn1n16f1t6s1 Rn1n16f1t6s2 0 sky130_fd_pr__res_xhigh_po w=10 l=7.3548435
XRn1n16f1p6s3 Rn1n16f1t6s2 Rn1n16f1t6s3 0 sky130_fd_pr__res_xhigh_po w=10 l=7.3548435
XRn1n16f1p6s4 Rn1n16f1t6s3 Rn1n16f1t6s4 0 sky130_fd_pr__res_xhigh_po w=10 l=7.3548435
XRn1n16f1p6s5 Rn1n16f1t6s4 Rn1n16f1t6s5 0 sky130_fd_pr__res_xhigh_po w=10 l=7.3548435
XRn1n16f1p6s6 Rn1n16f1t6s5 Rn1n16f1t6s6 0 sky130_fd_pr__res_xhigh_po w=10 l=7.3548435
XRn1n16f1p6s7 Rn1n16f1t6s6 n1p 0 sky130_fd_pr__res_xhigh_po w=10 l=7.3548435
XRn1n16f1p7s0 tap16 Rn1n16f1t7s0 0 sky130_fd_pr__res_xhigh_po w=10 l=7.3548435
XRn1n16f1p7s1 Rn1n16f1t7s0 Rn1n16f1t7s1 0 sky130_fd_pr__res_xhigh_po w=10 l=7.3548435
XRn1n16f1p7s2 Rn1n16f1t7s1 Rn1n16f1t7s2 0 sky130_fd_pr__res_xhigh_po w=10 l=7.3548435
XRn1n16f1p7s3 Rn1n16f1t7s2 Rn1n16f1t7s3 0 sky130_fd_pr__res_xhigh_po w=10 l=7.3548435
XRn1n16f1p7s4 Rn1n16f1t7s3 Rn1n16f1t7s4 0 sky130_fd_pr__res_xhigh_po w=10 l=7.3548435
XRn1n16f1p7s5 Rn1n16f1t7s4 Rn1n16f1t7s5 0 sky130_fd_pr__res_xhigh_po w=10 l=7.3548435
XRn1n16f1p7s6 Rn1n16f1t7s5 Rn1n16f1t7s6 0 sky130_fd_pr__res_xhigh_po w=10 l=7.3548435
XRn1n16f1p7s7 Rn1n16f1t7s6 n1p 0 sky130_fd_pr__res_xhigh_po w=10 l=7.3548435
* n1 input 17 w=+0.0088751960388594 w+  bank=f alpha=0.001 R=3755.78558348297 G_phys=0.000266255881165782 G_eff=2.66255881165782e-07
* PDK sky130_fd_pr__res_xhigh_po Rn1p17f1 W=10 L=18.568138
* tile Rn1p17f1 8s x 8p same W=10 L=18.568138
XRn1p17f1p0s0 tap17n Rn1p17f1t0s0 0 sky130_fd_pr__res_xhigh_po w=10 l=18.568138
XRn1p17f1p0s1 Rn1p17f1t0s0 Rn1p17f1t0s1 0 sky130_fd_pr__res_xhigh_po w=10 l=18.568138
XRn1p17f1p0s2 Rn1p17f1t0s1 Rn1p17f1t0s2 0 sky130_fd_pr__res_xhigh_po w=10 l=18.568138
XRn1p17f1p0s3 Rn1p17f1t0s2 Rn1p17f1t0s3 0 sky130_fd_pr__res_xhigh_po w=10 l=18.568138
XRn1p17f1p0s4 Rn1p17f1t0s3 Rn1p17f1t0s4 0 sky130_fd_pr__res_xhigh_po w=10 l=18.568138
XRn1p17f1p0s5 Rn1p17f1t0s4 Rn1p17f1t0s5 0 sky130_fd_pr__res_xhigh_po w=10 l=18.568138
XRn1p17f1p0s6 Rn1p17f1t0s5 Rn1p17f1t0s6 0 sky130_fd_pr__res_xhigh_po w=10 l=18.568138
XRn1p17f1p0s7 Rn1p17f1t0s6 n1p 0 sky130_fd_pr__res_xhigh_po w=10 l=18.568138
XRn1p17f1p1s0 tap17n Rn1p17f1t1s0 0 sky130_fd_pr__res_xhigh_po w=10 l=18.568138
XRn1p17f1p1s1 Rn1p17f1t1s0 Rn1p17f1t1s1 0 sky130_fd_pr__res_xhigh_po w=10 l=18.568138
XRn1p17f1p1s2 Rn1p17f1t1s1 Rn1p17f1t1s2 0 sky130_fd_pr__res_xhigh_po w=10 l=18.568138
XRn1p17f1p1s3 Rn1p17f1t1s2 Rn1p17f1t1s3 0 sky130_fd_pr__res_xhigh_po w=10 l=18.568138
XRn1p17f1p1s4 Rn1p17f1t1s3 Rn1p17f1t1s4 0 sky130_fd_pr__res_xhigh_po w=10 l=18.568138
XRn1p17f1p1s5 Rn1p17f1t1s4 Rn1p17f1t1s5 0 sky130_fd_pr__res_xhigh_po w=10 l=18.568138
XRn1p17f1p1s6 Rn1p17f1t1s5 Rn1p17f1t1s6 0 sky130_fd_pr__res_xhigh_po w=10 l=18.568138
XRn1p17f1p1s7 Rn1p17f1t1s6 n1p 0 sky130_fd_pr__res_xhigh_po w=10 l=18.568138
XRn1p17f1p2s0 tap17n Rn1p17f1t2s0 0 sky130_fd_pr__res_xhigh_po w=10 l=18.568138
XRn1p17f1p2s1 Rn1p17f1t2s0 Rn1p17f1t2s1 0 sky130_fd_pr__res_xhigh_po w=10 l=18.568138
XRn1p17f1p2s2 Rn1p17f1t2s1 Rn1p17f1t2s2 0 sky130_fd_pr__res_xhigh_po w=10 l=18.568138
XRn1p17f1p2s3 Rn1p17f1t2s2 Rn1p17f1t2s3 0 sky130_fd_pr__res_xhigh_po w=10 l=18.568138
XRn1p17f1p2s4 Rn1p17f1t2s3 Rn1p17f1t2s4 0 sky130_fd_pr__res_xhigh_po w=10 l=18.568138
XRn1p17f1p2s5 Rn1p17f1t2s4 Rn1p17f1t2s5 0 sky130_fd_pr__res_xhigh_po w=10 l=18.568138
XRn1p17f1p2s6 Rn1p17f1t2s5 Rn1p17f1t2s6 0 sky130_fd_pr__res_xhigh_po w=10 l=18.568138
XRn1p17f1p2s7 Rn1p17f1t2s6 n1p 0 sky130_fd_pr__res_xhigh_po w=10 l=18.568138
XRn1p17f1p3s0 tap17n Rn1p17f1t3s0 0 sky130_fd_pr__res_xhigh_po w=10 l=18.568138
XRn1p17f1p3s1 Rn1p17f1t3s0 Rn1p17f1t3s1 0 sky130_fd_pr__res_xhigh_po w=10 l=18.568138
XRn1p17f1p3s2 Rn1p17f1t3s1 Rn1p17f1t3s2 0 sky130_fd_pr__res_xhigh_po w=10 l=18.568138
XRn1p17f1p3s3 Rn1p17f1t3s2 Rn1p17f1t3s3 0 sky130_fd_pr__res_xhigh_po w=10 l=18.568138
XRn1p17f1p3s4 Rn1p17f1t3s3 Rn1p17f1t3s4 0 sky130_fd_pr__res_xhigh_po w=10 l=18.568138
XRn1p17f1p3s5 Rn1p17f1t3s4 Rn1p17f1t3s5 0 sky130_fd_pr__res_xhigh_po w=10 l=18.568138
XRn1p17f1p3s6 Rn1p17f1t3s5 Rn1p17f1t3s6 0 sky130_fd_pr__res_xhigh_po w=10 l=18.568138
XRn1p17f1p3s7 Rn1p17f1t3s6 n1p 0 sky130_fd_pr__res_xhigh_po w=10 l=18.568138
XRn1p17f1p4s0 tap17n Rn1p17f1t4s0 0 sky130_fd_pr__res_xhigh_po w=10 l=18.568138
XRn1p17f1p4s1 Rn1p17f1t4s0 Rn1p17f1t4s1 0 sky130_fd_pr__res_xhigh_po w=10 l=18.568138
XRn1p17f1p4s2 Rn1p17f1t4s1 Rn1p17f1t4s2 0 sky130_fd_pr__res_xhigh_po w=10 l=18.568138
XRn1p17f1p4s3 Rn1p17f1t4s2 Rn1p17f1t4s3 0 sky130_fd_pr__res_xhigh_po w=10 l=18.568138
XRn1p17f1p4s4 Rn1p17f1t4s3 Rn1p17f1t4s4 0 sky130_fd_pr__res_xhigh_po w=10 l=18.568138
XRn1p17f1p4s5 Rn1p17f1t4s4 Rn1p17f1t4s5 0 sky130_fd_pr__res_xhigh_po w=10 l=18.568138
XRn1p17f1p4s6 Rn1p17f1t4s5 Rn1p17f1t4s6 0 sky130_fd_pr__res_xhigh_po w=10 l=18.568138
XRn1p17f1p4s7 Rn1p17f1t4s6 n1p 0 sky130_fd_pr__res_xhigh_po w=10 l=18.568138
XRn1p17f1p5s0 tap17n Rn1p17f1t5s0 0 sky130_fd_pr__res_xhigh_po w=10 l=18.568138
XRn1p17f1p5s1 Rn1p17f1t5s0 Rn1p17f1t5s1 0 sky130_fd_pr__res_xhigh_po w=10 l=18.568138
XRn1p17f1p5s2 Rn1p17f1t5s1 Rn1p17f1t5s2 0 sky130_fd_pr__res_xhigh_po w=10 l=18.568138
XRn1p17f1p5s3 Rn1p17f1t5s2 Rn1p17f1t5s3 0 sky130_fd_pr__res_xhigh_po w=10 l=18.568138
XRn1p17f1p5s4 Rn1p17f1t5s3 Rn1p17f1t5s4 0 sky130_fd_pr__res_xhigh_po w=10 l=18.568138
XRn1p17f1p5s5 Rn1p17f1t5s4 Rn1p17f1t5s5 0 sky130_fd_pr__res_xhigh_po w=10 l=18.568138
XRn1p17f1p5s6 Rn1p17f1t5s5 Rn1p17f1t5s6 0 sky130_fd_pr__res_xhigh_po w=10 l=18.568138
XRn1p17f1p5s7 Rn1p17f1t5s6 n1p 0 sky130_fd_pr__res_xhigh_po w=10 l=18.568138
XRn1p17f1p6s0 tap17n Rn1p17f1t6s0 0 sky130_fd_pr__res_xhigh_po w=10 l=18.568138
XRn1p17f1p6s1 Rn1p17f1t6s0 Rn1p17f1t6s1 0 sky130_fd_pr__res_xhigh_po w=10 l=18.568138
XRn1p17f1p6s2 Rn1p17f1t6s1 Rn1p17f1t6s2 0 sky130_fd_pr__res_xhigh_po w=10 l=18.568138
XRn1p17f1p6s3 Rn1p17f1t6s2 Rn1p17f1t6s3 0 sky130_fd_pr__res_xhigh_po w=10 l=18.568138
XRn1p17f1p6s4 Rn1p17f1t6s3 Rn1p17f1t6s4 0 sky130_fd_pr__res_xhigh_po w=10 l=18.568138
XRn1p17f1p6s5 Rn1p17f1t6s4 Rn1p17f1t6s5 0 sky130_fd_pr__res_xhigh_po w=10 l=18.568138
XRn1p17f1p6s6 Rn1p17f1t6s5 Rn1p17f1t6s6 0 sky130_fd_pr__res_xhigh_po w=10 l=18.568138
XRn1p17f1p6s7 Rn1p17f1t6s6 n1p 0 sky130_fd_pr__res_xhigh_po w=10 l=18.568138
XRn1p17f1p7s0 tap17n Rn1p17f1t7s0 0 sky130_fd_pr__res_xhigh_po w=10 l=18.568138
XRn1p17f1p7s1 Rn1p17f1t7s0 Rn1p17f1t7s1 0 sky130_fd_pr__res_xhigh_po w=10 l=18.568138
XRn1p17f1p7s2 Rn1p17f1t7s1 Rn1p17f1t7s2 0 sky130_fd_pr__res_xhigh_po w=10 l=18.568138
XRn1p17f1p7s3 Rn1p17f1t7s2 Rn1p17f1t7s3 0 sky130_fd_pr__res_xhigh_po w=10 l=18.568138
XRn1p17f1p7s4 Rn1p17f1t7s3 Rn1p17f1t7s4 0 sky130_fd_pr__res_xhigh_po w=10 l=18.568138
XRn1p17f1p7s5 Rn1p17f1t7s4 Rn1p17f1t7s5 0 sky130_fd_pr__res_xhigh_po w=10 l=18.568138
XRn1p17f1p7s6 Rn1p17f1t7s5 Rn1p17f1t7s6 0 sky130_fd_pr__res_xhigh_po w=10 l=18.568138
XRn1p17f1p7s7 Rn1p17f1t7s6 n1p 0 sky130_fd_pr__res_xhigh_po w=10 l=18.568138
* n1 input 18 w=-0.194172060066752 w-  bank=n alpha=1 R=171669.051262443 G_phys=5.82516180200256e-06 G_eff=5.82516180200256e-06
* PDK sky130_fd_pr__res_xhigh_po Rn1n18n1 W=10 L=853.43289
* tile Rn1n18n1 8s x 8p same W=10 L=853.43289
XRn1n18n1p0s0 in18 Rn1n18n1t0s0 0 sky130_fd_pr__res_xhigh_po w=10 l=853.43289
XRn1n18n1p0s1 Rn1n18n1t0s0 Rn1n18n1t0s1 0 sky130_fd_pr__res_xhigh_po w=10 l=853.43289
XRn1n18n1p0s2 Rn1n18n1t0s1 Rn1n18n1t0s2 0 sky130_fd_pr__res_xhigh_po w=10 l=853.43289
XRn1n18n1p0s3 Rn1n18n1t0s2 Rn1n18n1t0s3 0 sky130_fd_pr__res_xhigh_po w=10 l=853.43289
XRn1n18n1p0s4 Rn1n18n1t0s3 Rn1n18n1t0s4 0 sky130_fd_pr__res_xhigh_po w=10 l=853.43289
XRn1n18n1p0s5 Rn1n18n1t0s4 Rn1n18n1t0s5 0 sky130_fd_pr__res_xhigh_po w=10 l=853.43289
XRn1n18n1p0s6 Rn1n18n1t0s5 Rn1n18n1t0s6 0 sky130_fd_pr__res_xhigh_po w=10 l=853.43289
XRn1n18n1p0s7 Rn1n18n1t0s6 n1p 0 sky130_fd_pr__res_xhigh_po w=10 l=853.43289
XRn1n18n1p1s0 in18 Rn1n18n1t1s0 0 sky130_fd_pr__res_xhigh_po w=10 l=853.43289
XRn1n18n1p1s1 Rn1n18n1t1s0 Rn1n18n1t1s1 0 sky130_fd_pr__res_xhigh_po w=10 l=853.43289
XRn1n18n1p1s2 Rn1n18n1t1s1 Rn1n18n1t1s2 0 sky130_fd_pr__res_xhigh_po w=10 l=853.43289
XRn1n18n1p1s3 Rn1n18n1t1s2 Rn1n18n1t1s3 0 sky130_fd_pr__res_xhigh_po w=10 l=853.43289
XRn1n18n1p1s4 Rn1n18n1t1s3 Rn1n18n1t1s4 0 sky130_fd_pr__res_xhigh_po w=10 l=853.43289
XRn1n18n1p1s5 Rn1n18n1t1s4 Rn1n18n1t1s5 0 sky130_fd_pr__res_xhigh_po w=10 l=853.43289
XRn1n18n1p1s6 Rn1n18n1t1s5 Rn1n18n1t1s6 0 sky130_fd_pr__res_xhigh_po w=10 l=853.43289
XRn1n18n1p1s7 Rn1n18n1t1s6 n1p 0 sky130_fd_pr__res_xhigh_po w=10 l=853.43289
XRn1n18n1p2s0 in18 Rn1n18n1t2s0 0 sky130_fd_pr__res_xhigh_po w=10 l=853.43289
XRn1n18n1p2s1 Rn1n18n1t2s0 Rn1n18n1t2s1 0 sky130_fd_pr__res_xhigh_po w=10 l=853.43289
XRn1n18n1p2s2 Rn1n18n1t2s1 Rn1n18n1t2s2 0 sky130_fd_pr__res_xhigh_po w=10 l=853.43289
XRn1n18n1p2s3 Rn1n18n1t2s2 Rn1n18n1t2s3 0 sky130_fd_pr__res_xhigh_po w=10 l=853.43289
XRn1n18n1p2s4 Rn1n18n1t2s3 Rn1n18n1t2s4 0 sky130_fd_pr__res_xhigh_po w=10 l=853.43289
XRn1n18n1p2s5 Rn1n18n1t2s4 Rn1n18n1t2s5 0 sky130_fd_pr__res_xhigh_po w=10 l=853.43289
XRn1n18n1p2s6 Rn1n18n1t2s5 Rn1n18n1t2s6 0 sky130_fd_pr__res_xhigh_po w=10 l=853.43289
XRn1n18n1p2s7 Rn1n18n1t2s6 n1p 0 sky130_fd_pr__res_xhigh_po w=10 l=853.43289
XRn1n18n1p3s0 in18 Rn1n18n1t3s0 0 sky130_fd_pr__res_xhigh_po w=10 l=853.43289
XRn1n18n1p3s1 Rn1n18n1t3s0 Rn1n18n1t3s1 0 sky130_fd_pr__res_xhigh_po w=10 l=853.43289
XRn1n18n1p3s2 Rn1n18n1t3s1 Rn1n18n1t3s2 0 sky130_fd_pr__res_xhigh_po w=10 l=853.43289
XRn1n18n1p3s3 Rn1n18n1t3s2 Rn1n18n1t3s3 0 sky130_fd_pr__res_xhigh_po w=10 l=853.43289
XRn1n18n1p3s4 Rn1n18n1t3s3 Rn1n18n1t3s4 0 sky130_fd_pr__res_xhigh_po w=10 l=853.43289
XRn1n18n1p3s5 Rn1n18n1t3s4 Rn1n18n1t3s5 0 sky130_fd_pr__res_xhigh_po w=10 l=853.43289
XRn1n18n1p3s6 Rn1n18n1t3s5 Rn1n18n1t3s6 0 sky130_fd_pr__res_xhigh_po w=10 l=853.43289
XRn1n18n1p3s7 Rn1n18n1t3s6 n1p 0 sky130_fd_pr__res_xhigh_po w=10 l=853.43289
XRn1n18n1p4s0 in18 Rn1n18n1t4s0 0 sky130_fd_pr__res_xhigh_po w=10 l=853.43289
XRn1n18n1p4s1 Rn1n18n1t4s0 Rn1n18n1t4s1 0 sky130_fd_pr__res_xhigh_po w=10 l=853.43289
XRn1n18n1p4s2 Rn1n18n1t4s1 Rn1n18n1t4s2 0 sky130_fd_pr__res_xhigh_po w=10 l=853.43289
XRn1n18n1p4s3 Rn1n18n1t4s2 Rn1n18n1t4s3 0 sky130_fd_pr__res_xhigh_po w=10 l=853.43289
XRn1n18n1p4s4 Rn1n18n1t4s3 Rn1n18n1t4s4 0 sky130_fd_pr__res_xhigh_po w=10 l=853.43289
XRn1n18n1p4s5 Rn1n18n1t4s4 Rn1n18n1t4s5 0 sky130_fd_pr__res_xhigh_po w=10 l=853.43289
XRn1n18n1p4s6 Rn1n18n1t4s5 Rn1n18n1t4s6 0 sky130_fd_pr__res_xhigh_po w=10 l=853.43289
XRn1n18n1p4s7 Rn1n18n1t4s6 n1p 0 sky130_fd_pr__res_xhigh_po w=10 l=853.43289
XRn1n18n1p5s0 in18 Rn1n18n1t5s0 0 sky130_fd_pr__res_xhigh_po w=10 l=853.43289
XRn1n18n1p5s1 Rn1n18n1t5s0 Rn1n18n1t5s1 0 sky130_fd_pr__res_xhigh_po w=10 l=853.43289
XRn1n18n1p5s2 Rn1n18n1t5s1 Rn1n18n1t5s2 0 sky130_fd_pr__res_xhigh_po w=10 l=853.43289
XRn1n18n1p5s3 Rn1n18n1t5s2 Rn1n18n1t5s3 0 sky130_fd_pr__res_xhigh_po w=10 l=853.43289
XRn1n18n1p5s4 Rn1n18n1t5s3 Rn1n18n1t5s4 0 sky130_fd_pr__res_xhigh_po w=10 l=853.43289
XRn1n18n1p5s5 Rn1n18n1t5s4 Rn1n18n1t5s5 0 sky130_fd_pr__res_xhigh_po w=10 l=853.43289
XRn1n18n1p5s6 Rn1n18n1t5s5 Rn1n18n1t5s6 0 sky130_fd_pr__res_xhigh_po w=10 l=853.43289
XRn1n18n1p5s7 Rn1n18n1t5s6 n1p 0 sky130_fd_pr__res_xhigh_po w=10 l=853.43289
XRn1n18n1p6s0 in18 Rn1n18n1t6s0 0 sky130_fd_pr__res_xhigh_po w=10 l=853.43289
XRn1n18n1p6s1 Rn1n18n1t6s0 Rn1n18n1t6s1 0 sky130_fd_pr__res_xhigh_po w=10 l=853.43289
XRn1n18n1p6s2 Rn1n18n1t6s1 Rn1n18n1t6s2 0 sky130_fd_pr__res_xhigh_po w=10 l=853.43289
XRn1n18n1p6s3 Rn1n18n1t6s2 Rn1n18n1t6s3 0 sky130_fd_pr__res_xhigh_po w=10 l=853.43289
XRn1n18n1p6s4 Rn1n18n1t6s3 Rn1n18n1t6s4 0 sky130_fd_pr__res_xhigh_po w=10 l=853.43289
XRn1n18n1p6s5 Rn1n18n1t6s4 Rn1n18n1t6s5 0 sky130_fd_pr__res_xhigh_po w=10 l=853.43289
XRn1n18n1p6s6 Rn1n18n1t6s5 Rn1n18n1t6s6 0 sky130_fd_pr__res_xhigh_po w=10 l=853.43289
XRn1n18n1p6s7 Rn1n18n1t6s6 n1p 0 sky130_fd_pr__res_xhigh_po w=10 l=853.43289
XRn1n18n1p7s0 in18 Rn1n18n1t7s0 0 sky130_fd_pr__res_xhigh_po w=10 l=853.43289
XRn1n18n1p7s1 Rn1n18n1t7s0 Rn1n18n1t7s1 0 sky130_fd_pr__res_xhigh_po w=10 l=853.43289
XRn1n18n1p7s2 Rn1n18n1t7s1 Rn1n18n1t7s2 0 sky130_fd_pr__res_xhigh_po w=10 l=853.43289
XRn1n18n1p7s3 Rn1n18n1t7s2 Rn1n18n1t7s3 0 sky130_fd_pr__res_xhigh_po w=10 l=853.43289
XRn1n18n1p7s4 Rn1n18n1t7s3 Rn1n18n1t7s4 0 sky130_fd_pr__res_xhigh_po w=10 l=853.43289
XRn1n18n1p7s5 Rn1n18n1t7s4 Rn1n18n1t7s5 0 sky130_fd_pr__res_xhigh_po w=10 l=853.43289
XRn1n18n1p7s6 Rn1n18n1t7s5 Rn1n18n1t7s6 0 sky130_fd_pr__res_xhigh_po w=10 l=853.43289
XRn1n18n1p7s7 Rn1n18n1t7s6 n1p 0 sky130_fd_pr__res_xhigh_po w=10 l=853.43289
* n1 input 19 w=+0.341327626188232 w+  bank=n alpha=1 R=97657.8828546125 G_phys=1.0239828785647e-05 G_eff=1.0239828785647e-05
* PDK sky130_fd_pr__res_xhigh_po Rn1p19n1 W=10 L=485.44937
* tile Rn1p19n1 8s x 8p same W=10 L=485.44937
XRn1p19n1p0s0 in19n Rn1p19n1t0s0 0 sky130_fd_pr__res_xhigh_po w=10 l=485.44937
XRn1p19n1p0s1 Rn1p19n1t0s0 Rn1p19n1t0s1 0 sky130_fd_pr__res_xhigh_po w=10 l=485.44937
XRn1p19n1p0s2 Rn1p19n1t0s1 Rn1p19n1t0s2 0 sky130_fd_pr__res_xhigh_po w=10 l=485.44937
XRn1p19n1p0s3 Rn1p19n1t0s2 Rn1p19n1t0s3 0 sky130_fd_pr__res_xhigh_po w=10 l=485.44937
XRn1p19n1p0s4 Rn1p19n1t0s3 Rn1p19n1t0s4 0 sky130_fd_pr__res_xhigh_po w=10 l=485.44937
XRn1p19n1p0s5 Rn1p19n1t0s4 Rn1p19n1t0s5 0 sky130_fd_pr__res_xhigh_po w=10 l=485.44937
XRn1p19n1p0s6 Rn1p19n1t0s5 Rn1p19n1t0s6 0 sky130_fd_pr__res_xhigh_po w=10 l=485.44937
XRn1p19n1p0s7 Rn1p19n1t0s6 n1p 0 sky130_fd_pr__res_xhigh_po w=10 l=485.44937
XRn1p19n1p1s0 in19n Rn1p19n1t1s0 0 sky130_fd_pr__res_xhigh_po w=10 l=485.44937
XRn1p19n1p1s1 Rn1p19n1t1s0 Rn1p19n1t1s1 0 sky130_fd_pr__res_xhigh_po w=10 l=485.44937
XRn1p19n1p1s2 Rn1p19n1t1s1 Rn1p19n1t1s2 0 sky130_fd_pr__res_xhigh_po w=10 l=485.44937
XRn1p19n1p1s3 Rn1p19n1t1s2 Rn1p19n1t1s3 0 sky130_fd_pr__res_xhigh_po w=10 l=485.44937
XRn1p19n1p1s4 Rn1p19n1t1s3 Rn1p19n1t1s4 0 sky130_fd_pr__res_xhigh_po w=10 l=485.44937
XRn1p19n1p1s5 Rn1p19n1t1s4 Rn1p19n1t1s5 0 sky130_fd_pr__res_xhigh_po w=10 l=485.44937
XRn1p19n1p1s6 Rn1p19n1t1s5 Rn1p19n1t1s6 0 sky130_fd_pr__res_xhigh_po w=10 l=485.44937
XRn1p19n1p1s7 Rn1p19n1t1s6 n1p 0 sky130_fd_pr__res_xhigh_po w=10 l=485.44937
XRn1p19n1p2s0 in19n Rn1p19n1t2s0 0 sky130_fd_pr__res_xhigh_po w=10 l=485.44937
XRn1p19n1p2s1 Rn1p19n1t2s0 Rn1p19n1t2s1 0 sky130_fd_pr__res_xhigh_po w=10 l=485.44937
XRn1p19n1p2s2 Rn1p19n1t2s1 Rn1p19n1t2s2 0 sky130_fd_pr__res_xhigh_po w=10 l=485.44937
XRn1p19n1p2s3 Rn1p19n1t2s2 Rn1p19n1t2s3 0 sky130_fd_pr__res_xhigh_po w=10 l=485.44937
XRn1p19n1p2s4 Rn1p19n1t2s3 Rn1p19n1t2s4 0 sky130_fd_pr__res_xhigh_po w=10 l=485.44937
XRn1p19n1p2s5 Rn1p19n1t2s4 Rn1p19n1t2s5 0 sky130_fd_pr__res_xhigh_po w=10 l=485.44937
XRn1p19n1p2s6 Rn1p19n1t2s5 Rn1p19n1t2s6 0 sky130_fd_pr__res_xhigh_po w=10 l=485.44937
XRn1p19n1p2s7 Rn1p19n1t2s6 n1p 0 sky130_fd_pr__res_xhigh_po w=10 l=485.44937
XRn1p19n1p3s0 in19n Rn1p19n1t3s0 0 sky130_fd_pr__res_xhigh_po w=10 l=485.44937
XRn1p19n1p3s1 Rn1p19n1t3s0 Rn1p19n1t3s1 0 sky130_fd_pr__res_xhigh_po w=10 l=485.44937
XRn1p19n1p3s2 Rn1p19n1t3s1 Rn1p19n1t3s2 0 sky130_fd_pr__res_xhigh_po w=10 l=485.44937
XRn1p19n1p3s3 Rn1p19n1t3s2 Rn1p19n1t3s3 0 sky130_fd_pr__res_xhigh_po w=10 l=485.44937
XRn1p19n1p3s4 Rn1p19n1t3s3 Rn1p19n1t3s4 0 sky130_fd_pr__res_xhigh_po w=10 l=485.44937
XRn1p19n1p3s5 Rn1p19n1t3s4 Rn1p19n1t3s5 0 sky130_fd_pr__res_xhigh_po w=10 l=485.44937
XRn1p19n1p3s6 Rn1p19n1t3s5 Rn1p19n1t3s6 0 sky130_fd_pr__res_xhigh_po w=10 l=485.44937
XRn1p19n1p3s7 Rn1p19n1t3s6 n1p 0 sky130_fd_pr__res_xhigh_po w=10 l=485.44937
XRn1p19n1p4s0 in19n Rn1p19n1t4s0 0 sky130_fd_pr__res_xhigh_po w=10 l=485.44937
XRn1p19n1p4s1 Rn1p19n1t4s0 Rn1p19n1t4s1 0 sky130_fd_pr__res_xhigh_po w=10 l=485.44937
XRn1p19n1p4s2 Rn1p19n1t4s1 Rn1p19n1t4s2 0 sky130_fd_pr__res_xhigh_po w=10 l=485.44937
XRn1p19n1p4s3 Rn1p19n1t4s2 Rn1p19n1t4s3 0 sky130_fd_pr__res_xhigh_po w=10 l=485.44937
XRn1p19n1p4s4 Rn1p19n1t4s3 Rn1p19n1t4s4 0 sky130_fd_pr__res_xhigh_po w=10 l=485.44937
XRn1p19n1p4s5 Rn1p19n1t4s4 Rn1p19n1t4s5 0 sky130_fd_pr__res_xhigh_po w=10 l=485.44937
XRn1p19n1p4s6 Rn1p19n1t4s5 Rn1p19n1t4s6 0 sky130_fd_pr__res_xhigh_po w=10 l=485.44937
XRn1p19n1p4s7 Rn1p19n1t4s6 n1p 0 sky130_fd_pr__res_xhigh_po w=10 l=485.44937
XRn1p19n1p5s0 in19n Rn1p19n1t5s0 0 sky130_fd_pr__res_xhigh_po w=10 l=485.44937
XRn1p19n1p5s1 Rn1p19n1t5s0 Rn1p19n1t5s1 0 sky130_fd_pr__res_xhigh_po w=10 l=485.44937
XRn1p19n1p5s2 Rn1p19n1t5s1 Rn1p19n1t5s2 0 sky130_fd_pr__res_xhigh_po w=10 l=485.44937
XRn1p19n1p5s3 Rn1p19n1t5s2 Rn1p19n1t5s3 0 sky130_fd_pr__res_xhigh_po w=10 l=485.44937
XRn1p19n1p5s4 Rn1p19n1t5s3 Rn1p19n1t5s4 0 sky130_fd_pr__res_xhigh_po w=10 l=485.44937
XRn1p19n1p5s5 Rn1p19n1t5s4 Rn1p19n1t5s5 0 sky130_fd_pr__res_xhigh_po w=10 l=485.44937
XRn1p19n1p5s6 Rn1p19n1t5s5 Rn1p19n1t5s6 0 sky130_fd_pr__res_xhigh_po w=10 l=485.44937
XRn1p19n1p5s7 Rn1p19n1t5s6 n1p 0 sky130_fd_pr__res_xhigh_po w=10 l=485.44937
XRn1p19n1p6s0 in19n Rn1p19n1t6s0 0 sky130_fd_pr__res_xhigh_po w=10 l=485.44937
XRn1p19n1p6s1 Rn1p19n1t6s0 Rn1p19n1t6s1 0 sky130_fd_pr__res_xhigh_po w=10 l=485.44937
XRn1p19n1p6s2 Rn1p19n1t6s1 Rn1p19n1t6s2 0 sky130_fd_pr__res_xhigh_po w=10 l=485.44937
XRn1p19n1p6s3 Rn1p19n1t6s2 Rn1p19n1t6s3 0 sky130_fd_pr__res_xhigh_po w=10 l=485.44937
XRn1p19n1p6s4 Rn1p19n1t6s3 Rn1p19n1t6s4 0 sky130_fd_pr__res_xhigh_po w=10 l=485.44937
XRn1p19n1p6s5 Rn1p19n1t6s4 Rn1p19n1t6s5 0 sky130_fd_pr__res_xhigh_po w=10 l=485.44937
XRn1p19n1p6s6 Rn1p19n1t6s5 Rn1p19n1t6s6 0 sky130_fd_pr__res_xhigh_po w=10 l=485.44937
XRn1p19n1p6s7 Rn1p19n1t6s6 n1p 0 sky130_fd_pr__res_xhigh_po w=10 l=485.44937
XRn1p19n1p7s0 in19n Rn1p19n1t7s0 0 sky130_fd_pr__res_xhigh_po w=10 l=485.44937
XRn1p19n1p7s1 Rn1p19n1t7s0 Rn1p19n1t7s1 0 sky130_fd_pr__res_xhigh_po w=10 l=485.44937
XRn1p19n1p7s2 Rn1p19n1t7s1 Rn1p19n1t7s2 0 sky130_fd_pr__res_xhigh_po w=10 l=485.44937
XRn1p19n1p7s3 Rn1p19n1t7s2 Rn1p19n1t7s3 0 sky130_fd_pr__res_xhigh_po w=10 l=485.44937
XRn1p19n1p7s4 Rn1p19n1t7s3 Rn1p19n1t7s4 0 sky130_fd_pr__res_xhigh_po w=10 l=485.44937
XRn1p19n1p7s5 Rn1p19n1t7s4 Rn1p19n1t7s5 0 sky130_fd_pr__res_xhigh_po w=10 l=485.44937
XRn1p19n1p7s6 Rn1p19n1t7s5 Rn1p19n1t7s6 0 sky130_fd_pr__res_xhigh_po w=10 l=485.44937
XRn1p19n1p7s7 Rn1p19n1t7s6 n1p 0 sky130_fd_pr__res_xhigh_po w=10 l=485.44937
* n1 input 20 w=-0.0323870183321868 w-  bank=f alpha=0.001 R=1029.21896024637 G_phys=0.000971610549965604 G_eff=9.71610549965604e-07
* PDK sky130_fd_pr__res_xhigh_po Rn1n20f1 W=10 L=5.0116483
* tile Rn1n20f1 8s x 8p same W=10 L=5.0116483
XRn1n20f1p0s0 tap20 Rn1n20f1t0s0 0 sky130_fd_pr__res_xhigh_po w=10 l=5.0116483
XRn1n20f1p0s1 Rn1n20f1t0s0 Rn1n20f1t0s1 0 sky130_fd_pr__res_xhigh_po w=10 l=5.0116483
XRn1n20f1p0s2 Rn1n20f1t0s1 Rn1n20f1t0s2 0 sky130_fd_pr__res_xhigh_po w=10 l=5.0116483
XRn1n20f1p0s3 Rn1n20f1t0s2 Rn1n20f1t0s3 0 sky130_fd_pr__res_xhigh_po w=10 l=5.0116483
XRn1n20f1p0s4 Rn1n20f1t0s3 Rn1n20f1t0s4 0 sky130_fd_pr__res_xhigh_po w=10 l=5.0116483
XRn1n20f1p0s5 Rn1n20f1t0s4 Rn1n20f1t0s5 0 sky130_fd_pr__res_xhigh_po w=10 l=5.0116483
XRn1n20f1p0s6 Rn1n20f1t0s5 Rn1n20f1t0s6 0 sky130_fd_pr__res_xhigh_po w=10 l=5.0116483
XRn1n20f1p0s7 Rn1n20f1t0s6 n1p 0 sky130_fd_pr__res_xhigh_po w=10 l=5.0116483
XRn1n20f1p1s0 tap20 Rn1n20f1t1s0 0 sky130_fd_pr__res_xhigh_po w=10 l=5.0116483
XRn1n20f1p1s1 Rn1n20f1t1s0 Rn1n20f1t1s1 0 sky130_fd_pr__res_xhigh_po w=10 l=5.0116483
XRn1n20f1p1s2 Rn1n20f1t1s1 Rn1n20f1t1s2 0 sky130_fd_pr__res_xhigh_po w=10 l=5.0116483
XRn1n20f1p1s3 Rn1n20f1t1s2 Rn1n20f1t1s3 0 sky130_fd_pr__res_xhigh_po w=10 l=5.0116483
XRn1n20f1p1s4 Rn1n20f1t1s3 Rn1n20f1t1s4 0 sky130_fd_pr__res_xhigh_po w=10 l=5.0116483
XRn1n20f1p1s5 Rn1n20f1t1s4 Rn1n20f1t1s5 0 sky130_fd_pr__res_xhigh_po w=10 l=5.0116483
XRn1n20f1p1s6 Rn1n20f1t1s5 Rn1n20f1t1s6 0 sky130_fd_pr__res_xhigh_po w=10 l=5.0116483
XRn1n20f1p1s7 Rn1n20f1t1s6 n1p 0 sky130_fd_pr__res_xhigh_po w=10 l=5.0116483
XRn1n20f1p2s0 tap20 Rn1n20f1t2s0 0 sky130_fd_pr__res_xhigh_po w=10 l=5.0116483
XRn1n20f1p2s1 Rn1n20f1t2s0 Rn1n20f1t2s1 0 sky130_fd_pr__res_xhigh_po w=10 l=5.0116483
XRn1n20f1p2s2 Rn1n20f1t2s1 Rn1n20f1t2s2 0 sky130_fd_pr__res_xhigh_po w=10 l=5.0116483
XRn1n20f1p2s3 Rn1n20f1t2s2 Rn1n20f1t2s3 0 sky130_fd_pr__res_xhigh_po w=10 l=5.0116483
XRn1n20f1p2s4 Rn1n20f1t2s3 Rn1n20f1t2s4 0 sky130_fd_pr__res_xhigh_po w=10 l=5.0116483
XRn1n20f1p2s5 Rn1n20f1t2s4 Rn1n20f1t2s5 0 sky130_fd_pr__res_xhigh_po w=10 l=5.0116483
XRn1n20f1p2s6 Rn1n20f1t2s5 Rn1n20f1t2s6 0 sky130_fd_pr__res_xhigh_po w=10 l=5.0116483
XRn1n20f1p2s7 Rn1n20f1t2s6 n1p 0 sky130_fd_pr__res_xhigh_po w=10 l=5.0116483
XRn1n20f1p3s0 tap20 Rn1n20f1t3s0 0 sky130_fd_pr__res_xhigh_po w=10 l=5.0116483
XRn1n20f1p3s1 Rn1n20f1t3s0 Rn1n20f1t3s1 0 sky130_fd_pr__res_xhigh_po w=10 l=5.0116483
XRn1n20f1p3s2 Rn1n20f1t3s1 Rn1n20f1t3s2 0 sky130_fd_pr__res_xhigh_po w=10 l=5.0116483
XRn1n20f1p3s3 Rn1n20f1t3s2 Rn1n20f1t3s3 0 sky130_fd_pr__res_xhigh_po w=10 l=5.0116483
XRn1n20f1p3s4 Rn1n20f1t3s3 Rn1n20f1t3s4 0 sky130_fd_pr__res_xhigh_po w=10 l=5.0116483
XRn1n20f1p3s5 Rn1n20f1t3s4 Rn1n20f1t3s5 0 sky130_fd_pr__res_xhigh_po w=10 l=5.0116483
XRn1n20f1p3s6 Rn1n20f1t3s5 Rn1n20f1t3s6 0 sky130_fd_pr__res_xhigh_po w=10 l=5.0116483
XRn1n20f1p3s7 Rn1n20f1t3s6 n1p 0 sky130_fd_pr__res_xhigh_po w=10 l=5.0116483
XRn1n20f1p4s0 tap20 Rn1n20f1t4s0 0 sky130_fd_pr__res_xhigh_po w=10 l=5.0116483
XRn1n20f1p4s1 Rn1n20f1t4s0 Rn1n20f1t4s1 0 sky130_fd_pr__res_xhigh_po w=10 l=5.0116483
XRn1n20f1p4s2 Rn1n20f1t4s1 Rn1n20f1t4s2 0 sky130_fd_pr__res_xhigh_po w=10 l=5.0116483
XRn1n20f1p4s3 Rn1n20f1t4s2 Rn1n20f1t4s3 0 sky130_fd_pr__res_xhigh_po w=10 l=5.0116483
XRn1n20f1p4s4 Rn1n20f1t4s3 Rn1n20f1t4s4 0 sky130_fd_pr__res_xhigh_po w=10 l=5.0116483
XRn1n20f1p4s5 Rn1n20f1t4s4 Rn1n20f1t4s5 0 sky130_fd_pr__res_xhigh_po w=10 l=5.0116483
XRn1n20f1p4s6 Rn1n20f1t4s5 Rn1n20f1t4s6 0 sky130_fd_pr__res_xhigh_po w=10 l=5.0116483
XRn1n20f1p4s7 Rn1n20f1t4s6 n1p 0 sky130_fd_pr__res_xhigh_po w=10 l=5.0116483
XRn1n20f1p5s0 tap20 Rn1n20f1t5s0 0 sky130_fd_pr__res_xhigh_po w=10 l=5.0116483
XRn1n20f1p5s1 Rn1n20f1t5s0 Rn1n20f1t5s1 0 sky130_fd_pr__res_xhigh_po w=10 l=5.0116483
XRn1n20f1p5s2 Rn1n20f1t5s1 Rn1n20f1t5s2 0 sky130_fd_pr__res_xhigh_po w=10 l=5.0116483
XRn1n20f1p5s3 Rn1n20f1t5s2 Rn1n20f1t5s3 0 sky130_fd_pr__res_xhigh_po w=10 l=5.0116483
XRn1n20f1p5s4 Rn1n20f1t5s3 Rn1n20f1t5s4 0 sky130_fd_pr__res_xhigh_po w=10 l=5.0116483
XRn1n20f1p5s5 Rn1n20f1t5s4 Rn1n20f1t5s5 0 sky130_fd_pr__res_xhigh_po w=10 l=5.0116483
XRn1n20f1p5s6 Rn1n20f1t5s5 Rn1n20f1t5s6 0 sky130_fd_pr__res_xhigh_po w=10 l=5.0116483
XRn1n20f1p5s7 Rn1n20f1t5s6 n1p 0 sky130_fd_pr__res_xhigh_po w=10 l=5.0116483
XRn1n20f1p6s0 tap20 Rn1n20f1t6s0 0 sky130_fd_pr__res_xhigh_po w=10 l=5.0116483
XRn1n20f1p6s1 Rn1n20f1t6s0 Rn1n20f1t6s1 0 sky130_fd_pr__res_xhigh_po w=10 l=5.0116483
XRn1n20f1p6s2 Rn1n20f1t6s1 Rn1n20f1t6s2 0 sky130_fd_pr__res_xhigh_po w=10 l=5.0116483
XRn1n20f1p6s3 Rn1n20f1t6s2 Rn1n20f1t6s3 0 sky130_fd_pr__res_xhigh_po w=10 l=5.0116483
XRn1n20f1p6s4 Rn1n20f1t6s3 Rn1n20f1t6s4 0 sky130_fd_pr__res_xhigh_po w=10 l=5.0116483
XRn1n20f1p6s5 Rn1n20f1t6s4 Rn1n20f1t6s5 0 sky130_fd_pr__res_xhigh_po w=10 l=5.0116483
XRn1n20f1p6s6 Rn1n20f1t6s5 Rn1n20f1t6s6 0 sky130_fd_pr__res_xhigh_po w=10 l=5.0116483
XRn1n20f1p6s7 Rn1n20f1t6s6 n1p 0 sky130_fd_pr__res_xhigh_po w=10 l=5.0116483
XRn1n20f1p7s0 tap20 Rn1n20f1t7s0 0 sky130_fd_pr__res_xhigh_po w=10 l=5.0116483
XRn1n20f1p7s1 Rn1n20f1t7s0 Rn1n20f1t7s1 0 sky130_fd_pr__res_xhigh_po w=10 l=5.0116483
XRn1n20f1p7s2 Rn1n20f1t7s1 Rn1n20f1t7s2 0 sky130_fd_pr__res_xhigh_po w=10 l=5.0116483
XRn1n20f1p7s3 Rn1n20f1t7s2 Rn1n20f1t7s3 0 sky130_fd_pr__res_xhigh_po w=10 l=5.0116483
XRn1n20f1p7s4 Rn1n20f1t7s3 Rn1n20f1t7s4 0 sky130_fd_pr__res_xhigh_po w=10 l=5.0116483
XRn1n20f1p7s5 Rn1n20f1t7s4 Rn1n20f1t7s5 0 sky130_fd_pr__res_xhigh_po w=10 l=5.0116483
XRn1n20f1p7s6 Rn1n20f1t7s5 Rn1n20f1t7s6 0 sky130_fd_pr__res_xhigh_po w=10 l=5.0116483
XRn1n20f1p7s7 Rn1n20f1t7s6 n1p 0 sky130_fd_pr__res_xhigh_po w=10 l=5.0116483
* n1 input 21 w=-0.0999542141187652 w-  bank=n alpha=1 R=333486.022847689 G_phys=2.99862642356296e-06 G_eff=2.99862642356296e-06
* PDK sky130_fd_pr__res_xhigh_po Rn1n21n1 W=10 L=1657.9869
* tile Rn1n21n1 8s x 8p same W=10 L=1657.9869
XRn1n21n1p0s0 in21 Rn1n21n1t0s0 0 sky130_fd_pr__res_xhigh_po w=10 l=1657.9869
XRn1n21n1p0s1 Rn1n21n1t0s0 Rn1n21n1t0s1 0 sky130_fd_pr__res_xhigh_po w=10 l=1657.9869
XRn1n21n1p0s2 Rn1n21n1t0s1 Rn1n21n1t0s2 0 sky130_fd_pr__res_xhigh_po w=10 l=1657.9869
XRn1n21n1p0s3 Rn1n21n1t0s2 Rn1n21n1t0s3 0 sky130_fd_pr__res_xhigh_po w=10 l=1657.9869
XRn1n21n1p0s4 Rn1n21n1t0s3 Rn1n21n1t0s4 0 sky130_fd_pr__res_xhigh_po w=10 l=1657.9869
XRn1n21n1p0s5 Rn1n21n1t0s4 Rn1n21n1t0s5 0 sky130_fd_pr__res_xhigh_po w=10 l=1657.9869
XRn1n21n1p0s6 Rn1n21n1t0s5 Rn1n21n1t0s6 0 sky130_fd_pr__res_xhigh_po w=10 l=1657.9869
XRn1n21n1p0s7 Rn1n21n1t0s6 n1p 0 sky130_fd_pr__res_xhigh_po w=10 l=1657.9869
XRn1n21n1p1s0 in21 Rn1n21n1t1s0 0 sky130_fd_pr__res_xhigh_po w=10 l=1657.9869
XRn1n21n1p1s1 Rn1n21n1t1s0 Rn1n21n1t1s1 0 sky130_fd_pr__res_xhigh_po w=10 l=1657.9869
XRn1n21n1p1s2 Rn1n21n1t1s1 Rn1n21n1t1s2 0 sky130_fd_pr__res_xhigh_po w=10 l=1657.9869
XRn1n21n1p1s3 Rn1n21n1t1s2 Rn1n21n1t1s3 0 sky130_fd_pr__res_xhigh_po w=10 l=1657.9869
XRn1n21n1p1s4 Rn1n21n1t1s3 Rn1n21n1t1s4 0 sky130_fd_pr__res_xhigh_po w=10 l=1657.9869
XRn1n21n1p1s5 Rn1n21n1t1s4 Rn1n21n1t1s5 0 sky130_fd_pr__res_xhigh_po w=10 l=1657.9869
XRn1n21n1p1s6 Rn1n21n1t1s5 Rn1n21n1t1s6 0 sky130_fd_pr__res_xhigh_po w=10 l=1657.9869
XRn1n21n1p1s7 Rn1n21n1t1s6 n1p 0 sky130_fd_pr__res_xhigh_po w=10 l=1657.9869
XRn1n21n1p2s0 in21 Rn1n21n1t2s0 0 sky130_fd_pr__res_xhigh_po w=10 l=1657.9869
XRn1n21n1p2s1 Rn1n21n1t2s0 Rn1n21n1t2s1 0 sky130_fd_pr__res_xhigh_po w=10 l=1657.9869
XRn1n21n1p2s2 Rn1n21n1t2s1 Rn1n21n1t2s2 0 sky130_fd_pr__res_xhigh_po w=10 l=1657.9869
XRn1n21n1p2s3 Rn1n21n1t2s2 Rn1n21n1t2s3 0 sky130_fd_pr__res_xhigh_po w=10 l=1657.9869
XRn1n21n1p2s4 Rn1n21n1t2s3 Rn1n21n1t2s4 0 sky130_fd_pr__res_xhigh_po w=10 l=1657.9869
XRn1n21n1p2s5 Rn1n21n1t2s4 Rn1n21n1t2s5 0 sky130_fd_pr__res_xhigh_po w=10 l=1657.9869
XRn1n21n1p2s6 Rn1n21n1t2s5 Rn1n21n1t2s6 0 sky130_fd_pr__res_xhigh_po w=10 l=1657.9869
XRn1n21n1p2s7 Rn1n21n1t2s6 n1p 0 sky130_fd_pr__res_xhigh_po w=10 l=1657.9869
XRn1n21n1p3s0 in21 Rn1n21n1t3s0 0 sky130_fd_pr__res_xhigh_po w=10 l=1657.9869
XRn1n21n1p3s1 Rn1n21n1t3s0 Rn1n21n1t3s1 0 sky130_fd_pr__res_xhigh_po w=10 l=1657.9869
XRn1n21n1p3s2 Rn1n21n1t3s1 Rn1n21n1t3s2 0 sky130_fd_pr__res_xhigh_po w=10 l=1657.9869
XRn1n21n1p3s3 Rn1n21n1t3s2 Rn1n21n1t3s3 0 sky130_fd_pr__res_xhigh_po w=10 l=1657.9869
XRn1n21n1p3s4 Rn1n21n1t3s3 Rn1n21n1t3s4 0 sky130_fd_pr__res_xhigh_po w=10 l=1657.9869
XRn1n21n1p3s5 Rn1n21n1t3s4 Rn1n21n1t3s5 0 sky130_fd_pr__res_xhigh_po w=10 l=1657.9869
XRn1n21n1p3s6 Rn1n21n1t3s5 Rn1n21n1t3s6 0 sky130_fd_pr__res_xhigh_po w=10 l=1657.9869
XRn1n21n1p3s7 Rn1n21n1t3s6 n1p 0 sky130_fd_pr__res_xhigh_po w=10 l=1657.9869
XRn1n21n1p4s0 in21 Rn1n21n1t4s0 0 sky130_fd_pr__res_xhigh_po w=10 l=1657.9869
XRn1n21n1p4s1 Rn1n21n1t4s0 Rn1n21n1t4s1 0 sky130_fd_pr__res_xhigh_po w=10 l=1657.9869
XRn1n21n1p4s2 Rn1n21n1t4s1 Rn1n21n1t4s2 0 sky130_fd_pr__res_xhigh_po w=10 l=1657.9869
XRn1n21n1p4s3 Rn1n21n1t4s2 Rn1n21n1t4s3 0 sky130_fd_pr__res_xhigh_po w=10 l=1657.9869
XRn1n21n1p4s4 Rn1n21n1t4s3 Rn1n21n1t4s4 0 sky130_fd_pr__res_xhigh_po w=10 l=1657.9869
XRn1n21n1p4s5 Rn1n21n1t4s4 Rn1n21n1t4s5 0 sky130_fd_pr__res_xhigh_po w=10 l=1657.9869
XRn1n21n1p4s6 Rn1n21n1t4s5 Rn1n21n1t4s6 0 sky130_fd_pr__res_xhigh_po w=10 l=1657.9869
XRn1n21n1p4s7 Rn1n21n1t4s6 n1p 0 sky130_fd_pr__res_xhigh_po w=10 l=1657.9869
XRn1n21n1p5s0 in21 Rn1n21n1t5s0 0 sky130_fd_pr__res_xhigh_po w=10 l=1657.9869
XRn1n21n1p5s1 Rn1n21n1t5s0 Rn1n21n1t5s1 0 sky130_fd_pr__res_xhigh_po w=10 l=1657.9869
XRn1n21n1p5s2 Rn1n21n1t5s1 Rn1n21n1t5s2 0 sky130_fd_pr__res_xhigh_po w=10 l=1657.9869
XRn1n21n1p5s3 Rn1n21n1t5s2 Rn1n21n1t5s3 0 sky130_fd_pr__res_xhigh_po w=10 l=1657.9869
XRn1n21n1p5s4 Rn1n21n1t5s3 Rn1n21n1t5s4 0 sky130_fd_pr__res_xhigh_po w=10 l=1657.9869
XRn1n21n1p5s5 Rn1n21n1t5s4 Rn1n21n1t5s5 0 sky130_fd_pr__res_xhigh_po w=10 l=1657.9869
XRn1n21n1p5s6 Rn1n21n1t5s5 Rn1n21n1t5s6 0 sky130_fd_pr__res_xhigh_po w=10 l=1657.9869
XRn1n21n1p5s7 Rn1n21n1t5s6 n1p 0 sky130_fd_pr__res_xhigh_po w=10 l=1657.9869
XRn1n21n1p6s0 in21 Rn1n21n1t6s0 0 sky130_fd_pr__res_xhigh_po w=10 l=1657.9869
XRn1n21n1p6s1 Rn1n21n1t6s0 Rn1n21n1t6s1 0 sky130_fd_pr__res_xhigh_po w=10 l=1657.9869
XRn1n21n1p6s2 Rn1n21n1t6s1 Rn1n21n1t6s2 0 sky130_fd_pr__res_xhigh_po w=10 l=1657.9869
XRn1n21n1p6s3 Rn1n21n1t6s2 Rn1n21n1t6s3 0 sky130_fd_pr__res_xhigh_po w=10 l=1657.9869
XRn1n21n1p6s4 Rn1n21n1t6s3 Rn1n21n1t6s4 0 sky130_fd_pr__res_xhigh_po w=10 l=1657.9869
XRn1n21n1p6s5 Rn1n21n1t6s4 Rn1n21n1t6s5 0 sky130_fd_pr__res_xhigh_po w=10 l=1657.9869
XRn1n21n1p6s6 Rn1n21n1t6s5 Rn1n21n1t6s6 0 sky130_fd_pr__res_xhigh_po w=10 l=1657.9869
XRn1n21n1p6s7 Rn1n21n1t6s6 n1p 0 sky130_fd_pr__res_xhigh_po w=10 l=1657.9869
XRn1n21n1p7s0 in21 Rn1n21n1t7s0 0 sky130_fd_pr__res_xhigh_po w=10 l=1657.9869
XRn1n21n1p7s1 Rn1n21n1t7s0 Rn1n21n1t7s1 0 sky130_fd_pr__res_xhigh_po w=10 l=1657.9869
XRn1n21n1p7s2 Rn1n21n1t7s1 Rn1n21n1t7s2 0 sky130_fd_pr__res_xhigh_po w=10 l=1657.9869
XRn1n21n1p7s3 Rn1n21n1t7s2 Rn1n21n1t7s3 0 sky130_fd_pr__res_xhigh_po w=10 l=1657.9869
XRn1n21n1p7s4 Rn1n21n1t7s3 Rn1n21n1t7s4 0 sky130_fd_pr__res_xhigh_po w=10 l=1657.9869
XRn1n21n1p7s5 Rn1n21n1t7s4 Rn1n21n1t7s5 0 sky130_fd_pr__res_xhigh_po w=10 l=1657.9869
XRn1n21n1p7s6 Rn1n21n1t7s5 Rn1n21n1t7s6 0 sky130_fd_pr__res_xhigh_po w=10 l=1657.9869
XRn1n21n1p7s7 Rn1n21n1t7s6 n1p 0 sky130_fd_pr__res_xhigh_po w=10 l=1657.9869
* n1 input 22 w=+0.693789300406694 w+  bank=n alpha=1 R=48045.3263170729 G_phys=2.08136790122008e-05 G_eff=2.08136790122008e-05
* PDK sky130_fd_pr__res_xhigh_po Rn1p22n1 W=10 L=238.77573
* tile Rn1p22n1 8s x 8p same W=10 L=238.77573
XRn1p22n1p0s0 in22n Rn1p22n1t0s0 0 sky130_fd_pr__res_xhigh_po w=10 l=238.77573
XRn1p22n1p0s1 Rn1p22n1t0s0 Rn1p22n1t0s1 0 sky130_fd_pr__res_xhigh_po w=10 l=238.77573
XRn1p22n1p0s2 Rn1p22n1t0s1 Rn1p22n1t0s2 0 sky130_fd_pr__res_xhigh_po w=10 l=238.77573
XRn1p22n1p0s3 Rn1p22n1t0s2 Rn1p22n1t0s3 0 sky130_fd_pr__res_xhigh_po w=10 l=238.77573
XRn1p22n1p0s4 Rn1p22n1t0s3 Rn1p22n1t0s4 0 sky130_fd_pr__res_xhigh_po w=10 l=238.77573
XRn1p22n1p0s5 Rn1p22n1t0s4 Rn1p22n1t0s5 0 sky130_fd_pr__res_xhigh_po w=10 l=238.77573
XRn1p22n1p0s6 Rn1p22n1t0s5 Rn1p22n1t0s6 0 sky130_fd_pr__res_xhigh_po w=10 l=238.77573
XRn1p22n1p0s7 Rn1p22n1t0s6 n1p 0 sky130_fd_pr__res_xhigh_po w=10 l=238.77573
XRn1p22n1p1s0 in22n Rn1p22n1t1s0 0 sky130_fd_pr__res_xhigh_po w=10 l=238.77573
XRn1p22n1p1s1 Rn1p22n1t1s0 Rn1p22n1t1s1 0 sky130_fd_pr__res_xhigh_po w=10 l=238.77573
XRn1p22n1p1s2 Rn1p22n1t1s1 Rn1p22n1t1s2 0 sky130_fd_pr__res_xhigh_po w=10 l=238.77573
XRn1p22n1p1s3 Rn1p22n1t1s2 Rn1p22n1t1s3 0 sky130_fd_pr__res_xhigh_po w=10 l=238.77573
XRn1p22n1p1s4 Rn1p22n1t1s3 Rn1p22n1t1s4 0 sky130_fd_pr__res_xhigh_po w=10 l=238.77573
XRn1p22n1p1s5 Rn1p22n1t1s4 Rn1p22n1t1s5 0 sky130_fd_pr__res_xhigh_po w=10 l=238.77573
XRn1p22n1p1s6 Rn1p22n1t1s5 Rn1p22n1t1s6 0 sky130_fd_pr__res_xhigh_po w=10 l=238.77573
XRn1p22n1p1s7 Rn1p22n1t1s6 n1p 0 sky130_fd_pr__res_xhigh_po w=10 l=238.77573
XRn1p22n1p2s0 in22n Rn1p22n1t2s0 0 sky130_fd_pr__res_xhigh_po w=10 l=238.77573
XRn1p22n1p2s1 Rn1p22n1t2s0 Rn1p22n1t2s1 0 sky130_fd_pr__res_xhigh_po w=10 l=238.77573
XRn1p22n1p2s2 Rn1p22n1t2s1 Rn1p22n1t2s2 0 sky130_fd_pr__res_xhigh_po w=10 l=238.77573
XRn1p22n1p2s3 Rn1p22n1t2s2 Rn1p22n1t2s3 0 sky130_fd_pr__res_xhigh_po w=10 l=238.77573
XRn1p22n1p2s4 Rn1p22n1t2s3 Rn1p22n1t2s4 0 sky130_fd_pr__res_xhigh_po w=10 l=238.77573
XRn1p22n1p2s5 Rn1p22n1t2s4 Rn1p22n1t2s5 0 sky130_fd_pr__res_xhigh_po w=10 l=238.77573
XRn1p22n1p2s6 Rn1p22n1t2s5 Rn1p22n1t2s6 0 sky130_fd_pr__res_xhigh_po w=10 l=238.77573
XRn1p22n1p2s7 Rn1p22n1t2s6 n1p 0 sky130_fd_pr__res_xhigh_po w=10 l=238.77573
XRn1p22n1p3s0 in22n Rn1p22n1t3s0 0 sky130_fd_pr__res_xhigh_po w=10 l=238.77573
XRn1p22n1p3s1 Rn1p22n1t3s0 Rn1p22n1t3s1 0 sky130_fd_pr__res_xhigh_po w=10 l=238.77573
XRn1p22n1p3s2 Rn1p22n1t3s1 Rn1p22n1t3s2 0 sky130_fd_pr__res_xhigh_po w=10 l=238.77573
XRn1p22n1p3s3 Rn1p22n1t3s2 Rn1p22n1t3s3 0 sky130_fd_pr__res_xhigh_po w=10 l=238.77573
XRn1p22n1p3s4 Rn1p22n1t3s3 Rn1p22n1t3s4 0 sky130_fd_pr__res_xhigh_po w=10 l=238.77573
XRn1p22n1p3s5 Rn1p22n1t3s4 Rn1p22n1t3s5 0 sky130_fd_pr__res_xhigh_po w=10 l=238.77573
XRn1p22n1p3s6 Rn1p22n1t3s5 Rn1p22n1t3s6 0 sky130_fd_pr__res_xhigh_po w=10 l=238.77573
XRn1p22n1p3s7 Rn1p22n1t3s6 n1p 0 sky130_fd_pr__res_xhigh_po w=10 l=238.77573
XRn1p22n1p4s0 in22n Rn1p22n1t4s0 0 sky130_fd_pr__res_xhigh_po w=10 l=238.77573
XRn1p22n1p4s1 Rn1p22n1t4s0 Rn1p22n1t4s1 0 sky130_fd_pr__res_xhigh_po w=10 l=238.77573
XRn1p22n1p4s2 Rn1p22n1t4s1 Rn1p22n1t4s2 0 sky130_fd_pr__res_xhigh_po w=10 l=238.77573
XRn1p22n1p4s3 Rn1p22n1t4s2 Rn1p22n1t4s3 0 sky130_fd_pr__res_xhigh_po w=10 l=238.77573
XRn1p22n1p4s4 Rn1p22n1t4s3 Rn1p22n1t4s4 0 sky130_fd_pr__res_xhigh_po w=10 l=238.77573
XRn1p22n1p4s5 Rn1p22n1t4s4 Rn1p22n1t4s5 0 sky130_fd_pr__res_xhigh_po w=10 l=238.77573
XRn1p22n1p4s6 Rn1p22n1t4s5 Rn1p22n1t4s6 0 sky130_fd_pr__res_xhigh_po w=10 l=238.77573
XRn1p22n1p4s7 Rn1p22n1t4s6 n1p 0 sky130_fd_pr__res_xhigh_po w=10 l=238.77573
XRn1p22n1p5s0 in22n Rn1p22n1t5s0 0 sky130_fd_pr__res_xhigh_po w=10 l=238.77573
XRn1p22n1p5s1 Rn1p22n1t5s0 Rn1p22n1t5s1 0 sky130_fd_pr__res_xhigh_po w=10 l=238.77573
XRn1p22n1p5s2 Rn1p22n1t5s1 Rn1p22n1t5s2 0 sky130_fd_pr__res_xhigh_po w=10 l=238.77573
XRn1p22n1p5s3 Rn1p22n1t5s2 Rn1p22n1t5s3 0 sky130_fd_pr__res_xhigh_po w=10 l=238.77573
XRn1p22n1p5s4 Rn1p22n1t5s3 Rn1p22n1t5s4 0 sky130_fd_pr__res_xhigh_po w=10 l=238.77573
XRn1p22n1p5s5 Rn1p22n1t5s4 Rn1p22n1t5s5 0 sky130_fd_pr__res_xhigh_po w=10 l=238.77573
XRn1p22n1p5s6 Rn1p22n1t5s5 Rn1p22n1t5s6 0 sky130_fd_pr__res_xhigh_po w=10 l=238.77573
XRn1p22n1p5s7 Rn1p22n1t5s6 n1p 0 sky130_fd_pr__res_xhigh_po w=10 l=238.77573
XRn1p22n1p6s0 in22n Rn1p22n1t6s0 0 sky130_fd_pr__res_xhigh_po w=10 l=238.77573
XRn1p22n1p6s1 Rn1p22n1t6s0 Rn1p22n1t6s1 0 sky130_fd_pr__res_xhigh_po w=10 l=238.77573
XRn1p22n1p6s2 Rn1p22n1t6s1 Rn1p22n1t6s2 0 sky130_fd_pr__res_xhigh_po w=10 l=238.77573
XRn1p22n1p6s3 Rn1p22n1t6s2 Rn1p22n1t6s3 0 sky130_fd_pr__res_xhigh_po w=10 l=238.77573
XRn1p22n1p6s4 Rn1p22n1t6s3 Rn1p22n1t6s4 0 sky130_fd_pr__res_xhigh_po w=10 l=238.77573
XRn1p22n1p6s5 Rn1p22n1t6s4 Rn1p22n1t6s5 0 sky130_fd_pr__res_xhigh_po w=10 l=238.77573
XRn1p22n1p6s6 Rn1p22n1t6s5 Rn1p22n1t6s6 0 sky130_fd_pr__res_xhigh_po w=10 l=238.77573
XRn1p22n1p6s7 Rn1p22n1t6s6 n1p 0 sky130_fd_pr__res_xhigh_po w=10 l=238.77573
XRn1p22n1p7s0 in22n Rn1p22n1t7s0 0 sky130_fd_pr__res_xhigh_po w=10 l=238.77573
XRn1p22n1p7s1 Rn1p22n1t7s0 Rn1p22n1t7s1 0 sky130_fd_pr__res_xhigh_po w=10 l=238.77573
XRn1p22n1p7s2 Rn1p22n1t7s1 Rn1p22n1t7s2 0 sky130_fd_pr__res_xhigh_po w=10 l=238.77573
XRn1p22n1p7s3 Rn1p22n1t7s2 Rn1p22n1t7s3 0 sky130_fd_pr__res_xhigh_po w=10 l=238.77573
XRn1p22n1p7s4 Rn1p22n1t7s3 Rn1p22n1t7s4 0 sky130_fd_pr__res_xhigh_po w=10 l=238.77573
XRn1p22n1p7s5 Rn1p22n1t7s4 Rn1p22n1t7s5 0 sky130_fd_pr__res_xhigh_po w=10 l=238.77573
XRn1p22n1p7s6 Rn1p22n1t7s5 Rn1p22n1t7s6 0 sky130_fd_pr__res_xhigh_po w=10 l=238.77573
XRn1p22n1p7s7 Rn1p22n1t7s6 n1p 0 sky130_fd_pr__res_xhigh_po w=10 l=238.77573
* n1 input 23 w=+0.0972685864670828 w+  bank=n alpha=1 R=342693.715864925 G_phys=2.91805759401248e-06 G_eff=2.91805759401248e-06
* PDK sky130_fd_pr__res_xhigh_po Rn1p23n1 W=10 L=1703.7675
* tile Rn1p23n1 8s x 8p same W=10 L=1703.7675
XRn1p23n1p0s0 in23n Rn1p23n1t0s0 0 sky130_fd_pr__res_xhigh_po w=10 l=1703.7675
XRn1p23n1p0s1 Rn1p23n1t0s0 Rn1p23n1t0s1 0 sky130_fd_pr__res_xhigh_po w=10 l=1703.7675
XRn1p23n1p0s2 Rn1p23n1t0s1 Rn1p23n1t0s2 0 sky130_fd_pr__res_xhigh_po w=10 l=1703.7675
XRn1p23n1p0s3 Rn1p23n1t0s2 Rn1p23n1t0s3 0 sky130_fd_pr__res_xhigh_po w=10 l=1703.7675
XRn1p23n1p0s4 Rn1p23n1t0s3 Rn1p23n1t0s4 0 sky130_fd_pr__res_xhigh_po w=10 l=1703.7675
XRn1p23n1p0s5 Rn1p23n1t0s4 Rn1p23n1t0s5 0 sky130_fd_pr__res_xhigh_po w=10 l=1703.7675
XRn1p23n1p0s6 Rn1p23n1t0s5 Rn1p23n1t0s6 0 sky130_fd_pr__res_xhigh_po w=10 l=1703.7675
XRn1p23n1p0s7 Rn1p23n1t0s6 n1p 0 sky130_fd_pr__res_xhigh_po w=10 l=1703.7675
XRn1p23n1p1s0 in23n Rn1p23n1t1s0 0 sky130_fd_pr__res_xhigh_po w=10 l=1703.7675
XRn1p23n1p1s1 Rn1p23n1t1s0 Rn1p23n1t1s1 0 sky130_fd_pr__res_xhigh_po w=10 l=1703.7675
XRn1p23n1p1s2 Rn1p23n1t1s1 Rn1p23n1t1s2 0 sky130_fd_pr__res_xhigh_po w=10 l=1703.7675
XRn1p23n1p1s3 Rn1p23n1t1s2 Rn1p23n1t1s3 0 sky130_fd_pr__res_xhigh_po w=10 l=1703.7675
XRn1p23n1p1s4 Rn1p23n1t1s3 Rn1p23n1t1s4 0 sky130_fd_pr__res_xhigh_po w=10 l=1703.7675
XRn1p23n1p1s5 Rn1p23n1t1s4 Rn1p23n1t1s5 0 sky130_fd_pr__res_xhigh_po w=10 l=1703.7675
XRn1p23n1p1s6 Rn1p23n1t1s5 Rn1p23n1t1s6 0 sky130_fd_pr__res_xhigh_po w=10 l=1703.7675
XRn1p23n1p1s7 Rn1p23n1t1s6 n1p 0 sky130_fd_pr__res_xhigh_po w=10 l=1703.7675
XRn1p23n1p2s0 in23n Rn1p23n1t2s0 0 sky130_fd_pr__res_xhigh_po w=10 l=1703.7675
XRn1p23n1p2s1 Rn1p23n1t2s0 Rn1p23n1t2s1 0 sky130_fd_pr__res_xhigh_po w=10 l=1703.7675
XRn1p23n1p2s2 Rn1p23n1t2s1 Rn1p23n1t2s2 0 sky130_fd_pr__res_xhigh_po w=10 l=1703.7675
XRn1p23n1p2s3 Rn1p23n1t2s2 Rn1p23n1t2s3 0 sky130_fd_pr__res_xhigh_po w=10 l=1703.7675
XRn1p23n1p2s4 Rn1p23n1t2s3 Rn1p23n1t2s4 0 sky130_fd_pr__res_xhigh_po w=10 l=1703.7675
XRn1p23n1p2s5 Rn1p23n1t2s4 Rn1p23n1t2s5 0 sky130_fd_pr__res_xhigh_po w=10 l=1703.7675
XRn1p23n1p2s6 Rn1p23n1t2s5 Rn1p23n1t2s6 0 sky130_fd_pr__res_xhigh_po w=10 l=1703.7675
XRn1p23n1p2s7 Rn1p23n1t2s6 n1p 0 sky130_fd_pr__res_xhigh_po w=10 l=1703.7675
XRn1p23n1p3s0 in23n Rn1p23n1t3s0 0 sky130_fd_pr__res_xhigh_po w=10 l=1703.7675
XRn1p23n1p3s1 Rn1p23n1t3s0 Rn1p23n1t3s1 0 sky130_fd_pr__res_xhigh_po w=10 l=1703.7675
XRn1p23n1p3s2 Rn1p23n1t3s1 Rn1p23n1t3s2 0 sky130_fd_pr__res_xhigh_po w=10 l=1703.7675
XRn1p23n1p3s3 Rn1p23n1t3s2 Rn1p23n1t3s3 0 sky130_fd_pr__res_xhigh_po w=10 l=1703.7675
XRn1p23n1p3s4 Rn1p23n1t3s3 Rn1p23n1t3s4 0 sky130_fd_pr__res_xhigh_po w=10 l=1703.7675
XRn1p23n1p3s5 Rn1p23n1t3s4 Rn1p23n1t3s5 0 sky130_fd_pr__res_xhigh_po w=10 l=1703.7675
XRn1p23n1p3s6 Rn1p23n1t3s5 Rn1p23n1t3s6 0 sky130_fd_pr__res_xhigh_po w=10 l=1703.7675
XRn1p23n1p3s7 Rn1p23n1t3s6 n1p 0 sky130_fd_pr__res_xhigh_po w=10 l=1703.7675
XRn1p23n1p4s0 in23n Rn1p23n1t4s0 0 sky130_fd_pr__res_xhigh_po w=10 l=1703.7675
XRn1p23n1p4s1 Rn1p23n1t4s0 Rn1p23n1t4s1 0 sky130_fd_pr__res_xhigh_po w=10 l=1703.7675
XRn1p23n1p4s2 Rn1p23n1t4s1 Rn1p23n1t4s2 0 sky130_fd_pr__res_xhigh_po w=10 l=1703.7675
XRn1p23n1p4s3 Rn1p23n1t4s2 Rn1p23n1t4s3 0 sky130_fd_pr__res_xhigh_po w=10 l=1703.7675
XRn1p23n1p4s4 Rn1p23n1t4s3 Rn1p23n1t4s4 0 sky130_fd_pr__res_xhigh_po w=10 l=1703.7675
XRn1p23n1p4s5 Rn1p23n1t4s4 Rn1p23n1t4s5 0 sky130_fd_pr__res_xhigh_po w=10 l=1703.7675
XRn1p23n1p4s6 Rn1p23n1t4s5 Rn1p23n1t4s6 0 sky130_fd_pr__res_xhigh_po w=10 l=1703.7675
XRn1p23n1p4s7 Rn1p23n1t4s6 n1p 0 sky130_fd_pr__res_xhigh_po w=10 l=1703.7675
XRn1p23n1p5s0 in23n Rn1p23n1t5s0 0 sky130_fd_pr__res_xhigh_po w=10 l=1703.7675
XRn1p23n1p5s1 Rn1p23n1t5s0 Rn1p23n1t5s1 0 sky130_fd_pr__res_xhigh_po w=10 l=1703.7675
XRn1p23n1p5s2 Rn1p23n1t5s1 Rn1p23n1t5s2 0 sky130_fd_pr__res_xhigh_po w=10 l=1703.7675
XRn1p23n1p5s3 Rn1p23n1t5s2 Rn1p23n1t5s3 0 sky130_fd_pr__res_xhigh_po w=10 l=1703.7675
XRn1p23n1p5s4 Rn1p23n1t5s3 Rn1p23n1t5s4 0 sky130_fd_pr__res_xhigh_po w=10 l=1703.7675
XRn1p23n1p5s5 Rn1p23n1t5s4 Rn1p23n1t5s5 0 sky130_fd_pr__res_xhigh_po w=10 l=1703.7675
XRn1p23n1p5s6 Rn1p23n1t5s5 Rn1p23n1t5s6 0 sky130_fd_pr__res_xhigh_po w=10 l=1703.7675
XRn1p23n1p5s7 Rn1p23n1t5s6 n1p 0 sky130_fd_pr__res_xhigh_po w=10 l=1703.7675
XRn1p23n1p6s0 in23n Rn1p23n1t6s0 0 sky130_fd_pr__res_xhigh_po w=10 l=1703.7675
XRn1p23n1p6s1 Rn1p23n1t6s0 Rn1p23n1t6s1 0 sky130_fd_pr__res_xhigh_po w=10 l=1703.7675
XRn1p23n1p6s2 Rn1p23n1t6s1 Rn1p23n1t6s2 0 sky130_fd_pr__res_xhigh_po w=10 l=1703.7675
XRn1p23n1p6s3 Rn1p23n1t6s2 Rn1p23n1t6s3 0 sky130_fd_pr__res_xhigh_po w=10 l=1703.7675
XRn1p23n1p6s4 Rn1p23n1t6s3 Rn1p23n1t6s4 0 sky130_fd_pr__res_xhigh_po w=10 l=1703.7675
XRn1p23n1p6s5 Rn1p23n1t6s4 Rn1p23n1t6s5 0 sky130_fd_pr__res_xhigh_po w=10 l=1703.7675
XRn1p23n1p6s6 Rn1p23n1t6s5 Rn1p23n1t6s6 0 sky130_fd_pr__res_xhigh_po w=10 l=1703.7675
XRn1p23n1p6s7 Rn1p23n1t6s6 n1p 0 sky130_fd_pr__res_xhigh_po w=10 l=1703.7675
XRn1p23n1p7s0 in23n Rn1p23n1t7s0 0 sky130_fd_pr__res_xhigh_po w=10 l=1703.7675
XRn1p23n1p7s1 Rn1p23n1t7s0 Rn1p23n1t7s1 0 sky130_fd_pr__res_xhigh_po w=10 l=1703.7675
XRn1p23n1p7s2 Rn1p23n1t7s1 Rn1p23n1t7s2 0 sky130_fd_pr__res_xhigh_po w=10 l=1703.7675
XRn1p23n1p7s3 Rn1p23n1t7s2 Rn1p23n1t7s3 0 sky130_fd_pr__res_xhigh_po w=10 l=1703.7675
XRn1p23n1p7s4 Rn1p23n1t7s3 Rn1p23n1t7s4 0 sky130_fd_pr__res_xhigh_po w=10 l=1703.7675
XRn1p23n1p7s5 Rn1p23n1t7s4 Rn1p23n1t7s5 0 sky130_fd_pr__res_xhigh_po w=10 l=1703.7675
XRn1p23n1p7s6 Rn1p23n1t7s5 Rn1p23n1t7s6 0 sky130_fd_pr__res_xhigh_po w=10 l=1703.7675
XRn1p23n1p7s7 Rn1p23n1t7s6 n1p 0 sky130_fd_pr__res_xhigh_po w=10 l=1703.7675
* n1 input 24 w=-0.0293783170287994 w-  bank=f alpha=0.001 R=1134.6236512002 G_phys=0.000881349510863982 G_eff=8.81349510863982e-07
* PDK sky130_fd_pr__res_xhigh_po Rn1n24f1 W=10 L=5.5357205
* tile Rn1n24f1 8s x 8p same W=10 L=5.5357205
XRn1n24f1p0s0 tap24 Rn1n24f1t0s0 0 sky130_fd_pr__res_xhigh_po w=10 l=5.5357205
XRn1n24f1p0s1 Rn1n24f1t0s0 Rn1n24f1t0s1 0 sky130_fd_pr__res_xhigh_po w=10 l=5.5357205
XRn1n24f1p0s2 Rn1n24f1t0s1 Rn1n24f1t0s2 0 sky130_fd_pr__res_xhigh_po w=10 l=5.5357205
XRn1n24f1p0s3 Rn1n24f1t0s2 Rn1n24f1t0s3 0 sky130_fd_pr__res_xhigh_po w=10 l=5.5357205
XRn1n24f1p0s4 Rn1n24f1t0s3 Rn1n24f1t0s4 0 sky130_fd_pr__res_xhigh_po w=10 l=5.5357205
XRn1n24f1p0s5 Rn1n24f1t0s4 Rn1n24f1t0s5 0 sky130_fd_pr__res_xhigh_po w=10 l=5.5357205
XRn1n24f1p0s6 Rn1n24f1t0s5 Rn1n24f1t0s6 0 sky130_fd_pr__res_xhigh_po w=10 l=5.5357205
XRn1n24f1p0s7 Rn1n24f1t0s6 n1p 0 sky130_fd_pr__res_xhigh_po w=10 l=5.5357205
XRn1n24f1p1s0 tap24 Rn1n24f1t1s0 0 sky130_fd_pr__res_xhigh_po w=10 l=5.5357205
XRn1n24f1p1s1 Rn1n24f1t1s0 Rn1n24f1t1s1 0 sky130_fd_pr__res_xhigh_po w=10 l=5.5357205
XRn1n24f1p1s2 Rn1n24f1t1s1 Rn1n24f1t1s2 0 sky130_fd_pr__res_xhigh_po w=10 l=5.5357205
XRn1n24f1p1s3 Rn1n24f1t1s2 Rn1n24f1t1s3 0 sky130_fd_pr__res_xhigh_po w=10 l=5.5357205
XRn1n24f1p1s4 Rn1n24f1t1s3 Rn1n24f1t1s4 0 sky130_fd_pr__res_xhigh_po w=10 l=5.5357205
XRn1n24f1p1s5 Rn1n24f1t1s4 Rn1n24f1t1s5 0 sky130_fd_pr__res_xhigh_po w=10 l=5.5357205
XRn1n24f1p1s6 Rn1n24f1t1s5 Rn1n24f1t1s6 0 sky130_fd_pr__res_xhigh_po w=10 l=5.5357205
XRn1n24f1p1s7 Rn1n24f1t1s6 n1p 0 sky130_fd_pr__res_xhigh_po w=10 l=5.5357205
XRn1n24f1p2s0 tap24 Rn1n24f1t2s0 0 sky130_fd_pr__res_xhigh_po w=10 l=5.5357205
XRn1n24f1p2s1 Rn1n24f1t2s0 Rn1n24f1t2s1 0 sky130_fd_pr__res_xhigh_po w=10 l=5.5357205
XRn1n24f1p2s2 Rn1n24f1t2s1 Rn1n24f1t2s2 0 sky130_fd_pr__res_xhigh_po w=10 l=5.5357205
XRn1n24f1p2s3 Rn1n24f1t2s2 Rn1n24f1t2s3 0 sky130_fd_pr__res_xhigh_po w=10 l=5.5357205
XRn1n24f1p2s4 Rn1n24f1t2s3 Rn1n24f1t2s4 0 sky130_fd_pr__res_xhigh_po w=10 l=5.5357205
XRn1n24f1p2s5 Rn1n24f1t2s4 Rn1n24f1t2s5 0 sky130_fd_pr__res_xhigh_po w=10 l=5.5357205
XRn1n24f1p2s6 Rn1n24f1t2s5 Rn1n24f1t2s6 0 sky130_fd_pr__res_xhigh_po w=10 l=5.5357205
XRn1n24f1p2s7 Rn1n24f1t2s6 n1p 0 sky130_fd_pr__res_xhigh_po w=10 l=5.5357205
XRn1n24f1p3s0 tap24 Rn1n24f1t3s0 0 sky130_fd_pr__res_xhigh_po w=10 l=5.5357205
XRn1n24f1p3s1 Rn1n24f1t3s0 Rn1n24f1t3s1 0 sky130_fd_pr__res_xhigh_po w=10 l=5.5357205
XRn1n24f1p3s2 Rn1n24f1t3s1 Rn1n24f1t3s2 0 sky130_fd_pr__res_xhigh_po w=10 l=5.5357205
XRn1n24f1p3s3 Rn1n24f1t3s2 Rn1n24f1t3s3 0 sky130_fd_pr__res_xhigh_po w=10 l=5.5357205
XRn1n24f1p3s4 Rn1n24f1t3s3 Rn1n24f1t3s4 0 sky130_fd_pr__res_xhigh_po w=10 l=5.5357205
XRn1n24f1p3s5 Rn1n24f1t3s4 Rn1n24f1t3s5 0 sky130_fd_pr__res_xhigh_po w=10 l=5.5357205
XRn1n24f1p3s6 Rn1n24f1t3s5 Rn1n24f1t3s6 0 sky130_fd_pr__res_xhigh_po w=10 l=5.5357205
XRn1n24f1p3s7 Rn1n24f1t3s6 n1p 0 sky130_fd_pr__res_xhigh_po w=10 l=5.5357205
XRn1n24f1p4s0 tap24 Rn1n24f1t4s0 0 sky130_fd_pr__res_xhigh_po w=10 l=5.5357205
XRn1n24f1p4s1 Rn1n24f1t4s0 Rn1n24f1t4s1 0 sky130_fd_pr__res_xhigh_po w=10 l=5.5357205
XRn1n24f1p4s2 Rn1n24f1t4s1 Rn1n24f1t4s2 0 sky130_fd_pr__res_xhigh_po w=10 l=5.5357205
XRn1n24f1p4s3 Rn1n24f1t4s2 Rn1n24f1t4s3 0 sky130_fd_pr__res_xhigh_po w=10 l=5.5357205
XRn1n24f1p4s4 Rn1n24f1t4s3 Rn1n24f1t4s4 0 sky130_fd_pr__res_xhigh_po w=10 l=5.5357205
XRn1n24f1p4s5 Rn1n24f1t4s4 Rn1n24f1t4s5 0 sky130_fd_pr__res_xhigh_po w=10 l=5.5357205
XRn1n24f1p4s6 Rn1n24f1t4s5 Rn1n24f1t4s6 0 sky130_fd_pr__res_xhigh_po w=10 l=5.5357205
XRn1n24f1p4s7 Rn1n24f1t4s6 n1p 0 sky130_fd_pr__res_xhigh_po w=10 l=5.5357205
XRn1n24f1p5s0 tap24 Rn1n24f1t5s0 0 sky130_fd_pr__res_xhigh_po w=10 l=5.5357205
XRn1n24f1p5s1 Rn1n24f1t5s0 Rn1n24f1t5s1 0 sky130_fd_pr__res_xhigh_po w=10 l=5.5357205
XRn1n24f1p5s2 Rn1n24f1t5s1 Rn1n24f1t5s2 0 sky130_fd_pr__res_xhigh_po w=10 l=5.5357205
XRn1n24f1p5s3 Rn1n24f1t5s2 Rn1n24f1t5s3 0 sky130_fd_pr__res_xhigh_po w=10 l=5.5357205
XRn1n24f1p5s4 Rn1n24f1t5s3 Rn1n24f1t5s4 0 sky130_fd_pr__res_xhigh_po w=10 l=5.5357205
XRn1n24f1p5s5 Rn1n24f1t5s4 Rn1n24f1t5s5 0 sky130_fd_pr__res_xhigh_po w=10 l=5.5357205
XRn1n24f1p5s6 Rn1n24f1t5s5 Rn1n24f1t5s6 0 sky130_fd_pr__res_xhigh_po w=10 l=5.5357205
XRn1n24f1p5s7 Rn1n24f1t5s6 n1p 0 sky130_fd_pr__res_xhigh_po w=10 l=5.5357205
XRn1n24f1p6s0 tap24 Rn1n24f1t6s0 0 sky130_fd_pr__res_xhigh_po w=10 l=5.5357205
XRn1n24f1p6s1 Rn1n24f1t6s0 Rn1n24f1t6s1 0 sky130_fd_pr__res_xhigh_po w=10 l=5.5357205
XRn1n24f1p6s2 Rn1n24f1t6s1 Rn1n24f1t6s2 0 sky130_fd_pr__res_xhigh_po w=10 l=5.5357205
XRn1n24f1p6s3 Rn1n24f1t6s2 Rn1n24f1t6s3 0 sky130_fd_pr__res_xhigh_po w=10 l=5.5357205
XRn1n24f1p6s4 Rn1n24f1t6s3 Rn1n24f1t6s4 0 sky130_fd_pr__res_xhigh_po w=10 l=5.5357205
XRn1n24f1p6s5 Rn1n24f1t6s4 Rn1n24f1t6s5 0 sky130_fd_pr__res_xhigh_po w=10 l=5.5357205
XRn1n24f1p6s6 Rn1n24f1t6s5 Rn1n24f1t6s6 0 sky130_fd_pr__res_xhigh_po w=10 l=5.5357205
XRn1n24f1p6s7 Rn1n24f1t6s6 n1p 0 sky130_fd_pr__res_xhigh_po w=10 l=5.5357205
XRn1n24f1p7s0 tap24 Rn1n24f1t7s0 0 sky130_fd_pr__res_xhigh_po w=10 l=5.5357205
XRn1n24f1p7s1 Rn1n24f1t7s0 Rn1n24f1t7s1 0 sky130_fd_pr__res_xhigh_po w=10 l=5.5357205
XRn1n24f1p7s2 Rn1n24f1t7s1 Rn1n24f1t7s2 0 sky130_fd_pr__res_xhigh_po w=10 l=5.5357205
XRn1n24f1p7s3 Rn1n24f1t7s2 Rn1n24f1t7s3 0 sky130_fd_pr__res_xhigh_po w=10 l=5.5357205
XRn1n24f1p7s4 Rn1n24f1t7s3 Rn1n24f1t7s4 0 sky130_fd_pr__res_xhigh_po w=10 l=5.5357205
XRn1n24f1p7s5 Rn1n24f1t7s4 Rn1n24f1t7s5 0 sky130_fd_pr__res_xhigh_po w=10 l=5.5357205
XRn1n24f1p7s6 Rn1n24f1t7s5 Rn1n24f1t7s6 0 sky130_fd_pr__res_xhigh_po w=10 l=5.5357205
XRn1n24f1p7s7 Rn1n24f1t7s6 n1p 0 sky130_fd_pr__res_xhigh_po w=10 l=5.5357205
* n1 input 25 w=+0.0497492024826392 w+  bank=n alpha=1 R=670027.491294269 G_phys=1.49247607447918e-06 G_eff=1.49247607447918e-06
* PDK sky130_fd_pr__res_xhigh_po Rn1p25n1 W=10 L=3331.2711
* tile Rn1p25n1 8s x 8p same W=10 L=3331.2711
XRn1p25n1p0s0 in25n Rn1p25n1t0s0 0 sky130_fd_pr__res_xhigh_po w=10 l=3331.2711
XRn1p25n1p0s1 Rn1p25n1t0s0 Rn1p25n1t0s1 0 sky130_fd_pr__res_xhigh_po w=10 l=3331.2711
XRn1p25n1p0s2 Rn1p25n1t0s1 Rn1p25n1t0s2 0 sky130_fd_pr__res_xhigh_po w=10 l=3331.2711
XRn1p25n1p0s3 Rn1p25n1t0s2 Rn1p25n1t0s3 0 sky130_fd_pr__res_xhigh_po w=10 l=3331.2711
XRn1p25n1p0s4 Rn1p25n1t0s3 Rn1p25n1t0s4 0 sky130_fd_pr__res_xhigh_po w=10 l=3331.2711
XRn1p25n1p0s5 Rn1p25n1t0s4 Rn1p25n1t0s5 0 sky130_fd_pr__res_xhigh_po w=10 l=3331.2711
XRn1p25n1p0s6 Rn1p25n1t0s5 Rn1p25n1t0s6 0 sky130_fd_pr__res_xhigh_po w=10 l=3331.2711
XRn1p25n1p0s7 Rn1p25n1t0s6 n1p 0 sky130_fd_pr__res_xhigh_po w=10 l=3331.2711
XRn1p25n1p1s0 in25n Rn1p25n1t1s0 0 sky130_fd_pr__res_xhigh_po w=10 l=3331.2711
XRn1p25n1p1s1 Rn1p25n1t1s0 Rn1p25n1t1s1 0 sky130_fd_pr__res_xhigh_po w=10 l=3331.2711
XRn1p25n1p1s2 Rn1p25n1t1s1 Rn1p25n1t1s2 0 sky130_fd_pr__res_xhigh_po w=10 l=3331.2711
XRn1p25n1p1s3 Rn1p25n1t1s2 Rn1p25n1t1s3 0 sky130_fd_pr__res_xhigh_po w=10 l=3331.2711
XRn1p25n1p1s4 Rn1p25n1t1s3 Rn1p25n1t1s4 0 sky130_fd_pr__res_xhigh_po w=10 l=3331.2711
XRn1p25n1p1s5 Rn1p25n1t1s4 Rn1p25n1t1s5 0 sky130_fd_pr__res_xhigh_po w=10 l=3331.2711
XRn1p25n1p1s6 Rn1p25n1t1s5 Rn1p25n1t1s6 0 sky130_fd_pr__res_xhigh_po w=10 l=3331.2711
XRn1p25n1p1s7 Rn1p25n1t1s6 n1p 0 sky130_fd_pr__res_xhigh_po w=10 l=3331.2711
XRn1p25n1p2s0 in25n Rn1p25n1t2s0 0 sky130_fd_pr__res_xhigh_po w=10 l=3331.2711
XRn1p25n1p2s1 Rn1p25n1t2s0 Rn1p25n1t2s1 0 sky130_fd_pr__res_xhigh_po w=10 l=3331.2711
XRn1p25n1p2s2 Rn1p25n1t2s1 Rn1p25n1t2s2 0 sky130_fd_pr__res_xhigh_po w=10 l=3331.2711
XRn1p25n1p2s3 Rn1p25n1t2s2 Rn1p25n1t2s3 0 sky130_fd_pr__res_xhigh_po w=10 l=3331.2711
XRn1p25n1p2s4 Rn1p25n1t2s3 Rn1p25n1t2s4 0 sky130_fd_pr__res_xhigh_po w=10 l=3331.2711
XRn1p25n1p2s5 Rn1p25n1t2s4 Rn1p25n1t2s5 0 sky130_fd_pr__res_xhigh_po w=10 l=3331.2711
XRn1p25n1p2s6 Rn1p25n1t2s5 Rn1p25n1t2s6 0 sky130_fd_pr__res_xhigh_po w=10 l=3331.2711
XRn1p25n1p2s7 Rn1p25n1t2s6 n1p 0 sky130_fd_pr__res_xhigh_po w=10 l=3331.2711
XRn1p25n1p3s0 in25n Rn1p25n1t3s0 0 sky130_fd_pr__res_xhigh_po w=10 l=3331.2711
XRn1p25n1p3s1 Rn1p25n1t3s0 Rn1p25n1t3s1 0 sky130_fd_pr__res_xhigh_po w=10 l=3331.2711
XRn1p25n1p3s2 Rn1p25n1t3s1 Rn1p25n1t3s2 0 sky130_fd_pr__res_xhigh_po w=10 l=3331.2711
XRn1p25n1p3s3 Rn1p25n1t3s2 Rn1p25n1t3s3 0 sky130_fd_pr__res_xhigh_po w=10 l=3331.2711
XRn1p25n1p3s4 Rn1p25n1t3s3 Rn1p25n1t3s4 0 sky130_fd_pr__res_xhigh_po w=10 l=3331.2711
XRn1p25n1p3s5 Rn1p25n1t3s4 Rn1p25n1t3s5 0 sky130_fd_pr__res_xhigh_po w=10 l=3331.2711
XRn1p25n1p3s6 Rn1p25n1t3s5 Rn1p25n1t3s6 0 sky130_fd_pr__res_xhigh_po w=10 l=3331.2711
XRn1p25n1p3s7 Rn1p25n1t3s6 n1p 0 sky130_fd_pr__res_xhigh_po w=10 l=3331.2711
XRn1p25n1p4s0 in25n Rn1p25n1t4s0 0 sky130_fd_pr__res_xhigh_po w=10 l=3331.2711
XRn1p25n1p4s1 Rn1p25n1t4s0 Rn1p25n1t4s1 0 sky130_fd_pr__res_xhigh_po w=10 l=3331.2711
XRn1p25n1p4s2 Rn1p25n1t4s1 Rn1p25n1t4s2 0 sky130_fd_pr__res_xhigh_po w=10 l=3331.2711
XRn1p25n1p4s3 Rn1p25n1t4s2 Rn1p25n1t4s3 0 sky130_fd_pr__res_xhigh_po w=10 l=3331.2711
XRn1p25n1p4s4 Rn1p25n1t4s3 Rn1p25n1t4s4 0 sky130_fd_pr__res_xhigh_po w=10 l=3331.2711
XRn1p25n1p4s5 Rn1p25n1t4s4 Rn1p25n1t4s5 0 sky130_fd_pr__res_xhigh_po w=10 l=3331.2711
XRn1p25n1p4s6 Rn1p25n1t4s5 Rn1p25n1t4s6 0 sky130_fd_pr__res_xhigh_po w=10 l=3331.2711
XRn1p25n1p4s7 Rn1p25n1t4s6 n1p 0 sky130_fd_pr__res_xhigh_po w=10 l=3331.2711
XRn1p25n1p5s0 in25n Rn1p25n1t5s0 0 sky130_fd_pr__res_xhigh_po w=10 l=3331.2711
XRn1p25n1p5s1 Rn1p25n1t5s0 Rn1p25n1t5s1 0 sky130_fd_pr__res_xhigh_po w=10 l=3331.2711
XRn1p25n1p5s2 Rn1p25n1t5s1 Rn1p25n1t5s2 0 sky130_fd_pr__res_xhigh_po w=10 l=3331.2711
XRn1p25n1p5s3 Rn1p25n1t5s2 Rn1p25n1t5s3 0 sky130_fd_pr__res_xhigh_po w=10 l=3331.2711
XRn1p25n1p5s4 Rn1p25n1t5s3 Rn1p25n1t5s4 0 sky130_fd_pr__res_xhigh_po w=10 l=3331.2711
XRn1p25n1p5s5 Rn1p25n1t5s4 Rn1p25n1t5s5 0 sky130_fd_pr__res_xhigh_po w=10 l=3331.2711
XRn1p25n1p5s6 Rn1p25n1t5s5 Rn1p25n1t5s6 0 sky130_fd_pr__res_xhigh_po w=10 l=3331.2711
XRn1p25n1p5s7 Rn1p25n1t5s6 n1p 0 sky130_fd_pr__res_xhigh_po w=10 l=3331.2711
XRn1p25n1p6s0 in25n Rn1p25n1t6s0 0 sky130_fd_pr__res_xhigh_po w=10 l=3331.2711
XRn1p25n1p6s1 Rn1p25n1t6s0 Rn1p25n1t6s1 0 sky130_fd_pr__res_xhigh_po w=10 l=3331.2711
XRn1p25n1p6s2 Rn1p25n1t6s1 Rn1p25n1t6s2 0 sky130_fd_pr__res_xhigh_po w=10 l=3331.2711
XRn1p25n1p6s3 Rn1p25n1t6s2 Rn1p25n1t6s3 0 sky130_fd_pr__res_xhigh_po w=10 l=3331.2711
XRn1p25n1p6s4 Rn1p25n1t6s3 Rn1p25n1t6s4 0 sky130_fd_pr__res_xhigh_po w=10 l=3331.2711
XRn1p25n1p6s5 Rn1p25n1t6s4 Rn1p25n1t6s5 0 sky130_fd_pr__res_xhigh_po w=10 l=3331.2711
XRn1p25n1p6s6 Rn1p25n1t6s5 Rn1p25n1t6s6 0 sky130_fd_pr__res_xhigh_po w=10 l=3331.2711
XRn1p25n1p6s7 Rn1p25n1t6s6 n1p 0 sky130_fd_pr__res_xhigh_po w=10 l=3331.2711
XRn1p25n1p7s0 in25n Rn1p25n1t7s0 0 sky130_fd_pr__res_xhigh_po w=10 l=3331.2711
XRn1p25n1p7s1 Rn1p25n1t7s0 Rn1p25n1t7s1 0 sky130_fd_pr__res_xhigh_po w=10 l=3331.2711
XRn1p25n1p7s2 Rn1p25n1t7s1 Rn1p25n1t7s2 0 sky130_fd_pr__res_xhigh_po w=10 l=3331.2711
XRn1p25n1p7s3 Rn1p25n1t7s2 Rn1p25n1t7s3 0 sky130_fd_pr__res_xhigh_po w=10 l=3331.2711
XRn1p25n1p7s4 Rn1p25n1t7s3 Rn1p25n1t7s4 0 sky130_fd_pr__res_xhigh_po w=10 l=3331.2711
XRn1p25n1p7s5 Rn1p25n1t7s4 Rn1p25n1t7s5 0 sky130_fd_pr__res_xhigh_po w=10 l=3331.2711
XRn1p25n1p7s6 Rn1p25n1t7s5 Rn1p25n1t7s6 0 sky130_fd_pr__res_xhigh_po w=10 l=3331.2711
XRn1p25n1p7s7 Rn1p25n1t7s6 n1p 0 sky130_fd_pr__res_xhigh_po w=10 l=3331.2711
* n1 input 26 w=-0.466063512962686 w-  bank=n alpha=1 R=71521.0103477937 G_phys=1.39819053888806e-05 G_eff=1.39819053888806e-05
* PDK sky130_fd_pr__res_xhigh_po Rn1n26n1 W=10 L=355.49684
* tile Rn1n26n1 8s x 8p same W=10 L=355.49684
XRn1n26n1p0s0 in26 Rn1n26n1t0s0 0 sky130_fd_pr__res_xhigh_po w=10 l=355.49684
XRn1n26n1p0s1 Rn1n26n1t0s0 Rn1n26n1t0s1 0 sky130_fd_pr__res_xhigh_po w=10 l=355.49684
XRn1n26n1p0s2 Rn1n26n1t0s1 Rn1n26n1t0s2 0 sky130_fd_pr__res_xhigh_po w=10 l=355.49684
XRn1n26n1p0s3 Rn1n26n1t0s2 Rn1n26n1t0s3 0 sky130_fd_pr__res_xhigh_po w=10 l=355.49684
XRn1n26n1p0s4 Rn1n26n1t0s3 Rn1n26n1t0s4 0 sky130_fd_pr__res_xhigh_po w=10 l=355.49684
XRn1n26n1p0s5 Rn1n26n1t0s4 Rn1n26n1t0s5 0 sky130_fd_pr__res_xhigh_po w=10 l=355.49684
XRn1n26n1p0s6 Rn1n26n1t0s5 Rn1n26n1t0s6 0 sky130_fd_pr__res_xhigh_po w=10 l=355.49684
XRn1n26n1p0s7 Rn1n26n1t0s6 n1p 0 sky130_fd_pr__res_xhigh_po w=10 l=355.49684
XRn1n26n1p1s0 in26 Rn1n26n1t1s0 0 sky130_fd_pr__res_xhigh_po w=10 l=355.49684
XRn1n26n1p1s1 Rn1n26n1t1s0 Rn1n26n1t1s1 0 sky130_fd_pr__res_xhigh_po w=10 l=355.49684
XRn1n26n1p1s2 Rn1n26n1t1s1 Rn1n26n1t1s2 0 sky130_fd_pr__res_xhigh_po w=10 l=355.49684
XRn1n26n1p1s3 Rn1n26n1t1s2 Rn1n26n1t1s3 0 sky130_fd_pr__res_xhigh_po w=10 l=355.49684
XRn1n26n1p1s4 Rn1n26n1t1s3 Rn1n26n1t1s4 0 sky130_fd_pr__res_xhigh_po w=10 l=355.49684
XRn1n26n1p1s5 Rn1n26n1t1s4 Rn1n26n1t1s5 0 sky130_fd_pr__res_xhigh_po w=10 l=355.49684
XRn1n26n1p1s6 Rn1n26n1t1s5 Rn1n26n1t1s6 0 sky130_fd_pr__res_xhigh_po w=10 l=355.49684
XRn1n26n1p1s7 Rn1n26n1t1s6 n1p 0 sky130_fd_pr__res_xhigh_po w=10 l=355.49684
XRn1n26n1p2s0 in26 Rn1n26n1t2s0 0 sky130_fd_pr__res_xhigh_po w=10 l=355.49684
XRn1n26n1p2s1 Rn1n26n1t2s0 Rn1n26n1t2s1 0 sky130_fd_pr__res_xhigh_po w=10 l=355.49684
XRn1n26n1p2s2 Rn1n26n1t2s1 Rn1n26n1t2s2 0 sky130_fd_pr__res_xhigh_po w=10 l=355.49684
XRn1n26n1p2s3 Rn1n26n1t2s2 Rn1n26n1t2s3 0 sky130_fd_pr__res_xhigh_po w=10 l=355.49684
XRn1n26n1p2s4 Rn1n26n1t2s3 Rn1n26n1t2s4 0 sky130_fd_pr__res_xhigh_po w=10 l=355.49684
XRn1n26n1p2s5 Rn1n26n1t2s4 Rn1n26n1t2s5 0 sky130_fd_pr__res_xhigh_po w=10 l=355.49684
XRn1n26n1p2s6 Rn1n26n1t2s5 Rn1n26n1t2s6 0 sky130_fd_pr__res_xhigh_po w=10 l=355.49684
XRn1n26n1p2s7 Rn1n26n1t2s6 n1p 0 sky130_fd_pr__res_xhigh_po w=10 l=355.49684
XRn1n26n1p3s0 in26 Rn1n26n1t3s0 0 sky130_fd_pr__res_xhigh_po w=10 l=355.49684
XRn1n26n1p3s1 Rn1n26n1t3s0 Rn1n26n1t3s1 0 sky130_fd_pr__res_xhigh_po w=10 l=355.49684
XRn1n26n1p3s2 Rn1n26n1t3s1 Rn1n26n1t3s2 0 sky130_fd_pr__res_xhigh_po w=10 l=355.49684
XRn1n26n1p3s3 Rn1n26n1t3s2 Rn1n26n1t3s3 0 sky130_fd_pr__res_xhigh_po w=10 l=355.49684
XRn1n26n1p3s4 Rn1n26n1t3s3 Rn1n26n1t3s4 0 sky130_fd_pr__res_xhigh_po w=10 l=355.49684
XRn1n26n1p3s5 Rn1n26n1t3s4 Rn1n26n1t3s5 0 sky130_fd_pr__res_xhigh_po w=10 l=355.49684
XRn1n26n1p3s6 Rn1n26n1t3s5 Rn1n26n1t3s6 0 sky130_fd_pr__res_xhigh_po w=10 l=355.49684
XRn1n26n1p3s7 Rn1n26n1t3s6 n1p 0 sky130_fd_pr__res_xhigh_po w=10 l=355.49684
XRn1n26n1p4s0 in26 Rn1n26n1t4s0 0 sky130_fd_pr__res_xhigh_po w=10 l=355.49684
XRn1n26n1p4s1 Rn1n26n1t4s0 Rn1n26n1t4s1 0 sky130_fd_pr__res_xhigh_po w=10 l=355.49684
XRn1n26n1p4s2 Rn1n26n1t4s1 Rn1n26n1t4s2 0 sky130_fd_pr__res_xhigh_po w=10 l=355.49684
XRn1n26n1p4s3 Rn1n26n1t4s2 Rn1n26n1t4s3 0 sky130_fd_pr__res_xhigh_po w=10 l=355.49684
XRn1n26n1p4s4 Rn1n26n1t4s3 Rn1n26n1t4s4 0 sky130_fd_pr__res_xhigh_po w=10 l=355.49684
XRn1n26n1p4s5 Rn1n26n1t4s4 Rn1n26n1t4s5 0 sky130_fd_pr__res_xhigh_po w=10 l=355.49684
XRn1n26n1p4s6 Rn1n26n1t4s5 Rn1n26n1t4s6 0 sky130_fd_pr__res_xhigh_po w=10 l=355.49684
XRn1n26n1p4s7 Rn1n26n1t4s6 n1p 0 sky130_fd_pr__res_xhigh_po w=10 l=355.49684
XRn1n26n1p5s0 in26 Rn1n26n1t5s0 0 sky130_fd_pr__res_xhigh_po w=10 l=355.49684
XRn1n26n1p5s1 Rn1n26n1t5s0 Rn1n26n1t5s1 0 sky130_fd_pr__res_xhigh_po w=10 l=355.49684
XRn1n26n1p5s2 Rn1n26n1t5s1 Rn1n26n1t5s2 0 sky130_fd_pr__res_xhigh_po w=10 l=355.49684
XRn1n26n1p5s3 Rn1n26n1t5s2 Rn1n26n1t5s3 0 sky130_fd_pr__res_xhigh_po w=10 l=355.49684
XRn1n26n1p5s4 Rn1n26n1t5s3 Rn1n26n1t5s4 0 sky130_fd_pr__res_xhigh_po w=10 l=355.49684
XRn1n26n1p5s5 Rn1n26n1t5s4 Rn1n26n1t5s5 0 sky130_fd_pr__res_xhigh_po w=10 l=355.49684
XRn1n26n1p5s6 Rn1n26n1t5s5 Rn1n26n1t5s6 0 sky130_fd_pr__res_xhigh_po w=10 l=355.49684
XRn1n26n1p5s7 Rn1n26n1t5s6 n1p 0 sky130_fd_pr__res_xhigh_po w=10 l=355.49684
XRn1n26n1p6s0 in26 Rn1n26n1t6s0 0 sky130_fd_pr__res_xhigh_po w=10 l=355.49684
XRn1n26n1p6s1 Rn1n26n1t6s0 Rn1n26n1t6s1 0 sky130_fd_pr__res_xhigh_po w=10 l=355.49684
XRn1n26n1p6s2 Rn1n26n1t6s1 Rn1n26n1t6s2 0 sky130_fd_pr__res_xhigh_po w=10 l=355.49684
XRn1n26n1p6s3 Rn1n26n1t6s2 Rn1n26n1t6s3 0 sky130_fd_pr__res_xhigh_po w=10 l=355.49684
XRn1n26n1p6s4 Rn1n26n1t6s3 Rn1n26n1t6s4 0 sky130_fd_pr__res_xhigh_po w=10 l=355.49684
XRn1n26n1p6s5 Rn1n26n1t6s4 Rn1n26n1t6s5 0 sky130_fd_pr__res_xhigh_po w=10 l=355.49684
XRn1n26n1p6s6 Rn1n26n1t6s5 Rn1n26n1t6s6 0 sky130_fd_pr__res_xhigh_po w=10 l=355.49684
XRn1n26n1p6s7 Rn1n26n1t6s6 n1p 0 sky130_fd_pr__res_xhigh_po w=10 l=355.49684
XRn1n26n1p7s0 in26 Rn1n26n1t7s0 0 sky130_fd_pr__res_xhigh_po w=10 l=355.49684
XRn1n26n1p7s1 Rn1n26n1t7s0 Rn1n26n1t7s1 0 sky130_fd_pr__res_xhigh_po w=10 l=355.49684
XRn1n26n1p7s2 Rn1n26n1t7s1 Rn1n26n1t7s2 0 sky130_fd_pr__res_xhigh_po w=10 l=355.49684
XRn1n26n1p7s3 Rn1n26n1t7s2 Rn1n26n1t7s3 0 sky130_fd_pr__res_xhigh_po w=10 l=355.49684
XRn1n26n1p7s4 Rn1n26n1t7s3 Rn1n26n1t7s4 0 sky130_fd_pr__res_xhigh_po w=10 l=355.49684
XRn1n26n1p7s5 Rn1n26n1t7s4 Rn1n26n1t7s5 0 sky130_fd_pr__res_xhigh_po w=10 l=355.49684
XRn1n26n1p7s6 Rn1n26n1t7s5 Rn1n26n1t7s6 0 sky130_fd_pr__res_xhigh_po w=10 l=355.49684
XRn1n26n1p7s7 Rn1n26n1t7s6 n1p 0 sky130_fd_pr__res_xhigh_po w=10 l=355.49684
* n1 input 27 w=+0.194887582685885 w+  bank=n alpha=1 R=171038.774630702 G_phys=5.84662748057655e-06 G_eff=5.84662748057655e-06
* PDK sky130_fd_pr__res_xhigh_po Rn1p27n1 W=10 L=850.29916
* tile Rn1p27n1 8s x 8p same W=10 L=850.29916
XRn1p27n1p0s0 in27n Rn1p27n1t0s0 0 sky130_fd_pr__res_xhigh_po w=10 l=850.29916
XRn1p27n1p0s1 Rn1p27n1t0s0 Rn1p27n1t0s1 0 sky130_fd_pr__res_xhigh_po w=10 l=850.29916
XRn1p27n1p0s2 Rn1p27n1t0s1 Rn1p27n1t0s2 0 sky130_fd_pr__res_xhigh_po w=10 l=850.29916
XRn1p27n1p0s3 Rn1p27n1t0s2 Rn1p27n1t0s3 0 sky130_fd_pr__res_xhigh_po w=10 l=850.29916
XRn1p27n1p0s4 Rn1p27n1t0s3 Rn1p27n1t0s4 0 sky130_fd_pr__res_xhigh_po w=10 l=850.29916
XRn1p27n1p0s5 Rn1p27n1t0s4 Rn1p27n1t0s5 0 sky130_fd_pr__res_xhigh_po w=10 l=850.29916
XRn1p27n1p0s6 Rn1p27n1t0s5 Rn1p27n1t0s6 0 sky130_fd_pr__res_xhigh_po w=10 l=850.29916
XRn1p27n1p0s7 Rn1p27n1t0s6 n1p 0 sky130_fd_pr__res_xhigh_po w=10 l=850.29916
XRn1p27n1p1s0 in27n Rn1p27n1t1s0 0 sky130_fd_pr__res_xhigh_po w=10 l=850.29916
XRn1p27n1p1s1 Rn1p27n1t1s0 Rn1p27n1t1s1 0 sky130_fd_pr__res_xhigh_po w=10 l=850.29916
XRn1p27n1p1s2 Rn1p27n1t1s1 Rn1p27n1t1s2 0 sky130_fd_pr__res_xhigh_po w=10 l=850.29916
XRn1p27n1p1s3 Rn1p27n1t1s2 Rn1p27n1t1s3 0 sky130_fd_pr__res_xhigh_po w=10 l=850.29916
XRn1p27n1p1s4 Rn1p27n1t1s3 Rn1p27n1t1s4 0 sky130_fd_pr__res_xhigh_po w=10 l=850.29916
XRn1p27n1p1s5 Rn1p27n1t1s4 Rn1p27n1t1s5 0 sky130_fd_pr__res_xhigh_po w=10 l=850.29916
XRn1p27n1p1s6 Rn1p27n1t1s5 Rn1p27n1t1s6 0 sky130_fd_pr__res_xhigh_po w=10 l=850.29916
XRn1p27n1p1s7 Rn1p27n1t1s6 n1p 0 sky130_fd_pr__res_xhigh_po w=10 l=850.29916
XRn1p27n1p2s0 in27n Rn1p27n1t2s0 0 sky130_fd_pr__res_xhigh_po w=10 l=850.29916
XRn1p27n1p2s1 Rn1p27n1t2s0 Rn1p27n1t2s1 0 sky130_fd_pr__res_xhigh_po w=10 l=850.29916
XRn1p27n1p2s2 Rn1p27n1t2s1 Rn1p27n1t2s2 0 sky130_fd_pr__res_xhigh_po w=10 l=850.29916
XRn1p27n1p2s3 Rn1p27n1t2s2 Rn1p27n1t2s3 0 sky130_fd_pr__res_xhigh_po w=10 l=850.29916
XRn1p27n1p2s4 Rn1p27n1t2s3 Rn1p27n1t2s4 0 sky130_fd_pr__res_xhigh_po w=10 l=850.29916
XRn1p27n1p2s5 Rn1p27n1t2s4 Rn1p27n1t2s5 0 sky130_fd_pr__res_xhigh_po w=10 l=850.29916
XRn1p27n1p2s6 Rn1p27n1t2s5 Rn1p27n1t2s6 0 sky130_fd_pr__res_xhigh_po w=10 l=850.29916
XRn1p27n1p2s7 Rn1p27n1t2s6 n1p 0 sky130_fd_pr__res_xhigh_po w=10 l=850.29916
XRn1p27n1p3s0 in27n Rn1p27n1t3s0 0 sky130_fd_pr__res_xhigh_po w=10 l=850.29916
XRn1p27n1p3s1 Rn1p27n1t3s0 Rn1p27n1t3s1 0 sky130_fd_pr__res_xhigh_po w=10 l=850.29916
XRn1p27n1p3s2 Rn1p27n1t3s1 Rn1p27n1t3s2 0 sky130_fd_pr__res_xhigh_po w=10 l=850.29916
XRn1p27n1p3s3 Rn1p27n1t3s2 Rn1p27n1t3s3 0 sky130_fd_pr__res_xhigh_po w=10 l=850.29916
XRn1p27n1p3s4 Rn1p27n1t3s3 Rn1p27n1t3s4 0 sky130_fd_pr__res_xhigh_po w=10 l=850.29916
XRn1p27n1p3s5 Rn1p27n1t3s4 Rn1p27n1t3s5 0 sky130_fd_pr__res_xhigh_po w=10 l=850.29916
XRn1p27n1p3s6 Rn1p27n1t3s5 Rn1p27n1t3s6 0 sky130_fd_pr__res_xhigh_po w=10 l=850.29916
XRn1p27n1p3s7 Rn1p27n1t3s6 n1p 0 sky130_fd_pr__res_xhigh_po w=10 l=850.29916
XRn1p27n1p4s0 in27n Rn1p27n1t4s0 0 sky130_fd_pr__res_xhigh_po w=10 l=850.29916
XRn1p27n1p4s1 Rn1p27n1t4s0 Rn1p27n1t4s1 0 sky130_fd_pr__res_xhigh_po w=10 l=850.29916
XRn1p27n1p4s2 Rn1p27n1t4s1 Rn1p27n1t4s2 0 sky130_fd_pr__res_xhigh_po w=10 l=850.29916
XRn1p27n1p4s3 Rn1p27n1t4s2 Rn1p27n1t4s3 0 sky130_fd_pr__res_xhigh_po w=10 l=850.29916
XRn1p27n1p4s4 Rn1p27n1t4s3 Rn1p27n1t4s4 0 sky130_fd_pr__res_xhigh_po w=10 l=850.29916
XRn1p27n1p4s5 Rn1p27n1t4s4 Rn1p27n1t4s5 0 sky130_fd_pr__res_xhigh_po w=10 l=850.29916
XRn1p27n1p4s6 Rn1p27n1t4s5 Rn1p27n1t4s6 0 sky130_fd_pr__res_xhigh_po w=10 l=850.29916
XRn1p27n1p4s7 Rn1p27n1t4s6 n1p 0 sky130_fd_pr__res_xhigh_po w=10 l=850.29916
XRn1p27n1p5s0 in27n Rn1p27n1t5s0 0 sky130_fd_pr__res_xhigh_po w=10 l=850.29916
XRn1p27n1p5s1 Rn1p27n1t5s0 Rn1p27n1t5s1 0 sky130_fd_pr__res_xhigh_po w=10 l=850.29916
XRn1p27n1p5s2 Rn1p27n1t5s1 Rn1p27n1t5s2 0 sky130_fd_pr__res_xhigh_po w=10 l=850.29916
XRn1p27n1p5s3 Rn1p27n1t5s2 Rn1p27n1t5s3 0 sky130_fd_pr__res_xhigh_po w=10 l=850.29916
XRn1p27n1p5s4 Rn1p27n1t5s3 Rn1p27n1t5s4 0 sky130_fd_pr__res_xhigh_po w=10 l=850.29916
XRn1p27n1p5s5 Rn1p27n1t5s4 Rn1p27n1t5s5 0 sky130_fd_pr__res_xhigh_po w=10 l=850.29916
XRn1p27n1p5s6 Rn1p27n1t5s5 Rn1p27n1t5s6 0 sky130_fd_pr__res_xhigh_po w=10 l=850.29916
XRn1p27n1p5s7 Rn1p27n1t5s6 n1p 0 sky130_fd_pr__res_xhigh_po w=10 l=850.29916
XRn1p27n1p6s0 in27n Rn1p27n1t6s0 0 sky130_fd_pr__res_xhigh_po w=10 l=850.29916
XRn1p27n1p6s1 Rn1p27n1t6s0 Rn1p27n1t6s1 0 sky130_fd_pr__res_xhigh_po w=10 l=850.29916
XRn1p27n1p6s2 Rn1p27n1t6s1 Rn1p27n1t6s2 0 sky130_fd_pr__res_xhigh_po w=10 l=850.29916
XRn1p27n1p6s3 Rn1p27n1t6s2 Rn1p27n1t6s3 0 sky130_fd_pr__res_xhigh_po w=10 l=850.29916
XRn1p27n1p6s4 Rn1p27n1t6s3 Rn1p27n1t6s4 0 sky130_fd_pr__res_xhigh_po w=10 l=850.29916
XRn1p27n1p6s5 Rn1p27n1t6s4 Rn1p27n1t6s5 0 sky130_fd_pr__res_xhigh_po w=10 l=850.29916
XRn1p27n1p6s6 Rn1p27n1t6s5 Rn1p27n1t6s6 0 sky130_fd_pr__res_xhigh_po w=10 l=850.29916
XRn1p27n1p6s7 Rn1p27n1t6s6 n1p 0 sky130_fd_pr__res_xhigh_po w=10 l=850.29916
XRn1p27n1p7s0 in27n Rn1p27n1t7s0 0 sky130_fd_pr__res_xhigh_po w=10 l=850.29916
XRn1p27n1p7s1 Rn1p27n1t7s0 Rn1p27n1t7s1 0 sky130_fd_pr__res_xhigh_po w=10 l=850.29916
XRn1p27n1p7s2 Rn1p27n1t7s1 Rn1p27n1t7s2 0 sky130_fd_pr__res_xhigh_po w=10 l=850.29916
XRn1p27n1p7s3 Rn1p27n1t7s2 Rn1p27n1t7s3 0 sky130_fd_pr__res_xhigh_po w=10 l=850.29916
XRn1p27n1p7s4 Rn1p27n1t7s3 Rn1p27n1t7s4 0 sky130_fd_pr__res_xhigh_po w=10 l=850.29916
XRn1p27n1p7s5 Rn1p27n1t7s4 Rn1p27n1t7s5 0 sky130_fd_pr__res_xhigh_po w=10 l=850.29916
XRn1p27n1p7s6 Rn1p27n1t7s5 Rn1p27n1t7s6 0 sky130_fd_pr__res_xhigh_po w=10 l=850.29916
XRn1p27n1p7s7 Rn1p27n1t7s6 n1p 0 sky130_fd_pr__res_xhigh_po w=10 l=850.29916
* n1 input 28 w=+0.209047565197081 w+  bank=n alpha=1 R=159453.344036359 G_phys=6.27142695591242e-06 G_eff=6.27142695591242e-06
* PDK sky130_fd_pr__res_xhigh_po Rn1p28n1 W=10 L=792.6964
* tile Rn1p28n1 8s x 8p same W=10 L=792.6964
XRn1p28n1p0s0 in28n Rn1p28n1t0s0 0 sky130_fd_pr__res_xhigh_po w=10 l=792.6964
XRn1p28n1p0s1 Rn1p28n1t0s0 Rn1p28n1t0s1 0 sky130_fd_pr__res_xhigh_po w=10 l=792.6964
XRn1p28n1p0s2 Rn1p28n1t0s1 Rn1p28n1t0s2 0 sky130_fd_pr__res_xhigh_po w=10 l=792.6964
XRn1p28n1p0s3 Rn1p28n1t0s2 Rn1p28n1t0s3 0 sky130_fd_pr__res_xhigh_po w=10 l=792.6964
XRn1p28n1p0s4 Rn1p28n1t0s3 Rn1p28n1t0s4 0 sky130_fd_pr__res_xhigh_po w=10 l=792.6964
XRn1p28n1p0s5 Rn1p28n1t0s4 Rn1p28n1t0s5 0 sky130_fd_pr__res_xhigh_po w=10 l=792.6964
XRn1p28n1p0s6 Rn1p28n1t0s5 Rn1p28n1t0s6 0 sky130_fd_pr__res_xhigh_po w=10 l=792.6964
XRn1p28n1p0s7 Rn1p28n1t0s6 n1p 0 sky130_fd_pr__res_xhigh_po w=10 l=792.6964
XRn1p28n1p1s0 in28n Rn1p28n1t1s0 0 sky130_fd_pr__res_xhigh_po w=10 l=792.6964
XRn1p28n1p1s1 Rn1p28n1t1s0 Rn1p28n1t1s1 0 sky130_fd_pr__res_xhigh_po w=10 l=792.6964
XRn1p28n1p1s2 Rn1p28n1t1s1 Rn1p28n1t1s2 0 sky130_fd_pr__res_xhigh_po w=10 l=792.6964
XRn1p28n1p1s3 Rn1p28n1t1s2 Rn1p28n1t1s3 0 sky130_fd_pr__res_xhigh_po w=10 l=792.6964
XRn1p28n1p1s4 Rn1p28n1t1s3 Rn1p28n1t1s4 0 sky130_fd_pr__res_xhigh_po w=10 l=792.6964
XRn1p28n1p1s5 Rn1p28n1t1s4 Rn1p28n1t1s5 0 sky130_fd_pr__res_xhigh_po w=10 l=792.6964
XRn1p28n1p1s6 Rn1p28n1t1s5 Rn1p28n1t1s6 0 sky130_fd_pr__res_xhigh_po w=10 l=792.6964
XRn1p28n1p1s7 Rn1p28n1t1s6 n1p 0 sky130_fd_pr__res_xhigh_po w=10 l=792.6964
XRn1p28n1p2s0 in28n Rn1p28n1t2s0 0 sky130_fd_pr__res_xhigh_po w=10 l=792.6964
XRn1p28n1p2s1 Rn1p28n1t2s0 Rn1p28n1t2s1 0 sky130_fd_pr__res_xhigh_po w=10 l=792.6964
XRn1p28n1p2s2 Rn1p28n1t2s1 Rn1p28n1t2s2 0 sky130_fd_pr__res_xhigh_po w=10 l=792.6964
XRn1p28n1p2s3 Rn1p28n1t2s2 Rn1p28n1t2s3 0 sky130_fd_pr__res_xhigh_po w=10 l=792.6964
XRn1p28n1p2s4 Rn1p28n1t2s3 Rn1p28n1t2s4 0 sky130_fd_pr__res_xhigh_po w=10 l=792.6964
XRn1p28n1p2s5 Rn1p28n1t2s4 Rn1p28n1t2s5 0 sky130_fd_pr__res_xhigh_po w=10 l=792.6964
XRn1p28n1p2s6 Rn1p28n1t2s5 Rn1p28n1t2s6 0 sky130_fd_pr__res_xhigh_po w=10 l=792.6964
XRn1p28n1p2s7 Rn1p28n1t2s6 n1p 0 sky130_fd_pr__res_xhigh_po w=10 l=792.6964
XRn1p28n1p3s0 in28n Rn1p28n1t3s0 0 sky130_fd_pr__res_xhigh_po w=10 l=792.6964
XRn1p28n1p3s1 Rn1p28n1t3s0 Rn1p28n1t3s1 0 sky130_fd_pr__res_xhigh_po w=10 l=792.6964
XRn1p28n1p3s2 Rn1p28n1t3s1 Rn1p28n1t3s2 0 sky130_fd_pr__res_xhigh_po w=10 l=792.6964
XRn1p28n1p3s3 Rn1p28n1t3s2 Rn1p28n1t3s3 0 sky130_fd_pr__res_xhigh_po w=10 l=792.6964
XRn1p28n1p3s4 Rn1p28n1t3s3 Rn1p28n1t3s4 0 sky130_fd_pr__res_xhigh_po w=10 l=792.6964
XRn1p28n1p3s5 Rn1p28n1t3s4 Rn1p28n1t3s5 0 sky130_fd_pr__res_xhigh_po w=10 l=792.6964
XRn1p28n1p3s6 Rn1p28n1t3s5 Rn1p28n1t3s6 0 sky130_fd_pr__res_xhigh_po w=10 l=792.6964
XRn1p28n1p3s7 Rn1p28n1t3s6 n1p 0 sky130_fd_pr__res_xhigh_po w=10 l=792.6964
XRn1p28n1p4s0 in28n Rn1p28n1t4s0 0 sky130_fd_pr__res_xhigh_po w=10 l=792.6964
XRn1p28n1p4s1 Rn1p28n1t4s0 Rn1p28n1t4s1 0 sky130_fd_pr__res_xhigh_po w=10 l=792.6964
XRn1p28n1p4s2 Rn1p28n1t4s1 Rn1p28n1t4s2 0 sky130_fd_pr__res_xhigh_po w=10 l=792.6964
XRn1p28n1p4s3 Rn1p28n1t4s2 Rn1p28n1t4s3 0 sky130_fd_pr__res_xhigh_po w=10 l=792.6964
XRn1p28n1p4s4 Rn1p28n1t4s3 Rn1p28n1t4s4 0 sky130_fd_pr__res_xhigh_po w=10 l=792.6964
XRn1p28n1p4s5 Rn1p28n1t4s4 Rn1p28n1t4s5 0 sky130_fd_pr__res_xhigh_po w=10 l=792.6964
XRn1p28n1p4s6 Rn1p28n1t4s5 Rn1p28n1t4s6 0 sky130_fd_pr__res_xhigh_po w=10 l=792.6964
XRn1p28n1p4s7 Rn1p28n1t4s6 n1p 0 sky130_fd_pr__res_xhigh_po w=10 l=792.6964
XRn1p28n1p5s0 in28n Rn1p28n1t5s0 0 sky130_fd_pr__res_xhigh_po w=10 l=792.6964
XRn1p28n1p5s1 Rn1p28n1t5s0 Rn1p28n1t5s1 0 sky130_fd_pr__res_xhigh_po w=10 l=792.6964
XRn1p28n1p5s2 Rn1p28n1t5s1 Rn1p28n1t5s2 0 sky130_fd_pr__res_xhigh_po w=10 l=792.6964
XRn1p28n1p5s3 Rn1p28n1t5s2 Rn1p28n1t5s3 0 sky130_fd_pr__res_xhigh_po w=10 l=792.6964
XRn1p28n1p5s4 Rn1p28n1t5s3 Rn1p28n1t5s4 0 sky130_fd_pr__res_xhigh_po w=10 l=792.6964
XRn1p28n1p5s5 Rn1p28n1t5s4 Rn1p28n1t5s5 0 sky130_fd_pr__res_xhigh_po w=10 l=792.6964
XRn1p28n1p5s6 Rn1p28n1t5s5 Rn1p28n1t5s6 0 sky130_fd_pr__res_xhigh_po w=10 l=792.6964
XRn1p28n1p5s7 Rn1p28n1t5s6 n1p 0 sky130_fd_pr__res_xhigh_po w=10 l=792.6964
XRn1p28n1p6s0 in28n Rn1p28n1t6s0 0 sky130_fd_pr__res_xhigh_po w=10 l=792.6964
XRn1p28n1p6s1 Rn1p28n1t6s0 Rn1p28n1t6s1 0 sky130_fd_pr__res_xhigh_po w=10 l=792.6964
XRn1p28n1p6s2 Rn1p28n1t6s1 Rn1p28n1t6s2 0 sky130_fd_pr__res_xhigh_po w=10 l=792.6964
XRn1p28n1p6s3 Rn1p28n1t6s2 Rn1p28n1t6s3 0 sky130_fd_pr__res_xhigh_po w=10 l=792.6964
XRn1p28n1p6s4 Rn1p28n1t6s3 Rn1p28n1t6s4 0 sky130_fd_pr__res_xhigh_po w=10 l=792.6964
XRn1p28n1p6s5 Rn1p28n1t6s4 Rn1p28n1t6s5 0 sky130_fd_pr__res_xhigh_po w=10 l=792.6964
XRn1p28n1p6s6 Rn1p28n1t6s5 Rn1p28n1t6s6 0 sky130_fd_pr__res_xhigh_po w=10 l=792.6964
XRn1p28n1p6s7 Rn1p28n1t6s6 n1p 0 sky130_fd_pr__res_xhigh_po w=10 l=792.6964
XRn1p28n1p7s0 in28n Rn1p28n1t7s0 0 sky130_fd_pr__res_xhigh_po w=10 l=792.6964
XRn1p28n1p7s1 Rn1p28n1t7s0 Rn1p28n1t7s1 0 sky130_fd_pr__res_xhigh_po w=10 l=792.6964
XRn1p28n1p7s2 Rn1p28n1t7s1 Rn1p28n1t7s2 0 sky130_fd_pr__res_xhigh_po w=10 l=792.6964
XRn1p28n1p7s3 Rn1p28n1t7s2 Rn1p28n1t7s3 0 sky130_fd_pr__res_xhigh_po w=10 l=792.6964
XRn1p28n1p7s4 Rn1p28n1t7s3 Rn1p28n1t7s4 0 sky130_fd_pr__res_xhigh_po w=10 l=792.6964
XRn1p28n1p7s5 Rn1p28n1t7s4 Rn1p28n1t7s5 0 sky130_fd_pr__res_xhigh_po w=10 l=792.6964
XRn1p28n1p7s6 Rn1p28n1t7s5 Rn1p28n1t7s6 0 sky130_fd_pr__res_xhigh_po w=10 l=792.6964
XRn1p28n1p7s7 Rn1p28n1t7s6 n1p 0 sky130_fd_pr__res_xhigh_po w=10 l=792.6964
* n1 input 29 w=+0.00919963467526149 w+  bank=f alpha=0.001 R=3623.33228546229 G_phys=0.000275989040257845 G_eff=2.75989040257845e-07
* PDK sky130_fd_pr__res_xhigh_po Rn1p29f1 W=10 L=17.90958
* tile Rn1p29f1 8s x 8p same W=10 L=17.90958
XRn1p29f1p0s0 tap29n Rn1p29f1t0s0 0 sky130_fd_pr__res_xhigh_po w=10 l=17.90958
XRn1p29f1p0s1 Rn1p29f1t0s0 Rn1p29f1t0s1 0 sky130_fd_pr__res_xhigh_po w=10 l=17.90958
XRn1p29f1p0s2 Rn1p29f1t0s1 Rn1p29f1t0s2 0 sky130_fd_pr__res_xhigh_po w=10 l=17.90958
XRn1p29f1p0s3 Rn1p29f1t0s2 Rn1p29f1t0s3 0 sky130_fd_pr__res_xhigh_po w=10 l=17.90958
XRn1p29f1p0s4 Rn1p29f1t0s3 Rn1p29f1t0s4 0 sky130_fd_pr__res_xhigh_po w=10 l=17.90958
XRn1p29f1p0s5 Rn1p29f1t0s4 Rn1p29f1t0s5 0 sky130_fd_pr__res_xhigh_po w=10 l=17.90958
XRn1p29f1p0s6 Rn1p29f1t0s5 Rn1p29f1t0s6 0 sky130_fd_pr__res_xhigh_po w=10 l=17.90958
XRn1p29f1p0s7 Rn1p29f1t0s6 n1p 0 sky130_fd_pr__res_xhigh_po w=10 l=17.90958
XRn1p29f1p1s0 tap29n Rn1p29f1t1s0 0 sky130_fd_pr__res_xhigh_po w=10 l=17.90958
XRn1p29f1p1s1 Rn1p29f1t1s0 Rn1p29f1t1s1 0 sky130_fd_pr__res_xhigh_po w=10 l=17.90958
XRn1p29f1p1s2 Rn1p29f1t1s1 Rn1p29f1t1s2 0 sky130_fd_pr__res_xhigh_po w=10 l=17.90958
XRn1p29f1p1s3 Rn1p29f1t1s2 Rn1p29f1t1s3 0 sky130_fd_pr__res_xhigh_po w=10 l=17.90958
XRn1p29f1p1s4 Rn1p29f1t1s3 Rn1p29f1t1s4 0 sky130_fd_pr__res_xhigh_po w=10 l=17.90958
XRn1p29f1p1s5 Rn1p29f1t1s4 Rn1p29f1t1s5 0 sky130_fd_pr__res_xhigh_po w=10 l=17.90958
XRn1p29f1p1s6 Rn1p29f1t1s5 Rn1p29f1t1s6 0 sky130_fd_pr__res_xhigh_po w=10 l=17.90958
XRn1p29f1p1s7 Rn1p29f1t1s6 n1p 0 sky130_fd_pr__res_xhigh_po w=10 l=17.90958
XRn1p29f1p2s0 tap29n Rn1p29f1t2s0 0 sky130_fd_pr__res_xhigh_po w=10 l=17.90958
XRn1p29f1p2s1 Rn1p29f1t2s0 Rn1p29f1t2s1 0 sky130_fd_pr__res_xhigh_po w=10 l=17.90958
XRn1p29f1p2s2 Rn1p29f1t2s1 Rn1p29f1t2s2 0 sky130_fd_pr__res_xhigh_po w=10 l=17.90958
XRn1p29f1p2s3 Rn1p29f1t2s2 Rn1p29f1t2s3 0 sky130_fd_pr__res_xhigh_po w=10 l=17.90958
XRn1p29f1p2s4 Rn1p29f1t2s3 Rn1p29f1t2s4 0 sky130_fd_pr__res_xhigh_po w=10 l=17.90958
XRn1p29f1p2s5 Rn1p29f1t2s4 Rn1p29f1t2s5 0 sky130_fd_pr__res_xhigh_po w=10 l=17.90958
XRn1p29f1p2s6 Rn1p29f1t2s5 Rn1p29f1t2s6 0 sky130_fd_pr__res_xhigh_po w=10 l=17.90958
XRn1p29f1p2s7 Rn1p29f1t2s6 n1p 0 sky130_fd_pr__res_xhigh_po w=10 l=17.90958
XRn1p29f1p3s0 tap29n Rn1p29f1t3s0 0 sky130_fd_pr__res_xhigh_po w=10 l=17.90958
XRn1p29f1p3s1 Rn1p29f1t3s0 Rn1p29f1t3s1 0 sky130_fd_pr__res_xhigh_po w=10 l=17.90958
XRn1p29f1p3s2 Rn1p29f1t3s1 Rn1p29f1t3s2 0 sky130_fd_pr__res_xhigh_po w=10 l=17.90958
XRn1p29f1p3s3 Rn1p29f1t3s2 Rn1p29f1t3s3 0 sky130_fd_pr__res_xhigh_po w=10 l=17.90958
XRn1p29f1p3s4 Rn1p29f1t3s3 Rn1p29f1t3s4 0 sky130_fd_pr__res_xhigh_po w=10 l=17.90958
XRn1p29f1p3s5 Rn1p29f1t3s4 Rn1p29f1t3s5 0 sky130_fd_pr__res_xhigh_po w=10 l=17.90958
XRn1p29f1p3s6 Rn1p29f1t3s5 Rn1p29f1t3s6 0 sky130_fd_pr__res_xhigh_po w=10 l=17.90958
XRn1p29f1p3s7 Rn1p29f1t3s6 n1p 0 sky130_fd_pr__res_xhigh_po w=10 l=17.90958
XRn1p29f1p4s0 tap29n Rn1p29f1t4s0 0 sky130_fd_pr__res_xhigh_po w=10 l=17.90958
XRn1p29f1p4s1 Rn1p29f1t4s0 Rn1p29f1t4s1 0 sky130_fd_pr__res_xhigh_po w=10 l=17.90958
XRn1p29f1p4s2 Rn1p29f1t4s1 Rn1p29f1t4s2 0 sky130_fd_pr__res_xhigh_po w=10 l=17.90958
XRn1p29f1p4s3 Rn1p29f1t4s2 Rn1p29f1t4s3 0 sky130_fd_pr__res_xhigh_po w=10 l=17.90958
XRn1p29f1p4s4 Rn1p29f1t4s3 Rn1p29f1t4s4 0 sky130_fd_pr__res_xhigh_po w=10 l=17.90958
XRn1p29f1p4s5 Rn1p29f1t4s4 Rn1p29f1t4s5 0 sky130_fd_pr__res_xhigh_po w=10 l=17.90958
XRn1p29f1p4s6 Rn1p29f1t4s5 Rn1p29f1t4s6 0 sky130_fd_pr__res_xhigh_po w=10 l=17.90958
XRn1p29f1p4s7 Rn1p29f1t4s6 n1p 0 sky130_fd_pr__res_xhigh_po w=10 l=17.90958
XRn1p29f1p5s0 tap29n Rn1p29f1t5s0 0 sky130_fd_pr__res_xhigh_po w=10 l=17.90958
XRn1p29f1p5s1 Rn1p29f1t5s0 Rn1p29f1t5s1 0 sky130_fd_pr__res_xhigh_po w=10 l=17.90958
XRn1p29f1p5s2 Rn1p29f1t5s1 Rn1p29f1t5s2 0 sky130_fd_pr__res_xhigh_po w=10 l=17.90958
XRn1p29f1p5s3 Rn1p29f1t5s2 Rn1p29f1t5s3 0 sky130_fd_pr__res_xhigh_po w=10 l=17.90958
XRn1p29f1p5s4 Rn1p29f1t5s3 Rn1p29f1t5s4 0 sky130_fd_pr__res_xhigh_po w=10 l=17.90958
XRn1p29f1p5s5 Rn1p29f1t5s4 Rn1p29f1t5s5 0 sky130_fd_pr__res_xhigh_po w=10 l=17.90958
XRn1p29f1p5s6 Rn1p29f1t5s5 Rn1p29f1t5s6 0 sky130_fd_pr__res_xhigh_po w=10 l=17.90958
XRn1p29f1p5s7 Rn1p29f1t5s6 n1p 0 sky130_fd_pr__res_xhigh_po w=10 l=17.90958
XRn1p29f1p6s0 tap29n Rn1p29f1t6s0 0 sky130_fd_pr__res_xhigh_po w=10 l=17.90958
XRn1p29f1p6s1 Rn1p29f1t6s0 Rn1p29f1t6s1 0 sky130_fd_pr__res_xhigh_po w=10 l=17.90958
XRn1p29f1p6s2 Rn1p29f1t6s1 Rn1p29f1t6s2 0 sky130_fd_pr__res_xhigh_po w=10 l=17.90958
XRn1p29f1p6s3 Rn1p29f1t6s2 Rn1p29f1t6s3 0 sky130_fd_pr__res_xhigh_po w=10 l=17.90958
XRn1p29f1p6s4 Rn1p29f1t6s3 Rn1p29f1t6s4 0 sky130_fd_pr__res_xhigh_po w=10 l=17.90958
XRn1p29f1p6s5 Rn1p29f1t6s4 Rn1p29f1t6s5 0 sky130_fd_pr__res_xhigh_po w=10 l=17.90958
XRn1p29f1p6s6 Rn1p29f1t6s5 Rn1p29f1t6s6 0 sky130_fd_pr__res_xhigh_po w=10 l=17.90958
XRn1p29f1p6s7 Rn1p29f1t6s6 n1p 0 sky130_fd_pr__res_xhigh_po w=10 l=17.90958
XRn1p29f1p7s0 tap29n Rn1p29f1t7s0 0 sky130_fd_pr__res_xhigh_po w=10 l=17.90958
XRn1p29f1p7s1 Rn1p29f1t7s0 Rn1p29f1t7s1 0 sky130_fd_pr__res_xhigh_po w=10 l=17.90958
XRn1p29f1p7s2 Rn1p29f1t7s1 Rn1p29f1t7s2 0 sky130_fd_pr__res_xhigh_po w=10 l=17.90958
XRn1p29f1p7s3 Rn1p29f1t7s2 Rn1p29f1t7s3 0 sky130_fd_pr__res_xhigh_po w=10 l=17.90958
XRn1p29f1p7s4 Rn1p29f1t7s3 Rn1p29f1t7s4 0 sky130_fd_pr__res_xhigh_po w=10 l=17.90958
XRn1p29f1p7s5 Rn1p29f1t7s4 Rn1p29f1t7s5 0 sky130_fd_pr__res_xhigh_po w=10 l=17.90958
XRn1p29f1p7s6 Rn1p29f1t7s5 Rn1p29f1t7s6 0 sky130_fd_pr__res_xhigh_po w=10 l=17.90958
XRn1p29f1p7s7 Rn1p29f1t7s6 n1p 0 sky130_fd_pr__res_xhigh_po w=10 l=17.90958
* n1 input 30 w=-0.379437042796868 w-  bank=n alpha=1 R=87849.4442388387 G_phys=1.13831112839061e-05 G_eff=1.13831112839061e-05
* PDK sky130_fd_pr__res_xhigh_po Rn1n30n1 W=10 L=436.68181
* tile Rn1n30n1 8s x 8p same W=10 L=436.68181
XRn1n30n1p0s0 in30 Rn1n30n1t0s0 0 sky130_fd_pr__res_xhigh_po w=10 l=436.68181
XRn1n30n1p0s1 Rn1n30n1t0s0 Rn1n30n1t0s1 0 sky130_fd_pr__res_xhigh_po w=10 l=436.68181
XRn1n30n1p0s2 Rn1n30n1t0s1 Rn1n30n1t0s2 0 sky130_fd_pr__res_xhigh_po w=10 l=436.68181
XRn1n30n1p0s3 Rn1n30n1t0s2 Rn1n30n1t0s3 0 sky130_fd_pr__res_xhigh_po w=10 l=436.68181
XRn1n30n1p0s4 Rn1n30n1t0s3 Rn1n30n1t0s4 0 sky130_fd_pr__res_xhigh_po w=10 l=436.68181
XRn1n30n1p0s5 Rn1n30n1t0s4 Rn1n30n1t0s5 0 sky130_fd_pr__res_xhigh_po w=10 l=436.68181
XRn1n30n1p0s6 Rn1n30n1t0s5 Rn1n30n1t0s6 0 sky130_fd_pr__res_xhigh_po w=10 l=436.68181
XRn1n30n1p0s7 Rn1n30n1t0s6 n1p 0 sky130_fd_pr__res_xhigh_po w=10 l=436.68181
XRn1n30n1p1s0 in30 Rn1n30n1t1s0 0 sky130_fd_pr__res_xhigh_po w=10 l=436.68181
XRn1n30n1p1s1 Rn1n30n1t1s0 Rn1n30n1t1s1 0 sky130_fd_pr__res_xhigh_po w=10 l=436.68181
XRn1n30n1p1s2 Rn1n30n1t1s1 Rn1n30n1t1s2 0 sky130_fd_pr__res_xhigh_po w=10 l=436.68181
XRn1n30n1p1s3 Rn1n30n1t1s2 Rn1n30n1t1s3 0 sky130_fd_pr__res_xhigh_po w=10 l=436.68181
XRn1n30n1p1s4 Rn1n30n1t1s3 Rn1n30n1t1s4 0 sky130_fd_pr__res_xhigh_po w=10 l=436.68181
XRn1n30n1p1s5 Rn1n30n1t1s4 Rn1n30n1t1s5 0 sky130_fd_pr__res_xhigh_po w=10 l=436.68181
XRn1n30n1p1s6 Rn1n30n1t1s5 Rn1n30n1t1s6 0 sky130_fd_pr__res_xhigh_po w=10 l=436.68181
XRn1n30n1p1s7 Rn1n30n1t1s6 n1p 0 sky130_fd_pr__res_xhigh_po w=10 l=436.68181
XRn1n30n1p2s0 in30 Rn1n30n1t2s0 0 sky130_fd_pr__res_xhigh_po w=10 l=436.68181
XRn1n30n1p2s1 Rn1n30n1t2s0 Rn1n30n1t2s1 0 sky130_fd_pr__res_xhigh_po w=10 l=436.68181
XRn1n30n1p2s2 Rn1n30n1t2s1 Rn1n30n1t2s2 0 sky130_fd_pr__res_xhigh_po w=10 l=436.68181
XRn1n30n1p2s3 Rn1n30n1t2s2 Rn1n30n1t2s3 0 sky130_fd_pr__res_xhigh_po w=10 l=436.68181
XRn1n30n1p2s4 Rn1n30n1t2s3 Rn1n30n1t2s4 0 sky130_fd_pr__res_xhigh_po w=10 l=436.68181
XRn1n30n1p2s5 Rn1n30n1t2s4 Rn1n30n1t2s5 0 sky130_fd_pr__res_xhigh_po w=10 l=436.68181
XRn1n30n1p2s6 Rn1n30n1t2s5 Rn1n30n1t2s6 0 sky130_fd_pr__res_xhigh_po w=10 l=436.68181
XRn1n30n1p2s7 Rn1n30n1t2s6 n1p 0 sky130_fd_pr__res_xhigh_po w=10 l=436.68181
XRn1n30n1p3s0 in30 Rn1n30n1t3s0 0 sky130_fd_pr__res_xhigh_po w=10 l=436.68181
XRn1n30n1p3s1 Rn1n30n1t3s0 Rn1n30n1t3s1 0 sky130_fd_pr__res_xhigh_po w=10 l=436.68181
XRn1n30n1p3s2 Rn1n30n1t3s1 Rn1n30n1t3s2 0 sky130_fd_pr__res_xhigh_po w=10 l=436.68181
XRn1n30n1p3s3 Rn1n30n1t3s2 Rn1n30n1t3s3 0 sky130_fd_pr__res_xhigh_po w=10 l=436.68181
XRn1n30n1p3s4 Rn1n30n1t3s3 Rn1n30n1t3s4 0 sky130_fd_pr__res_xhigh_po w=10 l=436.68181
XRn1n30n1p3s5 Rn1n30n1t3s4 Rn1n30n1t3s5 0 sky130_fd_pr__res_xhigh_po w=10 l=436.68181
XRn1n30n1p3s6 Rn1n30n1t3s5 Rn1n30n1t3s6 0 sky130_fd_pr__res_xhigh_po w=10 l=436.68181
XRn1n30n1p3s7 Rn1n30n1t3s6 n1p 0 sky130_fd_pr__res_xhigh_po w=10 l=436.68181
XRn1n30n1p4s0 in30 Rn1n30n1t4s0 0 sky130_fd_pr__res_xhigh_po w=10 l=436.68181
XRn1n30n1p4s1 Rn1n30n1t4s0 Rn1n30n1t4s1 0 sky130_fd_pr__res_xhigh_po w=10 l=436.68181
XRn1n30n1p4s2 Rn1n30n1t4s1 Rn1n30n1t4s2 0 sky130_fd_pr__res_xhigh_po w=10 l=436.68181
XRn1n30n1p4s3 Rn1n30n1t4s2 Rn1n30n1t4s3 0 sky130_fd_pr__res_xhigh_po w=10 l=436.68181
XRn1n30n1p4s4 Rn1n30n1t4s3 Rn1n30n1t4s4 0 sky130_fd_pr__res_xhigh_po w=10 l=436.68181
XRn1n30n1p4s5 Rn1n30n1t4s4 Rn1n30n1t4s5 0 sky130_fd_pr__res_xhigh_po w=10 l=436.68181
XRn1n30n1p4s6 Rn1n30n1t4s5 Rn1n30n1t4s6 0 sky130_fd_pr__res_xhigh_po w=10 l=436.68181
XRn1n30n1p4s7 Rn1n30n1t4s6 n1p 0 sky130_fd_pr__res_xhigh_po w=10 l=436.68181
XRn1n30n1p5s0 in30 Rn1n30n1t5s0 0 sky130_fd_pr__res_xhigh_po w=10 l=436.68181
XRn1n30n1p5s1 Rn1n30n1t5s0 Rn1n30n1t5s1 0 sky130_fd_pr__res_xhigh_po w=10 l=436.68181
XRn1n30n1p5s2 Rn1n30n1t5s1 Rn1n30n1t5s2 0 sky130_fd_pr__res_xhigh_po w=10 l=436.68181
XRn1n30n1p5s3 Rn1n30n1t5s2 Rn1n30n1t5s3 0 sky130_fd_pr__res_xhigh_po w=10 l=436.68181
XRn1n30n1p5s4 Rn1n30n1t5s3 Rn1n30n1t5s4 0 sky130_fd_pr__res_xhigh_po w=10 l=436.68181
XRn1n30n1p5s5 Rn1n30n1t5s4 Rn1n30n1t5s5 0 sky130_fd_pr__res_xhigh_po w=10 l=436.68181
XRn1n30n1p5s6 Rn1n30n1t5s5 Rn1n30n1t5s6 0 sky130_fd_pr__res_xhigh_po w=10 l=436.68181
XRn1n30n1p5s7 Rn1n30n1t5s6 n1p 0 sky130_fd_pr__res_xhigh_po w=10 l=436.68181
XRn1n30n1p6s0 in30 Rn1n30n1t6s0 0 sky130_fd_pr__res_xhigh_po w=10 l=436.68181
XRn1n30n1p6s1 Rn1n30n1t6s0 Rn1n30n1t6s1 0 sky130_fd_pr__res_xhigh_po w=10 l=436.68181
XRn1n30n1p6s2 Rn1n30n1t6s1 Rn1n30n1t6s2 0 sky130_fd_pr__res_xhigh_po w=10 l=436.68181
XRn1n30n1p6s3 Rn1n30n1t6s2 Rn1n30n1t6s3 0 sky130_fd_pr__res_xhigh_po w=10 l=436.68181
XRn1n30n1p6s4 Rn1n30n1t6s3 Rn1n30n1t6s4 0 sky130_fd_pr__res_xhigh_po w=10 l=436.68181
XRn1n30n1p6s5 Rn1n30n1t6s4 Rn1n30n1t6s5 0 sky130_fd_pr__res_xhigh_po w=10 l=436.68181
XRn1n30n1p6s6 Rn1n30n1t6s5 Rn1n30n1t6s6 0 sky130_fd_pr__res_xhigh_po w=10 l=436.68181
XRn1n30n1p6s7 Rn1n30n1t6s6 n1p 0 sky130_fd_pr__res_xhigh_po w=10 l=436.68181
XRn1n30n1p7s0 in30 Rn1n30n1t7s0 0 sky130_fd_pr__res_xhigh_po w=10 l=436.68181
XRn1n30n1p7s1 Rn1n30n1t7s0 Rn1n30n1t7s1 0 sky130_fd_pr__res_xhigh_po w=10 l=436.68181
XRn1n30n1p7s2 Rn1n30n1t7s1 Rn1n30n1t7s2 0 sky130_fd_pr__res_xhigh_po w=10 l=436.68181
XRn1n30n1p7s3 Rn1n30n1t7s2 Rn1n30n1t7s3 0 sky130_fd_pr__res_xhigh_po w=10 l=436.68181
XRn1n30n1p7s4 Rn1n30n1t7s3 Rn1n30n1t7s4 0 sky130_fd_pr__res_xhigh_po w=10 l=436.68181
XRn1n30n1p7s5 Rn1n30n1t7s4 Rn1n30n1t7s5 0 sky130_fd_pr__res_xhigh_po w=10 l=436.68181
XRn1n30n1p7s6 Rn1n30n1t7s5 Rn1n30n1t7s6 0 sky130_fd_pr__res_xhigh_po w=10 l=436.68181
XRn1n30n1p7s7 Rn1n30n1t7s6 n1p 0 sky130_fd_pr__res_xhigh_po w=10 l=436.68181
* n1 input 31 w=-0.216631724491884 w-  bank=n alpha=1 R=153870.96885979 G_phys=6.49895173475653e-06 G_eff=6.49895173475653e-06
* PDK sky130_fd_pr__res_xhigh_po Rn1n31n1 W=10 L=764.94083
* tile Rn1n31n1 8s x 8p same W=10 L=764.94083
XRn1n31n1p0s0 in31 Rn1n31n1t0s0 0 sky130_fd_pr__res_xhigh_po w=10 l=764.94083
XRn1n31n1p0s1 Rn1n31n1t0s0 Rn1n31n1t0s1 0 sky130_fd_pr__res_xhigh_po w=10 l=764.94083
XRn1n31n1p0s2 Rn1n31n1t0s1 Rn1n31n1t0s2 0 sky130_fd_pr__res_xhigh_po w=10 l=764.94083
XRn1n31n1p0s3 Rn1n31n1t0s2 Rn1n31n1t0s3 0 sky130_fd_pr__res_xhigh_po w=10 l=764.94083
XRn1n31n1p0s4 Rn1n31n1t0s3 Rn1n31n1t0s4 0 sky130_fd_pr__res_xhigh_po w=10 l=764.94083
XRn1n31n1p0s5 Rn1n31n1t0s4 Rn1n31n1t0s5 0 sky130_fd_pr__res_xhigh_po w=10 l=764.94083
XRn1n31n1p0s6 Rn1n31n1t0s5 Rn1n31n1t0s6 0 sky130_fd_pr__res_xhigh_po w=10 l=764.94083
XRn1n31n1p0s7 Rn1n31n1t0s6 n1p 0 sky130_fd_pr__res_xhigh_po w=10 l=764.94083
XRn1n31n1p1s0 in31 Rn1n31n1t1s0 0 sky130_fd_pr__res_xhigh_po w=10 l=764.94083
XRn1n31n1p1s1 Rn1n31n1t1s0 Rn1n31n1t1s1 0 sky130_fd_pr__res_xhigh_po w=10 l=764.94083
XRn1n31n1p1s2 Rn1n31n1t1s1 Rn1n31n1t1s2 0 sky130_fd_pr__res_xhigh_po w=10 l=764.94083
XRn1n31n1p1s3 Rn1n31n1t1s2 Rn1n31n1t1s3 0 sky130_fd_pr__res_xhigh_po w=10 l=764.94083
XRn1n31n1p1s4 Rn1n31n1t1s3 Rn1n31n1t1s4 0 sky130_fd_pr__res_xhigh_po w=10 l=764.94083
XRn1n31n1p1s5 Rn1n31n1t1s4 Rn1n31n1t1s5 0 sky130_fd_pr__res_xhigh_po w=10 l=764.94083
XRn1n31n1p1s6 Rn1n31n1t1s5 Rn1n31n1t1s6 0 sky130_fd_pr__res_xhigh_po w=10 l=764.94083
XRn1n31n1p1s7 Rn1n31n1t1s6 n1p 0 sky130_fd_pr__res_xhigh_po w=10 l=764.94083
XRn1n31n1p2s0 in31 Rn1n31n1t2s0 0 sky130_fd_pr__res_xhigh_po w=10 l=764.94083
XRn1n31n1p2s1 Rn1n31n1t2s0 Rn1n31n1t2s1 0 sky130_fd_pr__res_xhigh_po w=10 l=764.94083
XRn1n31n1p2s2 Rn1n31n1t2s1 Rn1n31n1t2s2 0 sky130_fd_pr__res_xhigh_po w=10 l=764.94083
XRn1n31n1p2s3 Rn1n31n1t2s2 Rn1n31n1t2s3 0 sky130_fd_pr__res_xhigh_po w=10 l=764.94083
XRn1n31n1p2s4 Rn1n31n1t2s3 Rn1n31n1t2s4 0 sky130_fd_pr__res_xhigh_po w=10 l=764.94083
XRn1n31n1p2s5 Rn1n31n1t2s4 Rn1n31n1t2s5 0 sky130_fd_pr__res_xhigh_po w=10 l=764.94083
XRn1n31n1p2s6 Rn1n31n1t2s5 Rn1n31n1t2s6 0 sky130_fd_pr__res_xhigh_po w=10 l=764.94083
XRn1n31n1p2s7 Rn1n31n1t2s6 n1p 0 sky130_fd_pr__res_xhigh_po w=10 l=764.94083
XRn1n31n1p3s0 in31 Rn1n31n1t3s0 0 sky130_fd_pr__res_xhigh_po w=10 l=764.94083
XRn1n31n1p3s1 Rn1n31n1t3s0 Rn1n31n1t3s1 0 sky130_fd_pr__res_xhigh_po w=10 l=764.94083
XRn1n31n1p3s2 Rn1n31n1t3s1 Rn1n31n1t3s2 0 sky130_fd_pr__res_xhigh_po w=10 l=764.94083
XRn1n31n1p3s3 Rn1n31n1t3s2 Rn1n31n1t3s3 0 sky130_fd_pr__res_xhigh_po w=10 l=764.94083
XRn1n31n1p3s4 Rn1n31n1t3s3 Rn1n31n1t3s4 0 sky130_fd_pr__res_xhigh_po w=10 l=764.94083
XRn1n31n1p3s5 Rn1n31n1t3s4 Rn1n31n1t3s5 0 sky130_fd_pr__res_xhigh_po w=10 l=764.94083
XRn1n31n1p3s6 Rn1n31n1t3s5 Rn1n31n1t3s6 0 sky130_fd_pr__res_xhigh_po w=10 l=764.94083
XRn1n31n1p3s7 Rn1n31n1t3s6 n1p 0 sky130_fd_pr__res_xhigh_po w=10 l=764.94083
XRn1n31n1p4s0 in31 Rn1n31n1t4s0 0 sky130_fd_pr__res_xhigh_po w=10 l=764.94083
XRn1n31n1p4s1 Rn1n31n1t4s0 Rn1n31n1t4s1 0 sky130_fd_pr__res_xhigh_po w=10 l=764.94083
XRn1n31n1p4s2 Rn1n31n1t4s1 Rn1n31n1t4s2 0 sky130_fd_pr__res_xhigh_po w=10 l=764.94083
XRn1n31n1p4s3 Rn1n31n1t4s2 Rn1n31n1t4s3 0 sky130_fd_pr__res_xhigh_po w=10 l=764.94083
XRn1n31n1p4s4 Rn1n31n1t4s3 Rn1n31n1t4s4 0 sky130_fd_pr__res_xhigh_po w=10 l=764.94083
XRn1n31n1p4s5 Rn1n31n1t4s4 Rn1n31n1t4s5 0 sky130_fd_pr__res_xhigh_po w=10 l=764.94083
XRn1n31n1p4s6 Rn1n31n1t4s5 Rn1n31n1t4s6 0 sky130_fd_pr__res_xhigh_po w=10 l=764.94083
XRn1n31n1p4s7 Rn1n31n1t4s6 n1p 0 sky130_fd_pr__res_xhigh_po w=10 l=764.94083
XRn1n31n1p5s0 in31 Rn1n31n1t5s0 0 sky130_fd_pr__res_xhigh_po w=10 l=764.94083
XRn1n31n1p5s1 Rn1n31n1t5s0 Rn1n31n1t5s1 0 sky130_fd_pr__res_xhigh_po w=10 l=764.94083
XRn1n31n1p5s2 Rn1n31n1t5s1 Rn1n31n1t5s2 0 sky130_fd_pr__res_xhigh_po w=10 l=764.94083
XRn1n31n1p5s3 Rn1n31n1t5s2 Rn1n31n1t5s3 0 sky130_fd_pr__res_xhigh_po w=10 l=764.94083
XRn1n31n1p5s4 Rn1n31n1t5s3 Rn1n31n1t5s4 0 sky130_fd_pr__res_xhigh_po w=10 l=764.94083
XRn1n31n1p5s5 Rn1n31n1t5s4 Rn1n31n1t5s5 0 sky130_fd_pr__res_xhigh_po w=10 l=764.94083
XRn1n31n1p5s6 Rn1n31n1t5s5 Rn1n31n1t5s6 0 sky130_fd_pr__res_xhigh_po w=10 l=764.94083
XRn1n31n1p5s7 Rn1n31n1t5s6 n1p 0 sky130_fd_pr__res_xhigh_po w=10 l=764.94083
XRn1n31n1p6s0 in31 Rn1n31n1t6s0 0 sky130_fd_pr__res_xhigh_po w=10 l=764.94083
XRn1n31n1p6s1 Rn1n31n1t6s0 Rn1n31n1t6s1 0 sky130_fd_pr__res_xhigh_po w=10 l=764.94083
XRn1n31n1p6s2 Rn1n31n1t6s1 Rn1n31n1t6s2 0 sky130_fd_pr__res_xhigh_po w=10 l=764.94083
XRn1n31n1p6s3 Rn1n31n1t6s2 Rn1n31n1t6s3 0 sky130_fd_pr__res_xhigh_po w=10 l=764.94083
XRn1n31n1p6s4 Rn1n31n1t6s3 Rn1n31n1t6s4 0 sky130_fd_pr__res_xhigh_po w=10 l=764.94083
XRn1n31n1p6s5 Rn1n31n1t6s4 Rn1n31n1t6s5 0 sky130_fd_pr__res_xhigh_po w=10 l=764.94083
XRn1n31n1p6s6 Rn1n31n1t6s5 Rn1n31n1t6s6 0 sky130_fd_pr__res_xhigh_po w=10 l=764.94083
XRn1n31n1p6s7 Rn1n31n1t6s6 n1p 0 sky130_fd_pr__res_xhigh_po w=10 l=764.94083
XRn1n31n1p7s0 in31 Rn1n31n1t7s0 0 sky130_fd_pr__res_xhigh_po w=10 l=764.94083
XRn1n31n1p7s1 Rn1n31n1t7s0 Rn1n31n1t7s1 0 sky130_fd_pr__res_xhigh_po w=10 l=764.94083
XRn1n31n1p7s2 Rn1n31n1t7s1 Rn1n31n1t7s2 0 sky130_fd_pr__res_xhigh_po w=10 l=764.94083
XRn1n31n1p7s3 Rn1n31n1t7s2 Rn1n31n1t7s3 0 sky130_fd_pr__res_xhigh_po w=10 l=764.94083
XRn1n31n1p7s4 Rn1n31n1t7s3 Rn1n31n1t7s4 0 sky130_fd_pr__res_xhigh_po w=10 l=764.94083
XRn1n31n1p7s5 Rn1n31n1t7s4 Rn1n31n1t7s5 0 sky130_fd_pr__res_xhigh_po w=10 l=764.94083
XRn1n31n1p7s6 Rn1n31n1t7s5 Rn1n31n1t7s6 0 sky130_fd_pr__res_xhigh_po w=10 l=764.94083
XRn1n31n1p7s7 Rn1n31n1t7s6 n1p 0 sky130_fd_pr__res_xhigh_po w=10 l=764.94083
* n1 input 32 w=+0.139103822260271 w+  bank=n alpha=1 R=239629.169002738 G_phys=4.17311466780814e-06 G_eff=4.17311466780814e-06
* PDK sky130_fd_pr__res_xhigh_po Rn1p32n1 W=10 L=1191.3306
* tile Rn1p32n1 8s x 8p same W=10 L=1191.3306
XRn1p32n1p0s0 in32n Rn1p32n1t0s0 0 sky130_fd_pr__res_xhigh_po w=10 l=1191.3306
XRn1p32n1p0s1 Rn1p32n1t0s0 Rn1p32n1t0s1 0 sky130_fd_pr__res_xhigh_po w=10 l=1191.3306
XRn1p32n1p0s2 Rn1p32n1t0s1 Rn1p32n1t0s2 0 sky130_fd_pr__res_xhigh_po w=10 l=1191.3306
XRn1p32n1p0s3 Rn1p32n1t0s2 Rn1p32n1t0s3 0 sky130_fd_pr__res_xhigh_po w=10 l=1191.3306
XRn1p32n1p0s4 Rn1p32n1t0s3 Rn1p32n1t0s4 0 sky130_fd_pr__res_xhigh_po w=10 l=1191.3306
XRn1p32n1p0s5 Rn1p32n1t0s4 Rn1p32n1t0s5 0 sky130_fd_pr__res_xhigh_po w=10 l=1191.3306
XRn1p32n1p0s6 Rn1p32n1t0s5 Rn1p32n1t0s6 0 sky130_fd_pr__res_xhigh_po w=10 l=1191.3306
XRn1p32n1p0s7 Rn1p32n1t0s6 n1p 0 sky130_fd_pr__res_xhigh_po w=10 l=1191.3306
XRn1p32n1p1s0 in32n Rn1p32n1t1s0 0 sky130_fd_pr__res_xhigh_po w=10 l=1191.3306
XRn1p32n1p1s1 Rn1p32n1t1s0 Rn1p32n1t1s1 0 sky130_fd_pr__res_xhigh_po w=10 l=1191.3306
XRn1p32n1p1s2 Rn1p32n1t1s1 Rn1p32n1t1s2 0 sky130_fd_pr__res_xhigh_po w=10 l=1191.3306
XRn1p32n1p1s3 Rn1p32n1t1s2 Rn1p32n1t1s3 0 sky130_fd_pr__res_xhigh_po w=10 l=1191.3306
XRn1p32n1p1s4 Rn1p32n1t1s3 Rn1p32n1t1s4 0 sky130_fd_pr__res_xhigh_po w=10 l=1191.3306
XRn1p32n1p1s5 Rn1p32n1t1s4 Rn1p32n1t1s5 0 sky130_fd_pr__res_xhigh_po w=10 l=1191.3306
XRn1p32n1p1s6 Rn1p32n1t1s5 Rn1p32n1t1s6 0 sky130_fd_pr__res_xhigh_po w=10 l=1191.3306
XRn1p32n1p1s7 Rn1p32n1t1s6 n1p 0 sky130_fd_pr__res_xhigh_po w=10 l=1191.3306
XRn1p32n1p2s0 in32n Rn1p32n1t2s0 0 sky130_fd_pr__res_xhigh_po w=10 l=1191.3306
XRn1p32n1p2s1 Rn1p32n1t2s0 Rn1p32n1t2s1 0 sky130_fd_pr__res_xhigh_po w=10 l=1191.3306
XRn1p32n1p2s2 Rn1p32n1t2s1 Rn1p32n1t2s2 0 sky130_fd_pr__res_xhigh_po w=10 l=1191.3306
XRn1p32n1p2s3 Rn1p32n1t2s2 Rn1p32n1t2s3 0 sky130_fd_pr__res_xhigh_po w=10 l=1191.3306
XRn1p32n1p2s4 Rn1p32n1t2s3 Rn1p32n1t2s4 0 sky130_fd_pr__res_xhigh_po w=10 l=1191.3306
XRn1p32n1p2s5 Rn1p32n1t2s4 Rn1p32n1t2s5 0 sky130_fd_pr__res_xhigh_po w=10 l=1191.3306
XRn1p32n1p2s6 Rn1p32n1t2s5 Rn1p32n1t2s6 0 sky130_fd_pr__res_xhigh_po w=10 l=1191.3306
XRn1p32n1p2s7 Rn1p32n1t2s6 n1p 0 sky130_fd_pr__res_xhigh_po w=10 l=1191.3306
XRn1p32n1p3s0 in32n Rn1p32n1t3s0 0 sky130_fd_pr__res_xhigh_po w=10 l=1191.3306
XRn1p32n1p3s1 Rn1p32n1t3s0 Rn1p32n1t3s1 0 sky130_fd_pr__res_xhigh_po w=10 l=1191.3306
XRn1p32n1p3s2 Rn1p32n1t3s1 Rn1p32n1t3s2 0 sky130_fd_pr__res_xhigh_po w=10 l=1191.3306
XRn1p32n1p3s3 Rn1p32n1t3s2 Rn1p32n1t3s3 0 sky130_fd_pr__res_xhigh_po w=10 l=1191.3306
XRn1p32n1p3s4 Rn1p32n1t3s3 Rn1p32n1t3s4 0 sky130_fd_pr__res_xhigh_po w=10 l=1191.3306
XRn1p32n1p3s5 Rn1p32n1t3s4 Rn1p32n1t3s5 0 sky130_fd_pr__res_xhigh_po w=10 l=1191.3306
XRn1p32n1p3s6 Rn1p32n1t3s5 Rn1p32n1t3s6 0 sky130_fd_pr__res_xhigh_po w=10 l=1191.3306
XRn1p32n1p3s7 Rn1p32n1t3s6 n1p 0 sky130_fd_pr__res_xhigh_po w=10 l=1191.3306
XRn1p32n1p4s0 in32n Rn1p32n1t4s0 0 sky130_fd_pr__res_xhigh_po w=10 l=1191.3306
XRn1p32n1p4s1 Rn1p32n1t4s0 Rn1p32n1t4s1 0 sky130_fd_pr__res_xhigh_po w=10 l=1191.3306
XRn1p32n1p4s2 Rn1p32n1t4s1 Rn1p32n1t4s2 0 sky130_fd_pr__res_xhigh_po w=10 l=1191.3306
XRn1p32n1p4s3 Rn1p32n1t4s2 Rn1p32n1t4s3 0 sky130_fd_pr__res_xhigh_po w=10 l=1191.3306
XRn1p32n1p4s4 Rn1p32n1t4s3 Rn1p32n1t4s4 0 sky130_fd_pr__res_xhigh_po w=10 l=1191.3306
XRn1p32n1p4s5 Rn1p32n1t4s4 Rn1p32n1t4s5 0 sky130_fd_pr__res_xhigh_po w=10 l=1191.3306
XRn1p32n1p4s6 Rn1p32n1t4s5 Rn1p32n1t4s6 0 sky130_fd_pr__res_xhigh_po w=10 l=1191.3306
XRn1p32n1p4s7 Rn1p32n1t4s6 n1p 0 sky130_fd_pr__res_xhigh_po w=10 l=1191.3306
XRn1p32n1p5s0 in32n Rn1p32n1t5s0 0 sky130_fd_pr__res_xhigh_po w=10 l=1191.3306
XRn1p32n1p5s1 Rn1p32n1t5s0 Rn1p32n1t5s1 0 sky130_fd_pr__res_xhigh_po w=10 l=1191.3306
XRn1p32n1p5s2 Rn1p32n1t5s1 Rn1p32n1t5s2 0 sky130_fd_pr__res_xhigh_po w=10 l=1191.3306
XRn1p32n1p5s3 Rn1p32n1t5s2 Rn1p32n1t5s3 0 sky130_fd_pr__res_xhigh_po w=10 l=1191.3306
XRn1p32n1p5s4 Rn1p32n1t5s3 Rn1p32n1t5s4 0 sky130_fd_pr__res_xhigh_po w=10 l=1191.3306
XRn1p32n1p5s5 Rn1p32n1t5s4 Rn1p32n1t5s5 0 sky130_fd_pr__res_xhigh_po w=10 l=1191.3306
XRn1p32n1p5s6 Rn1p32n1t5s5 Rn1p32n1t5s6 0 sky130_fd_pr__res_xhigh_po w=10 l=1191.3306
XRn1p32n1p5s7 Rn1p32n1t5s6 n1p 0 sky130_fd_pr__res_xhigh_po w=10 l=1191.3306
XRn1p32n1p6s0 in32n Rn1p32n1t6s0 0 sky130_fd_pr__res_xhigh_po w=10 l=1191.3306
XRn1p32n1p6s1 Rn1p32n1t6s0 Rn1p32n1t6s1 0 sky130_fd_pr__res_xhigh_po w=10 l=1191.3306
XRn1p32n1p6s2 Rn1p32n1t6s1 Rn1p32n1t6s2 0 sky130_fd_pr__res_xhigh_po w=10 l=1191.3306
XRn1p32n1p6s3 Rn1p32n1t6s2 Rn1p32n1t6s3 0 sky130_fd_pr__res_xhigh_po w=10 l=1191.3306
XRn1p32n1p6s4 Rn1p32n1t6s3 Rn1p32n1t6s4 0 sky130_fd_pr__res_xhigh_po w=10 l=1191.3306
XRn1p32n1p6s5 Rn1p32n1t6s4 Rn1p32n1t6s5 0 sky130_fd_pr__res_xhigh_po w=10 l=1191.3306
XRn1p32n1p6s6 Rn1p32n1t6s5 Rn1p32n1t6s6 0 sky130_fd_pr__res_xhigh_po w=10 l=1191.3306
XRn1p32n1p6s7 Rn1p32n1t6s6 n1p 0 sky130_fd_pr__res_xhigh_po w=10 l=1191.3306
XRn1p32n1p7s0 in32n Rn1p32n1t7s0 0 sky130_fd_pr__res_xhigh_po w=10 l=1191.3306
XRn1p32n1p7s1 Rn1p32n1t7s0 Rn1p32n1t7s1 0 sky130_fd_pr__res_xhigh_po w=10 l=1191.3306
XRn1p32n1p7s2 Rn1p32n1t7s1 Rn1p32n1t7s2 0 sky130_fd_pr__res_xhigh_po w=10 l=1191.3306
XRn1p32n1p7s3 Rn1p32n1t7s2 Rn1p32n1t7s3 0 sky130_fd_pr__res_xhigh_po w=10 l=1191.3306
XRn1p32n1p7s4 Rn1p32n1t7s3 Rn1p32n1t7s4 0 sky130_fd_pr__res_xhigh_po w=10 l=1191.3306
XRn1p32n1p7s5 Rn1p32n1t7s4 Rn1p32n1t7s5 0 sky130_fd_pr__res_xhigh_po w=10 l=1191.3306
XRn1p32n1p7s6 Rn1p32n1t7s5 Rn1p32n1t7s6 0 sky130_fd_pr__res_xhigh_po w=10 l=1191.3306
XRn1p32n1p7s7 Rn1p32n1t7s6 n1p 0 sky130_fd_pr__res_xhigh_po w=10 l=1191.3306
* n1 bias w+  bank=f alpha=0.001 R=1034.77721072674 G_phys=0.000966391595827364 G_eff=9.66391595827364e-07
* PDK sky130_fd_pr__res_xhigh_po Rn1bpf1 W=10 L=5.039284
* tile Rn1bpf1 8s x 8p same W=10 L=5.039284
XRn1bpf1p0s0 taprefn Rn1bpf1t0s0 0 sky130_fd_pr__res_xhigh_po w=10 l=5.039284
XRn1bpf1p0s1 Rn1bpf1t0s0 Rn1bpf1t0s1 0 sky130_fd_pr__res_xhigh_po w=10 l=5.039284
XRn1bpf1p0s2 Rn1bpf1t0s1 Rn1bpf1t0s2 0 sky130_fd_pr__res_xhigh_po w=10 l=5.039284
XRn1bpf1p0s3 Rn1bpf1t0s2 Rn1bpf1t0s3 0 sky130_fd_pr__res_xhigh_po w=10 l=5.039284
XRn1bpf1p0s4 Rn1bpf1t0s3 Rn1bpf1t0s4 0 sky130_fd_pr__res_xhigh_po w=10 l=5.039284
XRn1bpf1p0s5 Rn1bpf1t0s4 Rn1bpf1t0s5 0 sky130_fd_pr__res_xhigh_po w=10 l=5.039284
XRn1bpf1p0s6 Rn1bpf1t0s5 Rn1bpf1t0s6 0 sky130_fd_pr__res_xhigh_po w=10 l=5.039284
XRn1bpf1p0s7 Rn1bpf1t0s6 n1p 0 sky130_fd_pr__res_xhigh_po w=10 l=5.039284
XRn1bpf1p1s0 taprefn Rn1bpf1t1s0 0 sky130_fd_pr__res_xhigh_po w=10 l=5.039284
XRn1bpf1p1s1 Rn1bpf1t1s0 Rn1bpf1t1s1 0 sky130_fd_pr__res_xhigh_po w=10 l=5.039284
XRn1bpf1p1s2 Rn1bpf1t1s1 Rn1bpf1t1s2 0 sky130_fd_pr__res_xhigh_po w=10 l=5.039284
XRn1bpf1p1s3 Rn1bpf1t1s2 Rn1bpf1t1s3 0 sky130_fd_pr__res_xhigh_po w=10 l=5.039284
XRn1bpf1p1s4 Rn1bpf1t1s3 Rn1bpf1t1s4 0 sky130_fd_pr__res_xhigh_po w=10 l=5.039284
XRn1bpf1p1s5 Rn1bpf1t1s4 Rn1bpf1t1s5 0 sky130_fd_pr__res_xhigh_po w=10 l=5.039284
XRn1bpf1p1s6 Rn1bpf1t1s5 Rn1bpf1t1s6 0 sky130_fd_pr__res_xhigh_po w=10 l=5.039284
XRn1bpf1p1s7 Rn1bpf1t1s6 n1p 0 sky130_fd_pr__res_xhigh_po w=10 l=5.039284
XRn1bpf1p2s0 taprefn Rn1bpf1t2s0 0 sky130_fd_pr__res_xhigh_po w=10 l=5.039284
XRn1bpf1p2s1 Rn1bpf1t2s0 Rn1bpf1t2s1 0 sky130_fd_pr__res_xhigh_po w=10 l=5.039284
XRn1bpf1p2s2 Rn1bpf1t2s1 Rn1bpf1t2s2 0 sky130_fd_pr__res_xhigh_po w=10 l=5.039284
XRn1bpf1p2s3 Rn1bpf1t2s2 Rn1bpf1t2s3 0 sky130_fd_pr__res_xhigh_po w=10 l=5.039284
XRn1bpf1p2s4 Rn1bpf1t2s3 Rn1bpf1t2s4 0 sky130_fd_pr__res_xhigh_po w=10 l=5.039284
XRn1bpf1p2s5 Rn1bpf1t2s4 Rn1bpf1t2s5 0 sky130_fd_pr__res_xhigh_po w=10 l=5.039284
XRn1bpf1p2s6 Rn1bpf1t2s5 Rn1bpf1t2s6 0 sky130_fd_pr__res_xhigh_po w=10 l=5.039284
XRn1bpf1p2s7 Rn1bpf1t2s6 n1p 0 sky130_fd_pr__res_xhigh_po w=10 l=5.039284
XRn1bpf1p3s0 taprefn Rn1bpf1t3s0 0 sky130_fd_pr__res_xhigh_po w=10 l=5.039284
XRn1bpf1p3s1 Rn1bpf1t3s0 Rn1bpf1t3s1 0 sky130_fd_pr__res_xhigh_po w=10 l=5.039284
XRn1bpf1p3s2 Rn1bpf1t3s1 Rn1bpf1t3s2 0 sky130_fd_pr__res_xhigh_po w=10 l=5.039284
XRn1bpf1p3s3 Rn1bpf1t3s2 Rn1bpf1t3s3 0 sky130_fd_pr__res_xhigh_po w=10 l=5.039284
XRn1bpf1p3s4 Rn1bpf1t3s3 Rn1bpf1t3s4 0 sky130_fd_pr__res_xhigh_po w=10 l=5.039284
XRn1bpf1p3s5 Rn1bpf1t3s4 Rn1bpf1t3s5 0 sky130_fd_pr__res_xhigh_po w=10 l=5.039284
XRn1bpf1p3s6 Rn1bpf1t3s5 Rn1bpf1t3s6 0 sky130_fd_pr__res_xhigh_po w=10 l=5.039284
XRn1bpf1p3s7 Rn1bpf1t3s6 n1p 0 sky130_fd_pr__res_xhigh_po w=10 l=5.039284
XRn1bpf1p4s0 taprefn Rn1bpf1t4s0 0 sky130_fd_pr__res_xhigh_po w=10 l=5.039284
XRn1bpf1p4s1 Rn1bpf1t4s0 Rn1bpf1t4s1 0 sky130_fd_pr__res_xhigh_po w=10 l=5.039284
XRn1bpf1p4s2 Rn1bpf1t4s1 Rn1bpf1t4s2 0 sky130_fd_pr__res_xhigh_po w=10 l=5.039284
XRn1bpf1p4s3 Rn1bpf1t4s2 Rn1bpf1t4s3 0 sky130_fd_pr__res_xhigh_po w=10 l=5.039284
XRn1bpf1p4s4 Rn1bpf1t4s3 Rn1bpf1t4s4 0 sky130_fd_pr__res_xhigh_po w=10 l=5.039284
XRn1bpf1p4s5 Rn1bpf1t4s4 Rn1bpf1t4s5 0 sky130_fd_pr__res_xhigh_po w=10 l=5.039284
XRn1bpf1p4s6 Rn1bpf1t4s5 Rn1bpf1t4s6 0 sky130_fd_pr__res_xhigh_po w=10 l=5.039284
XRn1bpf1p4s7 Rn1bpf1t4s6 n1p 0 sky130_fd_pr__res_xhigh_po w=10 l=5.039284
XRn1bpf1p5s0 taprefn Rn1bpf1t5s0 0 sky130_fd_pr__res_xhigh_po w=10 l=5.039284
XRn1bpf1p5s1 Rn1bpf1t5s0 Rn1bpf1t5s1 0 sky130_fd_pr__res_xhigh_po w=10 l=5.039284
XRn1bpf1p5s2 Rn1bpf1t5s1 Rn1bpf1t5s2 0 sky130_fd_pr__res_xhigh_po w=10 l=5.039284
XRn1bpf1p5s3 Rn1bpf1t5s2 Rn1bpf1t5s3 0 sky130_fd_pr__res_xhigh_po w=10 l=5.039284
XRn1bpf1p5s4 Rn1bpf1t5s3 Rn1bpf1t5s4 0 sky130_fd_pr__res_xhigh_po w=10 l=5.039284
XRn1bpf1p5s5 Rn1bpf1t5s4 Rn1bpf1t5s5 0 sky130_fd_pr__res_xhigh_po w=10 l=5.039284
XRn1bpf1p5s6 Rn1bpf1t5s5 Rn1bpf1t5s6 0 sky130_fd_pr__res_xhigh_po w=10 l=5.039284
XRn1bpf1p5s7 Rn1bpf1t5s6 n1p 0 sky130_fd_pr__res_xhigh_po w=10 l=5.039284
XRn1bpf1p6s0 taprefn Rn1bpf1t6s0 0 sky130_fd_pr__res_xhigh_po w=10 l=5.039284
XRn1bpf1p6s1 Rn1bpf1t6s0 Rn1bpf1t6s1 0 sky130_fd_pr__res_xhigh_po w=10 l=5.039284
XRn1bpf1p6s2 Rn1bpf1t6s1 Rn1bpf1t6s2 0 sky130_fd_pr__res_xhigh_po w=10 l=5.039284
XRn1bpf1p6s3 Rn1bpf1t6s2 Rn1bpf1t6s3 0 sky130_fd_pr__res_xhigh_po w=10 l=5.039284
XRn1bpf1p6s4 Rn1bpf1t6s3 Rn1bpf1t6s4 0 sky130_fd_pr__res_xhigh_po w=10 l=5.039284
XRn1bpf1p6s5 Rn1bpf1t6s4 Rn1bpf1t6s5 0 sky130_fd_pr__res_xhigh_po w=10 l=5.039284
XRn1bpf1p6s6 Rn1bpf1t6s5 Rn1bpf1t6s6 0 sky130_fd_pr__res_xhigh_po w=10 l=5.039284
XRn1bpf1p6s7 Rn1bpf1t6s6 n1p 0 sky130_fd_pr__res_xhigh_po w=10 l=5.039284
XRn1bpf1p7s0 taprefn Rn1bpf1t7s0 0 sky130_fd_pr__res_xhigh_po w=10 l=5.039284
XRn1bpf1p7s1 Rn1bpf1t7s0 Rn1bpf1t7s1 0 sky130_fd_pr__res_xhigh_po w=10 l=5.039284
XRn1bpf1p7s2 Rn1bpf1t7s1 Rn1bpf1t7s2 0 sky130_fd_pr__res_xhigh_po w=10 l=5.039284
XRn1bpf1p7s3 Rn1bpf1t7s2 Rn1bpf1t7s3 0 sky130_fd_pr__res_xhigh_po w=10 l=5.039284
XRn1bpf1p7s4 Rn1bpf1t7s3 Rn1bpf1t7s4 0 sky130_fd_pr__res_xhigh_po w=10 l=5.039284
XRn1bpf1p7s5 Rn1bpf1t7s4 Rn1bpf1t7s5 0 sky130_fd_pr__res_xhigh_po w=10 l=5.039284
XRn1bpf1p7s6 Rn1bpf1t7s5 Rn1bpf1t7s6 0 sky130_fd_pr__res_xhigh_po w=10 l=5.039284
XRn1bpf1p7s7 Rn1bpf1t7s6 n1p 0 sky130_fd_pr__res_xhigh_po w=10 l=5.039284
* feedback TIA n1: Rf=33333.3333333333 A=1000000 V(n1lin) = -I(n1p)*Rf*A/(A+1)  (uncompensated)
Vn1ib n1p n1inn DC 0
Xn1tia 0 n1inn vddtia vsstia n1lin OPAx189
Cn1load n1lin 0 1p
* PDK sky130_fd_pr__res_xhigh_po Rn1f W=10 L=165.62771
* tile Rn1f 8s x 8p same W=10 L=165.62771
XRn1fp0s0 n1lin Rn1ft0s0 0 sky130_fd_pr__res_xhigh_po w=10 l=165.62771
XRn1fp0s1 Rn1ft0s0 Rn1ft0s1 0 sky130_fd_pr__res_xhigh_po w=10 l=165.62771
XRn1fp0s2 Rn1ft0s1 Rn1ft0s2 0 sky130_fd_pr__res_xhigh_po w=10 l=165.62771
XRn1fp0s3 Rn1ft0s2 Rn1ft0s3 0 sky130_fd_pr__res_xhigh_po w=10 l=165.62771
XRn1fp0s4 Rn1ft0s3 Rn1ft0s4 0 sky130_fd_pr__res_xhigh_po w=10 l=165.62771
XRn1fp0s5 Rn1ft0s4 Rn1ft0s5 0 sky130_fd_pr__res_xhigh_po w=10 l=165.62771
XRn1fp0s6 Rn1ft0s5 Rn1ft0s6 0 sky130_fd_pr__res_xhigh_po w=10 l=165.62771
XRn1fp0s7 Rn1ft0s6 n1p 0 sky130_fd_pr__res_xhigh_po w=10 l=165.62771
XRn1fp1s0 n1lin Rn1ft1s0 0 sky130_fd_pr__res_xhigh_po w=10 l=165.62771
XRn1fp1s1 Rn1ft1s0 Rn1ft1s1 0 sky130_fd_pr__res_xhigh_po w=10 l=165.62771
XRn1fp1s2 Rn1ft1s1 Rn1ft1s2 0 sky130_fd_pr__res_xhigh_po w=10 l=165.62771
XRn1fp1s3 Rn1ft1s2 Rn1ft1s3 0 sky130_fd_pr__res_xhigh_po w=10 l=165.62771
XRn1fp1s4 Rn1ft1s3 Rn1ft1s4 0 sky130_fd_pr__res_xhigh_po w=10 l=165.62771
XRn1fp1s5 Rn1ft1s4 Rn1ft1s5 0 sky130_fd_pr__res_xhigh_po w=10 l=165.62771
XRn1fp1s6 Rn1ft1s5 Rn1ft1s6 0 sky130_fd_pr__res_xhigh_po w=10 l=165.62771
XRn1fp1s7 Rn1ft1s6 n1p 0 sky130_fd_pr__res_xhigh_po w=10 l=165.62771
XRn1fp2s0 n1lin Rn1ft2s0 0 sky130_fd_pr__res_xhigh_po w=10 l=165.62771
XRn1fp2s1 Rn1ft2s0 Rn1ft2s1 0 sky130_fd_pr__res_xhigh_po w=10 l=165.62771
XRn1fp2s2 Rn1ft2s1 Rn1ft2s2 0 sky130_fd_pr__res_xhigh_po w=10 l=165.62771
XRn1fp2s3 Rn1ft2s2 Rn1ft2s3 0 sky130_fd_pr__res_xhigh_po w=10 l=165.62771
XRn1fp2s4 Rn1ft2s3 Rn1ft2s4 0 sky130_fd_pr__res_xhigh_po w=10 l=165.62771
XRn1fp2s5 Rn1ft2s4 Rn1ft2s5 0 sky130_fd_pr__res_xhigh_po w=10 l=165.62771
XRn1fp2s6 Rn1ft2s5 Rn1ft2s6 0 sky130_fd_pr__res_xhigh_po w=10 l=165.62771
XRn1fp2s7 Rn1ft2s6 n1p 0 sky130_fd_pr__res_xhigh_po w=10 l=165.62771
XRn1fp3s0 n1lin Rn1ft3s0 0 sky130_fd_pr__res_xhigh_po w=10 l=165.62771
XRn1fp3s1 Rn1ft3s0 Rn1ft3s1 0 sky130_fd_pr__res_xhigh_po w=10 l=165.62771
XRn1fp3s2 Rn1ft3s1 Rn1ft3s2 0 sky130_fd_pr__res_xhigh_po w=10 l=165.62771
XRn1fp3s3 Rn1ft3s2 Rn1ft3s3 0 sky130_fd_pr__res_xhigh_po w=10 l=165.62771
XRn1fp3s4 Rn1ft3s3 Rn1ft3s4 0 sky130_fd_pr__res_xhigh_po w=10 l=165.62771
XRn1fp3s5 Rn1ft3s4 Rn1ft3s5 0 sky130_fd_pr__res_xhigh_po w=10 l=165.62771
XRn1fp3s6 Rn1ft3s5 Rn1ft3s6 0 sky130_fd_pr__res_xhigh_po w=10 l=165.62771
XRn1fp3s7 Rn1ft3s6 n1p 0 sky130_fd_pr__res_xhigh_po w=10 l=165.62771
XRn1fp4s0 n1lin Rn1ft4s0 0 sky130_fd_pr__res_xhigh_po w=10 l=165.62771
XRn1fp4s1 Rn1ft4s0 Rn1ft4s1 0 sky130_fd_pr__res_xhigh_po w=10 l=165.62771
XRn1fp4s2 Rn1ft4s1 Rn1ft4s2 0 sky130_fd_pr__res_xhigh_po w=10 l=165.62771
XRn1fp4s3 Rn1ft4s2 Rn1ft4s3 0 sky130_fd_pr__res_xhigh_po w=10 l=165.62771
XRn1fp4s4 Rn1ft4s3 Rn1ft4s4 0 sky130_fd_pr__res_xhigh_po w=10 l=165.62771
XRn1fp4s5 Rn1ft4s4 Rn1ft4s5 0 sky130_fd_pr__res_xhigh_po w=10 l=165.62771
XRn1fp4s6 Rn1ft4s5 Rn1ft4s6 0 sky130_fd_pr__res_xhigh_po w=10 l=165.62771
XRn1fp4s7 Rn1ft4s6 n1p 0 sky130_fd_pr__res_xhigh_po w=10 l=165.62771
XRn1fp5s0 n1lin Rn1ft5s0 0 sky130_fd_pr__res_xhigh_po w=10 l=165.62771
XRn1fp5s1 Rn1ft5s0 Rn1ft5s1 0 sky130_fd_pr__res_xhigh_po w=10 l=165.62771
XRn1fp5s2 Rn1ft5s1 Rn1ft5s2 0 sky130_fd_pr__res_xhigh_po w=10 l=165.62771
XRn1fp5s3 Rn1ft5s2 Rn1ft5s3 0 sky130_fd_pr__res_xhigh_po w=10 l=165.62771
XRn1fp5s4 Rn1ft5s3 Rn1ft5s4 0 sky130_fd_pr__res_xhigh_po w=10 l=165.62771
XRn1fp5s5 Rn1ft5s4 Rn1ft5s5 0 sky130_fd_pr__res_xhigh_po w=10 l=165.62771
XRn1fp5s6 Rn1ft5s5 Rn1ft5s6 0 sky130_fd_pr__res_xhigh_po w=10 l=165.62771
XRn1fp5s7 Rn1ft5s6 n1p 0 sky130_fd_pr__res_xhigh_po w=10 l=165.62771
XRn1fp6s0 n1lin Rn1ft6s0 0 sky130_fd_pr__res_xhigh_po w=10 l=165.62771
XRn1fp6s1 Rn1ft6s0 Rn1ft6s1 0 sky130_fd_pr__res_xhigh_po w=10 l=165.62771
XRn1fp6s2 Rn1ft6s1 Rn1ft6s2 0 sky130_fd_pr__res_xhigh_po w=10 l=165.62771
XRn1fp6s3 Rn1ft6s2 Rn1ft6s3 0 sky130_fd_pr__res_xhigh_po w=10 l=165.62771
XRn1fp6s4 Rn1ft6s3 Rn1ft6s4 0 sky130_fd_pr__res_xhigh_po w=10 l=165.62771
XRn1fp6s5 Rn1ft6s4 Rn1ft6s5 0 sky130_fd_pr__res_xhigh_po w=10 l=165.62771
XRn1fp6s6 Rn1ft6s5 Rn1ft6s6 0 sky130_fd_pr__res_xhigh_po w=10 l=165.62771
XRn1fp6s7 Rn1ft6s6 n1p 0 sky130_fd_pr__res_xhigh_po w=10 l=165.62771
XRn1fp7s0 n1lin Rn1ft7s0 0 sky130_fd_pr__res_xhigh_po w=10 l=165.62771
XRn1fp7s1 Rn1ft7s0 Rn1ft7s1 0 sky130_fd_pr__res_xhigh_po w=10 l=165.62771
XRn1fp7s2 Rn1ft7s1 Rn1ft7s2 0 sky130_fd_pr__res_xhigh_po w=10 l=165.62771
XRn1fp7s3 Rn1ft7s2 Rn1ft7s3 0 sky130_fd_pr__res_xhigh_po w=10 l=165.62771
XRn1fp7s4 Rn1ft7s3 Rn1ft7s4 0 sky130_fd_pr__res_xhigh_po w=10 l=165.62771
XRn1fp7s5 Rn1ft7s4 Rn1ft7s5 0 sky130_fd_pr__res_xhigh_po w=10 l=165.62771
XRn1fp7s6 Rn1ft7s5 Rn1ft7s6 0 sky130_fd_pr__res_xhigh_po w=10 l=165.62771
XRn1fp7s7 Rn1ft7s6 n1p 0 sky130_fd_pr__res_xhigh_po w=10 l=165.62771

.control
set numdgt=12
set seed=58005
op
print v(n1lin)
print v(n1p)
print i(Vn1ib)
print i(Vddtia)
.endc
.end
