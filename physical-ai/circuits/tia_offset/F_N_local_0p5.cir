* Physical AI - Experiment 19 architecture N: matched replica-null TIA
* Signal TIA plus a replica TIA loaded by dummy G_tot to 0 V. Same A, Rf, Vos. Vlin = Vsig - Vrep. Unity subtractor VCVS.
* Frozen Experiment 9 network F. Weights were not edited.
* Behavioral circuit analysis. Not transistor-level or PCB power.
* A_tia=100000 vos=0 vos_replica=None unmatched=False rout=0 Ileak=0
* shape: 16 -> 32 -> 16

Vin1 in1 0 DC 0
* passive invert in1 -> in1n: R2/R1=1.0000200002 closed-loop -1 at A=100000
Rinv1ia in1 inv1m 9995.68581775664
Rinv1ib in1n inv1m 9976.47485118482
Einv1amp in1n 0 0 inv1m 100000
* load-compensated divider in1->tap1: G_load=0.000710070664287583 Ra=584186.385313021 Rb=1000 target beta=0.001 (no tap buffer)
Rdiv1a in1 tap1 585481.553245392
Rdiv1b tap1 0 1001.34249343891
* load-compensated divider in1n->tap1n: G_load=0.00138944868118558 Ra=418088.075239315 Rb=1000 target beta=0.001 (no tap buffer)
Rdiv1na in1n tap1n 416752.930013447
Rdiv1nb tap1n 0 1001.43361221122
Vin2 in2 0 DC 0
* passive invert in2 -> in2n: R2/R1=1.0000200002 closed-loop -1 at A=100000
Rinv2ia in2 inv2m 9997.36472312998
Rinv2ib in2n inv2m 10000.1549925815
Einv2amp in2n 0 0 inv2m 100000
* load-compensated divider in2->tap2: G_load=0.000564213455228197 Ra=638659.638594056 Rb=1000 target beta=0.001 (no tap buffer)
Rdiv2a in2 tap2 641052.660131751
Rdiv2b tap2 0 998.378294415253
* load-compensated divider in2n->tap2n: G_load=0.000578042323514278 Ra=633062.868539065 Rb=1000 target beta=0.001 (no tap buffer)
Rdiv2na in2n tap2n 631965.659060942
Rdiv2nb tap2n 0 1002.67345435094
Vin3 in3 0 DC 0
* passive invert in3 -> in3n: R2/R1=1.0000200002 closed-loop -1 at A=100000
Rinv3ia in3 inv3m 10007.5109159738
Rinv3ib in3n inv3m 10008.7446355642
Einv3amp in3n 0 0 inv3m 100000
* load-compensated divider in3->tap3: G_load=0.000475353763139489 Ra=677125.734152175 Rb=1000 target beta=0.001 (no tap buffer)
Rdiv3a in3 tap3 675158.387720466
Rdiv3b tap3 0 1004.27658918518
Vin4 in4 0 DC 0
* passive invert in4 -> in4n: R2/R1=1.0000200002 closed-loop -1 at A=100000
Rinv4ia in4 inv4m 10006.8400604977
Rinv4ib in4n inv4m 10018.0455685893
Einv4amp in4n 0 0 inv4m 100000
* load-compensated divider in4->tap4: G_load=0.000604265102392725 Ra=622715.035382877 Rb=1000 target beta=0.001 (no tap buffer)
Rdiv4a in4 tap4 624211.857323965
Rdiv4b tap4 0 1001.76223669724
* load-compensated divider in4n->tap4n: G_load=0.000838243797048297 Ra=543453.486204666 Rb=1000 target beta=0.001 (no tap buffer)
Rdiv4na in4n tap4n 541862.29842506
Rdiv4nb tap4n 0 1004.48722754447
Vin5 in5 0 DC 0
* passive invert in5 -> in5n: R2/R1=1.0000200002 closed-loop -1 at A=100000
Rinv5ia in5 inv5m 9968.36603268399
Rinv5ib in5n inv5m 10017.0669157428
Einv5amp in5n 0 0 inv5m 100000
* load-compensated divider in5n->tap5n: G_load=0.000124571614130361 Ra=888338.268054662 Rb=1000 target beta=0.001 (no tap buffer)
Rdiv5na in5n tap5n 887901.006742021
Rdiv5nb tap5n 0 1000.11527897076
Vin6 in6 0 DC 0
* passive invert in6 -> in6n: R2/R1=1.0000200002 closed-loop -1 at A=100000
Rinv6ia in6 inv6m 9967.44458272565
Rinv6ib in6n inv6m 9959.97678941577
Einv6amp in6n 0 0 inv6m 100000
Vin7 in7 0 DC 0
* passive invert in7 -> in7n: R2/R1=1.0000200002 closed-loop -1 at A=100000
Rinv7ia in7 inv7m 9953.38683840112
Rinv7ib in7n inv7m 10032.0388299343
Einv7amp in7n 0 0 inv7m 100000
* load-compensated divider in7->tap7: G_load=0.000876983911873088 Ra=532236.847466142 Rb=1000 target beta=0.001 (no tap buffer)
Rdiv7a in7 tap7 532759.577820006
Rdiv7b tap7 0 1002.92908156969
* load-compensated divider in7n->tap7n: G_load=0.000379458526114055 Ra=724197.198457419 Rb=1000 target beta=0.001 (no tap buffer)
Rdiv7na in7n tap7n 722690.421647779
Rdiv7nb tap7n 0 996.152062815331
Vin8 in8 0 DC 0
* passive invert in8 -> in8n: R2/R1=1.0000200002 closed-loop -1 at A=100000
Rinv8ia in8 inv8m 9959.23070560485
Rinv8ib in8n inv8m 9974.50297447906
Einv8amp in8n 0 0 inv8m 100000
* load-compensated divider in8->tap8: G_load=0.00202030909723981 Ra=330760.848587637 Rb=1000 target beta=0.001 (no tap buffer)
Rdiv8a in8 tap8 329740.180733077
Rdiv8b tap8 0 1002.97778204526
Vin9 in9 0 DC 0
* passive invert in9 -> in9n: R2/R1=1.0000200002 closed-loop -1 at A=100000
Rinv9ia in9 inv9m 10016.697914668
Rinv9ib in9n inv9m 10039.035843387
Einv9amp in9n 0 0 inv9m 100000
* load-compensated divider in9n->tap9n: G_load=0.0021264464173835 Ra=319532.103427525 Rb=1000 target beta=0.001 (no tap buffer)
Rdiv9na in9n tap9n 319442.823226127
Rdiv9nb tap9n 0 1000.23691541851
Vin10 in10 0 DC 0
* passive invert in10 -> in10n: R2/R1=1.0000200002 closed-loop -1 at A=100000
Rinv10ia in10 inv10m 9971.86812188163
Rinv10ib in10n inv10m 10050.1988078195
Einv10amp in10n 0 0 inv10m 100000
* load-compensated divider in10->tap10: G_load=0.00154386072332109 Ra=392710.178997446 Rb=1000 target beta=0.001 (no tap buffer)
Rdiv10a in10 tap10 391609.744429173
Rdiv10b tap10 0 997.757879112744
* load-compensated divider in10n->tap10n: G_load=0.000661819331650786 Ra=601148.380556888 Rb=1000 target beta=0.001 (no tap buffer)
Rdiv10na in10n tap10n 600194.458673967
Rdiv10nb tap10n 0 1003.02421007705
Vin11 in11 0 DC 0
* passive invert in11 -> in11n: R2/R1=1.0000200002 closed-loop -1 at A=100000
Rinv11ia in11 inv11m 10016.9893900738
Rinv11ib in11n inv11m 9973.9174337475
Einv11amp in11n 0 0 inv11m 100000
* load-compensated divider in11->tap11: G_load=0.000923704741727117 Ra=519310.462947183 Rb=1000 target beta=0.001 (no tap buffer)
Rdiv11a in11 tap11 520651.107372656
Rdiv11b tap11 0 998.140264227561
Vin12 in12 0 DC 0
* passive invert in12 -> in12n: R2/R1=1.0000200002 closed-loop -1 at A=100000
Rinv12ia in12 inv12m 9972.82201950692
Rinv12ib in12n inv12m 10024.0291180072
Einv12amp in12n 0 0 inv12m 100000
* load-compensated divider in12n->tap12n: G_load=0.000192713812047279 Ra=837585.6721951 Rb=1000 target beta=0.001 (no tap buffer)
Rdiv12na in12n tap12n 840123.737738243
Rdiv12nb tap12n 0 999.728098488518
Vin13 in13 0 DC 0
* passive invert in13 -> in13n: R2/R1=1.0000200002 closed-loop -1 at A=100000
Rinv13ia in13 inv13m 10030.4561182388
Rinv13ib in13n inv13m 9995.61401299814
Einv13amp in13n 0 0 inv13m 100000
* load-compensated divider in13->tap13: G_load=0.00071375434054134 Ra=582930.689870309 Rb=1000 target beta=0.001 (no tap buffer)
Rdiv13a in13 tap13 584965.743577151
Rdiv13b tap13 0 1000.73220345189
* load-compensated divider in13n->tap13n: G_load=0.00155701882010588 Ra=390689.341879241 Rb=1000 target beta=0.001 (no tap buffer)
Rdiv13na in13n tap13n 389356.124472596
Rdiv13nb tap13n 0 998.853400057786
Vin14 in14 0 DC 0
* passive invert in14 -> in14n: R2/R1=1.0000200002 closed-loop -1 at A=100000
Rinv14ia in14 inv14m 9974.75154374109
Rinv14ib in14n inv14m 9980.51307028463
Einv14amp in14n 0 0 inv14m 100000
* load-compensated divider in14->tap14: G_load=0.000700934410618815 Ra=587324.234117032 Rb=1000 target beta=0.001 (no tap buffer)
Rdiv14a in14 tap14 585297.874624416
Rdiv14b tap14 0 997.835020076676
Vin15 in15 0 DC 0
* passive invert in15 -> in15n: R2/R1=1.0000200002 closed-loop -1 at A=100000
Rinv15ia in15 inv15m 9970.07152256541
Rinv15ib in15n inv15m 10043.8231293233
Einv15amp in15n 0 0 inv15m 100000
* load-compensated divider in15->tap15: G_load=0.00161191394702755 Ra=382478.144479797 Rb=1000 target beta=0.001 (no tap buffer)
Rdiv15a in15 tap15 380913.347265631
Rdiv15b tap15 0 1000.76373461454
Vin16 in16 0 DC 0
* passive invert in16 -> in16n: R2/R1=1.0000200002 closed-loop -1 at A=100000
Rinv16ia in16 inv16m 9991.39710886878
Rinv16ib in16n inv16m 10042.0270785917
Einv16amp in16n 0 0 inv16m 100000
* load-compensated divider in16n->tap16n: G_load=0.00225822429382311 Ra=306608.726076314 Rb=1000 target beta=0.001 (no tap buffer)
Rdiv16na in16n tap16n 305424.291986764
Rdiv16nb tap16n 0 1002.42855416813
Vref vref 0 DC 1
* passive invert vref -> vrefn: R2/R1=1.0000200002 closed-loop -1 at A=100000
Rinvrefia vref invrefm 9979.26303370852
Rinvrefib vrefn invrefm 9959.33323255687
Einvrefamp vrefn 0 0 invrefm 100000
* load-compensated divider vref->tapref: G_load=0.00551473635150906 Ra=153344.655270446 Rb=1000 target beta=0.001 (no tap buffer)
Rdivrefa vref tapref 153162.245625615
Rdivrefb tapref 0 998.913652460577
* load-compensated divider vrefn->taprefn: G_load=0.00666252414777637 Ra=130374.79304909 Rb=1000 target beta=0.001 (no tap buffer)
Rdivrefna vrefn taprefn 130884.780021271
Rdivrefnb taprefn 0 1001.1481858035

* h1 input 1 w=-0.0168555731920106 w-  bank=f alpha=0.001 R=1977.58527423636 G_phys=0.000505667195760317 G_eff=5.05667195760317e-07
Rh1n1f1 tap1 h1p 1984.64010697771
* h1 input 2 w=+0.167421682129858 w+  bank=n alpha=1 R=199098.067283059 G_phys=5.02265046389574e-06 G_eff=5.02265046389574e-06
Rh1p2n1 in2n h1p 198632.861281095
* h1 input 3 w=-0.175338604042315 w-  bank=n alpha=1 R=190108.353579049 G_phys=5.26015812126946e-06 G_eff=5.26015812126946e-06
Rh1n3n1 in3 h1p 190642.516452754
* h1 input 4 w=-0.3026243730549 w-  bank=n alpha=1 R=110147.55023478 G_phys=9.078731191647e-06 G_eff=9.078731191647e-06
Rh1n4n1 in4 h1p 110355.521313225
* h1 input 5 w=-0.0731653551060092 w-  bank=n alpha=1 R=455589.032336913 G_phys=2.19496065318027e-06 G_eff=2.19496065318027e-06
Rh1n5n1 in5 h1p 454486.054725745
* h1 input 6 w=+0.135452999280782 w+  bank=n alpha=1 R=246087.820205711 G_phys=4.06358997842346e-06 G_eff=4.06358997842346e-06
Rh1p6n1 in6n h1p 246309.484050777
* h1 input 7 w=+0.21541693193391 w+  bank=n alpha=1 R=154738.687595643 G_phys=6.46250795801731e-06 G_eff=6.46250795801731e-06
Rh1p7n1 in7n h1p 155191.665631632
* h1 input 8 w=-0.0225117532106789 w-  bank=f alpha=0.001 R=1480.70801156087 G_phys=0.000675352596320366 G_eff=6.75352596320366e-07
Rh1n8f1 tap8 h1p 1479.03920726091
* h1 input 9 w=-0.120865686071453 w-  bank=n alpha=1 R=275788.227550601 G_phys=3.62597058214359e-06 G_eff=3.62597058214359e-06
Rh1n9n1 in9 h1p 276405.176176563
* h1 input 10 w=+0.732018397911567 w+  bank=n alpha=1 R=45536.19612353 G_phys=2.1960551937347e-05 G_eff=2.1960551937347e-05
Rh1p10n1 in10n h1p 45310.2806359976
* h1 input 11 w=+0.435334885703784 w+  bank=n alpha=1 R=76569.405365814 G_phys=1.30600465711135e-05 G_eff=1.30600465711135e-05
Rh1p11n1 in11n h1p 76556.4613602206
* h1 input 12 w=+0.385479984810207 w+  bank=n alpha=1 R=86472.2803954274 G_phys=1.15643995443062e-05 G_eff=1.15643995443062e-05
Rh1p12n1 in12n h1p 86881.720171304
* h1 input 13 w=-0.42800728852471 w-  bank=n alpha=1 R=77880.2936936643 G_phys=1.28402186557413e-05 G_eff=1.28402186557413e-05
Rh1n13n1 in13 h1p 78224.2519251713
* h1 input 14 w=+0.104452911276431 w+  bank=n alpha=1 R=319123.066327159 G_phys=3.13358733829293e-06 G_eff=3.13358733829293e-06
Rh1p14n1 in14n h1p 319143.832952664
* h1 input 15 w=-0.361295245628978 w-  bank=n alpha=1 R=92260.6475911506 G_phys=1.08388573688693e-05 G_eff=1.08388573688693e-05
Rh1n15n1 in15 h1p 92578.4591774445
* h1 input 16 w=+0.0759383856082483 w+  bank=n alpha=1 R=438952.356786904 G_phys=2.27815156824745e-06 G_eff=2.27815156824745e-06
Rh1p16n1 in16n h1p 437927.630964776
* h1 bias w-  bank=n alpha=1 R=365943.245315286 G_phys=2.73266418441043e-06 G_eff=2.73266418441043e-06
Rh1bnn1 vref h1p 367594.312027675
* replica dummy G_tot for h1: same R as weights/biases, dest=0
Rh1dmy000 0 h1rp 1985.90616583123
Rh1dmy001 0 h1rp 198775.346466302
Rh1dmy002 0 h1rp 189706.125601429
Rh1dmy003 0 h1rp 109905.664478754
Rh1dmy004 0 h1rp 454552.884757158
Rh1dmy005 0 h1rp 246044.732252727
Rh1dmy006 0 h1rp 155488.506745456
Rh1dmy007 0 h1rp 1484.44228422273
Rh1dmy008 0 h1rp 274923.239366576
Rh1dmy009 0 h1rp 45514.1257551429
Rh1dmy010 0 h1rp 76831.6017991523
Rh1dmy011 0 h1rp 86715.0107814729
Rh1dmy012 0 h1rp 78227.0355026309
Rh1dmy013 0 h1rp 320088.967854704
Rh1dmy014 0 h1rp 92205.9088390527
Rh1dmy015 0 h1rp 437725.614092579
Rh1dmy016 0 h1rp 365089.980850996
* feedback TIA h1: Rf=33333.3333333333 A=100000 V(h1sig) = -I(h1p)*Rf*A/(A+1)  (uncompensated)
Eh1tia h1sig 0 0 h1p 100000
Rh1f h1sig h1p 33362.3016834951
* feedback TIA h1r: Rf=33333.3333333333 A=100000 V(h1rep) = -I(h1rp)*Rf*A/(A+1)  (uncompensated)
Eh1rtia h1rep 0 0 h1rp 100000
Rh1rf h1rep h1rp 33337.6564543873
* replica null h1: v(h1lin)=v(h1sig)-v(h1rep) Vos_sig=0 Vos_rep=0
Eh1null h1lin 0 h1sig h1rep 1
* direct bounded ReLU: y=max(0, min(15, v(h1lin)))
Bh1relu h1y 0 V = max(0, min(15, v(h1lin)))

* h2 input 1 w=+0.0248542194622879 w+  bank=f alpha=0.001 R=1341.15389879417 G_phys=0.000745626583868636 G_eff=7.45626583868636e-07
Rh2p1f1 tap1n h2p 1347.74962935938
* h2 input 2 w=+0.400223191665755 w+  bank=n alpha=1 R=83286.8610002279 G_phys=1.20066957499727e-05 G_eff=1.20066957499727e-05
Rh2p2n1 in2n h2p 83018.7718435399
* h2 input 3 w=+0.358260577298724 w+  bank=n alpha=1 R=93042.1471004872 G_phys=1.07478173189617e-05 G_eff=1.07478173189617e-05
Rh2p3n1 in3n h2p 93042.1951240429
* h2 input 4 w=+0.348073132477087 w+  bank=n alpha=1 R=95765.315455733 G_phys=1.04421939743126e-05 G_eff=1.04421939743126e-05
Rh2p4n1 in4n h2p 95457.8451814891
* h2 input 5 w=-0.489776715185261 w-  bank=n alpha=1 R=68058.2238800895 G_phys=1.46933014555578e-05 G_eff=1.46933014555578e-05
Rh2n5n1 in5 h2p 67824.0886216581
* h2 input 6 w=-0.262585224656684 w-  bank=n alpha=1 R=126942.913017726 G_phys=7.87755673970051e-06 G_eff=7.87755673970051e-06
Rh2n6n1 in6 h2p 126414.472899944
* h2 input 7 w=+0.634452480443638 w+  bank=n alpha=1 R=52538.7390873232 G_phys=1.90335744133091e-05 G_eff=1.90335744133091e-05
Rh2p7n1 in7n h2p 52440.3824382324
* h2 input 8 w=-0.0150494358056585 w-  bank=f alpha=0.001 R=2214.92245714621 G_phys=0.000451483074169756 G_eff=4.51483074169756e-07
Rh2n8f1 tap8 h2p 2205.36287817998
* h2 input 9 w=+0.317089980091076 w+  bank=n alpha=1 R=105122.632142962 G_phys=9.51269940273229e-06 G_eff=9.51269940273229e-06
Rh2p9n1 in9n h2p 105384.796919387
* h2 input 10 w=-0.171694565495531 w-  bank=n alpha=1 R=194143.2056229 G_phys=5.15083696486594e-06 G_eff=5.15083696486594e-06
Rh2n10n1 in10 h2p 193274.59558911
* h2 input 11 w=+0.113535277026032 w+  bank=n alpha=1 R=293594.503897589 G_phys=3.40605831078097e-06 G_eff=3.40605831078097e-06
Rh2p11n1 in11n h2p 294981.463715434
* h2 input 12 w=+0.342235951147447 w+  bank=n alpha=1 R=97398.6900603912 G_phys=1.02670785344234e-05 G_eff=1.02670785344234e-05
Rh2p12n1 in12n h2p 97217.4724391388
* h2 input 13 w=-0.268945400148547 w-  bank=n alpha=1 R=123940.89400645 G_phys=8.0683620044564e-06 G_eff=8.0683620044564e-06
Rh2n13n1 in13 h2p 124512.738185229
* h2 input 14 w=+0.239258603190851 w+  bank=n alpha=1 R=139319.267473714 G_phys=7.17775809572554e-06 G_eff=7.17775809572554e-06
Rh2p14n1 in14n h2p 138782.54622537
* h2 input 15 w=+0.347826837541335 w+  bank=n alpha=1 R=95833.1265320264 G_phys=1.043480512624e-05 G_eff=1.043480512624e-05
Rh2p15n1 in15n h2p 96181.0214686756
* h2 input 16 w=+0.00438097035906581 w+  bank=f alpha=0.001 R=7608.66442849918 G_phys=0.000131429110771974 G_eff=1.31429110771974e-07
Rh2p16f1 tap16n h2p 7622.72250713637
* h2 bias w-  bank=n alpha=1 R=664931.752911819 G_phys=1.50391374095293e-06 G_eff=1.50391374095293e-06
Rh2bnn1 vref h2p 663116.674125553
* replica dummy G_tot for h2: same R as weights/biases, dest=0
Rh2dmy000 0 h2rp 1335.60639092088
Rh2dmy001 0 h2rp 82988.1865293129
Rh2dmy002 0 h2rp 93054.5159404315
Rh2dmy003 0 h2rp 95880.4361949328
Rh2dmy004 0 h2rp 67786.8369358242
Rh2dmy005 0 h2rp 127356.347377074
Rh2dmy006 0 h2rp 52309.0166863312
Rh2dmy007 0 h2rp 2218.49774193879
Rh2dmy008 0 h2rp 104991.964366436
Rh2dmy009 0 h2rp 194203.988033663
Rh2dmy010 0 h2rp 294747.589869448
Rh2dmy011 0 h2rp 97656.2632505737
Rh2dmy012 0 h2rp 124259.917578675
Rh2dmy013 0 h2rp 139240.145618
Rh2dmy014 0 h2rp 95820.5282410211
Rh2dmy015 0 h2rp 7614.2441994276
Rh2dmy016 0 h2rp 662735.850697742
* feedback TIA h2: Rf=33333.3333333333 A=100000 V(h2sig) = -I(h2p)*Rf*A/(A+1)  (uncompensated)
Eh2tia h2sig 0 0 h2p 100000
Rh2f h2sig h2p 33494.0842544711
* feedback TIA h2r: Rf=33333.3333333333 A=100000 V(h2rep) = -I(h2rp)*Rf*A/(A+1)  (uncompensated)
Eh2rtia h2rep 0 0 h2rp 100000
Rh2rf h2rep h2rp 33422.2588253222
* replica null h2: v(h2lin)=v(h2sig)-v(h2rep) Vos_sig=0 Vos_rep=0
Eh2null h2lin 0 h2sig h2rep 1
* direct bounded ReLU: y=max(0, min(15, v(h2lin)))
Bh2relu h2y 0 V = max(0, min(15, v(h2lin)))

* h3 input 1 w=-0.916033562434709 w-  bank=n alpha=1 R=36388.7686000689 G_phys=2.74810068730413e-05 G_eff=2.74810068730413e-05
Rh3n1n1 in1 h3p 36345.8013604158
* h3 input 2 w=+0.507521982744407 w+  bank=n alpha=1 R=65678.6000738028 G_phys=1.52256594823322e-05 G_eff=1.52256594823322e-05
Rh3p2n1 in2n h3p 65551.1192595044
* h3 input 3 w=+0.0871477019742823 w+  bank=n alpha=1 R=382492.395991924 G_phys=2.61443105922847e-06 G_eff=2.61443105922847e-06
Rh3p3n1 in3n h3p 382380.330515324
* h3 input 4 w=-0.0658557100969535 w-  bank=n alpha=1 R=506157.071030889 G_phys=1.97567130290861e-06 G_eff=1.97567130290861e-06
Rh3n4n1 in4 h3p 503809.459672163
* h3 input 5 w=-0.179053685151098 w-  bank=n alpha=1 R=186163.905563878 G_phys=5.37161055453294e-06 G_eff=5.37161055453294e-06
Rh3n5n1 in5 h3p 186971.797448504
* h3 input 6 w=+0.315007728496672 w+  bank=n alpha=1 R=105817.509597024 G_phys=9.45023185490017e-06 G_eff=9.45023185490017e-06
Rh3p6n1 in6n h3p 105333.683242398
* h3 input 7 w=+0.677608935484657 w+  bank=n alpha=1 R=49192.5823107569 G_phys=2.03282680645397e-05 G_eff=2.03282680645397e-05
Rh3p7n1 in7n h3p 48990.1118963233
* h3 input 8 w=+0.295351776524173 w+  bank=n alpha=1 R=112859.769206789 G_phys=8.8605532957252e-06 G_eff=8.8605532957252e-06
Rh3p8n1 in8n h3p 112974.999258311
* h3 input 9 w=+0.00172302579693755 w+  bank=f alpha=0.001 R=19345.8121129578 G_phys=5.16907739081266e-05 G_eff=5.16907739081266e-08
Rh3p9f1 tap9n h3p 19258.3518228824
* h3 input 10 w=+0.317835264102281 w+  bank=n alpha=1 R=104876.132695604 G_phys=9.53505792306844e-06 G_eff=9.53505792306844e-06
Rh3p10n1 in10n h3p 104745.645075526
* h3 input 11 w=-0.530129158700576 w-  bank=n alpha=1 R=62877.7587240027 G_phys=1.59038747610173e-05 G_eff=1.59038747610173e-05
Rh3n11n1 in11 h3p 62799.5528664203
* h3 input 12 w=-0.291249394999097 w-  bank=n alpha=1 R=114449.450902505 G_phys=8.7374818499729e-06 G_eff=8.7374818499729e-06
Rh3n12n1 in12 h3p 114048.510527008
* h3 input 13 w=-0.395820894073244 w-  bank=n alpha=1 R=84213.1727567804 G_phys=1.18746268221973e-05 G_eff=1.18746268221973e-05
Rh3n13n1 in13 h3p 84238.1938485985
* h3 input 14 w=-0.0451489915790311 w-  bank=n alpha=1 R=738296.297825057 G_phys=1.35446974737093e-06 G_eff=1.35446974737093e-06
Rh3n14n1 in14 h3p 739152.991332898
* h3 input 15 w=+0.0633187763010491 w+  bank=n alpha=1 R=526436.789852823 G_phys=1.89956328903147e-06 G_eff=1.89956328903147e-06
Rh3p15n1 in15n h3p 526136.36773571
* h3 input 16 w=-0.149745176344707 w-  bank=n alpha=1 R=222600.381174225 G_phys=4.49235529034122e-06 G_eff=4.49235529034122e-06
Rh3n16n1 in16 h3p 221782.810534738
* h3 bias w-  bank=n alpha=1 R=602168.780003591 G_phys=1.66066397529616e-06 G_eff=1.66066397529616e-06
Rh3bnn1 vref h3p 600787.162899255
* replica dummy G_tot for h3: same R as weights/biases, dest=0
Rh3dmy000 0 h3rp 36331.3147706574
Rh3dmy001 0 h3rp 65893.8574393611
Rh3dmy002 0 h3rp 382089.208098474
Rh3dmy003 0 h3rp 504241.703752429
Rh3dmy004 0 h3rp 186269.917943415
Rh3dmy005 0 h3rp 105484.573722581
Rh3dmy006 0 h3rp 49199.4001760403
Rh3dmy007 0 h3rp 112451.006776995
Rh3dmy008 0 h3rp 19287.0560370608
Rh3dmy009 0 h3rp 104697.178966555
Rh3dmy010 0 h3rp 62891.0676258593
Rh3dmy011 0 h3rp 114183.042417734
Rh3dmy012 0 h3rp 84444.0792561917
Rh3dmy013 0 h3rp 741884.021030383
Rh3dmy014 0 h3rp 525753.320003832
Rh3dmy015 0 h3rp 223120.424981394
Rh3dmy016 0 h3rp 602964.921924238
* feedback TIA h3: Rf=33333.3333333333 A=100000 V(h3sig) = -I(h3p)*Rf*A/(A+1)  (uncompensated)
Eh3tia h3sig 0 0 h3p 100000
Rh3f h3sig h3p 33174.8738278059
* feedback TIA h3r: Rf=33333.3333333333 A=100000 V(h3rep) = -I(h3rp)*Rf*A/(A+1)  (uncompensated)
Eh3rtia h3rep 0 0 h3rp 100000
Rh3rf h3rep h3rp 33347.1253134615
* replica null h3: v(h3lin)=v(h3sig)-v(h3rep) Vos_sig=0 Vos_rep=0
Eh3null h3lin 0 h3sig h3rep 1
* direct bounded ReLU: y=max(0, min(15, v(h3lin)))
Bh3relu h3y 0 V = max(0, min(15, v(h3lin)))

* h4 input 1 w=+0.0673940677866904 w+  bank=n alpha=1 R=494603.374273786 G_phys=2.02182203360071e-06 G_eff=2.02182203360071e-06
Rh4p1n1 in1n h4p 496489.612099885
* h4 input 2 w=-0.087995350925692 w-  bank=n alpha=1 R=378807.891356463 G_phys=2.63986052777076e-06 G_eff=2.63986052777076e-06
Rh4n2n1 in2 h4p 378408.338060619
* h4 input 3 w=-0.354237391786533 w-  bank=n alpha=1 R=94098.8560389478 G_phys=1.0627121753596e-05 G_eff=1.0627121753596e-05
Rh4n3n1 in3 h4p 93637.2478009853
* h4 input 4 w=-0.0201421700797575 w-  bank=f alpha=0.001 R=1654.90278362969 G_phys=0.000604265102392725 G_eff=6.04265102392725e-07
Rh4n4f1 tap4 h4p 1651.7999521408
* h4 input 5 w=-0.808084436849872 w-  bank=n alpha=1 R=41249.814763511 G_phys=2.42425331054962e-05 G_eff=2.42425331054962e-05
Rh4n5n1 in5 h4p 41391.0162647865
* h4 input 6 w=-0.290030636557288 w-  bank=n alpha=1 R=114930.387110153 G_phys=8.70091909671864e-06 G_eff=8.70091909671864e-06
Rh4n6n1 in6 h4p 114482.211166092
* h4 input 7 w=+0.344262354214072 w+  bank=n alpha=1 R=96825.3801942158 G_phys=1.03278706264222e-05 G_eff=1.03278706264222e-05
Rh4p7n1 in7n h4p 97235.1568055031
* h4 input 8 w=-0.872472737770673 w-  bank=n alpha=1 R=38205.5872811637 G_phys=2.61741821331202e-05 G_eff=2.61741821331202e-05
Rh4n8n1 in8 h4p 38101.3295803404
* h4 input 9 w=+0.163024654235771 w+  bank=n alpha=1 R=204468.051103029 G_phys=4.89073962707314e-06 G_eff=4.89073962707314e-06
Rh4p9n1 in9n h4p 204276.287865632
* h4 input 10 w=-0.143734302026109 w-  bank=n alpha=1 R=231909.383240185 G_phys=4.31202906078326e-06 G_eff=4.31202906078326e-06
Rh4n10n1 in10 h4p 231889.160543632
* h4 input 11 w=-0.110414936368951 w-  bank=n alpha=1 R=301891.523280421 G_phys=3.31244809106853e-06 G_eff=3.31244809106853e-06
Rh4n11n1 in11 h4p 302465.604878414
* h4 input 12 w=+0.321561566587255 w+  bank=n alpha=1 R=103660.812724298 G_phys=9.64684699761765e-06 G_eff=9.64684699761765e-06
Rh4p12n1 in12n h4p 103719.189183741
* h4 input 13 w=-0.501486514423905 w-  bank=n alpha=1 R=66469.0522568205 G_phys=1.50445954327172e-05 G_eff=1.50445954327172e-05
Rh4n13n1 in13 h4p 66462.1545839133
* h4 input 14 w=-0.0233644803539605 w-  bank=f alpha=0.001 R=1426.66701028012 G_phys=0.000700934410618815 G_eff=7.00934410618815e-07
Rh4n14f1 tap14 h4p 1429.64477956838
* h4 input 15 w=-0.211065663454959 w-  bank=n alpha=1 R=157928.735483053 G_phys=6.33196990364878e-06 G_eff=6.33196990364878e-06
Rh4n15n1 in15 h4p 157299.822581945
* h4 input 16 w=+0.18002446765288 w+  bank=n alpha=1 R=185160.016124064 G_phys=5.40073402958641e-06 G_eff=5.40073402958641e-06
Rh4p16n1 in16n h4p 184557.480043717
* h4 bias w+  bank=n alpha=1 R=704963.006730694 G_phys=1.41851414961128e-06 G_eff=1.41851414961128e-06
Rh4bpn1 vrefn h4p 707292.188860085
* replica dummy G_tot for h4: same R as weights/biases, dest=0
Rh4dmy000 0 h4rp 495483.331758088
Rh4dmy001 0 h4rp 379464.779864387
Rh4dmy002 0 h4rp 93690.7263613133
Rh4dmy003 0 h4rp 1659.14023537718
Rh4dmy004 0 h4rp 41260.6431925575
Rh4dmy005 0 h4rp 115404.289849745
Rh4dmy006 0 h4rp 97198.1664851104
Rh4dmy007 0 h4rp 38157.3351110893
Rh4dmy008 0 h4rp 204174.779137687
Rh4dmy009 0 h4rp 232671.264804841
Rh4dmy010 0 h4rp 301469.462742292
Rh4dmy011 0 h4rp 104137.110336177
Rh4dmy012 0 h4rp 66717.8592743664
Rh4dmy013 0 h4rp 1426.67723836802
Rh4dmy014 0 h4rp 158363.638791156
Rh4dmy015 0 h4rp 185669.741164273
Rh4dmy016 0 h4rp 706638.486338955
* feedback TIA h4: Rf=33333.3333333333 A=100000 V(h4sig) = -I(h4p)*Rf*A/(A+1)  (uncompensated)
Eh4tia h4sig 0 0 h4p 100000
Rh4f h4sig h4p 33404.6709985469
* feedback TIA h4r: Rf=33333.3333333333 A=100000 V(h4rep) = -I(h4rp)*Rf*A/(A+1)  (uncompensated)
Eh4rtia h4rep 0 0 h4rp 100000
Rh4rf h4rep h4rp 33217.9087882362
* replica null h4: v(h4lin)=v(h4sig)-v(h4rep) Vos_sig=0 Vos_rep=0
Eh4null h4lin 0 h4sig h4rep 1
* direct bounded ReLU: y=max(0, min(15, v(h4lin)))
Bh4relu h4y 0 V = max(0, min(15, v(h4lin)))

* h5 input 1 w=-0.122756848133934 w-  bank=n alpha=1 R=271539.501380525 G_phys=3.68270544401802e-06 G_eff=3.68270544401802e-06
Rh5n1n1 in1 h5p 270728.43201604
* h5 input 2 w=+0.794704720471975 w+  bank=n alpha=1 R=41944.300159104 G_phys=2.38411416141592e-05 G_eff=2.38411416141592e-05
Rh5p2n1 in2n h5p 41865.671947788
* h5 input 3 w=-0.26372184795707 w-  bank=n alpha=1 R=126395.797661631 G_phys=7.91165543871211e-06 G_eff=7.91165543871211e-06
Rh5n3n1 in3 h5p 126038.925963023
* h5 input 4 w=+0.65217090039031 w+  bank=n alpha=1 R=51111.3472149464 G_phys=1.95651270117093e-05 G_eff=1.95651270117093e-05
Rh5p4n1 in4n h5p 51171.2989836623
* h5 input 5 w=-0.272670344884174 w-  bank=n alpha=1 R=122247.739656077 G_phys=8.18011034652521e-06 G_eff=8.18011034652521e-06
Rh5n5n1 in5 h5p 122062.884044199
* h5 input 6 w=+0.0607101548077554 w+  bank=n alpha=1 R=549056.964833751 G_phys=1.82130464423266e-06 G_eff=1.82130464423266e-06
Rh5p6n1 in6n h5p 550879.801897538
* h5 input 7 w=+0.629980287413506 w+  bank=n alpha=1 R=52911.7085078791 G_phys=1.88994086224052e-05 G_eff=1.88994086224052e-05
Rh5p7n1 in7n h5p 53066.5206480819
* h5 input 8 w=-0.369402487956774 w-  bank=n alpha=1 R=90235.8116690157 G_phys=1.10820746387032e-05 G_eff=1.10820746387032e-05
Rh5n8n1 in8 h5p 90367.209083487
* h5 input 9 w=-0.0924511829208223 w-  bank=n alpha=1 R=360550.641757401 G_phys=2.77353548762467e-06 G_eff=2.77353548762467e-06
Rh5n9n1 in9 h5p 361412.83021477
* h5 input 10 w=-0.00426485730080124 w-  bank=f alpha=0.001 R=7815.81445340996 G_phys=0.000127945719024037 G_eff=1.27945719024037e-07
Rh5n10f1 tap10 h5p 7853.4824604697
* h5 input 11 w=+0.540478898079688 w+  bank=n alpha=1 R=61673.6998461292 G_phys=1.62143669423906e-05 G_eff=1.62143669423906e-05
Rh5p11n1 in11n h5p 61666.5194250619
* h5 input 12 w=+0.161688921548601 w+  bank=n alpha=1 R=206157.187604928 G_phys=4.85066764645802e-06 G_eff=4.85066764645802e-06
Rh5p12n1 in12n h5p 206967.079935812
* h5 input 13 w=+0.0259557799028364 w+  bank=f alpha=0.001 R=1284.23547503154 G_phys=0.000778673397085092 G_eff=7.78673397085092e-07
Rh5p13f1 tap13n h5p 1280.73848237511
* h5 input 14 w=+0.470073429319239 w+  bank=n alpha=1 R=70910.907220616 G_phys=1.41022028795772e-05 G_eff=1.41022028795772e-05
Rh5p14n1 in14n h5p 70625.4258202572
* h5 input 15 w=+0.188749264833093 w+  bank=n alpha=1 R=176601.129349083 G_phys=5.66247794499279e-06 G_eff=5.66247794499279e-06
Rh5p15n1 in15n h5p 176984.347983404
* h5 input 16 w=+0.031866913791992 w+  bank=f alpha=0.001 R=1046.01699276288 G_phys=0.000956007413759761 G_eff=9.56007413759761e-07
Rh5p16f1 tap16n h5p 1049.60556780554
* h5 bias w+  bank=f alpha=0.001 R=1837.62567566174 G_phys=0.000544180467896375 G_eff=5.44180467896375e-07
Rh5bpf1 taprefn h5p 1840.12184924587
* replica dummy G_tot for h5: same R as weights/biases, dest=0
Rh5dmy000 0 h5rp 272240.428086472
Rh5dmy001 0 h5rp 41884.1100644623
Rh5dmy002 0 h5rp 126811.223723349
Rh5dmy003 0 h5rp 51222.3628674753
Rh5dmy004 0 h5rp 122342.290662496
Rh5dmy005 0 h5rp 548442.801158805
Rh5dmy006 0 h5rp 53056.5805067299
Rh5dmy007 0 h5rp 90645.5856074908
Rh5dmy008 0 h5rp 360174.781729604
Rh5dmy009 0 h5rp 7836.08880400702
Rh5dmy010 0 h5rp 61511.7750862716
Rh5dmy011 0 h5rp 207001.809392204
Rh5dmy012 0 h5rp 1288.6568883277
Rh5dmy013 0 h5rp 70759.1679192682
Rh5dmy014 0 h5rp 176518.065374656
Rh5dmy015 0 h5rp 1047.6187100705
Rh5dmy016 0 h5rp 1842.98073446366
* feedback TIA h5: Rf=33333.3333333333 A=100000 V(h5sig) = -I(h5p)*Rf*A/(A+1)  (uncompensated)
Eh5tia h5sig 0 0 h5p 100000
Rh5f h5sig h5p 33186.0941874588
* feedback TIA h5r: Rf=33333.3333333333 A=100000 V(h5rep) = -I(h5rp)*Rf*A/(A+1)  (uncompensated)
Eh5rtia h5rep 0 0 h5rp 100000
Rh5rf h5rep h5rp 33397.0780814559
* replica null h5: v(h5lin)=v(h5sig)-v(h5rep) Vos_sig=0 Vos_rep=0
Eh5null h5lin 0 h5sig h5rep 1
* direct bounded ReLU: y=max(0, min(15, v(h5lin)))
Bh5relu h5y 0 V = max(0, min(15, v(h5lin)))

* h6 input 1 w=-0.340583473625464 w-  bank=n alpha=1 R=97871.2589266431 G_phys=1.02175042087639e-05 G_eff=1.02175042087639e-05
Rh6n1n1 in1 h6p 98317.4821122022
* h6 input 2 w=-0.593797589144587 w-  bank=n alpha=1 R=56135.8515809279 G_phys=1.78139276743376e-05 G_eff=1.78139276743376e-05
Rh6n2n1 in2 h6p 56306.6997019618
* h6 input 3 w=-0.388639564922933 w-  bank=n alpha=1 R=85769.2740057059 G_phys=1.1659186947688e-05 G_eff=1.1659186947688e-05
Rh6n3n1 in3 h6p 85932.8124696806
* h6 input 4 w=+0.284617429170421 w+  bank=n alpha=1 R=117116.275803947 G_phys=8.53852287511263e-06 G_eff=8.53852287511263e-06
Rh6p4n1 in4n h6p 116580.306837141
* h6 input 5 w=-0.270576674342045 w-  bank=n alpha=1 R=123193.669278364 G_phys=8.11730023026134e-06 G_eff=8.11730023026134e-06
Rh6n5n1 in5 h6p 122937.006091784
* h6 input 6 w=+0.0593082278184784 w+  bank=n alpha=1 R=562035.565037534 G_phys=1.77924683455435e-06 G_eff=1.77924683455435e-06
Rh6p6n1 in6n h6p 559824.216296019
* h6 input 7 w=+0.460681196235491 w+  bank=n alpha=1 R=72356.6179946576 G_phys=1.38204358870647e-05 G_eff=1.38204358870647e-05
Rh6p7n1 in7n h6p 72334.6054205304
* h6 input 8 w=+0.530418434730864 w+  bank=n alpha=1 R=62843.46687582 G_phys=1.59125530419259e-05 G_eff=1.59125530419259e-05
Rh6p8n1 in8n h6p 62947.5696373848
* h6 input 9 w=+0.069052799324409 w+  bank=n alpha=1 R=482722.40458687 G_phys=2.07158397973227e-06 G_eff=2.07158397973227e-06
Rh6p9n1 in9n h6p 482008.624174979
* h6 input 10 w=+0.150678240315211 w+  bank=n alpha=1 R=221221.944612585 G_phys=4.52034720945633e-06 G_eff=4.52034720945633e-06
Rh6p10n1 in10n h6p 220183.906586577
* h6 input 11 w=+0.0896190095447204 w+  bank=n alpha=1 R=371944.897658123 G_phys=2.68857028634161e-06 G_eff=2.68857028634161e-06
Rh6p11n1 in11n h6p 373242.539173665
* h6 input 12 w=-0.177342454994274 w-  bank=n alpha=1 R=187960.256524077 G_phys=5.32027364982823e-06 G_eff=5.32027364982823e-06
Rh6n12n1 in12 h6p 188215.057729447
* h6 input 13 w=+0.643544080066549 w+  bank=n alpha=1 R=51796.5037140678 G_phys=1.93063224019965e-05 G_eff=1.93063224019965e-05
Rh6p13n1 in13n h6p 51950.3454460041
* h6 input 14 w=+0.0993069474158396 w+  bank=n alpha=1 R=335659.63108052 G_phys=2.97920842247519e-06 G_eff=2.97920842247519e-06
Rh6p14n1 in14n h6p 334737.167498128
* h6 input 15 w=-0.324176483950696 w-  bank=n alpha=1 R=102824.649484455 G_phys=9.72529451852089e-06 G_eff=9.72529451852089e-06
Rh6n15n1 in15 h6p 103256.472497471
* h6 input 16 w=+0.0932186969347454 w+  bank=n alpha=1 R=357582.056276406 G_phys=2.79656090804236e-06 G_eff=2.79656090804236e-06
Rh6p16n1 in16n h6p 358424.494560337
* h6 bias w-  bank=f alpha=0.001 R=1678.78030803583 G_phys=0.000595670556304058 G_eff=5.95670556304058e-07
Rh6bnf1 tapref h6p 1684.34319765839
* replica dummy G_tot for h6: same R as weights/biases, dest=0
Rh6dmy000 0 h6rp 97816.9941770127
Rh6dmy001 0 h6rp 56290.1416497333
Rh6dmy002 0 h6rp 85857.7464164341
Rh6dmy003 0 h6rp 117585.982041659
Rh6dmy004 0 h6rp 122941.531654485
Rh6dmy005 0 h6rp 561386.839883907
Rh6dmy006 0 h6rp 72469.8109644687
Rh6dmy007 0 h6rp 62825.1216689115
Rh6dmy008 0 h6rp 483523.043112487
Rh6dmy009 0 h6rp 221722.941103881
Rh6dmy010 0 h6rp 371980.770903259
Rh6dmy011 0 h6rp 188109.9348955
Rh6dmy012 0 h6rp 51614.2847710236
Rh6dmy013 0 h6rp 335069.648308954
Rh6dmy014 0 h6rp 102326.060231244
Rh6dmy015 0 h6rp 358200.722325289
Rh6dmy016 0 h6rp 1677.4974994788
* feedback TIA h6: Rf=33333.3333333333 A=100000 V(h6sig) = -I(h6p)*Rf*A/(A+1)  (uncompensated)
Eh6tia h6sig 0 0 h6p 100000
Rh6f h6sig h6p 33405.0147537112
* feedback TIA h6r: Rf=33333.3333333333 A=100000 V(h6rep) = -I(h6rp)*Rf*A/(A+1)  (uncompensated)
Eh6rtia h6rep 0 0 h6rp 100000
Rh6rf h6rep h6rp 33227.6425846865
* replica null h6: v(h6lin)=v(h6sig)-v(h6rep) Vos_sig=0 Vos_rep=0
Eh6null h6lin 0 h6sig h6rep 1
* direct bounded ReLU: y=max(0, min(15, v(h6lin)))
Bh6relu h6y 0 V = max(0, min(15, v(h6lin)))

* h7 input 1 w=+0.32217720874051 w+  bank=n alpha=1 R=103462.729296227 G_phys=9.6653162622153e-06 G_eff=9.6653162622153e-06
Rh7p1n1 in1n h7p 103315.415308535
* h7 input 2 w=-0.146738476402048 w-  bank=n alpha=1 R=227161.50631143 G_phys=4.40215429206143e-06 G_eff=4.40215429206143e-06
Rh7n2n1 in2 h7p 226081.972918042
* h7 input 3 w=+0.524171111363509 w+  bank=n alpha=1 R=63592.4655340589 G_phys=1.57251333409053e-05 G_eff=1.57251333409053e-05
Rh7p3n1 in3n h7p 63318.6237725566
* h7 input 4 w=-0.439531494343149 w-  bank=n alpha=1 R=75838.3273151968 G_phys=1.31859448302945e-05 G_eff=1.31859448302945e-05
Rh7n4n1 in4 h7p 76131.2890888731
* h7 input 5 w=+0.367500929015048 w+  bank=n alpha=1 R=90702.718555491 G_phys=1.10250278704514e-05 G_eff=1.10250278704514e-05
Rh7p5n1 in5n h7p 90482.6382232636
* h7 input 6 w=-1.05409273633464 w-  bank=n alpha=1 R=31622.7711133294 G_phys=3.16227820900391e-05 G_eff=3.16227820900391e-05
Rh7n6n1 in6 h7p 31477.5542587486
* h7 input 7 w=-0.045065971974084 w-  bank=n alpha=1 R=739656.372051673 G_phys=1.35197915922252e-06 G_eff=1.35197915922252e-06
Rh7n7n1 in7 h7p 738063.839927342
* h7 input 8 w=-0.167915862386558 w-  bank=n alpha=1 R=198512.117077998 G_phys=5.03747587159673e-06 G_eff=5.03747587159673e-06
Rh7n8n1 in8 h7p 198666.12393308
* h7 input 9 w=+0.0197430594045346 w+  bank=f alpha=0.001 R=1688.35703982521 G_phys=0.000592291782136037 G_eff=5.92291782136037e-07
Rh7p9f1 tap9n h7p 1690.51959424653
* h7 input 10 w=-0.287534460104587 w-  bank=n alpha=1 R=115928.133696423 G_phys=8.6260338031376e-06 G_eff=8.6260338031376e-06
Rh7n10n1 in10 h7p 116031.341740236
* h7 input 11 w=-0.517871662481308 w-  bank=n alpha=1 R=64366.0114044885 G_phys=1.55361498744393e-05 G_eff=1.55361498744393e-05
Rh7n11n1 in11 h7p 64339.5385327482
* h7 input 12 w=+0.348150035983652 w+  bank=n alpha=1 R=95744.1616777503 G_phys=1.04445010795096e-05 G_eff=1.04445010795096e-05
Rh7p12n1 in12n h7p 95416.6683440689
* h7 input 13 w=-0.408247593362815 w-  bank=n alpha=1 R=81649.7975132203 G_phys=1.22474278008844e-05 G_eff=1.22474278008844e-05
Rh7n13n1 in13 h7p 81805.7788400821
* h7 input 14 w=-0.41711419269885 w-  bank=n alpha=1 R=79914.1671916195 G_phys=1.25134257809655e-05 G_eff=1.25134257809655e-05
Rh7n14n1 in14 h7p 79720.5188844329
* h7 input 15 w=-0.341449872918214 w-  bank=n alpha=1 R=97622.9191372918 G_phys=1.02434961875464e-05 G_eff=1.02434961875464e-05
Rh7n15n1 in15 h7p 97357.8726959017
* h7 input 16 w=-0.0335582003371702 w-  bank=n alpha=1 R=993299.193592697 G_phys=1.00674601011511e-06 G_eff=1.00674601011511e-06
Rh7n16n1 in16 h7p 992277.23723107
* h7 bias w-  bank=f alpha=0.001 R=1569.92559182808 G_phys=0.000636972863685573 G_eff=6.36972863685573e-07
Rh7bnf1 tapref h7p 1569.84069502583
* replica dummy G_tot for h7: same R as weights/biases, dest=0
Rh7dmy000 0 h7rp 103087.724942491
Rh7dmy001 0 h7rp 226044.498429208
Rh7dmy002 0 h7rp 63743.5119853491
Rh7dmy003 0 h7rp 75504.5028019664
Rh7dmy004 0 h7rp 90302.8745143434
Rh7dmy005 0 h7rp 31632.4527595497
Rh7dmy006 0 h7rp 741984.825444417
Rh7dmy007 0 h7rp 198203.775614271
Rh7dmy008 0 h7rp 1680.88073314127
Rh7dmy009 0 h7rp 116433.564533856
Rh7dmy010 0 h7rp 64445.183550788
Rh7dmy011 0 h7rp 95399.5421310993
Rh7dmy012 0 h7rp 81646.9973838537
Rh7dmy013 0 h7rp 79520.9720480954
Rh7dmy014 0 h7rp 97802.892005335
Rh7dmy015 0 h7rp 997820.614150006
Rh7dmy016 0 h7rp 1569.06936326887
* feedback TIA h7: Rf=33333.3333333333 A=100000 V(h7sig) = -I(h7p)*Rf*A/(A+1)  (uncompensated)
Eh7tia h7sig 0 0 h7p 100000
Rh7f h7sig h7p 33385.6052439431
* feedback TIA h7r: Rf=33333.3333333333 A=100000 V(h7rep) = -I(h7rp)*Rf*A/(A+1)  (uncompensated)
Eh7rtia h7rep 0 0 h7rp 100000
Rh7rf h7rep h7rp 33262.5284592675
* replica null h7: v(h7lin)=v(h7sig)-v(h7rep) Vos_sig=0 Vos_rep=0
Eh7null h7lin 0 h7sig h7rep 1
* direct bounded ReLU: y=max(0, min(15, v(h7lin)))
Bh7relu h7y 0 V = max(0, min(15, v(h7lin)))

* h8 input 1 w=+0.185544590700454 w+  bank=n alpha=1 R=179651.334525549 G_phys=5.56633772101363e-06 G_eff=5.56633772101363e-06
Rh8p1n1 in1n h8p 179269.549932855
* h8 input 2 w=-0.385658106289114 w-  bank=n alpha=1 R=86432.3419882805 G_phys=1.15697431886734e-05 G_eff=1.15697431886734e-05
Rh8n2n1 in2 h8p 86716.9206135897
* h8 input 3 w=+0.230915543832556 w+  bank=n alpha=1 R=144352.92133259 G_phys=6.92746631497669e-06 G_eff=6.92746631497669e-06
Rh8p3n1 in3n h8p 144328.384663337
* h8 input 4 w=+0.205353187615931 w+  bank=n alpha=1 R=162321.966950307 G_phys=6.16059562847793e-06 G_eff=6.16059562847793e-06
Rh8p4n1 in4n h8p 162319.273511973
* h8 input 5 w=+0.00415238713767869 w+  bank=f alpha=0.001 R=8027.51097817138 G_phys=0.000124571614130361 G_eff=1.24571614130361e-07
Rh8p5f1 tap5n h8p 7987.66214173144
* h8 input 6 w=-0.514726379917983 w-  bank=n alpha=1 R=64759.3257968335 G_phys=1.54417913975395e-05 G_eff=1.54417913975395e-05
Rh8n6n1 in6 h8p 64967.4082769122
* h8 input 7 w=+0.210716479044664 w+  bank=n alpha=1 R=158190.443787113 G_phys=6.32149437133992e-06 G_eff=6.32149437133992e-06
Rh8p7n1 in7n h8p 158112.930065211
* h8 input 8 w=+0.375574589425665 w+  bank=n alpha=1 R=88752.8982839526 G_phys=1.126723768277e-05 G_eff=1.126723768277e-05
Rh8p8n1 in8n h8p 89097.0912929724
* h8 input 9 w=+0.00572491873576676 w+  bank=f alpha=0.001 R=5822.49895096002 G_phys=0.000171747562073003 G_eff=1.71747562073003e-07
Rh8p9f1 tap9n h8p 5800.43339988774
* h8 input 10 w=-0.367556769900021 w-  bank=n alpha=1 R=90688.9385887256 G_phys=1.10267030970006e-05 G_eff=1.10267030970006e-05
Rh8n10n1 in10 h8p 90999.7768616853
* h8 input 11 w=+0.41225604099869 w+  bank=n alpha=1 R=80855.9002618455 G_phys=1.23676812299607e-05 G_eff=1.23676812299607e-05
Rh8p11n1 in11n h8p 80523.9623586085
* h8 input 12 w=+0.21126612483399 w+  bank=n alpha=1 R=157778.883668767 G_phys=6.33798374501969e-06 G_eff=6.33798374501969e-06
Rh8p12n1 in12n h8p 158080.340980766
* h8 input 13 w=+0.318427374873886 w+  bank=n alpha=1 R=104681.117151235 G_phys=9.55282124621658e-06 G_eff=9.55282124621658e-06
Rh8p13n1 in13n h8p 104559.446922161
* h8 input 14 w=-0.262828471961964 w-  bank=n alpha=1 R=126825.427566909 G_phys=7.88485415885892e-06 G_eff=7.88485415885892e-06
Rh8n14n1 in14 h8p 126991.548644576
* h8 input 15 w=+0.319620775512722 w+  bank=n alpha=1 R=104290.258603689 G_phys=9.58862326538165e-06 G_eff=9.58862326538165e-06
Rh8p15n1 in15n h8p 104673.868826924
* h8 input 16 w=+0.15331491024055 w+  bank=n alpha=1 R=217417.427183263 G_phys=4.59944730721651e-06 G_eff=4.59944730721651e-06
Rh8p16n1 in16n h8p 216611.123702885
* h8 bias w-  bank=f alpha=0.001 R=1092.27499465772 G_phys=0.00091552036336176 G_eff=9.1552036336176e-07
Rh8bnf1 tapref h8p 1096.12228890516
* replica dummy G_tot for h8: same R as weights/biases, dest=0
Rh8dmy000 0 h8rp 179121.526390477
Rh8dmy001 0 h8rp 86297.7435283818
Rh8dmy002 0 h8rp 144978.99641702
Rh8dmy003 0 h8rp 161664.138509454
Rh8dmy004 0 h8rp 7992.69170672665
Rh8dmy005 0 h8rp 64829.4635098997
Rh8dmy006 0 h8rp 157576.211203173
Rh8dmy007 0 h8rp 88351.7285385252
Rh8dmy008 0 h8rp 5809.63712949918
Rh8dmy009 0 h8rp 90746.9487578285
Rh8dmy010 0 h8rp 80634.3636543793
Rh8dmy011 0 h8rp 158218.12491466
Rh8dmy012 0 h8rp 105193.170281119
Rh8dmy013 0 h8rp 126837.201381129
Rh8dmy014 0 h8rp 104397.708008884
Rh8dmy015 0 h8rp 217272.99066399
Rh8dmy016 0 h8rp 1086.93300462891
* feedback TIA h8: Rf=33333.3333333333 A=100000 V(h8sig) = -I(h8p)*Rf*A/(A+1)  (uncompensated)
Eh8tia h8sig 0 0 h8p 100000
Rh8f h8sig h8p 33195.1165466782
* feedback TIA h8r: Rf=33333.3333333333 A=100000 V(h8rep) = -I(h8rp)*Rf*A/(A+1)  (uncompensated)
Eh8rtia h8rep 0 0 h8rp 100000
Rh8rf h8rep h8rp 33338.5061205545
* replica null h8: v(h8lin)=v(h8sig)-v(h8rep) Vos_sig=0 Vos_rep=0
Eh8null h8lin 0 h8sig h8rep 1
* direct bounded ReLU: y=max(0, min(15, v(h8lin)))
Bh8relu h8y 0 V = max(0, min(15, v(h8lin)))

* h9 input 1 w=-0.192368051906404 w-  bank=n alpha=1 R=173278.946285486 G_phys=5.77104155719211e-06 G_eff=5.77104155719211e-06
Rh9n1n1 in1 h9p 173423.868491311
* h9 input 2 w=-0.0188071151742732 w-  bank=f alpha=0.001 R=1772.37885898263 G_phys=0.000564213455228197 G_eff=5.64213455228197e-07
Rh9n2f1 tap2 h9p 1766.9496128598
* h9 input 3 w=+0.675590388456855 w+  bank=n alpha=1 R=49339.5612235861 G_phys=2.02677116537057e-05 G_eff=2.02677116537057e-05
Rh9p3n1 in3n h9p 49343.2000810152
* h9 input 4 w=-0.777819910920126 w-  bank=n alpha=1 R=42854.8213607717 G_phys=2.33345973276038e-05 G_eff=2.33345973276038e-05
Rh9n4n1 in4 h9p 42698.3411826859
* h9 input 5 w=-0.0591658911038067 w-  bank=n alpha=1 R=563387.666634648 G_phys=1.7749767331142e-06 G_eff=1.7749767331142e-06
Rh9n5n1 in5 h9p 562523.958542953
* h9 input 6 w=-0.373077376819092 w-  bank=n alpha=1 R=89346.9703725748 G_phys=1.11923213045728e-05 G_eff=1.11923213045728e-05
Rh9n6n1 in6 h9p 89223.800858658
* h9 input 7 w=+0.173600484730372 w+  bank=n alpha=1 R=192011.752646342 G_phys=5.20801454191117e-06 G_eff=5.20801454191117e-06
Rh9p7n1 in7n h9p 191328.956798167
* h9 input 8 w=+0.21285190098274 w+  bank=n alpha=1 R=156603.409128286 G_phys=6.38555702948219e-06 G_eff=6.38555702948219e-06
Rh9p8n1 in8n h9p 156612.747868318
* h9 input 9 w=+0.47939396555815 w+  bank=n alpha=1 R=69532.2338789223 G_phys=1.43818189667445e-05 G_eff=1.43818189667445e-05
Rh9p9n1 in9n h9p 69584.9117074861
* h9 input 10 w=-0.695860852133009 w-  bank=n alpha=1 R=47902.2971778874 G_phys=2.08758255639903e-05 G_eff=2.08758255639903e-05
Rh9n10n1 in10 h9p 47691.4408264625
* h9 input 11 w=+0.426719797848979 w+  bank=n alpha=1 R=78115.2726012736 G_phys=1.28015939354694e-05 G_eff=1.28015939354694e-05
Rh9p11n1 in11n h9p 78074.0833919686
* h9 input 12 w=+0.190883817865507 w+  bank=n alpha=1 R=174626.292087365 G_phys=5.7265145359652e-06 G_eff=5.7265145359652e-06
Rh9p12n1 in12n h9p 175325.566016165
* h9 input 13 w=-0.203891646942192 w-  bank=n alpha=1 R=163485.526912165 G_phys=6.11674940826577e-06 G_eff=6.11674940826577e-06
Rh9n13n1 in13 h9p 163585.993536908
* h9 input 14 w=-0.0564974778722501 w-  bank=n alpha=1 R=589996.838597032 G_phys=1.6949243361675e-06 G_eff=1.6949243361675e-06
Rh9n14n1 in14 h9p 589167.15208401
* h9 input 15 w=-0.251891815788561 w-  bank=n alpha=1 R=132331.942699216 G_phys=7.55675447365683e-06 G_eff=7.55675447365683e-06
Rh9n15n1 in15 h9p 132601.996703861
* h9 input 16 w=-0.340248378281639 w-  bank=n alpha=1 R=97967.6479331866 G_phys=1.02074513484492e-05 G_eff=1.02074513484492e-05
Rh9n16n1 in16 h9p 98227.8975093516
* h9 bias w-  bank=f alpha=0.001 R=1259.76757958347 G_phys=0.000793797218000037 G_eff=7.93797218000037e-07
Rh9bnf1 tapref h9p 1264.35847931372
* replica dummy G_tot for h9: same R as weights/biases, dest=0
Rh9dmy000 0 h9rp 173759.350382611
Rh9dmy001 0 h9rp 1767.30570451794
Rh9dmy002 0 h9rp 49178.3849603283
Rh9dmy003 0 h9rp 42805.0529033467
Rh9dmy004 0 h9rp 565085.625038964
Rh9dmy005 0 h9rp 89143.6415575538
Rh9dmy006 0 h9rp 191482.731903469
Rh9dmy007 0 h9rp 156433.626626186
Rh9dmy008 0 h9rp 69714.8300252547
Rh9dmy009 0 h9rp 48085.5010397261
Rh9dmy010 0 h9rp 78254.8734789046
Rh9dmy011 0 h9rp 174349.231742096
Rh9dmy012 0 h9rp 164263.227730014
Rh9dmy013 0 h9rp 589182.412562079
Rh9dmy014 0 h9rp 132676.738229371
Rh9dmy015 0 h9rp 97725.1249925032
Rh9dmy016 0 h9rp 1262.27794199374
* feedback TIA h9: Rf=33333.3333333333 A=100000 V(h9sig) = -I(h9p)*Rf*A/(A+1)  (uncompensated)
Eh9tia h9sig 0 0 h9p 100000
Rh9f h9sig h9p 33190.3444864894
* feedback TIA h9r: Rf=33333.3333333333 A=100000 V(h9rep) = -I(h9rp)*Rf*A/(A+1)  (uncompensated)
Eh9rtia h9rep 0 0 h9rp 100000
Rh9rf h9rep h9rp 33352.9926214261
* replica null h9: v(h9lin)=v(h9sig)-v(h9rep) Vos_sig=0 Vos_rep=0
Eh9null h9lin 0 h9sig h9rep 1
* direct bounded ReLU: y=max(0, min(15, v(h9lin)))
Bh9relu h9y 0 V = max(0, min(15, v(h9lin)))

* h10 input 1 w=+0.0856004623316453 w+  bank=n alpha=1 R=389405.996479186 G_phys=2.56801386994936e-06 G_eff=2.56801386994936e-06
Rh10p1n1 in1n h10p 390050.545047439
* h10 input 2 w=+0.717707405140542 w+  bank=n alpha=1 R=46444.1819808254 G_phys=2.15312221542163e-05 G_eff=2.15312221542163e-05
Rh10p2n1 in2n h10p 46350.5996454782
* h10 input 3 w=+0.367326370670395 w+  bank=n alpha=1 R=90745.8216857607 G_phys=1.10197911201119e-05 G_eff=1.10197911201119e-05
Rh10p3n1 in3n h10p 90425.980802247
* h10 input 4 w=+0.5220921972442 w+  bank=n alpha=1 R=63845.6837878046 G_phys=1.5662765917326e-05 G_eff=1.5662765917326e-05
Rh10p4n1 in4n h10p 64142.3525830441
* h10 input 5 w=+0.0909071116243784 w+  bank=n alpha=1 R=366674.649955487 G_phys=2.72721334873135e-06 G_eff=2.72721334873135e-06
Rh10p5n1 in5n h10p 368179.617520947
* h10 input 6 w=-0.0568053629833511 w-  bank=n alpha=1 R=586799.055277631 G_phys=1.70416088950053e-06 G_eff=1.70416088950053e-06
Rh10n6n1 in6 h10p 585928.642170254
* h10 input 7 w=+0.372078007523385 w+  bank=n alpha=1 R=89586.9485950155 G_phys=1.11623402257016e-05 G_eff=1.11623402257016e-05
Rh10p7n1 in7n h10p 89158.3965542184
* h10 input 8 w=+0.384900055079612 w+  bank=n alpha=1 R=86602.568363984 G_phys=1.15470016523884e-05 G_eff=1.15470016523884e-05
Rh10p8n1 in8n h10p 86239.3859633521
* h10 input 9 w=+0.617655459577812 w+  bank=n alpha=1 R=53967.5199440765 G_phys=1.85296637873344e-05 G_eff=1.85296637873344e-05
Rh10p9n1 in9n h10p 54061.1885029579
* h10 input 10 w=+0.306521845436409 w+  bank=n alpha=1 R=108747.007202293 G_phys=9.19565536309227e-06 G_eff=9.19565536309227e-06
Rh10p10n1 in10n h10p 108580.114027973
* h10 input 11 w=-0.0307901580575706 w-  bank=f alpha=0.001 R=1082.5970191841 G_phys=0.000923704741727117 G_eff=9.23704741727117e-07
Rh10n11f1 tap11 h10p 1078.94671204916
* h10 input 12 w=+0.163538031424557 w+  bank=n alpha=1 R=203826.186746724 G_phys=4.9061409427367e-06 G_eff=4.9061409427367e-06
Rh10p12n1 in12n h10p 203162.739712598
* h10 input 13 w=-0.0170713095619708 w-  bank=f alpha=0.001 R=1952.59380730749 G_phys=0.000512139286859123 G_eff=5.12139286859123e-07
Rh10n13f1 tap13 h10p 1955.73382999031
* h10 input 14 w=-0.123347220224403 w-  bank=n alpha=1 R=270239.842233093 G_phys=3.7004166067321e-06 G_eff=3.7004166067321e-06
Rh10n14n1 in14 h10p 271477.78746226
* h10 input 15 w=-0.136765368652097 w-  bank=n alpha=1 R=243726.417453869 G_phys=4.10296105956291e-06 G_eff=4.10296105956291e-06
Rh10n15n1 in15 h10p 242943.032262631
* h10 input 16 w=+0.269183781267177 w+  bank=n alpha=1 R=123831.1356517 G_phys=8.07551343801532e-06 G_eff=8.07551343801532e-06
Rh10p16n1 in16n h10p 123471.374919977
* h10 bias w-  bank=n alpha=1 R=519656.094343386 G_phys=1.92434960522027e-06 G_eff=1.92434960522027e-06
Rh10bnn1 vref h10p 520867.369794738
* replica dummy G_tot for h10: same R as weights/biases, dest=0
Rh10dmy000 0 h10rp 390552.067626214
Rh10dmy001 0 h10rp 46302.9363640342
Rh10dmy002 0 h10rp 90873.8625279003
Rh10dmy003 0 h10rp 63721.1084156108
Rh10dmy004 0 h10rp 365047.263892217
Rh10dmy005 0 h10rp 584711.023249086
Rh10dmy006 0 h10rp 89205.6925386632
Rh10dmy007 0 h10rp 86974.7305717219
Rh10dmy008 0 h10rp 53959.0713151782
Rh10dmy009 0 h10rp 108950.62151892
Rh10dmy010 0 h10rp 1085.5851592019
Rh10dmy011 0 h10rp 202977.343679438
Rh10dmy012 0 h10rp 1951.09701572613
Rh10dmy013 0 h10rp 270956.743215277
Rh10dmy014 0 h10rp 244104.814164779
Rh10dmy015 0 h10rp 123625.589150916
Rh10dmy016 0 h10rp 519411.895387438
* feedback TIA h10: Rf=33333.3333333333 A=100000 V(h10sig) = -I(h10p)*Rf*A/(A+1)  (uncompensated)
Eh10tia h10sig 0 0 h10p 100000
Rh10f h10sig h10p 33220.3673489412
* feedback TIA h10r: Rf=33333.3333333333 A=100000 V(h10rep) = -I(h10rp)*Rf*A/(A+1)  (uncompensated)
Eh10rtia h10rep 0 0 h10rp 100000
Rh10rf h10rep h10rp 33499.5615210768
* replica null h10: v(h10lin)=v(h10sig)-v(h10rep) Vos_sig=0 Vos_rep=0
Eh10null h10lin 0 h10sig h10rep 1
* direct bounded ReLU: y=max(0, min(15, v(h10lin)))
Bh10relu h10y 0 V = max(0, min(15, v(h10lin)))

* h11 input 1 w=+0.100174494534941 w+  bank=n alpha=1 R=332752.69806035 G_phys=3.00523483604823e-06 G_eff=3.00523483604823e-06
Rh11p1n1 in1n h11p 331238.515269866
* h11 input 2 w=-0.350357054027393 w-  bank=n alpha=1 R=95141.0366943178 G_phys=1.05107116208218e-05 G_eff=1.05107116208218e-05
Rh11n2n1 in2 h11p 95564.7237587854
* h11 input 3 w=-0.364058373495884 w-  bank=n alpha=1 R=91560.4083302596 G_phys=1.09217512048765e-05 G_eff=1.09217512048765e-05
Rh11n3n1 in3 h11p 91273.5271890255
* h11 input 4 w=+0.201551043415431 w+  bank=n alpha=1 R=165384.077246515 G_phys=6.04653130246294e-06 G_eff=6.04653130246294e-06
Rh11p4n1 in4n h11p 165426.545862198
* h11 input 5 w=+0.30370864041576 w+  bank=n alpha=1 R=109754.313501591 G_phys=9.1112592124728e-06 G_eff=9.1112592124728e-06
Rh11p5n1 in5n h11p 109779.619815762
* h11 input 6 w=+0.221531530750713 w+  bank=n alpha=1 R=150467.670314809 G_phys=6.64594592252139e-06 G_eff=6.64594592252139e-06
Rh11p6n1 in6n h11p 150895.114292581
* h11 input 7 w=-0.554388667333083 w-  bank=n alpha=1 R=60126.2891856812 G_phys=1.66316600199925e-05 G_eff=1.66316600199925e-05
Rh11n7n1 in7 h11p 60407.0744580504
* h11 input 8 w=+0.382929077760783 w+  bank=n alpha=1 R=87048.3211362621 G_phys=1.14878723328235e-05 G_eff=1.14878723328235e-05
Rh11p8n1 in8n h11p 86646.9993167498
* h11 input 9 w=-0.415059943002996 w-  bank=n alpha=1 R=80309.6851316552 G_phys=1.24517982900899e-05 G_eff=1.24517982900899e-05
Rh11n9n1 in9 h11p 80504.8096566945
* h11 input 10 w=-0.579957638432045 w-  bank=n alpha=1 R=57475.4622138477 G_phys=1.73987291529614e-05 G_eff=1.73987291529614e-05
Rh11n10n1 in10 h11p 57651.9585068668
* h11 input 11 w=+0.208304459025755 w+  bank=n alpha=1 R=160022.178542092 G_phys=6.24913377077265e-06 G_eff=6.24913377077265e-06
Rh11p11n1 in11n h11p 159895.169558615
* h11 input 12 w=+0.150185585205542 w+  bank=n alpha=1 R=221947.620923232 G_phys=4.50556755616625e-06 G_eff=4.50556755616625e-06
Rh11p12n1 in12n h11p 222191.522484871
* h11 input 13 w=-0.130595100347527 w-  bank=n alpha=1 R=255241.837133476 G_phys=3.9178530104258e-06 G_eff=3.9178530104258e-06
Rh11n13n1 in13 h11p 254426.291282327
* h11 input 14 w=+0.223944918125423 w+  bank=n alpha=1 R=148846.125254178 G_phys=6.71834754376269e-06 G_eff=6.71834754376269e-06
Rh11p14n1 in14n h11p 148379.168326218
* h11 input 15 w=+0.219816736012751 w+  bank=n alpha=1 R=151641.471609331 G_phys=6.59450208038254e-06 G_eff=6.59450208038254e-06
Rh11p15n1 in15n h11p 151955.246664476
* h11 input 16 w=-0.0825561420887272 w-  bank=n alpha=1 R=403765.637419301 G_phys=2.47668426266182e-06 G_eff=2.47668426266182e-06
Rh11n16n1 in16 h11p 404356.215131859
* h11 bias w-  bank=f alpha=0.001 R=2978.62482206369 G_phys=0.000335725396697381 G_eff=3.35725396697381e-07
Rh11bnf1 tapref h11p 2985.95176845053
* replica dummy G_tot for h11: same R as weights/biases, dest=0
Rh11dmy000 0 h11rp 332416.827822699
Rh11dmy001 0 h11rp 95239.282454025
Rh11dmy002 0 h11rp 91213.2788157764
Rh11dmy003 0 h11rp 165805.80463395
Rh11dmy004 0 h11rp 109855.443266564
Rh11dmy005 0 h11rp 150724.804891142
Rh11dmy006 0 h11rp 59989.4041994972
Rh11dmy007 0 h11rp 86856.5595376346
Rh11dmy008 0 h11rp 80145.0758835132
Rh11dmy009 0 h11rp 57513.0930506029
Rh11dmy010 0 h11rp 160517.324916717
Rh11dmy011 0 h11rp 221487.295005389
Rh11dmy012 0 h11rp 255570.459879903
Rh11dmy013 0 h11rp 148974.436154278
Rh11dmy014 0 h11rp 151592.819849559
Rh11dmy015 0 h11rp 403358.947622892
Rh11dmy016 0 h11rp 2988.81322071833
* feedback TIA h11: Rf=33333.3333333333 A=100000 V(h11sig) = -I(h11p)*Rf*A/(A+1)  (uncompensated)
Eh11tia h11sig 0 0 h11p 100000
Rh11f h11sig h11p 33446.3308021219
* feedback TIA h11r: Rf=33333.3333333333 A=100000 V(h11rep) = -I(h11rp)*Rf*A/(A+1)  (uncompensated)
Eh11rtia h11rep 0 0 h11rp 100000
Rh11rf h11rep h11rp 33199.4639652502
* replica null h11: v(h11lin)=v(h11sig)-v(h11rep) Vos_sig=0 Vos_rep=0
Eh11null h11lin 0 h11sig h11rep 1
* direct bounded ReLU: y=max(0, min(15, v(h11lin)))
Bh11relu h11y 0 V = max(0, min(15, v(h11lin)))

* h12 input 1 w=-0.0647804813106503 w-  bank=n alpha=1 R=514558.284516066 G_phys=1.94341443931951e-06 G_eff=1.94341443931951e-06
Rh12n1n1 in1 h12p 516584.165982143
* h12 input 2 w=-0.668825239918342 w-  bank=n alpha=1 R=49838.6295011879 G_phys=2.00647571975503e-05 G_eff=2.00647571975503e-05
Rh12n2n1 in2 h12p 49616.7838538217
* h12 input 3 w=+0.43152134817872 w+  bank=n alpha=1 R=77246.0817385283 G_phys=1.29456404453616e-05 G_eff=1.29456404453616e-05
Rh12p3n1 in3n h12p 77460.5809285265
* h12 input 4 w=+0.0766102486579458 w+  bank=n alpha=1 R=435102.795216892 G_phys=2.29830745973837e-06 G_eff=2.29830745973837e-06
Rh12p4n1 in4n h12p 436138.089746696
* h12 input 5 w=+0.112143595115044 w+  bank=n alpha=1 R=297237.959057206 G_phys=3.36430785345132e-06 G_eff=3.36430785345132e-06
Rh12p5n1 in5n h12p 296178.148536821
* h12 input 6 w=-0.214387519256146 w-  bank=n alpha=1 R=155481.687781961 G_phys=6.43162557768439e-06 G_eff=6.43162557768439e-06
Rh12n6n1 in6 h12p 155176.889999441
* h12 input 7 w=+0.0362945018752433 w+  bank=n alpha=1 R=918412.751548746 G_phys=1.0888350562573e-06 G_eff=1.0888350562573e-06
Rh12p7n1 in7n h12p 916874.691544394
* h12 input 8 w=-0.654320698371061 w-  bank=n alpha=1 R=50943.4187491196 G_phys=1.96296209511318e-05 G_eff=1.96296209511318e-05
Rh12n8n1 in8 h12p 51088.4912878538
* h12 input 9 w=-0.424313635659581 w-  bank=n alpha=1 R=78558.2421397273 G_phys=1.27294090697874e-05 G_eff=1.27294090697874e-05
Rh12n9n1 in9 h12p 78224.5202832408
* h12 input 10 w=-0.147731830075345 w-  bank=n alpha=1 R=225634.064888609 G_phys=4.43195490226035e-06 G_eff=4.43195490226035e-06
Rh12n10n1 in10 h12p 224953.557832931
* h12 input 11 w=+0.422841356490785 w+  bank=n alpha=1 R=78831.7718256581 G_phys=1.26852406947236e-05 G_eff=1.26852406947236e-05
Rh12p11n1 in11n h12p 78837.3099942331
* h12 input 12 w=+0.250573650346706 w+  bank=n alpha=1 R=133028.086900644 G_phys=7.51720951040119e-06 G_eff=7.51720951040119e-06
Rh12p12n1 in12n h12p 133600.665332235
* h12 input 13 w=+0.0601122436783251 w+  bank=n alpha=1 R=554518.202842467 G_phys=1.80336731034975e-06 G_eff=1.80336731034975e-06
Rh12p13n1 in13n h12p 556033.384587216
* h12 input 14 w=-0.651755086554606 w-  bank=n alpha=1 R=51143.9557910386 G_phys=1.95526525966382e-05 G_eff=1.95526525966382e-05
Rh12n14n1 in14 h12p 50965.8028679944
* h12 input 15 w=+0.130109285988943 w+  bank=n alpha=1 R=256194.88324735 G_phys=3.90327857966829e-06 G_eff=3.90327857966829e-06
Rh12p15n1 in15n h12p 254921.462802512
* h12 input 16 w=-0.0778767908450736 w-  bank=n alpha=1 R=428026.54002071 G_phys=2.33630372535221e-06 G_eff=2.33630372535221e-06
Rh12n16n1 in16 h12p 429721.059503565
* h12 bias w+  bank=f alpha=0.001 R=1892.24272993526 G_phys=0.000528473426891809 G_eff=5.28473426891809e-07
Rh12bpf1 taprefn h12p 1897.26102597698
* replica dummy G_tot for h12: same R as weights/biases, dest=0
Rh12dmy000 0 h12rp 513650.860269546
Rh12dmy001 0 h12rp 49891.3137356591
Rh12dmy002 0 h12rp 77117.9631702369
Rh12dmy003 0 h12rp 436479.408651747
Rh12dmy004 0 h12rp 297443.446547158
Rh12dmy005 0 h12rp 155789.669341427
Rh12dmy006 0 h12rp 917598.681937002
Rh12dmy007 0 h12rp 50726.4725556508
Rh12dmy008 0 h12rp 78888.5183188299
Rh12dmy009 0 h12rp 224907.293134661
Rh12dmy010 0 h12rp 78569.6976526992
Rh12dmy011 0 h12rp 132927.187673895
Rh12dmy012 0 h12rp 554472.05380962
Rh12dmy013 0 h12rp 51183.2928513499
Rh12dmy014 0 h12rp 255836.114268567
Rh12dmy015 0 h12rp 428804.438654091
Rh12dmy016 0 h12rp 1899.10104087336
* feedback TIA h12: Rf=33333.3333333333 A=100000 V(h12sig) = -I(h12p)*Rf*A/(A+1)  (uncompensated)
Eh12tia h12sig 0 0 h12p 100000
Rh12f h12sig h12p 33428.596956845
* feedback TIA h12r: Rf=33333.3333333333 A=100000 V(h12rep) = -I(h12rp)*Rf*A/(A+1)  (uncompensated)
Eh12rtia h12rep 0 0 h12rp 100000
Rh12rf h12rep h12rp 33394.141683736
* replica null h12: v(h12lin)=v(h12sig)-v(h12rep) Vos_sig=0 Vos_rep=0
Eh12null h12lin 0 h12sig h12rep 1
* direct bounded ReLU: y=max(0, min(15, v(h12lin)))
Bh12relu h12y 0 V = max(0, min(15, v(h12lin)))

* h13 input 1 w=+0.034343742118514 w+  bank=n alpha=1 R=970579.537264929 G_phys=1.03031226355542e-06 G_eff=1.03031226355542e-06
Rh13p1n1 in1n h13p 972299.728050801
* h13 input 2 w=-0.102232912320493 w-  bank=n alpha=1 R=326052.858876169 G_phys=3.06698736961478e-06 G_eff=3.06698736961478e-06
Rh13n2n1 in2 h13p 324500.966622841
* h13 input 3 w=+1.31993068300228 w+  bank=n alpha=1 R=25253.8514049194 G_phys=3.95979204900683e-05 G_eff=3.95979204900683e-05
Rh13p3n1 in3n h13p 25168.1957660073
* h13 input 4 w=-0.233319639483811 w-  bank=n alpha=1 R=142865.527338714 G_phys=6.99958918451433e-06 G_eff=6.99958918451433e-06
Rh13n4n1 in4 h13p 142692.405361934
* h13 input 5 w=-0.375430599339701 w-  bank=n alpha=1 R=88786.9379639253 G_phys=1.1262917980191e-05 G_eff=1.1262917980191e-05
Rh13n5n1 in5 h13p 88527.4020730641
* h13 input 6 w=+0.442115486842334 w+  bank=n alpha=1 R=75395.0818855177 G_phys=1.326346460527e-05 G_eff=1.326346460527e-05
Rh13p6n1 in6n h13p 75456.6100291179
* h13 input 7 w=-0.102130412545238 w-  bank=n alpha=1 R=326380.090930979 G_phys=3.06391237635715e-06 G_eff=3.06391237635715e-06
Rh13n7n1 in7 h13p 327723.726125621
* h13 input 8 w=-0.136235661297007 w-  bank=n alpha=1 R=244674.067098066 G_phys=4.08706983891021e-06 G_eff=4.08706983891021e-06
Rh13n8n1 in8 h13p 245027.071704924
* h13 input 9 w=+0.0915800560074952 w+  bank=n alpha=1 R=363980.268046628 G_phys=2.74740168022485e-06 G_eff=2.74740168022485e-06
Rh13p9n1 in9n h13p 364566.462517387
* h13 input 10 w=-0.194905587913072 w-  bank=n alpha=1 R=171022.974201232 G_phys=5.84716763739217e-06 G_eff=5.84716763739217e-06
Rh13n10n1 in10 h13p 170939.570312954
* h13 input 11 w=-0.611958537828416 w-  bank=n alpha=1 R=54469.9212002489 G_phys=1.83587561348525e-05 G_eff=1.83587561348525e-05
Rh13n11n1 in11 h13p 54504.7922256769
* h13 input 12 w=+0.19411196838682 w+  bank=n alpha=1 R=171722.195237894 G_phys=5.8233590516046e-06 G_eff=5.8233590516046e-06
Rh13p12n1 in12n h13p 171796.872244864
* h13 input 13 w=+0.146421986160596 w+  bank=n alpha=1 R=227652.514539539 G_phys=4.39265958481789e-06 G_eff=4.39265958481789e-06
Rh13p13n1 in13n h13p 227184.528333459
* h13 input 14 w=+0.246088955287688 w+  bank=n alpha=1 R=135452.374505655 G_phys=7.38266865863065e-06 G_eff=7.38266865863065e-06
Rh13p14n1 in14n h13p 135981.721661228
* h13 input 15 w=-0.101801651380703 w-  bank=n alpha=1 R=327434.112131228 G_phys=3.05404954142109e-06 G_eff=3.05404954142109e-06
Rh13n15n1 in15 h13p 327861.913001091
* h13 input 16 w=-0.212672591801914 w-  bank=n alpha=1 R=156735.445084435 G_phys=6.38017775405741e-06 G_eff=6.38017775405741e-06
Rh13n16n1 in16 h13p 156119.386625094
* h13 bias w+  bank=f alpha=0.001 R=1569.64655542844 G_phys=0.000637086098486067 G_eff=6.37086098486067e-07
Rh13bpf1 taprefn h13p 1577.23021387775
* replica dummy G_tot for h13: same R as weights/biases, dest=0
Rh13dmy000 0 h13rp 970618.162657315
Rh13dmy001 0 h13rp 326453.601338276
Rh13dmy002 0 h13rp 25282.2851854929
Rh13dmy003 0 h13rp 142396.978794964
Rh13dmy004 0 h13rp 88903.4280399166
Rh13dmy005 0 h13rp 75618.2642542011
Rh13dmy006 0 h13rp 326673.095151772
Rh13dmy007 0 h13rp 245740.416222364
Rh13dmy008 0 h13rp 365100.711440884
Rh13dmy009 0 h13rp 170496.687209154
Rh13dmy010 0 h13rp 54733.4934562129
Rh13dmy011 0 h13rp 170867.099463257
Rh13dmy012 0 h13rp 228446.57968572
Rh13dmy013 0 h13rp 136089.205511938
Rh13dmy014 0 h13rp 328941.431745086
Rh13dmy015 0 h13rp 157513.22101683
Rh13dmy016 0 h13rp 1577.26204935612
* feedback TIA h13: Rf=33333.3333333333 A=100000 V(h13sig) = -I(h13p)*Rf*A/(A+1)  (uncompensated)
Eh13tia h13sig 0 0 h13p 100000
Rh13f h13sig h13p 33498.797602327
* feedback TIA h13r: Rf=33333.3333333333 A=100000 V(h13rep) = -I(h13rp)*Rf*A/(A+1)  (uncompensated)
Eh13rtia h13rep 0 0 h13rp 100000
Rh13rf h13rep h13rp 33195.2614498214
* replica null h13: v(h13lin)=v(h13sig)-v(h13rep) Vos_sig=0 Vos_rep=0
Eh13null h13lin 0 h13sig h13rep 1
* direct bounded ReLU: y=max(0, min(15, v(h13lin)))
Bh13relu h13y 0 V = max(0, min(15, v(h13lin)))

* h14 input 1 w=-0.089975491938664 w-  bank=n alpha=1 R=370471.254061679 G_phys=2.69926475815992e-06 G_eff=2.69926475815992e-06
Rh14n1n1 in1 h14p 370690.558091452
* h14 input 2 w=-0.0792638889786837 w-  bank=n alpha=1 R=420536.183157725 G_phys=2.37791666936051e-06 G_eff=2.37791666936051e-06
Rh14n2n1 in2 h14p 421550.140334723
* h14 input 3 w=-0.392380373690676 w-  bank=n alpha=1 R=84951.5815987547 G_phys=1.17714112107203e-05 G_eff=1.17714112107203e-05
Rh14n3n1 in3 h14p 85364.3621490664
* h14 input 4 w=+0.471386854681532 w+  bank=n alpha=1 R=70713.3281343902 G_phys=1.4141605640446e-05 G_eff=1.4141605640446e-05
Rh14p4n1 in4n h14p 70760.5346593171
* h14 input 5 w=-0.118903138220599 w-  bank=n alpha=1 R=280340.231823744 G_phys=3.56709414661796e-06 G_eff=3.56709414661796e-06
Rh14n5n1 in5 h14p 281291.124420991
* h14 input 6 w=+0.618408634475196 w+  bank=n alpha=1 R=53901.7915906385 G_phys=1.85522590342559e-05 G_eff=1.85522590342559e-05
Rh14p6n1 in6n h14p 54014.8739663651
* h14 input 7 w=-0.0462466843022721 w-  bank=n alpha=1 R=720772.393442608 G_phys=1.38740052906816e-06 G_eff=1.38740052906816e-06
Rh14n7n1 in7 h14p 720553.956716263
* h14 input 8 w=-0.0297824475583231 w-  bank=f alpha=0.001 R=1119.22746671698 G_phys=0.000893473426749692 G_eff=8.93473426749692e-07
Rh14n8f1 tap8 h14p 1121.38068386047
* h14 input 9 w=+0.0766531636417715 w+  bank=n alpha=1 R=434859.198885937 G_phys=2.29959490925314e-06 G_eff=2.29959490925314e-06
Rh14p9n1 in9n h14p 433811.288861054
* h14 input 10 w=-0.0192124865162136 w-  bank=f alpha=0.001 R=1734.98278347277 G_phys=0.000576374595486407 G_eff=5.76374595486407e-07
Rh14n10f1 tap10 h14p 1729.29784079516
* h14 input 11 w=-0.118584174544602 w-  bank=n alpha=1 R=281094.281436313 G_phys=3.55752523633807e-06 G_eff=3.55752523633807e-06
Rh14n11n1 in11 h14p 281605.745545177
* h14 input 12 w=+0.498792575097448 w+  bank=n alpha=1 R=66828.0463613979 G_phys=1.49637772529234e-05 G_eff=1.49637772529234e-05
Rh14p12n1 in12n h14p 66889.0323474821
* h14 input 13 w=+0.131240430694277 w+  bank=n alpha=1 R=253986.771888785 G_phys=3.93721292082832e-06 G_eff=3.93721292082832e-06
Rh14p13n1 in13n h14p 252802.061685866
* h14 input 14 w=-0.699789872634837 w-  bank=n alpha=1 R=47633.346289833 G_phys=2.09936961790451e-05 G_eff=2.09936961790451e-05
Rh14n14n1 in14 h14p 47753.5210877431
* h14 input 15 w=+0.0882030102342884 w+  bank=n alpha=1 R=377916.051218569 G_phys=2.64609030702865e-06 G_eff=2.64609030702865e-06
Rh14p15n1 in15n h14p 376336.119217669
* h14 input 16 w=-0.409062788225599 w-  bank=n alpha=1 R=81487.082894839 G_phys=1.2271883646768e-05 G_eff=1.2271883646768e-05
Rh14n16n1 in16 h14p 81334.1317137128
* h14 bias w+  bank=n alpha=1 R=404190.380335226 G_phys=2.47408164234543e-06 G_eff=2.47408164234543e-06
Rh14bpn1 vrefn h14p 403515.740601728
* replica dummy G_tot for h14: same R as weights/biases, dest=0
Rh14dmy000 0 h14rp 372167.253176903
Rh14dmy001 0 h14rp 419137.482751789
Rh14dmy002 0 h14rp 85242.7642073715
Rh14dmy003 0 h14rp 70982.0468895289
Rh14dmy004 0 h14rp 279941.332094926
Rh14dmy005 0 h14rp 53716.617964508
Rh14dmy006 0 h14rp 718518.175433616
Rh14dmy007 0 h14rp 1120.04826158425
Rh14dmy008 0 h14rp 435295.249538922
Rh14dmy009 0 h14rp 1732.66551548862
Rh14dmy010 0 h14rp 279970.540958579
Rh14dmy011 0 h14rp 66744.4697903662
Rh14dmy012 0 h14rp 255212.235413496
Rh14dmy013 0 h14rp 47761.4021808932
Rh14dmy014 0 h14rp 378136.840115569
Rh14dmy015 0 h14rp 81855.6261066725
Rh14dmy016 0 h14rp 404860.707315739
* feedback TIA h14: Rf=33333.3333333333 A=100000 V(h14sig) = -I(h14p)*Rf*A/(A+1)  (uncompensated)
Eh14tia h14sig 0 0 h14p 100000
Rh14f h14sig h14p 33208.5434832805
* feedback TIA h14r: Rf=33333.3333333333 A=100000 V(h14rep) = -I(h14rp)*Rf*A/(A+1)  (uncompensated)
Eh14rtia h14rep 0 0 h14rp 100000
Rh14rf h14rep h14rp 33406.0364416359
* replica null h14: v(h14lin)=v(h14sig)-v(h14rep) Vos_sig=0 Vos_rep=0
Eh14null h14lin 0 h14sig h14rep 1
* direct bounded ReLU: y=max(0, min(15, v(h14lin)))
Bh14relu h14y 0 V = max(0, min(15, v(h14lin)))

* h15 input 1 w=-0.104362920527351 w-  bank=n alpha=1 R=319398.241874589 G_phys=3.13088761582053e-06 G_eff=3.13088761582053e-06
Rh15n1n1 in1 h15p 318014.23604033
* h15 input 2 w=+0.0920701784982539 w+  bank=n alpha=1 R=362042.670895501 G_phys=2.76210535494762e-06 G_eff=2.76210535494762e-06
Rh15p2n1 in2n h15p 363843.353533673
* h15 input 3 w=+0.710914651543076 w+  bank=n alpha=1 R=46887.9537944276 G_phys=2.13274395462923e-05 G_eff=2.13274395462923e-05
Rh15p3n1 in3n h15p 46985.3505113375
* h15 input 4 w=+0.0431405504557543 w+  bank=n alpha=1 R=772668.243246468 G_phys=1.29421651367263e-06 G_eff=1.29421651367263e-06
Rh15p4n1 in4n h15p 770526.321986688
* h15 input 5 w=-0.544653793286569 w-  bank=n alpha=1 R=61200.9569091444 G_phys=1.63396137985971e-05 G_eff=1.63396137985971e-05
Rh15n5n1 in5 h15p 60960.2287473567
* h15 input 6 w=+0.236607896967987 w+  bank=n alpha=1 R=140880.054133795 G_phys=7.0982369090396e-06 G_eff=7.0982369090396e-06
Rh15p6n1 in6n h15p 140885.763529795
* h15 input 7 w=+0.205722108048513 w+  bank=n alpha=1 R=162030.875774774 G_phys=6.17166324145539e-06 G_eff=6.17166324145539e-06
Rh15p7n1 in7n h15p 161432.854998695
* h15 input 8 w=+0.119910326826568 w+  bank=n alpha=1 R=277985.509801377 G_phys=3.59730980479705e-06 G_eff=3.59730980479705e-06
Rh15p8n1 in8n h15p 278520.453598331
* h15 input 9 w=-0.0351999996705356 w-  bank=n alpha=1 R=946969.705833129 G_phys=1.05599999011607e-06 G_eff=1.05599999011607e-06
Rh15n9n1 in9 h15p 948184.817745488
* h15 input 10 w=-0.0279846802936883 w-  bank=f alpha=0.001 R=1191.12789510236 G_phys=0.000839540408810648 G_eff=8.39540408810648e-07
Rh15n10f1 tap10 h15p 1187.34212709547
* h15 input 11 w=-0.155672537202176 w-  bank=n alpha=1 R=214124.68719542 G_phys=4.67017611606528e-06 G_eff=4.67017611606528e-06
Rh15n11n1 in11 h15p 214229.637661107
* h15 input 12 w=-0.248740189524738 w-  bank=n alpha=1 R=134008.635263254 G_phys=7.46220568574215e-06 G_eff=7.46220568574215e-06
Rh15n12n1 in12 h15p 134088.610553085
* h15 input 13 w=+0.142944744841187 w+  bank=n alpha=1 R=233190.337779587 G_phys=4.28834234523561e-06 G_eff=4.28834234523561e-06
Rh15p13n1 in13n h15p 232800.188325431
* h15 input 14 w=-0.364164748984914 w-  bank=n alpha=1 R=91533.6627892949 G_phys=1.09249424695474e-05 G_eff=1.09249424695474e-05
Rh15n14n1 in14 h15p 91214.2767821347
* h15 input 15 w=-0.240848341925517 w-  bank=n alpha=1 R=138399.679511357 G_phys=7.22545025776552e-06 G_eff=7.22545025776552e-06
Rh15n15n1 in15 h15p 139006.391361661
* h15 input 16 w=-0.736896288827917 w-  bank=n alpha=1 R=45234.7689066968 G_phys=2.21068886648375e-05 G_eff=2.21068886648375e-05
Rh15n16n1 in16 h15p 45040.0688305876
* h15 bias w+  bank=f alpha=0.001 R=23679.3163125671 G_phys=4.22309490189663e-05 G_eff=4.22309490189663e-08
Rh15bpf1 taprefn h15p 23633.1534495334
* replica dummy G_tot for h15: same R as weights/biases, dest=0
Rh15dmy000 0 h15rp 320372.485505553
Rh15dmy001 0 h15rp 363594.344309244
Rh15dmy002 0 h15rp 46745.3816916681
Rh15dmy003 0 h15rp 775509.108273836
Rh15dmy004 0 h15rp 61225.3788609415
Rh15dmy005 0 h15rp 140873.234905002
Rh15dmy006 0 h15rp 162717.39203551
Rh15dmy007 0 h15rp 279319.521838287
Rh15dmy008 0 h15rp 945683.5521357
Rh15dmy009 0 h15rp 1194.76993411153
Rh15dmy010 0 h15rp 214386.952900945
Rh15dmy011 0 h15rp 134599.004568576
Rh15dmy012 0 h15rp 232308.412858739
Rh15dmy013 0 h15rp 91667.4363466696
Rh15dmy014 0 h15rp 137798.761866706
Rh15dmy015 0 h15rp 45264.5359215532
Rh15dmy016 0 h15rp 23771.5206424813
* feedback TIA h15: Rf=33333.3333333333 A=100000 V(h15sig) = -I(h15p)*Rf*A/(A+1)  (uncompensated)
Eh15tia h15sig 0 0 h15p 100000
Rh15f h15sig h15p 33433.6553162736
* feedback TIA h15r: Rf=33333.3333333333 A=100000 V(h15rep) = -I(h15rp)*Rf*A/(A+1)  (uncompensated)
Eh15rtia h15rep 0 0 h15rp 100000
Rh15rf h15rep h15rp 33456.5043025565
* replica null h15: v(h15lin)=v(h15sig)-v(h15rep) Vos_sig=0 Vos_rep=0
Eh15null h15lin 0 h15sig h15rep 1
* direct bounded ReLU: y=max(0, min(15, v(h15lin)))
Bh15relu h15y 0 V = max(0, min(15, v(h15lin)))

* h16 input 1 w=-0.211528252190937 w-  bank=n alpha=1 R=157583.362922343 G_phys=6.3458475657281e-06 G_eff=6.3458475657281e-06
Rh16n1n1 in1 h16p 158304.541520466
* h16 input 2 w=-0.194947045242045 w-  bank=n alpha=1 R=170986.604551748 G_phys=5.84841135726135e-06 G_eff=5.84841135726135e-06
Rh16n2n1 in2 h16p 171760.683077934
* h16 input 3 w=-0.281660896127353 w-  bank=n alpha=1 R=118345.619827403 G_phys=8.44982688382059e-06 G_eff=8.44982688382059e-06
Rh16n3n1 in3 h16p 117795.31419916
* h16 input 4 w=-0.246854224570453 w-  bank=n alpha=1 R=135032.460519305 G_phys=7.4056267371136e-06 G_eff=7.4056267371136e-06
Rh16n4n1 in4 h16p 134512.140048473
* h16 input 5 w=+0.785179968580328 w+  bank=n alpha=1 R=42453.112238208 G_phys=2.35553990574098e-05 G_eff=2.35553990574098e-05
Rh16p5n1 in5n h16p 42539.1425177391
* h16 input 6 w=-0.342055263707418 w-  bank=n alpha=1 R=97450.1399921314 G_phys=1.02616579112226e-05 G_eff=1.02616579112226e-05
Rh16n6n1 in6 h16p 97371.7632152735
* h16 input 7 w=-0.213390213186068 w-  bank=n alpha=1 R=156208.351056231 G_phys=6.40170639558203e-06 G_eff=6.40170639558203e-06
Rh16n7n1 in7 h16p 155449.742338937
* h16 input 8 w=-0.06183287092446 w-  bank=n alpha=1 R=539087.589415927 G_phys=1.8549861277338e-06 G_eff=1.8549861277338e-06
Rh16n8n1 in8 h16p 536644.525717247
* h16 input 9 w=+0.114369297885863 w+  bank=n alpha=1 R=291453.510247121 G_phys=3.43107893657588e-06 G_eff=3.43107893657588e-06
Rh16p9n1 in9n h16p 290741.368584018
* h16 input 10 w=+0.418702574206734 w+  bank=n alpha=1 R=79611.0064440994 G_phys=1.2561077226202e-05 G_eff=1.2561077226202e-05
Rh16p10n1 in10n h16p 79444.6286110389
* h16 input 11 w=-0.38263995973155 w-  bank=n alpha=1 R=87114.0937729534 G_phys=1.14791987919465e-05 G_eff=1.14791987919465e-05
Rh16n11n1 in11 h16p 86772.9735445789
* h16 input 12 w=-0.447982918675276 w-  bank=n alpha=1 R=74407.5989144918 G_phys=1.34394875602583e-05 G_eff=1.34394875602583e-05
Rh16n12n1 in12 h16p 74595.4478811508
* h16 input 13 w=-0.354860709093241 w-  bank=n alpha=1 R=93933.5702126856 G_phys=1.06458212727972e-05 G_eff=1.06458212727972e-05
Rh16n13n1 in13 h16p 93804.9733688262
* h16 input 14 w=-0.245379266072843 w-  bank=n alpha=1 R=135844.131685674 G_phys=7.36137798218528e-06 G_eff=7.36137798218528e-06
Rh16n14n1 in14 h16p 136027.884149299
* h16 input 15 w=-0.0999148922371372 w-  bank=n alpha=1 R=333617.267526249 G_phys=2.99744676711412e-06 G_eff=2.99744676711412e-06
Rh16n15n1 in15 h16p 332878.428836729
* h16 input 16 w=-0.428765175056332 w-  bank=n alpha=1 R=77742.632267077 G_phys=1.286295525169e-05 G_eff=1.286295525169e-05
Rh16n16n1 in16 h16p 78013.5916807621
* h16 bias w+  bank=n alpha=1 R=388758.166916054 G_phys=2.572293227774e-06 G_eff=2.572293227774e-06
Rh16bpn1 vrefn h16p 388516.669918243
* replica dummy G_tot for h16: same R as weights/biases, dest=0
Rh16dmy000 0 h16rp 157979.511497919
Rh16dmy001 0 h16rp 170924.047568771
Rh16dmy002 0 h16rp 118589.637775676
Rh16dmy003 0 h16rp 135584.996075982
Rh16dmy004 0 h16rp 42352.9549735754
Rh16dmy005 0 h16rp 97023.1287418004
Rh16dmy006 0 h16rp 155482.187719765
Rh16dmy007 0 h16rp 541592.861917548
Rh16dmy008 0 h16rp 290042.6418665
Rh16dmy009 0 h16rp 79848.1599122591
Rh16dmy010 0 h16rp 87011.053482966
Rh16dmy011 0 h16rp 74488.5997572984
Rh16dmy012 0 h16rp 93571.6500549343
Rh16dmy013 0 h16rp 136399.118441437
Rh16dmy014 0 h16rp 333684.861468585
Rh16dmy015 0 h16rp 77984.6433582768
Rh16dmy016 0 h16rp 389289.703762221
* feedback TIA h16: Rf=33333.3333333333 A=100000 V(h16sig) = -I(h16p)*Rf*A/(A+1)  (uncompensated)
Eh16tia h16sig 0 0 h16p 100000
Rh16f h16sig h16p 33391.8978715899
* feedback TIA h16r: Rf=33333.3333333333 A=100000 V(h16rep) = -I(h16rp)*Rf*A/(A+1)  (uncompensated)
Eh16rtia h16rep 0 0 h16rp 100000
Rh16rf h16rep h16rp 33168.8026664302
* replica null h16: v(h16lin)=v(h16sig)-v(h16rep) Vos_sig=0 Vos_rep=0
Eh16null h16lin 0 h16sig h16rep 1
* direct bounded ReLU: y=max(0, min(15, v(h16lin)))
Bh16relu h16y 0 V = max(0, min(15, v(h16lin)))

* h17 input 1 w=+0.690050155404084 w+  bank=n alpha=1 R=48305.667453714 G_phys=2.07015046621225e-05 G_eff=2.07015046621225e-05
Rh17p1n1 in1n h17p 48151.9376892649
* h17 input 2 w=-0.128803090681736 w-  bank=n alpha=1 R=258792.961852894 G_phys=3.86409272045207e-06 G_eff=3.86409272045207e-06
Rh17n2n1 in2 h17p 258931.147677382
* h17 input 3 w=-0.49836012605351 w-  bank=n alpha=1 R=66886.036002315 G_phys=1.49508037816053e-05 G_eff=1.49508037816053e-05
Rh17n3n1 in3 h17p 67127.9231197023
* h17 input 4 w=-0.0597081457071854 w-  bank=n alpha=1 R=558271.119267432 G_phys=1.79124437121556e-06 G_eff=1.79124437121556e-06
Rh17n4n1 in4 h17p 555498.142994737
* h17 input 5 w=+0.0531710366485299 w+  bank=n alpha=1 R=626907.71958562 G_phys=1.5951310994559e-06 G_eff=1.5951310994559e-06
Rh17p5n1 in5n h17p 624486.224017549
* h17 input 6 w=+0.325686197829899 w+  bank=n alpha=1 R=102348.007239603 G_phys=9.77058593489698e-06 G_eff=9.77058593489698e-06
Rh17p6n1 in6n h17p 102372.871454822
* h17 input 7 w=-0.138446110206034 w-  bank=n alpha=1 R=240767.568577601 G_phys=4.15338330618101e-06 G_eff=4.15338330618101e-06
Rh17n7n1 in7 h17p 240726.857096748
* h17 input 8 w=-0.354640771144099 w-  bank=n alpha=1 R=93991.8250961316 G_phys=1.0639223134323e-05 G_eff=1.0639223134323e-05
Rh17n8n1 in8 h17p 94399.6960711514
* h17 input 9 w=+0.283153126675736 w+  bank=n alpha=1 R=117721.932738911 G_phys=8.49459380027208e-06 G_eff=8.49459380027208e-06
Rh17p9n1 in9n h17p 117491.969208665
* h17 input 10 w=+0.187509087652136 w+  bank=n alpha=1 R=177769.161754831 G_phys=5.62527262956408e-06 G_eff=5.62527262956408e-06
Rh17p10n1 in10n h17p 178457.761756458
* h17 input 11 w=+0.286891884918939 w+  bank=n alpha=1 R=116187.78740553 G_phys=8.60675654756817e-06 G_eff=8.60675654756817e-06
Rh17p11n1 in11n h17p 116612.697010056
* h17 input 12 w=-0.663420236101193 w-  bank=n alpha=1 R=50244.6737670041 G_phys=1.99026070830358e-05 G_eff=1.99026070830358e-05
Rh17n12n1 in12 h17p 50467.0548131586
* h17 input 13 w=-0.00672050178940724 w-  bank=f alpha=0.001 R=4959.94709589586 G_phys=0.000201615053682217 G_eff=2.01615053682217e-07
Rh17n13f1 tap13 h17p 4935.70458878642
* h17 input 14 w=+0.213870810385993 w+  bank=n alpha=1 R=155857.32935305 G_phys=6.41612431157979e-06 G_eff=6.41612431157979e-06
Rh17p14n1 in14n h17p 156575.671977894
* h17 input 15 w=+0.856655380645102 w+  bank=n alpha=1 R=38911.0184637278 G_phys=2.56996614193531e-05 G_eff=2.56996614193531e-05
Rh17p15n1 in15n h17p 38952.1357603623
* h17 input 16 w=-0.153994690926048 w-  bank=n alpha=1 R=216457.6787218 G_phys=4.61984072778143e-06 G_eff=4.61984072778143e-06
Rh17n16n1 in16 h17p 216069.949933858
* h17 bias w+  bank=n alpha=1 R=358017.249275869 G_phys=2.79316150834244e-06 G_eff=2.79316150834244e-06
Rh17bpn1 vrefn h17p 356778.38266146
* replica dummy G_tot for h17: same R as weights/biases, dest=0
Rh17dmy000 0 h17rp 48357.8622514562
Rh17dmy001 0 h17rp 258944.38478957
Rh17dmy002 0 h17rp 66966.0189730065
Rh17dmy003 0 h17rp 557856.627262514
Rh17dmy004 0 h17rp 629394.463191866
Rh17dmy005 0 h17rp 101986.048333
Rh17dmy006 0 h17rp 240929.407858313
Rh17dmy007 0 h17rp 93880.2988347422
Rh17dmy008 0 h17rp 117645.73678134
Rh17dmy009 0 h17rp 178241.028499575
Rh17dmy010 0 h17rp 116257.980817077
Rh17dmy011 0 h17rp 50061.1874790165
Rh17dmy012 0 h17rp 4948.90267770099
Rh17dmy013 0 h17rp 156372.390129626
Rh17dmy014 0 h17rp 39098.4775210759
Rh17dmy015 0 h17rp 215393.14484463
Rh17dmy016 0 h17rp 358472.068269658
* feedback TIA h17: Rf=33333.3333333333 A=100000 V(h17sig) = -I(h17p)*Rf*A/(A+1)  (uncompensated)
Eh17tia h17sig 0 0 h17p 100000
Rh17f h17sig h17p 33275.0020309732
* feedback TIA h17r: Rf=33333.3333333333 A=100000 V(h17rep) = -I(h17rp)*Rf*A/(A+1)  (uncompensated)
Eh17rtia h17rep 0 0 h17rp 100000
Rh17rf h17rep h17rp 33362.3179489832
* replica null h17: v(h17lin)=v(h17sig)-v(h17rep) Vos_sig=0 Vos_rep=0
Eh17null h17lin 0 h17sig h17rep 1
* direct bounded ReLU: y=max(0, min(15, v(h17lin)))
Bh17relu h17y 0 V = max(0, min(15, v(h17lin)))

* h18 input 1 w=+0.00309692999044255 w+  bank=f alpha=0.001 R=10763.3473911917 G_phys=9.29078997132766e-05 G_eff=9.29078997132766e-08
Rh18p1f1 tap1n h18p 10765.3521672195
* h18 input 2 w=-0.290006429631547 w-  bank=n alpha=1 R=114939.98038486 G_phys=8.70019288894641e-06 G_eff=8.70019288894641e-06
Rh18n2n1 in2 h18p 114588.34085933
* h18 input 3 w=+0.161902441115013 w+  bank=n alpha=1 R=205885.304160755 G_phys=4.8570732334504e-06 G_eff=4.8570732334504e-06
Rh18p3n1 in3n h18p 205069.590080069
* h18 input 4 w=-0.201165440039706 w-  bank=n alpha=1 R=165701.093223339 G_phys=6.03496320119118e-06 G_eff=6.03496320119118e-06
Rh18n4n1 in4 h18p 165025.113940058
* h18 input 5 w=+0.167521926893116 w+  bank=n alpha=1 R=198978.927424831 G_phys=5.02565780679349e-06 G_eff=5.02565780679349e-06
Rh18p5n1 in5n h18p 198763.040691482
* h18 input 6 w=+0.306365656745506 w+  bank=n alpha=1 R=108802.447661498 G_phys=9.19096970236517e-06 G_eff=9.19096970236517e-06
Rh18p6n1 in6n h18p 108570.434554647
* h18 input 7 w=+0.567135277617062 w+  bank=n alpha=1 R=58774.9248704654 G_phys=1.70140583285119e-05 G_eff=1.70140583285119e-05
Rh18p7n1 in7n h18p 58542.9176332894
* h18 input 8 w=+0.27754647202065 w+  bank=n alpha=1 R=120100.007363283 G_phys=8.3263941606195e-06 G_eff=8.3263941606195e-06
Rh18p8n1 in8n h18p 120179.286309475
* h18 input 9 w=-0.295299170614896 w-  bank=n alpha=1 R=112879.874548662 G_phys=8.85897511844687e-06 G_eff=8.85897511844687e-06
Rh18n9n1 in9 h18p 112511.269115234
* h18 input 10 w=+0.627786354607437 w+  bank=n alpha=1 R=53096.6197157584 G_phys=1.88335906382231e-05 G_eff=1.88335906382231e-05
Rh18p10n1 in10n h18p 53114.2821401044
* h18 input 11 w=+0.158870042328046 w+  bank=n alpha=1 R=209815.09694889 G_phys=4.76610126984139e-06 G_eff=4.76610126984139e-06
Rh18p11n1 in11n h18p 209280.537486337
* h18 input 12 w=+0.503831351799562 w+  bank=n alpha=1 R=66159.704461175 G_phys=1.51149405539869e-05 G_eff=1.51149405539869e-05
Rh18p12n1 in12n h18p 66399.4033069472
* h18 input 13 w=+0.0259448474340262 w+  bank=f alpha=0.001 R=1284.77661771166 G_phys=0.000778345423020786 G_eff=7.78345423020786e-07
Rh18p13f1 tap13n h18p 1282.87698955507
* h18 input 14 w=-0.0445667146819355 w-  bank=n alpha=1 R=747942.350501428 G_phys=1.33700144045806e-06 G_eff=1.33700144045806e-06
Rh18n14n1 in14 h18p 750903.188326422
* h18 input 15 w=-0.425048584977393 w-  bank=n alpha=1 R=78422.4074880905 G_phys=1.27514575493218e-05 G_eff=1.27514575493218e-05
Rh18n15n1 in15 h18p 78673.0323227058
* h18 input 16 w=-0.290071708244206 w-  bank=n alpha=1 R=114914.113944786 G_phys=8.70215124732617e-06 G_eff=8.70215124732617e-06
Rh18n16n1 in16 h18p 114931.605375854
* h18 bias w+  bank=n alpha=1 R=322935.946819115 G_phys=3.09658930772463e-06 G_eff=3.09658930772463e-06
Rh18bpn1 vrefn h18p 321815.229408194
* replica dummy G_tot for h18: same R as weights/biases, dest=0
Rh18dmy000 0 h18rp 10815.1122671213
Rh18dmy001 0 h18rp 114648.115709428
Rh18dmy002 0 h18rp 205899.993535001
Rh18dmy003 0 h18rp 165057.73386697
Rh18dmy004 0 h18rp 198209.936548385
Rh18dmy005 0 h18rp 108516.905337017
Rh18dmy006 0 h18rp 58665.8308770721
Rh18dmy007 0 h18rp 120326.415839087
Rh18dmy008 0 h18rp 112685.696320838
Rh18dmy009 0 h18rp 53241.029743382
Rh18dmy010 0 h18rp 208880.528100642
Rh18dmy011 0 h18rp 66419.9292264892
Rh18dmy012 0 h18rp 1279.03284529231
Rh18dmy013 0 h18rp 747863.180442561
Rh18dmy014 0 h18rp 78456.0445518245
Rh18dmy015 0 h18rp 114620.533507161
Rh18dmy016 0 h18rp 322516.945190154
* feedback TIA h18: Rf=33333.3333333333 A=100000 V(h18sig) = -I(h18p)*Rf*A/(A+1)  (uncompensated)
Eh18tia h18sig 0 0 h18p 100000
Rh18f h18sig h18p 33450.7982720847
* feedback TIA h18r: Rf=33333.3333333333 A=100000 V(h18rep) = -I(h18rp)*Rf*A/(A+1)  (uncompensated)
Eh18rtia h18rep 0 0 h18rp 100000
Rh18rf h18rep h18rp 33199.4266473003
* replica null h18: v(h18lin)=v(h18sig)-v(h18rep) Vos_sig=0 Vos_rep=0
Eh18null h18lin 0 h18sig h18rep 1
* direct bounded ReLU: y=max(0, min(15, v(h18lin)))
Bh18relu h18y 0 V = max(0, min(15, v(h18lin)))

* h19 input 1 w=+0.361917529899694 w+  bank=n alpha=1 R=92102.0138001377 G_phys=1.08575258969908e-05 G_eff=1.08575258969908e-05
Rh19p1n1 in1n h19p 92198.4759250319
* h19 input 2 w=+0.460196491117441 w+  bank=n alpha=1 R=72432.8281000013 G_phys=1.38058947335232e-05 G_eff=1.38058947335232e-05
Rh19p2n1 in2n h19p 72777.0551017379
* h19 input 3 w=+0.284766719035728 w+  bank=n alpha=1 R=117054.877220927 G_phys=8.54300157107185e-06 G_eff=8.54300157107185e-06
Rh19p3n1 in3n h19p 116497.635163399
* h19 input 4 w=-0.664899666016021 w-  bank=n alpha=1 R=50132.8772400529 G_phys=1.99469899804806e-05 G_eff=1.99469899804806e-05
Rh19n4n1 in4 h19p 50074.6369533007
* h19 input 5 w=+0.507213486118456 w+  bank=n alpha=1 R=65718.5470134534 G_phys=1.52164045835537e-05 G_eff=1.52164045835537e-05
Rh19p5n1 in5n h19p 65657.178997338
* h19 input 6 w=+0.130688397719858 w+  bank=n alpha=1 R=255059.622085094 G_phys=3.92065193159573e-06 G_eff=3.92065193159573e-06
Rh19p6n1 in6n h19p 254923.652857555
* h19 input 7 w=+0.0897047942241856 w+  bank=n alpha=1 R=371589.206815729 G_phys=2.69114382672557e-06 G_eff=2.69114382672557e-06
Rh19p7n1 in7n h19p 370978.406183284
* h19 input 8 w=+0.0897866911799249 w+  bank=n alpha=1 R=371250.269892853 G_phys=2.69360073539775e-06 G_eff=2.69360073539775e-06
Rh19p8n1 in8n h19p 369692.539026336
* h19 input 9 w=-0.272382660879323 w-  bank=n alpha=1 R=122376.854773812 G_phys=8.17147982637969e-06 G_eff=8.17147982637969e-06
Rh19n9n1 in9 h19p 122449.631718477
* h19 input 10 w=+0.0908546616405757 w+  bank=n alpha=1 R=366886.329566679 G_phys=2.72563984921727e-06 G_eff=2.72563984921727e-06
Rh19p10n1 in10n h19p 368619.537372056
* h19 input 11 w=-0.0411180740799587 w-  bank=n alpha=1 R=810673.507434053 G_phys=1.23354222239876e-06 G_eff=1.23354222239876e-06
Rh19n11n1 in11 h19p 806769.638048563
* h19 input 12 w=-0.14910928160707 w-  bank=n alpha=1 R=223549.687679219 G_phys=4.47327844821211e-06 G_eff=4.47327844821211e-06
Rh19n12n1 in12 h19p 224322.348529718
* h19 input 13 w=-0.0351824330179761 w-  bank=n alpha=1 R=947442.529523243 G_phys=1.05547299053928e-06 G_eff=1.05547299053928e-06
Rh19n13n1 in13 h19p 951409.404804294
* h19 input 14 w=+0.491588757414346 w+  bank=n alpha=1 R=67807.3548887889 G_phys=1.47476627224304e-05 G_eff=1.47476627224304e-05
Rh19p14n1 in14n h19p 68132.1126015762
* h19 input 15 w=-0.0385925197286318 w-  bank=n alpha=1 R=863725.239184197 G_phys=1.15777559185895e-06 G_eff=1.15777559185895e-06
Rh19n15n1 in15 h19p 864024.806839585
* h19 input 16 w=-0.690622583753164 w-  bank=n alpha=1 R=48265.628894127 G_phys=2.07186775125949e-05 G_eff=2.07186775125949e-05
Rh19n16n1 in16 h19p 48146.0627301689
* h19 bias w+  bank=f alpha=0.001 R=1659.50290630424 G_phys=0.000602590086586248 G_eff=6.02590086586248e-07
Rh19bpf1 taprefn h19p 1662.45289690205
* replica dummy G_tot for h19: same R as weights/biases, dest=0
Rh19dmy000 0 h19rp 92109.8221691138
Rh19dmy001 0 h19rp 72705.4427006513
Rh19dmy002 0 h19rp 117020.901464231
Rh19dmy003 0 h19rp 50132.0078972675
Rh19dmy004 0 h19rp 65823.5577503901
Rh19dmy005 0 h19rp 255975.822438728
Rh19dmy006 0 h19rp 373435.343906886
Rh19dmy007 0 h19rp 370677.753257549
Rh19dmy008 0 h19rp 122121.172012739
Rh19dmy009 0 h19rp 367005.703656001
Rh19dmy010 0 h19rp 814373.810787006
Rh19dmy011 0 h19rp 223767.293132595
Rh19dmy012 0 h19rp 948860.591269107
Rh19dmy013 0 h19rp 67741.0281561715
Rh19dmy014 0 h19rp 866069.867651211
Rh19dmy015 0 h19rp 48256.639663529
Rh19dmy016 0 h19rp 1666.89039643483
* feedback TIA h19: Rf=33333.3333333333 A=100000 V(h19sig) = -I(h19p)*Rf*A/(A+1)  (uncompensated)
Eh19tia h19sig 0 0 h19p 100000
Rh19f h19sig h19p 33290.2269000953
* feedback TIA h19r: Rf=33333.3333333333 A=100000 V(h19rep) = -I(h19rp)*Rf*A/(A+1)  (uncompensated)
Eh19rtia h19rep 0 0 h19rp 100000
Rh19rf h19rep h19rp 33416.6937045271
* replica null h19: v(h19lin)=v(h19sig)-v(h19rep) Vos_sig=0 Vos_rep=0
Eh19null h19lin 0 h19sig h19rep 1
* direct bounded ReLU: y=max(0, min(15, v(h19lin)))
Bh19relu h19y 0 V = max(0, min(15, v(h19lin)))

* h20 input 1 w=-0.0810043123301717 w-  bank=n alpha=1 R=411500.72600416 G_phys=2.43012936990515e-06 G_eff=2.43012936990515e-06
Rh20n1n1 in1 h20p 410820.116600978
* h20 input 2 w=+0.646296718361532 w+  bank=n alpha=1 R=51575.8975503369 G_phys=1.9388901550846e-05 G_eff=1.9388901550846e-05
Rh20p2n1 in2n h20p 51669.3979772168
* h20 input 3 w=-0.000929252010170944 w-  bank=f alpha=0.001 R=35871.1447147705 G_phys=2.78775603051283e-05 G_eff=2.78775603051283e-08
Rh20n3f1 tap3 h20p 35811.357303062
* h20 input 4 w=+0.269987692172837 w+  bank=n alpha=1 R=123462.418101617 G_phys=8.09963076518511e-06 G_eff=8.09963076518511e-06
Rh20p4n1 in4n h20p 123911.841646164
* h20 input 5 w=+0.140155013181344 w+  bank=n alpha=1 R=237831.901811489 G_phys=4.20465039544031e-06 G_eff=4.20465039544031e-06
Rh20p5n1 in5n h20p 238486.099640087
* h20 input 6 w=+0.15481044132605 w+  bank=n alpha=1 R=215317.087451028 G_phys=4.6443132397815e-06 G_eff=4.6443132397815e-06
Rh20p6n1 in6n h20p 214627.786456326
* h20 input 7 w=-0.803119096824844 w-  bank=n alpha=1 R=41504.8446302892 G_phys=2.40935729047453e-05 G_eff=2.40935729047453e-05
Rh20n7n1 in7 h20p 41703.0330823333
* h20 input 8 w=+0.12095822380885 w+  bank=n alpha=1 R=275577.238849092 G_phys=3.62874671426549e-06 G_eff=3.62874671426549e-06
Rh20p8n1 in8n h20p 274590.785178817
* h20 input 9 w=+0.307944073046154 w+  bank=n alpha=1 R=108244.763419549 G_phys=9.23832219138461e-06 G_eff=9.23832219138461e-06
Rh20p9n1 in9n h20p 107975.426606608
* h20 input 10 w=+0.100067069291622 w+  bank=n alpha=1 R=333109.918870425 G_phys=3.00201207874865e-06 G_eff=3.00201207874865e-06
Rh20p10n1 in10n h20p 332135.346855089
* h20 input 11 w=+0.376050768766317 w+  bank=n alpha=1 R=88640.513733525 G_phys=1.12815230629895e-05 G_eff=1.12815230629895e-05
Rh20p11n1 in11n h20p 88441.7576215654
* h20 input 12 w=-0.859853426992325 w-  bank=n alpha=1 R=38766.2970070722 G_phys=2.57956028097698e-05 G_eff=2.57956028097698e-05
Rh20n12n1 in12 h20p 38657.3466671465
* h20 input 13 w=+0.0677970111280841 w+  bank=n alpha=1 R=491663.758898737 G_phys=2.03391033384252e-06 G_eff=2.03391033384252e-06
Rh20p13n1 in13n h20p 493761.612342009
* h20 input 14 w=-0.43012675419833 w-  bank=n alpha=1 R=77496.5356327578 G_phys=1.29038026259499e-05 G_eff=1.29038026259499e-05
Rh20n14n1 in14 h20p 77328.2826184889
* h20 input 15 w=-0.0800571778528839 w-  bank=n alpha=1 R=416369.078043045 G_phys=2.40171533558652e-06 G_eff=2.40171533558652e-06
Rh20n15n1 in15 h20p 415269.524268865
* h20 input 16 w=-0.127529601563162 w-  bank=n alpha=1 R=261377.224775726 G_phys=3.82588804689485e-06 G_eff=3.82588804689485e-06
Rh20n16n1 in16 h20p 262397.30302074
* h20 bias w+  bank=f alpha=0.001 R=1236.06584989005 G_phys=0.000809018386915995 G_eff=8.09018386915995e-07
Rh20bpf1 taprefn h20p 1242.16283018015
* replica dummy G_tot for h20: same R as weights/biases, dest=0
Rh20dmy000 0 h20rp 409688.552359236
Rh20dmy001 0 h20rp 51318.5204999919
Rh20dmy002 0 h20rp 36017.6938018114
Rh20dmy003 0 h20rp 123491.588397662
Rh20dmy004 0 h20rp 237575.787022569
Rh20dmy005 0 h20rp 215325.530103154
Rh20dmy006 0 h20rp 41552.5914936207
Rh20dmy007 0 h20rp 276580.25789463
Rh20dmy008 0 h20rp 107796.802138962
Rh20dmy009 0 h20rp 331498.971261383
Rh20dmy010 0 h20rp 88307.2600153237
Rh20dmy011 0 h20rp 38928.4716592092
Rh20dmy012 0 h20rp 489461.246939641
Rh20dmy013 0 h20rp 77130.0782078935
Rh20dmy014 0 h20rp 417340.943343904
Rh20dmy015 0 h20rp 260652.11795756
Rh20dmy016 0 h20rp 1232.1079340089
* feedback TIA h20: Rf=33333.3333333333 A=100000 V(h20sig) = -I(h20p)*Rf*A/(A+1)  (uncompensated)
Eh20tia h20sig 0 0 h20p 100000
Rh20f h20sig h20p 33488.0662282423
* feedback TIA h20r: Rf=33333.3333333333 A=100000 V(h20rep) = -I(h20rp)*Rf*A/(A+1)  (uncompensated)
Eh20rtia h20rep 0 0 h20rp 100000
Rh20rf h20rep h20rp 33426.0045664102
* replica null h20: v(h20lin)=v(h20sig)-v(h20rep) Vos_sig=0 Vos_rep=0
Eh20null h20lin 0 h20sig h20rep 1
* direct bounded ReLU: y=max(0, min(15, v(h20lin)))
Bh20relu h20y 0 V = max(0, min(15, v(h20lin)))

* h21 input 1 w=-0.00681344895090886 w-  bank=f alpha=0.001 R=4892.28488736045 G_phys=0.000204403468527266 G_eff=2.04403468527266e-07
Rh21n1f1 tap1 h21p 4896.78479825711
* h21 input 2 w=+0.17215275761211 w+  bank=n alpha=1 R=193626.484964238 G_phys=5.1645827283633e-06 G_eff=5.1645827283633e-06
Rh21p2n1 in2n h21p 194025.58423198
* h21 input 3 w=-0.241244992284912 w-  bank=n alpha=1 R=138172.12542993 G_phys=7.23734976854735e-06 G_eff=7.23734976854735e-06
Rh21n3n1 in3 h21p 138606.721784093
* h21 input 4 w=-0.253516997925259 w-  bank=n alpha=1 R=131483.622818698 G_phys=7.60550993775776e-06 G_eff=7.60550993775776e-06
Rh21n4n1 in4 h21p 131432.718579126
* h21 input 5 w=+0.732528033504134 w+  bank=n alpha=1 R=45504.515607245 G_phys=2.1975841005124e-05 G_eff=2.1975841005124e-05
Rh21p5n1 in5n h21p 45491.0704722698
* h21 input 6 w=-0.335745026911547 w-  bank=n alpha=1 R=99281.6889648676 G_phys=1.00723508073464e-05 G_eff=1.00723508073464e-05
Rh21n6n1 in6 h21p 98875.8190633183
* h21 input 7 w=-0.133397447206163 w-  bank=n alpha=1 R=249879.844265815 G_phys=4.00192341618489e-06 G_eff=4.00192341618489e-06
Rh21n7n1 in7 h21p 248800.924157241
* h21 input 8 w=-0.602502751086194 w-  bank=n alpha=1 R=55324.7819586548 G_phys=1.80750825325858e-05 G_eff=1.80750825325858e-05
Rh21n8n1 in8 h21p 55258.9870737889
* h21 input 9 w=-0.464313715662176 w-  bank=n alpha=1 R=71790.5420601142 G_phys=1.39294114698653e-05 G_eff=1.39294114698653e-05
Rh21n9n1 in9 h21p 71843.8490497702
* h21 input 10 w=+0.0220606443883595 w+  bank=f alpha=0.001 R=1510.98638582479 G_phys=0.000661819331650786 G_eff=6.61819331650786e-07
Rh21p10f1 tap10n h21p 1504.00658886588
* h21 input 11 w=+0.293613135845564 w+  bank=n alpha=1 R=113528.072364127 G_phys=8.80839407536691e-06 G_eff=8.80839407536691e-06
Rh21p11n1 in11n h21p 114027.997501523
* h21 input 12 w=+0.585788543436 w+  bank=n alpha=1 R=56903.3548143728 G_phys=1.757365630308e-05 G_eff=1.757365630308e-05
Rh21p12n1 in12n h21p 57180.8465063797
* h21 input 13 w=-0.255400978522459 w-  bank=n alpha=1 R=130513.726009089 G_phys=7.66202935567376e-06 G_eff=7.66202935567376e-06
Rh21n13n1 in13 h21p 131002.488080329
* h21 input 14 w=+0.15251581562556 w+  bank=n alpha=1 R=218556.568685111 G_phys=4.57547446876679e-06 G_eff=4.57547446876679e-06
Rh21p14n1 in14n h21p 217662.272535668
* h21 input 15 w=-0.610279514665944 w-  bank=n alpha=1 R=54619.7808254787 G_phys=1.83083854399783e-05 G_eff=1.83083854399783e-05
Rh21n15n1 in15 h21p 54886.9788997545
* h21 input 16 w=+0.0580238118020399 w+  bank=n alpha=1 R=574476.793200985 G_phys=1.7407143540612e-06 G_eff=1.7407143540612e-06
Rh21p16n1 in16n h21p 574939.126143976
* h21 bias w-  bank=f alpha=0.001 R=5534.66769609038 G_phys=0.00018067932076688 G_eff=1.8067932076688e-07
Rh21bnf1 tapref h21p 5549.82932574534
* replica dummy G_tot for h21: same R as weights/biases, dest=0
Rh21dmy000 0 h21rp 4883.43132116876
Rh21dmy001 0 h21rp 194320.312905006
Rh21dmy002 0 h21rp 138788.840341747
Rh21dmy003 0 h21rp 131054.62249989
Rh21dmy004 0 h21rp 45521.7934292865
Rh21dmy005 0 h21rp 99195.4494330737
Rh21dmy006 0 h21rp 249913.05600865
Rh21dmy007 0 h21rp 55092.0115193949
Rh21dmy008 0 h21rp 71524.7391197785
Rh21dmy009 0 h21rp 1517.26481464634
Rh21dmy010 0 h21rp 113037.665294702
Rh21dmy011 0 h21rp 56983.3903135296
Rh21dmy012 0 h21rp 130385.895643007
Rh21dmy013 0 h21rp 219002.931071667
Rh21dmy014 0 h21rp 54484.3386248957
Rh21dmy015 0 h21rp 574224.741798735
Rh21dmy016 0 h21rp 5551.06555217049
* feedback TIA h21: Rf=33333.3333333333 A=100000 V(h21sig) = -I(h21p)*Rf*A/(A+1)  (uncompensated)
Eh21tia h21sig 0 0 h21p 100000
Rh21f h21sig h21p 33452.1337471234
* feedback TIA h21r: Rf=33333.3333333333 A=100000 V(h21rep) = -I(h21rp)*Rf*A/(A+1)  (uncompensated)
Eh21rtia h21rep 0 0 h21rp 100000
Rh21rf h21rep h21rp 33305.1207671053
* replica null h21: v(h21lin)=v(h21sig)-v(h21rep) Vos_sig=0 Vos_rep=0
Eh21null h21lin 0 h21sig h21rep 1
* direct bounded ReLU: y=max(0, min(15, v(h21lin)))
Bh21relu h21y 0 V = max(0, min(15, v(h21lin)))

* h22 input 1 w=+0.733134048211177 w+  bank=n alpha=1 R=45466.901195853 G_phys=2.19940214463353e-05 G_eff=2.19940214463353e-05
Rh22p1n1 in1n h22p 45561.0657301954
* h22 input 2 w=-0.468945077984231 w-  bank=n alpha=1 R=71081.5293693183 G_phys=1.40683523395269e-05 G_eff=1.40683523395269e-05
Rh22n2n1 in2 h22p 70996.7847970689
* h22 input 3 w=+0.0425168801269381 w+  bank=n alpha=1 R=784002.335867861 G_phys=1.27550640380814e-06 G_eff=1.27550640380814e-06
Rh22p3n1 in3n h22p 780470.202516173
* h22 input 4 w=-0.440513463519883 w-  bank=n alpha=1 R=75669.2725506874 G_phys=1.32154039055965e-05 G_eff=1.32154039055965e-05
Rh22n4n1 in4 h22p 75606.5650556165
* h22 input 5 w=+0.139436850403416 w+  bank=n alpha=1 R=239056.843559604 G_phys=4.18310551210248e-06 G_eff=4.18310551210248e-06
Rh22p5n1 in5n h22p 240216.167185269
* h22 input 6 w=-0.216633688080034 w-  bank=n alpha=1 R=153869.574158838 G_phys=6.49901064240101e-06 G_eff=6.49901064240101e-06
Rh22n6n1 in6 h22p 154510.321535199
* h22 input 7 w=+0.3413541130964 w+  bank=n alpha=1 R=97650.305224006 G_phys=1.0240623392892e-05 G_eff=1.0240623392892e-05
Rh22p7n1 in7n h22p 97635.8026175621
* h22 input 8 w=+0.375494249585175 w+  bank=n alpha=1 R=88771.88763918 G_phys=1.12648274875552e-05 G_eff=1.12648274875552e-05
Rh22p8n1 in8n h22p 89094.4944651772
* h22 input 9 w=-0.0598723775607 w-  bank=n alpha=1 R=556739.763667131 G_phys=1.796171326821e-06 G_eff=1.796171326821e-06
Rh22n9n1 in9 h22p 556836.841694438
* h22 input 10 w=-0.886177024526985 w-  bank=n alpha=1 R=37614.7568835083 G_phys=2.65853107358095e-05 G_eff=2.65853107358095e-05
Rh22n10n1 in10 h22p 37740.8896102961
* h22 input 11 w=-0.158397755226926 w-  bank=n alpha=1 R=210440.692707917 G_phys=4.75193265680777e-06 G_eff=4.75193265680777e-06
Rh22n11n1 in11 h22p 209694.764262546
* h22 input 12 w=+0.00642379373490928 w+  bank=f alpha=0.001 R=5189.04166430307 G_phys=0.000192713812047279 G_eff=1.92713812047279e-07
Rh22p12f1 tap12n h22p 5181.83988247163
* h22 input 13 w=+0.483338726494796 w+  bank=n alpha=1 R=68964.7477144421 G_phys=1.45001617948439e-05 G_eff=1.45001617948439e-05
Rh22p13n1 in13n h22p 69178.1906101722
* h22 input 14 w=+0.995892890290009 w+  bank=n alpha=1 R=33470.8015875347 G_phys=2.98767867087003e-05 G_eff=2.98767867087003e-05
Rh22p14n1 in14n h22p 33313.0224136557
* h22 input 15 w=-0.0635579626600016 w-  bank=n alpha=1 R=524455.661230796 G_phys=1.90673887980005e-06 G_eff=1.90673887980005e-06
Rh22n15n1 in15 h22p 523702.381137053
* h22 input 16 w=+0.143429643183018 w+  bank=n alpha=1 R=232401.981860887 G_phys=4.30288929549054e-06 G_eff=4.30288929549054e-06
Rh22p16n1 in16n h22p 232027.411430616
* h22 bias w+  bank=f alpha=0.001 R=8748.48537925215 G_phys=0.000114305500512305 G_eff=1.14305500512305e-07
Rh22bpf1 taprefn h22p 8730.65147555868
* replica dummy G_tot for h22: same R as weights/biases, dest=0
Rh22dmy000 0 h22rp 45291.2848021844
Rh22dmy001 0 h22rp 70926.0178149544
Rh22dmy002 0 h22rp 780366.505818758
Rh22dmy003 0 h22rp 75482.4041203446
Rh22dmy004 0 h22rp 238162.160067056
Rh22dmy005 0 h22rp 154493.300682589
Rh22dmy006 0 h22rp 97906.9569945399
Rh22dmy007 0 h22rp 89038.7667602064
Rh22dmy008 0 h22rp 554324.314375988
Rh22dmy009 0 h22rp 37555.1141271505
Rh22dmy010 0 h22rp 210054.700002961
Rh22dmy011 0 h22rp 5180.35237599923
Rh22dmy012 0 h22rp 69055.2047817136
Rh22dmy013 0 h22rp 33401.5782592256
Rh22dmy014 0 h22rp 525776.215486531
Rh22dmy015 0 h22rp 231441.987466314
Rh22dmy016 0 h22rp 8713.72704762525
* feedback TIA h22: Rf=33333.3333333333 A=100000 V(h22sig) = -I(h22p)*Rf*A/(A+1)  (uncompensated)
Eh22tia h22sig 0 0 h22p 100000
Rh22f h22sig h22p 33456.417822816
* feedback TIA h22r: Rf=33333.3333333333 A=100000 V(h22rep) = -I(h22rp)*Rf*A/(A+1)  (uncompensated)
Eh22rtia h22rep 0 0 h22rp 100000
Rh22rf h22rep h22rp 33301.8345729034
* replica null h22: v(h22lin)=v(h22sig)-v(h22rep) Vos_sig=0 Vos_rep=0
Eh22null h22lin 0 h22sig h22rep 1
* direct bounded ReLU: y=max(0, min(15, v(h22lin)))
Bh22relu h22y 0 V = max(0, min(15, v(h22lin)))

* h23 input 1 w=-0.311855168471888 w-  bank=n alpha=1 R=106887.224273592 G_phys=9.35565505415663e-06 G_eff=9.35565505415663e-06
Rh23n1n1 in1 h23p 106538.89166143
* h23 input 2 w=-0.519305850985266 w-  bank=n alpha=1 R=64188.2491215741 G_phys=1.5579175529558e-05 G_eff=1.5579175529558e-05
Rh23n2n1 in2 h23p 64471.9029175475
* h23 input 3 w=+0.0590711076347425 w+  bank=n alpha=1 R=564291.659121157 G_phys=1.77213322904228e-06 G_eff=1.77213322904228e-06
Rh23p3n1 in3n h23p 565335.583320471
* h23 input 4 w=-0.153433475387477 w-  bank=n alpha=1 R=217249.418675776 G_phys=4.60300426162431e-06 G_eff=4.60300426162431e-06
Rh23n4n1 in4 h23p 216891.29540857
* h23 input 5 w=+0.565735693190981 w+  bank=n alpha=1 R=58920.3292889647 G_phys=1.69720707957294e-05 G_eff=1.69720707957294e-05
Rh23p5n1 in5n h23p 58924.0046546043
* h23 input 6 w=-0.371646754353268 w-  bank=n alpha=1 R=89690.90391046 G_phys=1.1149402630598e-05 G_eff=1.1149402630598e-05
Rh23n6n1 in6 h23p 89305.5136268281
* h23 input 7 w=-0.111660278324499 w-  bank=n alpha=1 R=298524.540987283 G_phys=3.34980834973497e-06 G_eff=3.34980834973497e-06
Rh23n7n1 in7 h23p 298996.804866905
* h23 input 8 w=+0.496809212320021 w+  bank=n alpha=1 R=67094.8374279775 G_phys=1.49042763696006e-05 G_eff=1.49042763696006e-05
Rh23p8n1 in8n h23p 66987.725220781
* h23 input 9 w=-0.177241184436762 w-  bank=n alpha=1 R=188067.65165365 G_phys=5.31723553310286e-06 G_eff=5.31723553310286e-06
Rh23n9n1 in9 h23p 187883.209787269
* h23 input 10 w=-0.405292848695184 w-  bank=n alpha=1 R=82245.0567303322 G_phys=1.21587854608555e-05 G_eff=1.21587854608555e-05
Rh23n10n1 in10 h23p 82064.3697355937
* h23 input 11 w=-0.16052467280172 w-  bank=n alpha=1 R=207652.398547522 G_phys=4.81574018405159e-06 G_eff=4.81574018405159e-06
Rh23n11n1 in11 h23p 207241.013952234
* h23 input 12 w=+0.846508036935069 w+  bank=n alpha=1 R=39377.4564196963 G_phys=2.53952411080521e-05 G_eff=2.53952411080521e-05
Rh23p12n1 in12n h23p 39344.4527541813
* h23 input 13 w=-0.0538311215013525 w-  bank=n alpha=1 R=619220.488142641 G_phys=1.61493364504058e-06 G_eff=1.61493364504058e-06
Rh23n13n1 in13 h23p 616436.875840037
* h23 input 14 w=+0.31071243911676 w+  bank=n alpha=1 R=107280.331061375 G_phys=9.3213731735028e-06 G_eff=9.3213731735028e-06
Rh23p14n1 in14n h23p 107054.935611502
* h23 input 15 w=+0.331311012578656 w+  bank=n alpha=1 R=100610.399497118 G_phys=9.93933037735967e-06 G_eff=9.93933037735967e-06
Rh23p15n1 in15n h23p 100810.75632817
* h23 input 16 w=-0.486368816876819 w-  bank=n alpha=1 R=68535.0955420638 G_phys=1.45910645063046e-05 G_eff=1.45910645063046e-05
Rh23n16n1 in16 h23p 68546.2697823012
* h23 bias w-  bank=n alpha=1 R=642782.148246781 G_phys=1.55573704516771e-06 G_eff=1.55573704516771e-06
Rh23bnn1 vref h23p 643315.001615974
* replica dummy G_tot for h23: same R as weights/biases, dest=0
Rh23dmy000 0 h23rp 107222.343470051
Rh23dmy001 0 h23rp 63927.7173638961
Rh23dmy002 0 h23rp 561840.51400259
Rh23dmy003 0 h23rp 217001.051600611
Rh23dmy004 0 h23rp 59172.8459746452
Rh23dmy005 0 h23rp 89998.0192723261
Rh23dmy006 0 h23rp 297211.443720943
Rh23dmy007 0 h23rp 66892.2150821547
Rh23dmy008 0 h23rp 187574.523660451
Rh23dmy009 0 h23rp 82313.3891357216
Rh23dmy010 0 h23rp 208545.668895556
Rh23dmy011 0 h23rp 39541.2346872911
Rh23dmy012 0 h23rp 618994.952433202
Rh23dmy013 0 h23rp 107774.288889909
Rh23dmy014 0 h23rp 100738.5432189
Rh23dmy015 0 h23rp 68578.8158199195
Rh23dmy016 0 h23rp 639655.385065679
* feedback TIA h23: Rf=33333.3333333333 A=100000 V(h23sig) = -I(h23p)*Rf*A/(A+1)  (uncompensated)
Eh23tia h23sig 0 0 h23p 100000
Rh23f h23sig h23p 33218.7321330755
* feedback TIA h23r: Rf=33333.3333333333 A=100000 V(h23rep) = -I(h23rp)*Rf*A/(A+1)  (uncompensated)
Eh23rtia h23rep 0 0 h23rp 100000
Rh23rf h23rep h23rp 33466.2722699322
* replica null h23: v(h23lin)=v(h23sig)-v(h23rep) Vos_sig=0 Vos_rep=0
Eh23null h23lin 0 h23sig h23rep 1
* direct bounded ReLU: y=max(0, min(15, v(h23lin)))
Bh23relu h23y 0 V = max(0, min(15, v(h23lin)))

* h24 input 1 w=+0.61389120350986 w+  bank=n alpha=1 R=54298.4378058415 G_phys=1.84167361052958e-05 G_eff=1.84167361052958e-05
Rh24p1n1 in1n h24p 54293.010364359
* h24 input 2 w=-0.0429199313830527 w-  bank=n alpha=1 R=776639.949300928 G_phys=1.28759794149158e-06 G_eff=1.28759794149158e-06
Rh24n2n1 in2 h24p 779392.553606058
* h24 input 3 w=-0.014915873427812 w-  bank=f alpha=0.001 R=2234.75571140073 G_phys=0.000447476202834361 G_eff=4.47476202834361e-07
Rh24n3f1 tap3 h24p 2233.68393163187
* h24 input 4 w=-0.169036355792668 w-  bank=n alpha=1 R=197196.237324345 G_phys=5.07109067378003e-06 G_eff=5.07109067378003e-06
Rh24n4n1 in4 h24p 197315.485324079
* h24 input 5 w=-0.510336523880732 w-  bank=n alpha=1 R=65316.378063357 G_phys=1.5310095716422e-05 G_eff=1.5310095716422e-05
Rh24n5n1 in5 h24p 65474.3099742746
* h24 input 6 w=-0.303361656916169 w-  bank=n alpha=1 R=109879.849919678 G_phys=9.10084970748506e-06 G_eff=9.10084970748506e-06
Rh24n6n1 in6 h24p 110132.106732323
* h24 input 7 w=-0.0292327970624363 w-  bank=f alpha=0.001 R=1140.27177290422 G_phys=0.000876983911873088 G_eff=8.76983911873088e-07
Rh24n7f1 tap7 h24p 1144.08265251014
* h24 input 8 w=-0.329334996951297 w-  bank=n alpha=1 R=101214.063618823 G_phys=9.88004990853891e-06 G_eff=9.88004990853891e-06
Rh24n8n1 in8 h24p 101702.396975216
* h24 input 9 w=+0.0109599477370603 w+  bank=f alpha=0.001 R=3041.37703326988 G_phys=0.000328798432111809 G_eff=3.28798432111809e-07
Rh24p9f1 tap9n h24p 3031.55018696178
* h24 input 10 w=+0.0571459019805778 w+  bank=n alpha=1 R=583302.252271078 G_phys=1.71437705941734e-06 G_eff=1.71437705941734e-06
Rh24p10n1 in10n h24p 584036.62016064
* h24 input 11 w=+0.243568584743939 w+  bank=n alpha=1 R=136853.992760915 G_phys=7.30705754231816e-06 G_eff=7.30705754231816e-06
Rh24p11n1 in11n h24p 136266.039033764
* h24 input 12 w=-0.323004255102081 w-  bank=n alpha=1 R=103197.814910515 G_phys=9.69012765306243e-06 G_eff=9.69012765306243e-06
Rh24n12n1 in12 h24p 103481.527512018
* h24 input 13 w=+0.243938800887145 w+  bank=n alpha=1 R=136646.294939994 G_phys=7.31816402661434e-06 G_eff=7.31816402661434e-06
Rh24p13n1 in13n h24p 137079.50376847
* h24 input 14 w=+0.0840399613598874 w+  bank=n alpha=1 R=396636.704657547 G_phys=2.52119884079662e-06 G_eff=2.52119884079662e-06
Rh24p14n1 in14n h24p 395013.981064117
* h24 input 15 w=-0.352451854106752 w-  bank=n alpha=1 R=94575.5652720646 G_phys=1.05735556232026e-05 G_eff=1.05735556232026e-05
Rh24n15n1 in15 h24p 94772.4587655445
* h24 input 16 w=+0.406056698737055 w+  bank=n alpha=1 R=82090.3421542089 G_phys=1.21817009621116e-05 G_eff=1.21817009621116e-05
Rh24p16n1 in16n h24p 82464.7092521555
* h24 bias w+  bank=f alpha=0.001 R=1792.9894089827 G_phys=0.000557727778530147 G_eff=5.57727778530147e-07
Rh24bpf1 taprefn h24p 1786.32504844865
* replica dummy G_tot for h24: same R as weights/biases, dest=0
Rh24dmy000 0 h24rp 54450.597977316
Rh24dmy001 0 h24rp 778775.862778674
Rh24dmy002 0 h24rp 2225.83232989681
Rh24dmy003 0 h24rp 197829.138924197
Rh24dmy004 0 h24rp 65069.954204246
Rh24dmy005 0 h24rp 109339.938921741
Rh24dmy006 0 h24rp 1136.56078340135
Rh24dmy007 0 h24rp 100719.297415595
Rh24dmy008 0 h24rp 3047.45775328413
Rh24dmy009 0 h24rp 585692.231399601
Rh24dmy010 0 h24rp 136487.68156306
Rh24dmy011 0 h24rp 103594.355918756
Rh24dmy012 0 h24rp 136382.080025771
Rh24dmy013 0 h24rp 397395.631946438
Rh24dmy014 0 h24rp 94372.1054360915
Rh24dmy015 0 h24rp 81993.2064496314
Rh24dmy016 0 h24rp 1787.1305431645
* feedback TIA h24: Rf=33333.3333333333 A=100000 V(h24sig) = -I(h24p)*Rf*A/(A+1)  (uncompensated)
Eh24tia h24sig 0 0 h24p 100000
Rh24f h24sig h24p 33409.0610047726
* feedback TIA h24r: Rf=33333.3333333333 A=100000 V(h24rep) = -I(h24rp)*Rf*A/(A+1)  (uncompensated)
Eh24rtia h24rep 0 0 h24rp 100000
Rh24rf h24rep h24rp 33459.1341204317
* replica null h24: v(h24lin)=v(h24sig)-v(h24rep) Vos_sig=0 Vos_rep=0
Eh24null h24lin 0 h24sig h24rep 1
* direct bounded ReLU: y=max(0, min(15, v(h24lin)))
Bh24relu h24y 0 V = max(0, min(15, v(h24lin)))

* h25 input 1 w=-0.507226781565224 w-  bank=n alpha=1 R=65716.824396519 G_phys=1.52168034469567e-05 G_eff=1.52168034469567e-05
Rh25n1n1 in1 h25p 65825.0023474149
* h25 input 2 w=-0.323616844242374 w-  bank=n alpha=1 R=103002.467042068 G_phys=9.70850532727122e-06 G_eff=9.70850532727122e-06
Rh25n2n1 in2 h25p 103513.637469726
* h25 input 3 w=+0.251581142719107 w+  bank=n alpha=1 R=132495.35705683 G_phys=7.5474342815732e-06 G_eff=7.5474342815732e-06
Rh25p3n1 in3n h25p 132846.062522875
* h25 input 4 w=+0.0279414599016099 w+  bank=f alpha=0.001 R=1192.97035483149 G_phys=0.000838243797048297 G_eff=8.38243797048297e-07
Rh25p4f1 tap4n h25p 1195.79851523697
* h25 input 5 w=+0.310516223746861 w+  bank=n alpha=1 R=107348.121560654 G_phys=9.31548671240582e-06 G_eff=9.31548671240582e-06
Rh25p5n1 in5n h25p 107444.636511653
* h25 input 6 w=-0.583310440311788 w-  bank=n alpha=1 R=57145.0998125736 G_phys=1.74993132093536e-05 G_eff=1.74993132093536e-05
Rh25n6n1 in6 h25p 56888.8667433082
* h25 input 7 w=-0.128366308561082 w-  bank=n alpha=1 R=259673.536670037 G_phys=3.85098925683245e-06 G_eff=3.85098925683245e-06
Rh25n7n1 in7 h25p 258689.474547124
* h25 input 8 w=-0.237966635841971 w-  bank=n alpha=1 R=140075.658990571 G_phys=7.13899907525912e-06 G_eff=7.13899907525912e-06
Rh25n8n1 in8 h25p 140075.345085454
* h25 input 9 w=+0.869293927250567 w+  bank=n alpha=1 R=38345.2964393311 G_phys=2.6078817817517e-05 G_eff=2.6078817817517e-05
Rh25p9n1 in9n h25p 38395.0943040394
* h25 input 10 w=-0.700407093798758 w-  bank=n alpha=1 R=47591.3702594662 G_phys=2.10122128139627e-05 G_eff=2.10122128139627e-05
Rh25n10n1 in10 h25p 47385.2085615664
* h25 input 11 w=+0.176416664646434 w+  bank=n alpha=1 R=188946.624742841 G_phys=5.29249993939301e-06 G_eff=5.29249993939301e-06
Rh25p11n1 in11n h25p 189744.01948935
* h25 input 12 w=+0.165054591787149 w+  bank=n alpha=1 R=201953.383861743 G_phys=4.95163775361447e-06 G_eff=4.95163775361447e-06
Rh25p12n1 in12n h25p 202236.951556761
* h25 input 13 w=+0.414882742059982 w+  bank=n alpha=1 R=80343.9862738715 G_phys=1.24464822617995e-05 G_eff=1.24464822617995e-05
Rh25p13n1 in13n h25p 80634.5420612076
* h25 input 14 w=-0.441614461314228 w-  bank=n alpha=1 R=75480.619982721 G_phys=1.32484338394269e-05 G_eff=1.32484338394269e-05
Rh25n14n1 in14 h25p 75362.1493581938
* h25 input 15 w=+0.152726206779301 w+  bank=n alpha=1 R=218255.491550983 G_phys=4.58178620337902e-06 G_eff=4.58178620337902e-06
Rh25p15n1 in15n h25p 219091.940187165
* h25 input 16 w=-0.0538945970745783 w-  bank=n alpha=1 R=618491.187292992 G_phys=1.61683791223735e-06 G_eff=1.61683791223735e-06
Rh25n16n1 in16 h25p 621475.287764691
* h25 bias w+  bank=n alpha=1 R=396065.019631007 G_phys=2.52483796961329e-06 G_eff=2.52483796961329e-06
Rh25bpn1 vrefn h25p 394887.711739387
* replica dummy G_tot for h25: same R as weights/biases, dest=0
Rh25dmy000 0 h25rp 65908.6345815746
Rh25dmy001 0 h25rp 102857.087502466
Rh25dmy002 0 h25rp 132113.345805519
Rh25dmy003 0 h25rp 1191.38502870007
Rh25dmy004 0 h25rp 107587.282365754
Rh25dmy005 0 h25rp 57157.8743114669
Rh25dmy006 0 h25rp 260230.254006774
Rh25dmy007 0 h25rp 140550.607026782
Rh25dmy008 0 h25rp 38253.4758202805
Rh25dmy009 0 h25rp 47440.741603835
Rh25dmy010 0 h25rp 189506.434960835
Rh25dmy011 0 h25rp 201127.19777399
Rh25dmy012 0 h25rp 80217.3222177769
Rh25dmy013 0 h25rp 75184.124248921
Rh25dmy014 0 h25rp 218223.869099782
Rh25dmy015 0 h25rp 616694.717317643
Rh25dmy016 0 h25rp 396507.132893662
* feedback TIA h25: Rf=33333.3333333333 A=100000 V(h25sig) = -I(h25p)*Rf*A/(A+1)  (uncompensated)
Eh25tia h25sig 0 0 h25p 100000
Rh25f h25sig h25p 33348.3847869913
* feedback TIA h25r: Rf=33333.3333333333 A=100000 V(h25rep) = -I(h25rp)*Rf*A/(A+1)  (uncompensated)
Eh25rtia h25rep 0 0 h25rp 100000
Rh25rf h25rep h25rp 33329.8697826265
* replica null h25: v(h25lin)=v(h25sig)-v(h25rep) Vos_sig=0 Vos_rep=0
Eh25null h25lin 0 h25sig h25rep 1
* direct bounded ReLU: y=max(0, min(15, v(h25lin)))
Bh25relu h25y 0 V = max(0, min(15, v(h25lin)))

* h26 input 1 w=-0.733410608571861 w-  bank=n alpha=1 R=45449.7561717056 G_phys=2.20023182571558e-05 G_eff=2.20023182571558e-05
Rh26n1n1 in1 h26p 45426.5017365791
* h26 input 2 w=+0.207000343516658 w+  bank=n alpha=1 R=161030.328583251 G_phys=6.21001030549975e-06 G_eff=6.21001030549975e-06
Rh26p2n1 in2n h26p 161418.77634921
* h26 input 3 w=-0.0671817515718929 w-  bank=n alpha=1 R=496166.482019488 G_phys=2.01545254715679e-06 G_eff=2.01545254715679e-06
Rh26n3n1 in3 h26p 498012.406052913
* h26 input 4 w=+0.312724326896377 w+  bank=n alpha=1 R=106590.151345592 G_phys=9.38172980689131e-06 G_eff=9.38172980689131e-06
Rh26p4n1 in4n h26p 106869.413039165
* h26 input 5 w=+0.0982363551813243 w+  bank=n alpha=1 R=339317.692231219 G_phys=2.94709065543973e-06 G_eff=2.94709065543973e-06
Rh26p5n1 in5n h26p 338188.990555033
* h26 input 6 w=+0.0433697195878843 w+  bank=n alpha=1 R=768585.401291025 G_phys=1.30109158763653e-06 G_eff=1.30109158763653e-06
Rh26p6n1 in6n h26p 771205.115645284
* h26 input 7 w=-0.253243820471769 w-  bank=n alpha=1 R=131625.45593901 G_phys=7.59731461415306e-06 G_eff=7.59731461415306e-06
Rh26n7n1 in7 h26p 131019.395010185
* h26 input 8 w=+0.388367135047654 w+  bank=n alpha=1 R=85829.4390158508 G_phys=1.16510140514296e-05 G_eff=1.16510140514296e-05
Rh26p8n1 in8n h26p 85781.2766553977
* h26 input 9 w=+0.190562655499984 w+  bank=n alpha=1 R=174920.596304013 G_phys=5.71687966499952e-06 G_eff=5.71687966499952e-06
Rh26p9n1 in9n h26p 174217.1693046
* h26 input 10 w=-0.282938574156096 w-  bank=n alpha=1 R=117811.201363245 G_phys=8.48815722468287e-06 G_eff=8.48815722468287e-06
Rh26n10n1 in10 h26p 117574.946012768
* h26 input 11 w=+0.123317846030254 w+  bank=n alpha=1 R=270304.21310761 G_phys=3.69953538090763e-06 G_eff=3.69953538090763e-06
Rh26p11n1 in11n h26p 271087.931616785
* h26 input 12 w=-0.494646699470857 w-  bank=n alpha=1 R=67388.1648639146 G_phys=1.48394009841257e-05 G_eff=1.48394009841257e-05
Rh26n12n1 in12 h26p 67546.2109907193
* h26 input 13 w=-0.136127092468903 w-  bank=n alpha=1 R=244869.208096457 G_phys=4.08381277406708e-06 G_eff=4.08381277406708e-06
Rh26n13n1 in13 h26p 245015.022556372
* h26 input 14 w=+0.481522107274068 w+  bank=n alpha=1 R=69224.928263493 G_phys=1.4445663218222e-05 G_eff=1.4445663218222e-05
Rh26p14n1 in14n h26p 69363.4607911884
* h26 input 15 w=+0.0644124429905188 w+  bank=n alpha=1 R=517498.355686336 G_phys=1.93237328971556e-06 G_eff=1.93237328971556e-06
Rh26p15n1 in15n h26p 517690.597101864
* h26 input 16 w=+0.0297993400818282 w+  bank=f alpha=0.001 R=1118.5930037981 G_phys=0.000893980202454845 G_eff=8.93980202454845e-07
Rh26p16f1 tap16n h26p 1113.75843910674
* h26 bias w-  bank=f alpha=0.001 R=2150.60895252505 G_phys=0.000464984579751652 G_eff=4.64984579751652e-07
Rh26bnf1 tapref h26p 2145.88338516737
* replica dummy G_tot for h26: same R as weights/biases, dest=0
Rh26dmy000 0 h26rp 45259.1179492049
Rh26dmy001 0 h26rp 161767.101779189
Rh26dmy002 0 h26rp 497940.081181033
Rh26dmy003 0 h26rp 106176.199468115
Rh26dmy004 0 h26rp 338962.132476932
Rh26dmy005 0 h26rp 769259.539222464
Rh26dmy006 0 h26rp 131672.597245707
Rh26dmy007 0 h26rp 85640.9534352032
Rh26dmy008 0 h26rp 175337.452424464
Rh26dmy009 0 h26rp 117287.308943839
Rh26dmy010 0 h26rp 269898.650864825
Rh26dmy011 0 h26rp 67403.4918456578
Rh26dmy012 0 h26rp 244156.762963043
Rh26dmy013 0 h26rp 69395.0513037672
Rh26dmy014 0 h26rp 519006.144707174
Rh26dmy015 0 h26rp 1123.95567963641
Rh26dmy016 0 h26rp 2152.64362539887
* feedback TIA h26: Rf=33333.3333333333 A=100000 V(h26sig) = -I(h26p)*Rf*A/(A+1)  (uncompensated)
Eh26tia h26sig 0 0 h26p 100000
Rh26f h26sig h26p 33292.4040798503
* feedback TIA h26r: Rf=33333.3333333333 A=100000 V(h26rep) = -I(h26rp)*Rf*A/(A+1)  (uncompensated)
Eh26rtia h26rep 0 0 h26rp 100000
Rh26rf h26rep h26rp 33366.0147008029
* replica null h26: v(h26lin)=v(h26sig)-v(h26rep) Vos_sig=0 Vos_rep=0
Eh26null h26lin 0 h26sig h26rep 1
* direct bounded ReLU: y=max(0, min(15, v(h26lin)))
Bh26relu h26y 0 V = max(0, min(15, v(h26lin)))

* h27 input 1 w=-0.473232380174693 w-  bank=n alpha=1 R=70437.5582267393 G_phys=1.41969714052408e-05 G_eff=1.41969714052408e-05
Rh27n1n1 in1 h27p 70253.7331484634
* h27 input 2 w=+0.0192680774504759 w+  bank=f alpha=0.001 R=1729.97713025645 G_phys=0.000578042323514278 G_eff=5.78042323514278e-07
Rh27p2f1 tap2n h27p 1736.6030180343
* h27 input 3 w=-0.33925202928177 w-  bank=n alpha=1 R=98255.3690361212 G_phys=1.01775608784531e-05 G_eff=1.01775608784531e-05
Rh27n3n1 in3 h27p 98067.6182486669
* h27 input 4 w=+0.300608725256371 w+  bank=n alpha=1 R=110886.113850838 G_phys=9.01826175769113e-06 G_eff=9.01826175769113e-06
Rh27p4n1 in4n h27p 110820.401707831
* h27 input 5 w=-0.265937781386581 w-  bank=n alpha=1 R=125342.60141427 G_phys=7.97813344159742e-06 G_eff=7.97813344159742e-06
Rh27n5n1 in5 h27p 125728.89527784
* h27 input 6 w=-0.0714924370091341 w-  bank=n alpha=1 R=466249.784282421 G_phys=2.14477311027402e-06 G_eff=2.14477311027402e-06
Rh27n6n1 in6 h27p 466229.679264752
* h27 input 7 w=+0.32365049129675 w+  bank=n alpha=1 R=102991.758794429 G_phys=9.7095147389025e-06 G_eff=9.7095147389025e-06
Rh27p7n1 in7n h27p 103416.792678786
* h27 input 8 w=+0.264468500812474 w+  bank=n alpha=1 R=126038.954472574 G_phys=7.93405502437422e-06 G_eff=7.93405502437422e-06
Rh27p8n1 in8n h27p 126057.557930984
* h27 input 9 w=-0.251852607935664 w-  bank=n alpha=1 R=132352.543841231 G_phys=7.55557823806993e-06 G_eff=7.55557823806993e-06
Rh27n9n1 in9 h27p 132558.433925003
* h27 input 10 w=-0.0922567674902895 w-  bank=n alpha=1 R=361310.440850226 G_phys=2.76770302470868e-06 G_eff=2.76770302470868e-06
Rh27n10n1 in10 h27p 361914.960105141
* h27 input 11 w=-0.519972660308657 w-  bank=n alpha=1 R=64105.9345573026 G_phys=1.55991798092597e-05 G_eff=1.55991798092597e-05
Rh27n11n1 in11 h27p 64230.4266603999
* h27 input 12 w=+0.109096005067641 w+  bank=n alpha=1 R=305541.282768935 G_phys=3.27288015202924e-06 G_eff=3.27288015202924e-06
Rh27p12n1 in12n h27p 306252.928386075
* h27 input 13 w=+0.0733868764952063 w+  bank=n alpha=1 R=454213.817582367 G_phys=2.20160629485619e-06 G_eff=2.20160629485619e-06
Rh27p13n1 in13n h27p 454832.9706867
* h27 input 14 w=-0.779894486957924 w-  bank=n alpha=1 R=42740.8244201779 G_phys=2.33968346087377e-05 G_eff=2.33968346087377e-05
Rh27n14n1 in14 h27p 42566.540897547
* h27 input 15 w=+0.520337169546291 w+  bank=n alpha=1 R=64061.0267423301 G_phys=1.56101150863887e-05 G_eff=1.56101150863887e-05
Rh27p15n1 in15n h27p 64120.168936146
* h27 input 16 w=+0.00922691889455085 w+  bank=f alpha=0.001 R=3612.61800545565 G_phys=0.000276807566836526 G_eff=2.76807566836526e-07
Rh27p16f1 tap16n h27p 3601.54150849478
* h27 bias w+  bank=f alpha=0.001 R=2714.58121636714 G_phys=0.000368380947297011 G_eff=3.68380947297011e-07
Rh27bpf1 taprefn h27p 2727.7273937107
* replica dummy G_tot for h27: same R as weights/biases, dest=0
Rh27dmy000 0 h27rp 70344.3052431423
Rh27dmy001 0 h27rp 1727.64715627139
Rh27dmy002 0 h27rp 98438.8731820297
Rh27dmy003 0 h27rp 111234.274185766
Rh27dmy004 0 h27rp 124792.8460853
Rh27dmy005 0 h27rp 465783.954789676
Rh27dmy006 0 h27rp 103423.213634668
Rh27dmy007 0 h27rp 126488.027044234
Rh27dmy008 0 h27rp 131772.997599307
Rh27dmy009 0 h27rp 362898.064075649
Rh27dmy010 0 h27rp 64308.3241167391
Rh27dmy011 0 h27rp 305092.423909042
Rh27dmy012 0 h27rp 451980.290036166
Rh27dmy013 0 h27rp 42890.1935151223
Rh27dmy014 0 h27rp 64065.6678875737
Rh27dmy015 0 h27rp 3606.81179714363
Rh27dmy016 0 h27rp 2717.92108159808
* feedback TIA h27: Rf=33333.3333333333 A=100000 V(h27sig) = -I(h27p)*Rf*A/(A+1)  (uncompensated)
Eh27tia h27sig 0 0 h27p 100000
Rh27f h27sig h27p 33470.3718584095
* feedback TIA h27r: Rf=33333.3333333333 A=100000 V(h27rep) = -I(h27rp)*Rf*A/(A+1)  (uncompensated)
Eh27rtia h27rep 0 0 h27rp 100000
Rh27rf h27rep h27rp 33372.512580351
* replica null h27: v(h27lin)=v(h27sig)-v(h27rep) Vos_sig=0 Vos_rep=0
Eh27null h27lin 0 h27sig h27rep 1
* direct bounded ReLU: y=max(0, min(15, v(h27lin)))
Bh27relu h27y 0 V = max(0, min(15, v(h27lin)))

* h28 input 1 w=+0.0928477001370985 w+  bank=n alpha=1 R=359010.86708786 G_phys=2.78543100411296e-06 G_eff=2.78543100411296e-06
Rh28p1n1 in1n h28p 359426.074932155
* h28 input 2 w=+0.628866123797832 w+  bank=n alpha=1 R=53005.4523083984 G_phys=1.8865983713935e-05 G_eff=1.8865983713935e-05
Rh28p2n1 in2n h28p 53165.5458979193
* h28 input 3 w=-0.429442295580587 w-  bank=n alpha=1 R=77620.0520451022 G_phys=1.28832688674176e-05 G_eff=1.28832688674176e-05
Rh28n3n1 in3 h28p 77745.7549896381
* h28 input 4 w=+0.0390774584408687 w+  bank=n alpha=1 R=853006.686291349 G_phys=1.17232375322606e-06 G_eff=1.17232375322606e-06
Rh28p4n1 in4n h28p 851082.167894223
* h28 input 5 w=-0.500231352741198 w-  bank=n alpha=1 R=66635.8339009967 G_phys=1.50069405822359e-05 G_eff=1.50069405822359e-05
Rh28n5n1 in5 h28p 66923.4158280092
* h28 input 6 w=-0.374880121408735 w-  bank=n alpha=1 R=88917.3136416848 G_phys=1.1246403642262e-05 G_eff=1.1246403642262e-05
Rh28n6n1 in6 h28p 88519.5482519814
* h28 input 7 w=-0.575469641796179 w-  bank=n alpha=1 R=57923.7042449224 G_phys=1.72640892538854e-05 G_eff=1.72640892538854e-05
Rh28n7n1 in7 h28p 57746.6914423391
* h28 input 8 w=+0.475130253886277 w+  bank=n alpha=1 R=70156.2004538479 G_phys=1.42539076165883e-05 G_eff=1.42539076165883e-05
Rh28p8n1 in8n h28p 70243.1831134366
* h28 input 9 w=-0.381841652824232 w-  bank=n alpha=1 R=87296.221056002 G_phys=1.1455249584727e-05 G_eff=1.1455249584727e-05
Rh28n9n1 in9 h28p 87389.6985998337
* h28 input 10 w=+0.758567082707225 w+  bank=n alpha=1 R=43942.4990791469 G_phys=2.27570124812167e-05 G_eff=2.27570124812167e-05
Rh28p10n1 in10n h28p 44099.8062374513
* h28 input 11 w=-0.0530277840915393 w-  bank=n alpha=1 R=628601.287125096 G_phys=1.59083352274618e-06 G_eff=1.59083352274618e-06
Rh28n11n1 in11 h28p 629529.271160143
* h28 input 12 w=+0.0401492881024246 w+  bank=n alpha=1 R=830234.729151284 G_phys=1.20447864307274e-06 G_eff=1.20447864307274e-06
Rh28p12n1 in12n h28p 828121.888691449
* h28 input 13 w=-0.344979802042177 w-  bank=n alpha=1 R=96624.0143220269 G_phys=1.03493940612653e-05 G_eff=1.03493940612653e-05
Rh28n13n1 in13 h28p 96781.7894564932
* h28 input 14 w=+0.139059200435423 w+  bank=n alpha=1 R=239706.062086937 G_phys=4.1717760130627e-06 G_eff=4.1717760130627e-06
Rh28p14n1 in14n h28p 238536.618413737
* h28 input 15 w=-0.317012120275182 w-  bank=n alpha=1 R=105148.450804967 G_phys=9.51036360825546e-06 G_eff=9.51036360825546e-06
Rh28n15n1 in15 h28p 104951.00292007
* h28 input 16 w=-0.398313118116402 w-  bank=n alpha=1 R=83686.2554037001 G_phys=1.1949393543492e-05 G_eff=1.1949393543492e-05
Rh28n16n1 in16 h28p 83360.0781754012
* h28 bias w-  bank=n alpha=1 R=393235.409243175 G_phys=2.54300598698528e-06 G_eff=2.54300598698528e-06
Rh28bnn1 vref h28p 391748.58528825
* replica dummy G_tot for h28: same R as weights/biases, dest=0
Rh28dmy000 0 h28rp 360592.407816188
Rh28dmy001 0 h28rp 53117.2676064699
Rh28dmy002 0 h28rp 77362.7129233925
Rh28dmy003 0 h28rp 850648.701204958
Rh28dmy004 0 h28rp 66366.8834161156
Rh28dmy005 0 h28rp 88996.001362935
Rh28dmy006 0 h28rp 57947.0968964766
Rh28dmy007 0 h28rp 69985.7501139642
Rh28dmy008 0 h28rp 87043.5258700848
Rh28dmy009 0 h28rp 43898.0467120384
Rh28dmy010 0 h28rp 629284.309872073
Rh28dmy011 0 h28rp 831226.498683434
Rh28dmy012 0 h28rp 96275.9814034938
Rh28dmy013 0 h28rp 238618.387125775
Rh28dmy014 0 h28rp 104983.661232671
Rh28dmy015 0 h28rp 83877.2038957071
Rh28dmy016 0 h28rp 394960.340817406
* feedback TIA h28: Rf=33333.3333333333 A=100000 V(h28sig) = -I(h28p)*Rf*A/(A+1)  (uncompensated)
Eh28tia h28sig 0 0 h28p 100000
Rh28f h28sig h28p 33355.8407469807
* feedback TIA h28r: Rf=33333.3333333333 A=100000 V(h28rep) = -I(h28rp)*Rf*A/(A+1)  (uncompensated)
Eh28rtia h28rep 0 0 h28rp 100000
Rh28rf h28rep h28rp 33272.6307768492
* replica null h28: v(h28lin)=v(h28sig)-v(h28rep) Vos_sig=0 Vos_rep=0
Eh28null h28lin 0 h28sig h28rep 1
* direct bounded ReLU: y=max(0, min(15, v(h28lin)))
Bh28relu h28y 0 V = max(0, min(15, v(h28lin)))

* h29 input 1 w=+0.125932002984804 w+  bank=n alpha=1 R=264693.108529018 G_phys=3.77796008954411e-06 G_eff=3.77796008954411e-06
Rh29p1n1 in1n h29p 265859.847603516
* h29 input 2 w=-0.650061827874195 w-  bank=n alpha=1 R=51277.1738072033 G_phys=1.95018548362258e-05 G_eff=1.95018548362258e-05
Rh29n2n1 in2 h29p 51175.4306534635
* h29 input 3 w=-0.0394473233812264 w-  bank=n alpha=1 R=845008.747772155 G_phys=1.18341970143679e-06 G_eff=1.18341970143679e-06
Rh29n3n1 in3 h29p 842068.162061567
* h29 input 4 w=-0.231823015010513 w-  bank=n alpha=1 R=143787.85183094 G_phys=6.9546904503154e-06 G_eff=6.9546904503154e-06
Rh29n4n1 in4 h29p 144176.182549134
* h29 input 5 w=+0.19053303604273 w+  bank=n alpha=1 R=174947.788717637 G_phys=5.71599108128189e-06 G_eff=5.71599108128189e-06
Rh29p5n1 in5n h29p 174401.137214627
* h29 input 6 w=+0.447719174196915 w+  bank=n alpha=1 R=74451.4312864178 G_phys=1.34315752259074e-05 G_eff=1.34315752259074e-05
Rh29p6n1 in6n h29p 74370.120755507
* h29 input 7 w=+0.0126486175371352 w+  bank=f alpha=0.001 R=2635.33411738237 G_phys=0.000379458526114055 G_eff=3.79458526114055e-07
Rh29p7f1 tap7n h29p 2641.17099049491
* h29 input 8 w=+0.108364236263017 w+  bank=n alpha=1 R=307604.561088107 G_phys=3.25092708789052e-06 G_eff=3.25092708789052e-06
Rh29p8n1 in8n h29p 306463.594013064
* h29 input 9 w=+0.430118110319429 w+  bank=n alpha=1 R=77498.0930437414 G_phys=1.29035433095829e-05 G_eff=1.29035433095829e-05
Rh29p9n1 in9n h29p 77589.8731710306
* h29 input 10 w=+0.849664650654267 w+  bank=n alpha=1 R=39231.1640924048 G_phys=2.5489939519628e-05 G_eff=2.5489939519628e-05
Rh29p10n1 in10n h29p 39252.7802261045
* h29 input 11 w=+0.430581993177771 w+  bank=n alpha=1 R=77414.6013104902 G_phys=1.29174597953331e-05 G_eff=1.29174597953331e-05
Rh29p11n1 in11n h29p 77484.2580860629
* h29 input 12 w=-0.974573192285427 w-  bank=n alpha=1 R=34203.006605553 G_phys=2.92371957685628e-05 G_eff=2.92371957685628e-05
Rh29n12n1 in12 h29p 34073.5078737045
* h29 input 13 w=+0.16029064712382 w+  bank=n alpha=1 R=207955.572776396 G_phys=4.80871941371461e-06 G_eff=4.80871941371461e-06
Rh29p13n1 in13n h29p 208660.640600389
* h29 input 14 w=+0.466636118473806 w+  bank=n alpha=1 R=71433.2474784727 G_phys=1.39990835542142e-05 G_eff=1.39990835542142e-05
Rh29p14n1 in14n h29p 71786.5616923061
* h29 input 15 w=-0.0331745755104183 w-  bank=f alpha=0.001 R=1004.78552688233 G_phys=0.000995237265312548 G_eff=9.95237265312548e-07
Rh29n15f1 tap15 h29p 1007.91996782285
* h29 input 16 w=-0.589046477086867 w-  bank=n alpha=1 R=56588.6303202822 G_phys=1.7671394312606e-05 G_eff=1.7671394312606e-05
Rh29n16n1 in16 h29p 56832.975536108
* h29 bias w-  bank=n alpha=1 R=500623.285959049 G_phys=1.99750996017752e-06 G_eff=1.99750996017752e-06
Rh29bnn1 vref h29p 501080.024605721
* replica dummy G_tot for h29: same R as weights/biases, dest=0
Rh29dmy000 0 h29rp 265074.492314564
Rh29dmy001 0 h29rp 51243.6580142999
Rh29dmy002 0 h29rp 845559.217364389
Rh29dmy003 0 h29rp 144195.060894677
Rh29dmy004 0 h29rp 174264.083460691
Rh29dmy005 0 h29rp 74415.3372261007
Rh29dmy006 0 h29rp 2628.64404565376
Rh29dmy007 0 h29rp 308858.768523683
Rh29dmy008 0 h29rp 77601.8314803367
Rh29dmy009 0 h29rp 39271.4901901851
Rh29dmy010 0 h29rp 77073.3578330413
Rh29dmy011 0 h29rp 34324.0695055223
Rh29dmy012 0 h29rp 207889.934800011
Rh29dmy013 0 h29rp 71368.0529035688
Rh29dmy014 0 h29rp 1007.17119336429
Rh29dmy015 0 h29rp 56856.7409496863
Rh29dmy016 0 h29rp 502896.972451471
* feedback TIA h29: Rf=33333.3333333333 A=100000 V(h29sig) = -I(h29p)*Rf*A/(A+1)  (uncompensated)
Eh29tia h29sig 0 0 h29p 100000
Rh29f h29sig h29p 33232.7804102695
* feedback TIA h29r: Rf=33333.3333333333 A=100000 V(h29rep) = -I(h29rp)*Rf*A/(A+1)  (uncompensated)
Eh29rtia h29rep 0 0 h29rp 100000
Rh29rf h29rep h29rp 33182.0271264232
* replica null h29: v(h29lin)=v(h29sig)-v(h29rep) Vos_sig=0 Vos_rep=0
Eh29null h29lin 0 h29sig h29rep 1
* direct bounded ReLU: y=max(0, min(15, v(h29lin)))
Bh29relu h29y 0 V = max(0, min(15, v(h29lin)))

* h30 input 1 w=-0.507901838841989 w-  bank=n alpha=1 R=65629.4795256756 G_phys=1.52370551652597e-05 G_eff=1.52370551652597e-05
Rh30n1n1 in1 h30p 65577.9184881096
* h30 input 2 w=-0.0392944483392576 w-  bank=n alpha=1 R=848296.254105474 G_phys=1.17883345017773e-06 G_eff=1.17883345017773e-06
Rh30n2n1 in2 h30p 851535.582165885
* h30 input 3 w=+0.205776196534446 w+  bank=n alpha=1 R=161988.285791615 G_phys=6.17328589603337e-06 G_eff=6.17328589603337e-06
Rh30p3n1 in3n h30p 162614.112217675
* h30 input 4 w=+0.172383143604269 w+  bank=n alpha=1 R=193367.707749053 G_phys=5.17149430812806e-06 G_eff=5.17149430812806e-06
Rh30p4n1 in4n h30p 193189.775385532
* h30 input 5 w=-0.0737740397875715 w-  bank=n alpha=1 R=451830.121128177 G_phys=2.21322119362714e-06 G_eff=2.21322119362714e-06
Rh30n5n1 in5 h30p 452868.896906367
* h30 input 6 w=-0.113337981854853 w-  bank=n alpha=1 R=294105.583916448 G_phys=3.40013945564559e-06 G_eff=3.40013945564559e-06
Rh30n6n1 in6 h30p 294182.75300066
* h30 input 7 w=-0.199472534274412 w-  bank=n alpha=1 R=167107.383753781 G_phys=5.98417602823235e-06 G_eff=5.98417602823235e-06
Rh30n7n1 in7 h30p 167426.482533801
* h30 input 8 w=+0.667476408484971 w+  bank=n alpha=1 R=49939.3430383448 G_phys=2.00242922545491e-05 G_eff=2.00242922545491e-05
Rh30p8n1 in8n h30p 50054.6173758815
* h30 input 9 w=+0.0327305955718174 w+  bank=f alpha=0.001 R=1018.41511744549 G_phys=0.000981917867154523 G_eff=9.81917867154523e-07
Rh30p9f1 tap9n h30p 1023.24044152647
* h30 input 10 w=-0.112124407230259 w-  bank=n alpha=1 R=297288.825481859 G_phys=3.36373221690776e-06 G_eff=3.36373221690776e-06
Rh30n10n1 in10 h30p 298709.355533371
* h30 input 11 w=+0.283868618501327 w+  bank=n alpha=1 R=117425.214204076 G_phys=8.51605855503981e-06 G_eff=8.51605855503981e-06
Rh30p11n1 in11n h30p 117525.767539063
* h30 input 12 w=-0.058671072800694 w-  bank=n alpha=1 R=568139.148342606 G_phys=1.76013218402082e-06 G_eff=1.76013218402082e-06
Rh30n12n1 in12 h30p 566033.459159719
* h30 input 13 w=-0.679698898194489 w-  bank=n alpha=1 R=49041.323182777 G_phys=2.03909669458347e-05 G_eff=2.03909669458347e-05
Rh30n13n1 in13 h30p 48901.0721329373
* h30 input 14 w=+0.213421552049108 w+  bank=n alpha=1 R=156185.413390975 G_phys=6.40264656147323e-06 G_eff=6.40264656147323e-06
Rh30p14n1 in14n h30p 155491.227405782
* h30 input 15 w=+0.353043376484901 w+  bank=n alpha=1 R=94417.1043944198 G_phys=1.0591301294547e-05 G_eff=1.0591301294547e-05
Rh30p15n1 in15n h30p 94486.4590117739
* h30 input 16 w=-0.0402310971621178 w-  bank=n alpha=1 R=828546.464915216 G_phys=1.20693291486354e-06 G_eff=1.20693291486354e-06
Rh30n16n1 in16 h30p 830664.770782964
* h30 bias w+  bank=f alpha=0.001 R=1174.50422834716 G_phys=0.000851423073552715 G_eff=8.51423073552714e-07
Rh30bpf1 taprefn h30p 1170.02414977541
* replica dummy G_tot for h30: same R as weights/biases, dest=0
Rh30dmy000 0 h30rp 65611.7586043392
Rh30dmy001 0 h30rp 845969.074572655
Rh30dmy002 0 h30rp 161257.222582081
Rh30dmy003 0 h30rp 193430.943794812
Rh30dmy004 0 h30rp 450821.944764391
Rh30dmy005 0 h30rp 292889.183543639
Rh30dmy006 0 h30rp 167548.89019949
Rh30dmy007 0 h30rp 50016.2147013808
Rh30dmy008 0 h30rp 1018.90363345157
Rh30dmy009 0 h30rp 296019.487331043
Rh30dmy010 0 h30rp 117589.531998691
Rh30dmy011 0 h30rp 565633.600192152
Rh30dmy012 0 h30rp 48808.7618220339
Rh30dmy013 0 h30rp 156082.932001923
Rh30dmy014 0 h30rp 94856.2633044057
Rh30dmy015 0 h30rp 830860.998123106
Rh30dmy016 0 h30rp 1171.49716499717
* feedback TIA h30: Rf=33333.3333333333 A=100000 V(h30sig) = -I(h30p)*Rf*A/(A+1)  (uncompensated)
Eh30tia h30sig 0 0 h30p 100000
Rh30f h30sig h30p 33480.2529680226
* feedback TIA h30r: Rf=33333.3333333333 A=100000 V(h30rep) = -I(h30rp)*Rf*A/(A+1)  (uncompensated)
Eh30rtia h30rep 0 0 h30rp 100000
Rh30rf h30rep h30rp 33386.9540056878
* replica null h30: v(h30lin)=v(h30sig)-v(h30rep) Vos_sig=0 Vos_rep=0
Eh30null h30lin 0 h30sig h30rep 1
* direct bounded ReLU: y=max(0, min(15, v(h30lin)))
Bh30relu h30y 0 V = max(0, min(15, v(h30lin)))

* h31 input 1 w=+0.786523739677983 w+  bank=n alpha=1 R=42380.5813502598 G_phys=2.35957121903395e-05 G_eff=2.35957121903395e-05
Rh31p1n1 in1n h31p 42259.8318559611
* h31 input 2 w=+0.575951127580127 w+  bank=n alpha=1 R=57875.2809693839 G_phys=1.72785338274038e-05 G_eff=1.72785338274038e-05
Rh31p2n1 in2n h31p 58084.9165240815
* h31 input 3 w=+0.131568206508636 w+  bank=n alpha=1 R=253354.014756941 G_phys=3.94704619525908e-06 G_eff=3.94704619525908e-06
Rh31p3n1 in3n h31p 253687.170149086
* h31 input 4 w=+0.217046331869883 w+  bank=n alpha=1 R=153577.040653773 G_phys=6.51138995609649e-06 G_eff=6.51138995609649e-06
Rh31p4n1 in4n h31p 153554.024918382
* h31 input 5 w=+0.0670548023806797 w+  bank=n alpha=1 R=497105.832093803 G_phys=2.01164407142039e-06 G_eff=2.01164407142039e-06
Rh31p5n1 in5n h31p 496134.483605478
* h31 input 6 w=-0.0924541633789126 w-  bank=n alpha=1 R=360539.018634786 G_phys=2.77362490136738e-06 G_eff=2.77362490136738e-06
Rh31n6n1 in6 h31p 361574.736802628
* h31 input 7 w=+0.532768880755568 w+  bank=n alpha=1 R=62566.2168669842 G_phys=1.59830664226671e-05 G_eff=1.59830664226671e-05
Rh31p7n1 in7n h31p 62423.2799477375
* h31 input 8 w=-0.213038536483163 w-  bank=n alpha=1 R=156466.214439883 G_phys=6.39115609449489e-06 G_eff=6.39115609449489e-06
Rh31n8n1 in8 h31p 157132.536679312
* h31 input 9 w=+0.217996086164886 w+  bank=n alpha=1 R=152907.943989971 G_phys=6.53988258494657e-06 G_eff=6.53988258494657e-06
Rh31p9n1 in9n h31p 153185.105721917
* h31 input 10 w=-0.173189336412784 w-  bank=n alpha=1 R=192467.58503587 G_phys=5.19568009238351e-06 G_eff=5.19568009238351e-06
Rh31n10n1 in10 h31p 193386.165531344
* h31 input 11 w=+0.227561810267943 w+  bank=n alpha=1 R=146480.348763639 G_phys=6.8268543080383e-06 G_eff=6.8268543080383e-06
Rh31p11n1 in11n h31p 146813.828138511
* h31 input 12 w=+0.400647928830177 w+  bank=n alpha=1 R=83198.5664587384 G_phys=1.20194378649053e-05 G_eff=1.20194378649053e-05
Rh31p12n1 in12n h31p 83308.4040641306
* h31 input 13 w=+0.0924404555732517 w+  bank=n alpha=1 R=360592.482226781 G_phys=2.77321366719755e-06 G_eff=2.77321366719755e-06
Rh31p13n1 in13n h31p 359956.381727603
* h31 input 14 w=+0.340918137300815 w+  bank=n alpha=1 R=97775.1832074605 G_phys=1.02275441190244e-05 G_eff=1.02275441190244e-05
Rh31p14n1 in14n h31p 97326.0614443104
* h31 input 15 w=+0.631456773568415 w+  bank=n alpha=1 R=52787.9891840638 G_phys=1.89437032070525e-05 G_eff=1.89437032070525e-05
Rh31p15n1 in15n h31p 52540.8439355105
* h31 input 16 w=+0.19173700817347 w+  bank=n alpha=1 R=173849.240951834 G_phys=5.75211024520409e-06 G_eff=5.75211024520409e-06
Rh31p16n1 in16n h31p 173902.52104031
* h31 bias w-  bank=n alpha=1 R=620531.31238591 G_phys=1.61152222303666e-06 G_eff=1.61152222303666e-06
Rh31bnn1 vref h31p 618693.97461529
* replica dummy G_tot for h31: same R as weights/biases, dest=0
Rh31dmy000 0 h31rp 42184.7833823132
Rh31dmy001 0 h31rp 57998.0895701718
Rh31dmy002 0 h31rp 253085.662315517
Rh31dmy003 0 h31rp 152889.313829064
Rh31dmy004 0 h31rp 497858.708142809
Rh31dmy005 0 h31rp 359478.57283924
Rh31dmy006 0 h31rp 62878.7818299388
Rh31dmy007 0 h31rp 156941.91954727
Rh31dmy008 0 h31rp 153449.76677919
Rh31dmy009 0 h31rp 192921.863695309
Rh31dmy010 0 h31rp 146685.952969141
Rh31dmy011 0 h31rp 83407.5630118817
Rh31dmy012 0 h31rp 360093.674160386
Rh31dmy013 0 h31rp 98029.8280231943
Rh31dmy014 0 h31rp 52700.7938709282
Rh31dmy015 0 h31rp 173044.148433519
Rh31dmy016 0 h31rp 621196.732668314
* feedback TIA h31: Rf=33333.3333333333 A=100000 V(h31sig) = -I(h31p)*Rf*A/(A+1)  (uncompensated)
Eh31tia h31sig 0 0 h31p 100000
Rh31f h31sig h31p 33355.5485785259
* feedback TIA h31r: Rf=33333.3333333333 A=100000 V(h31rep) = -I(h31rp)*Rf*A/(A+1)  (uncompensated)
Eh31rtia h31rep 0 0 h31rp 100000
Rh31rf h31rep h31rp 33340.8297562364
* replica null h31: v(h31lin)=v(h31sig)-v(h31rep) Vos_sig=0 Vos_rep=0
Eh31null h31lin 0 h31sig h31rep 1
* direct bounded ReLU: y=max(0, min(15, v(h31lin)))
Bh31relu h31y 0 V = max(0, min(15, v(h31lin)))

* h32 input 1 w=+0.018363806586789 w+  bank=f alpha=0.001 R=1815.16469234181 G_phys=0.000550914197603669 G_eff=5.50914197603669e-07
Rh32p1f1 tap1n h32p 1808.93466683607
* h32 input 2 w=+0.274234487929714 w+  bank=n alpha=1 R=121550.478880237 G_phys=8.22703463789143e-06 G_eff=8.22703463789143e-06
Rh32p2n1 in2n h32p 121556.395345769
* h32 input 3 w=+0.286642259390481 w+  bank=n alpha=1 R=116288.970803585 G_phys=8.59926778171444e-06 G_eff=8.59926778171444e-06
Rh32p3n1 in3n h32p 116811.021231447
* h32 input 4 w=-0.106012181190002 w-  bank=n alpha=1 R=314429.275571559 G_phys=3.18036543570007e-06 G_eff=3.18036543570007e-06
Rh32n4n1 in4 h32p 313772.924443953
* h32 input 5 w=-0.539184466126997 w-  bank=n alpha=1 R=61821.7612476287 G_phys=1.61755339838099e-05 G_eff=1.61755339838099e-05
Rh32n5n1 in5 h32p 61559.4210017416
* h32 input 6 w=-0.141969883388357 w-  bank=n alpha=1 R=234791.580705539 G_phys=4.25909650165071e-06 G_eff=4.25909650165071e-06
Rh32n6n1 in6 h32p 234862.901733217
* h32 input 7 w=-0.343812430494534 w-  bank=n alpha=1 R=96952.0889206571 G_phys=1.0314372914836e-05 G_eff=1.0314372914836e-05
Rh32n7n1 in7 h32p 96826.8239892126
* h32 input 8 w=-0.197072814561277 w-  bank=n alpha=1 R=169142.219882229 G_phys=5.91218443683832e-06 G_eff=5.91218443683832e-06
Rh32n8n1 in8 h32p 168634.884436878
* h32 input 9 w=-0.180430465047897 w-  bank=n alpha=1 R=184743.376482927 G_phys=5.41291395143692e-06 G_eff=5.41291395143692e-06
Rh32n9n1 in9 h32p 185336.839327251
* h32 input 10 w=+0.113268490856906 w+  bank=n alpha=1 R=294286.019714378 G_phys=3.39805472570718e-06 G_eff=3.39805472570718e-06
Rh32p10n1 in10n h32p 293618.89588209
* h32 input 11 w=+0.0737822862098911 w+  bank=n alpha=1 R=451779.621446112 G_phys=2.21346858629673e-06 G_eff=2.21346858629673e-06
Rh32p11n1 in11n h32p 452336.046330174
* h32 input 12 w=+0.131260687318804 w+  bank=n alpha=1 R=253947.575730529 G_phys=3.93782061956414e-06 G_eff=3.93782061956414e-06
Rh32p12n1 in12n h32p 253668.185796949
* h32 input 13 w=-0.105796213840622 w-  bank=n alpha=1 R=315071.136511074 G_phys=3.17388641521865e-06 G_eff=3.17388641521865e-06
Rh32n13n1 in13 h32p 313509.883695288
* h32 input 14 w=-0.365435123738796 w-  bank=n alpha=1 R=91215.4611529876 G_phys=1.09630537121639e-05 G_eff=1.09630537121639e-05
Rh32n14n1 in14 h32p 91199.4062560916
* h32 input 15 w=-0.0205558893905 w-  bank=f alpha=0.001 R=1621.59528591055 G_phys=0.000616676681714999 G_eff=6.16676681714999e-07
Rh32n15f1 tap15 h32p 1613.74648358676
* h32 input 16 w=-0.212152037098157 w-  bank=n alpha=1 R=157120.024814614 G_phys=6.36456111294471e-06 G_eff=6.36456111294471e-06
Rh32n16n1 in16 h32p 157353.539676186
* h32 bias w+  bank=f alpha=0.001 R=4134.96891231251 G_phys=0.000241839786756884 G_eff=2.41839786756884e-07
Rh32bpf1 taprefn h32p 4118.08767826094
* replica dummy G_tot for h32: same R as weights/biases, dest=0
Rh32dmy000 0 h32rp 1818.89796355521
Rh32dmy001 0 h32rp 121737.307342653
Rh32dmy002 0 h32rp 116426.544136764
Rh32dmy003 0 h32rp 314483.756325581
Rh32dmy004 0 h32rp 61827.7911957828
Rh32dmy005 0 h32rp 235519.293626927
Rh32dmy006 0 h32rp 96947.2582858189
Rh32dmy007 0 h32rp 169690.662605012
Rh32dmy008 0 h32rp 184547.446143752
Rh32dmy009 0 h32rp 293790.531131008
Rh32dmy010 0 h32rp 453708.77597513
Rh32dmy011 0 h32rp 253631.562776205
Rh32dmy012 0 h32rp 315776.577262276
Rh32dmy013 0 h32rp 91109.1929748327
Rh32dmy014 0 h32rp 1619.44228570951
Rh32dmy015 0 h32rp 157640.995303051
Rh32dmy016 0 h32rp 4133.41417414335
* feedback TIA h32: Rf=33333.3333333333 A=100000 V(h32sig) = -I(h32p)*Rf*A/(A+1)  (uncompensated)
Eh32tia h32sig 0 0 h32p 100000
Rh32f h32sig h32p 33475.0992580219
* feedback TIA h32r: Rf=33333.3333333333 A=100000 V(h32rep) = -I(h32rp)*Rf*A/(A+1)  (uncompensated)
Eh32rtia h32rep 0 0 h32rp 100000
Rh32rf h32rep h32rp 33338.1094203546
* replica null h32: v(h32lin)=v(h32sig)-v(h32rep) Vos_sig=0 Vos_rep=0
Eh32null h32lin 0 h32sig h32rep 1
* direct bounded ReLU: y=max(0, min(15, v(h32lin)))
Bh32relu h32y 0 V = max(0, min(15, v(h32lin)))

* passive invert h1y -> h1yn: R2/R1=1.0000200002 closed-loop -1 at A=100000
Rinvh1ia h1y invh1m 9971.27842700087
Rinvh1ib h1yn invh1m 9962.17382239806
Einvh1amp h1yn 0 0 invh1m 100000
* load-compensated divider h1y->htap1: G_load=0.000717504633896169 Ra=581657.819306003 Rb=1000 target beta=0.001 (no tap buffer)
Rdivh1a h1y htap1 581291.214097609
Rdivh1b htap1 0 1002.87743102829
* load-compensated divider h1yn->htap1n: G_load=6.00022240247825e-05 Ra=942450.852798063 Rb=1000 target beta=0.001 (no tap buffer)
Rdivh1na h1yn htap1n 946887.866405095
Rdivh1nb htap1n 0 996.794927374581
* passive invert h2y -> h2yn: R2/R1=1.0000200002 closed-loop -1 at A=100000
Rinvh2ia h2y invh2m 10024.9614049926
Rinvh2ib h2yn invh2m 9969.09818328522
Einvh2amp h2yn 0 0 invh2m 100000
* load-compensated divider h2y->htap2: G_load=0.000712380497940648 Ra=583398.375069923 Rb=1000 target beta=0.001 (no tap buffer)
Rdivh2a h2y htap2 582594.005433251
Rdivh2b htap2 0 999.258281653568
* load-compensated divider h2yn->htap2n: G_load=0.00034407671071968 Ra=743261.148736882 Rb=1000 target beta=0.001 (no tap buffer)
Rdivh2na h2yn htap2n 744017.796340153
Rdivh2nb htap2n 0 997.542609313129
* passive invert h3y -> h3yn: R2/R1=1.0000200002 closed-loop -1 at A=100000
Rinvh3ia h3y invh3m 10014.9988472806
Rinvh3ib h3yn invh3m 10030.9735793331
Einvh3amp h3yn 0 0 invh3m 100000
* load-compensated divider h3yn->htap3n: G_load=0.000928920570217644 Ra=517906.240114014 Rb=1000 target beta=0.001 (no tap buffer)
Rdivh3na h3yn htap3n 515879.404603456
Rdivh3nb htap3n 0 999.007571715457
* passive invert h4y -> h4yn: R2/R1=1.0000200002 closed-loop -1 at A=100000
Rinvh4ia h4y invh4m 10023.7962961805
Rinvh4ib h4yn invh4m 9963.04316350513
Einvh4amp h4yn 0 0 invh4m 100000
* load-compensated divider h4y->htap4: G_load=0.0014954055609593 Ra=400335.727237843 Rb=1000 target beta=0.001 (no tap buffer)
Rdivh4a h4y htap4 398515.110674381
Rdivh4b htap4 0 995.538833922691
* load-compensated divider h4yn->htap4n: G_load=0.000814282747184905 Ra=550630.821766937 Rb=1000 target beta=0.001 (no tap buffer)
Rdivh4na h4yn htap4n 551949.149434922
Rdivh4nb htap4n 0 1004.77401447443
* passive invert h5y -> h5yn: R2/R1=1.0000200002 closed-loop -1 at A=100000
Rinvh5ia h5y invh5m 10037.5454662824
Rinvh5ib h5yn invh5m 9984.38546015922
Einvh5amp h5yn 0 0 invh5m 100000
* load-compensated divider h5yn->htap5n: G_load=0.00063839892598525 Ra=609741.610639333 Rb=1000 target beta=0.001 (no tap buffer)
Rdivh5na h5yn htap5n 610056.508828064
Rdivh5nb htap5n 0 1000.63157965849
* passive invert h6y -> h6yn: R2/R1=1.0000200002 closed-loop -1 at A=100000
Rinvh6ia h6y invh6m 10042.1462326937
Rinvh6ib h6yn invh6m 9951.76526840656
Einvh6amp h6yn 0 0 invh6m 100000
* load-compensated divider h6y->htap6: G_load=0.000176838972885357 Ra=848884.191480051 Rb=1000 target beta=0.001 (no tap buffer)
Rdivh6a h6y htap6 846032.215472815
Rdivh6b htap6 0 997.762209908427
* load-compensated divider h6yn->htap6n: G_load=0.00101622287932375 Ra=495480.93628174 Rb=1000 target beta=0.001 (no tap buffer)
Rdivh6na h6yn htap6n 494457.450330815
Rdivh6nb htap6n 0 1003.48138958551
* passive invert h7y -> h7yn: R2/R1=1.0000200002 closed-loop -1 at A=100000
Rinvh7ia h7y invh7m 9964.47694995994
Rinvh7ib h7yn invh7m 9964.55730217428
Einvh7amp h7yn 0 0 invh7m 100000
* load-compensated divider h7y->htap7: G_load=0.000978460874628438 Ra=504937.961023675 Rb=1000 target beta=0.001 (no tap buffer)
Rdivh7a h7y htap7 504152.643980382
Rdivh7b htap7 0 999.28452465723
* passive invert h8y -> h8yn: R2/R1=1.0000200002 closed-loop -1 at A=100000
Rinvh8ia h8y invh8m 9977.5884321179
Rinvh8ib h8yn invh8m 9951.05813093361
Einvh8amp h8yn 0 0 invh8m 100000
* load-compensated divider h8y->htap8: G_load=0.000501432225011038 Ra=665364.698691381 Rb=1000 target beta=0.001 (no tap buffer)
Rdivh8a h8y htap8 663324.746210895
Rdivh8b htap8 0 996.473574664788
* load-compensated divider h8yn->htap8n: G_load=0.00121560414490552 Ra=450892.819593727 Rb=1000 target beta=0.001 (no tap buffer)
Rdivh8na h8yn htap8n 450323.699360635
Rdivh8nb htap8n 0 1002.97563525407
* passive invert h9y -> h9yn: R2/R1=1.0000200002 closed-loop -1 at A=100000
Rinvh9ia h9y invh9m 10034.9956060872
Rinvh9ib h9yn invh9m 10007.5591375579
Einvh9amp h9yn 0 0 invh9m 100000
* load-compensated divider h9y->htap9: G_load=0.00094144317858438 Ra=514565.664872268 Rb=1000 target beta=0.001 (no tap buffer)
Rdivh9a h9y htap9 513699.4258669
Rdivh9b htap9 0 1003.9454356241
* passive invert h10y -> h10yn: R2/R1=1.0000200002 closed-loop -1 at A=100000
Rinvh10ia h10y invh10m 9994.1325094271
Rinvh10ib h10yn invh10m 9957.96221181064
Einvh10amp h10yn 0 0 invh10m 100000
* passive invert h11y -> h11yn: R2/R1=1.0000200002 closed-loop -1 at A=100000
Rinvh11ia h11y invh11m 9999.38452598435
Rinvh11ib h11yn invh11m 10008.9063026836
Einvh11amp h11yn 0 0 invh11m 100000
* load-compensated divider h11y->htap11: G_load=0.000344332712001725 Ra=743119.609514284 Rb=1000 target beta=0.001 (no tap buffer)
Rdivh11a h11y htap11 740870.915975139
Rdivh11b htap11 0 1002.83135366071
* load-compensated divider h11yn->htap11n: G_load=0.000646362512497387 Ra=606792.241937412 Rb=1000 target beta=0.001 (no tap buffer)
Rdivh11na h11yn htap11n 607079.125941623
Rdivh11nb htap11n 0 998.200410394284
* passive invert h12y -> h12yn: R2/R1=1.0000200002 closed-loop -1 at A=100000
Rinvh12ia h12y invh12m 9984.28325588281
Rinvh12ib h12yn invh12m 10046.058088013
Einvh12amp h12yn 0 0 invh12m 100000
* load-compensated divider h12y->htap12: G_load=0.0014576014431314 Ra=406493.901927036 Rb=1000 target beta=0.001 (no tap buffer)
Rdivh12a h12y htap12 406160.103080627
Rdivh12b htap12 0 999.474837812976
* passive invert h13y -> h13yn: R2/R1=1.0000200002 closed-loop -1 at A=100000
Rinvh13ia h13y invh13m 10011.279640877
Rinvh13ib h13yn invh13m 9999.42071959007
Einvh13amp h13yn 0 0 invh13m 100000
* load-compensated divider h13y->htap13: G_load=0.000608857399561785 Ra=620937.567414057 Rb=1000 target beta=0.001 (no tap buffer)
Rdivh13a h13y htap13 621757.612790408
Rdivh13b htap13 0 1004.07443266304
* passive invert h14y -> h14yn: R2/R1=1.0000200002 closed-loop -1 at A=100000
Rinvh14ia h14y invh14m 10030.9484613591
Rinvh14ib h14yn invh14m 10026.3871019168
Einvh14amp h14yn 0 0 invh14m 100000
* load-compensated divider h14y->htap14: G_load=0.000644987911304399 Ra=607299.295718131 Rb=1000 target beta=0.001 (no tap buffer)
Rdivh14a h14y htap14 605661.181362607
Rdivh14b htap14 0 995.780985595496
* load-compensated divider h14yn->htap14n: G_load=0.000230447960623581 Ra=811899.431727056 Rb=1000 target beta=0.001 (no tap buffer)
Rdivh14na h14yn htap14n 815523.723618707
Rdivh14nb htap14n 0 1000.09998058981
* passive invert h15y -> h15yn: R2/R1=1.0000200002 closed-loop -1 at A=100000
Rinvh15ia h15y invh15m 10006.2901913292
Rinvh15ib h15yn invh15m 9999.11093946037
Einvh15amp h15yn 0 0 invh15m 100000
* load-compensated divider h15yn->htap15n: G_load=7.55198625914195e-05 Ra=928853.138604946 Rb=1000 target beta=0.001 (no tap buffer)
Rdivh15na h15yn htap15n 925625.673281854
Rdivh15nb htap15n 0 1004.27891911388
* passive invert h16y -> h16yn: R2/R1=1.0000200002 closed-loop -1 at A=100000
Rinvh16ia h16y invh16m 10023.8503826027
Rinvh16ib h16yn invh16m 10041.7305582051
Einvh16amp h16yn 0 0 invh16m 100000
* load-compensated divider h16y->htap16: G_load=0.000874717171138128 Ra=532880.380774191 Rb=1000 target beta=0.001 (no tap buffer)
Rdivh16a h16y htap16 534869.947194557
Rdivh16b htap16 0 1000.32427443171
* load-compensated divider h16yn->htap16n: G_load=0.000453600446759896 Ra=687259.007264885 Rb=1000 target beta=0.001 (no tap buffer)
Rdivh16na h16yn htap16n 686900.528344563
Rdivh16nb htap16n 0 997.389858989356
* passive invert h17y -> h17yn: R2/R1=1.0000200002 closed-loop -1 at A=100000
Rinvh17ia h17y invh17m 10020.6965377105
Rinvh17ib h17yn invh17m 9993.59098492491
Einvh17amp h17yn 0 0 invh17m 100000
* load-compensated divider h17y->htap17: G_load=0.000805385822001192 Ra=553344.325531842 Rb=1000 target beta=0.001 (no tap buffer)
Rdivh17a h17y htap17 552634.903006055
Rdivh17b htap17 0 995.78653778517
* load-compensated divider h17yn->htap17n: G_load=0.000738531412423623 Ra=574622.921887463 Rb=1000 target beta=0.001 (no tap buffer)
Rdivh17na h17yn htap17n 572306.731134233
Rdivh17nb htap17n 0 999.061945033197
* passive invert h18y -> h18yn: R2/R1=1.0000200002 closed-loop -1 at A=100000
Rinvh18ia h18y invh18m 9959.66258764813
Rinvh18ib h18yn invh18m 10041.0417219033
Einvh18amp h18yn 0 0 invh18m 100000
* passive invert h19y -> h19yn: R2/R1=1.0000200002 closed-loop -1 at A=100000
Rinvh19ia h19y invh19m 10011.8499323801
Rinvh19ib h19yn invh19m 10018.7175533399
Einvh19amp h19yn 0 0 invh19m 100000
* passive invert h20y -> h20yn: R2/R1=1.0000200002 closed-loop -1 at A=100000
Rinvh20ia h20y invh20m 10026.9917173782
Rinvh20ib h20yn invh20m 10024.6293979103
Einvh20amp h20yn 0 0 invh20m 100000
* load-compensated divider h20y->htap20: G_load=0.0016896004824873 Ra=371430.629383342 Rb=1000 target beta=0.001 (no tap buffer)
Rdivh20a h20y htap20 372134.240356568
Rdivh20b htap20 0 998.302584660763
* load-compensated divider h20yn->htap20n: G_load=0.00028049585678463 Ra=780166.522762927 Rb=1000 target beta=0.001 (no tap buffer)
Rdivh20na h20yn htap20n 777274.814836747
Rdivh20nb htap20n 0 1003.86854534798
* passive invert h21y -> h21yn: R2/R1=1.0000200002 closed-loop -1 at A=100000
Rinvh21ia h21y invh21m 9995.16544158802
Rinvh21ib h21yn invh21m 9978.26249012314
Einvh21amp h21yn 0 0 invh21m 100000
* load-compensated divider h21y->htap21: G_load=0.000996893144360737 Ra=500277.144433689 Rb=1000 target beta=0.001 (no tap buffer)
Rdivh21a h21y htap21 499196.978716793
Rdivh21b htap21 0 1001.63204004959
* passive invert h22y -> h22yn: R2/R1=1.0000200002 closed-loop -1 at A=100000
Rinvh22ia h22y invh22m 9955.06470660055
Rinvh22ib h22yn invh22m 10036.5773423657
Einvh22amp h22yn 0 0 invh22m 100000
* load-compensated divider h22yn->htap22n: G_load=0.000238269487966002 Ra=806771.070198113 Rb=1000 target beta=0.001 (no tap buffer)
Rdivh22na h22yn htap22n 805629.553928461
Rdivh22nb htap22n 0 1003.97282330973
* passive invert h23y -> h23yn: R2/R1=1.0000200002 closed-loop -1 at A=100000
Rinvh23ia h23y invh23m 10007.7209848556
Rinvh23ib h23yn invh23m 10043.4181289202
Einvh23amp h23yn 0 0 invh23m 100000
* load-compensated divider h23yn->htap23n: G_load=0.000186102491889634 Ra=842254.364046101 Rb=1000 target beta=0.001 (no tap buffer)
Rdivh23na h23yn htap23n 842180.720407656
Rdivh23nb htap23n 0 1001.21193825806
* passive invert h24y -> h24yn: R2/R1=1.0000200002 closed-loop -1 at A=100000
Rinvh24ia h24y invh24m 9983.20857535554
Rinvh24ib h24yn invh24m 10014.3057868194
Einvh24amp h24yn 0 0 invh24m 100000
* load-compensated divider h24y->htap24: G_load=0.00179208295517046 Ra=357797.392140525 Rb=1000 target beta=0.001 (no tap buffer)
Rdivh24a h24y htap24 357400.97551853
Rdivh24b htap24 0 1000.56424463476
* load-compensated divider h24yn->htap24n: G_load=0.000321063215271205 Ra=756209.0810279 Rb=1000 target beta=0.001 (no tap buffer)
Rdivh24na h24yn htap24n 753777.719043599
Rdivh24nb htap24n 0 1001.69194768492
* passive invert h25y -> h25yn: R2/R1=1.0000200002 closed-loop -1 at A=100000
Rinvh25ia h25y invh25m 9956.08373080578
Rinvh25ib h25yn invh25m 10025.5427530699
Einvh25amp h25yn 0 0 invh25m 100000
* load-compensated divider h25y->htap25: G_load=0.00043215997093136 Ra=697547.774184983 Rb=1000 target beta=0.001 (no tap buffer)
Rdivh25a h25y htap25 699842.882062127
Rdivh25b htap25 0 1004.88790594726
* passive invert h26y -> h26yn: R2/R1=1.0000200002 closed-loop -1 at A=100000
Rinvh26ia h26y invh26m 10028.4239109289
Rinvh26ib h26yn invh26m 10047.2210115169
Einvh26amp h26yn 0 0 invh26m 100000
* load-compensated divider h26yn->htap26n: G_load=0.000228692257589393 Ra=813059.571124804 Rb=1000 target beta=0.001 (no tap buffer)
Rdivh26na h26yn htap26n 810696.830066213
Rdivh26nb htap26n 0 1003.50716545743
* passive invert h27y -> h27yn: R2/R1=1.0000200002 closed-loop -1 at A=100000
Rinvh27ia h27y invh27m 9998.4703838806
Rinvh27ib h27yn invh27m 9950.66195870183
Einvh27amp h27yn 0 0 invh27m 100000
* passive invert h28y -> h28yn: R2/R1=1.0000200002 closed-loop -1 at A=100000
Rinvh28ia h28y invh28m 10043.0816512702
Rinvh28ib h28yn invh28m 9999.88673125807
Einvh28amp h28yn 0 0 invh28m 100000
* load-compensated divider h28y->htap28: G_load=0.000369491999393624 Ra=729467.569319376 Rb=1000 target beta=0.001 (no tap buffer)
Rdivh28a h28y htap28 733007.688255877
Rdivh28b htap28 0 1004.92950968086
* passive invert h29y -> h29yn: R2/R1=1.0000200002 closed-loop -1 at A=100000
Rinvh29ia h29y invh29m 9959.10131453884
Rinvh29ib h29yn invh29m 10016.4219457473
Einvh29amp h29yn 0 0 invh29m 100000
* load-compensated divider h29y->htap29: G_load=0.000860568019222978 Ra=536932.802068268 Rb=1000 target beta=0.001 (no tap buffer)
Rdivh29a h29y htap29 538215.846304251
Rdivh29b htap29 0 998.113092540484
* load-compensated divider h29yn->htap29n: G_load=0.00122218503343532 Ra=449557.523324521 Rb=1000 target beta=0.001 (no tap buffer)
Rdivh29na h29yn htap29n 450099.242453679
Rdivh29nb htap29n 0 996.052890911134
* passive invert h30y -> h30yn: R2/R1=1.0000200002 closed-loop -1 at A=100000
Rinvh30ia h30y invh30m 10006.6284571966
Rinvh30ib h30yn invh30m 10030.62680203
Einvh30amp h30yn 0 0 invh30m 100000
* load-compensated divider h30y->htap30: G_load=0.000487976394847741 Ra=671381.618323471 Rb=1000 target beta=0.001 (no tap buffer)
Rdivh30a h30y htap30 668665.610299302
Rdivh30b htap30 0 997.074496169134
* passive invert h31y -> h31yn: R2/R1=1.0000200002 closed-loop -1 at A=100000
Rinvh31ia h31y invh31m 10021.7107301367
Rinvh31ib h31yn invh31m 9981.70579219374
Einvh31amp h31yn 0 0 invh31m 100000
* passive invert h32y -> h32yn: R2/R1=1.0000200002 closed-loop -1 at A=100000
Rinvh32ia h32y invh32m 9966.37954348678
Rinvh32ib h32yn invh32m 9974.428707772
Einvh32amp h32yn 0 0 invh32m 100000
* load-compensated divider h32yn->htap32n: G_load=9.22574297882182e-05 Ra=914619.550991473 Rb=1000 target beta=0.001 (no tap buffer)
Rdivh32na h32yn htap32n 914802.538542432
Rdivh32nb htap32n 0 999.514364395486

* o1 input 1 w=+0.115109951768787 w+  bank=n alpha=1 R=289578.206064126 G_phys=3.4532985530636e-06 G_eff=3.4532985530636e-06
Ro1p1n1 h1yn o1p 289005.108333518
* o1 input 2 w=+0.416557305918275 w+  bank=n alpha=1 R=80021.0027762017 G_phys=1.24967191775482e-05 G_eff=1.24967191775482e-05
Ro1p2n1 h2yn o1p 80363.2896679176
* o1 input 3 w=+0.460762298204741 w+  bank=n alpha=1 R=72343.8820042555 G_phys=1.38228689461422e-05 G_eff=1.38228689461422e-05
Ro1p3n1 h3yn o1p 72194.4057649333
* o1 input 4 w=+0.128235529120638 w+  bank=n alpha=1 R=259938.361559493 G_phys=3.84706587361914e-06 G_eff=3.84706587361914e-06
Ro1p4n1 h4yn o1p 259564.339867202
* o1 input 5 w=+0.25946188501651 w+  bank=n alpha=1 R=128471.021210735 G_phys=7.78385655049531e-06 G_eff=7.78385655049531e-06
Ro1p5n1 h5yn o1p 128696.79772861
* o1 input 6 w=+0.0121141451968155 w+  bank=f alpha=0.001 R=2751.60424378073 G_phys=0.000363424355904464 G_eff=3.63424355904464e-07
Ro1p6f1 htap6n o1p 2755.25060989873
* o1 input 7 w=-0.240253536162518 w-  bank=n alpha=1 R=138742.321406604 G_phys=7.20760608487554e-06 G_eff=7.20760608487554e-06
Ro1n7n1 h7y o1p 138782.527263958
* o1 input 8 w=+0.187475674056081 w+  bank=n alpha=1 R=177800.845369208 G_phys=5.62427022168244e-06 G_eff=5.62427022168244e-06
Ro1p8n1 h8yn o1p 178323.498549554
* o1 input 9 w=-0.249792136720497 w-  bank=n alpha=1 R=133444.28600101 G_phys=7.4937641016149e-06 G_eff=7.4937641016149e-06
Ro1n9n1 h9y o1p 133393.440430519
* o1 input 10 w=-0.0478130377197742 w-  bank=n alpha=1 R=697159.915433434 G_phys=1.43439113159322e-06 G_eff=1.43439113159322e-06
Ro1n10n1 h10y o1p 693904.640965189
* o1 input 11 w=+0.103135444855694 w+  bank=n alpha=1 R=323199.588463238 G_phys=3.09406334567083e-06 G_eff=3.09406334567083e-06
Ro1p11n1 h11yn o1p 323118.611935739
* o1 input 12 w=-0.0209153710838255 w-  bank=f alpha=0.001 R=1593.72421362923 G_phys=0.000627461132514765 G_eff=6.27461132514765e-07
Ro1n12f1 htap12 o1p 1587.11122194583
* o1 input 13 w=-0.0177641479719743 w-  bank=f alpha=0.001 R=1876.43862153827 G_phys=0.00053292443915923 G_eff=5.3292443915923e-07
Ro1n13f1 htap13 o1p 1876.97688214609
* o1 input 14 w=-0.162077236015947 w-  bank=n alpha=1 R=205663.263717389 G_phys=4.86231708047842e-06 G_eff=4.86231708047842e-06
Ro1n14n1 h14y o1p 206527.874854662
* o1 input 15 w=+0.156787201998635 w+  bank=n alpha=1 R=212602.386600556 G_phys=4.70361605995906e-06 G_eff=4.70361605995906e-06
Ro1p15n1 h15yn o1p 213569.256782754
* o1 input 16 w=-0.00694237968883333 w-  bank=f alpha=0.001 R=4801.42758353441 G_phys=0.000208271390665 G_eff=2.08271390665e-07
Ro1n16f1 htap16 o1p 4797.48655729338
* o1 input 17 w=+0.263424706628807 w+  bank=n alpha=1 R=126538.37128612 G_phys=7.90274119886422e-06 G_eff=7.90274119886422e-06
Ro1p17n1 h17yn o1p 126820.014583288
* o1 input 18 w=+0.403807796552332 w+  bank=n alpha=1 R=82547.5229005725 G_phys=1.211423389657e-05 G_eff=1.211423389657e-05
Ro1p18n1 h18yn o1p 82380.0620814615
* o1 input 19 w=+0.415931315874452 w+  bank=n alpha=1 R=80141.4369659891 G_phys=1.24779394762336e-05 G_eff=1.24779394762336e-05
Ro1p19n1 h19yn o1p 79939.7527124894
* o1 input 20 w=+0.0719298844689274 w+  bank=n alpha=1 R=463414.248186827 G_phys=2.15789653406782e-06 G_eff=2.15789653406782e-06
Ro1p20n1 h20yn o1p 463159.071335682
* o1 input 21 w=-0.387164693396724 w-  bank=n alpha=1 R=86096.0048833198 G_phys=1.16149408019017e-05 G_eff=1.16149408019017e-05
Ro1n21n1 h21y o1p 86086.1051518724
* o1 input 22 w=+0.13881898843949 w+  bank=n alpha=1 R=240120.848797735 G_phys=4.1645696531847e-06 G_eff=4.1645696531847e-06
Ro1p22n1 h22yn o1p 240414.605129786
* o1 input 23 w=-0.118143194098524 w-  bank=n alpha=1 R=282143.491952108 G_phys=3.54429582295573e-06 G_eff=3.54429582295573e-06
Ro1n23n1 h23y o1p 283240.836253746
* o1 input 24 w=-0.494956544406075 w-  bank=n alpha=1 R=67345.9795815646 G_phys=1.48486963321823e-05 G_eff=1.48486963321823e-05
Ro1n24n1 h24y o1p 67071.2945355504
* o1 input 25 w=-0.0137314432186455 w-  bank=f alpha=0.001 R=2427.51856469617 G_phys=0.000411943296559366 G_eff=4.11943296559366e-07
Ro1n25f1 htap25 o1p 2427.3304527685
* o1 input 26 w=+0.00762307525297978 w+  bank=f alpha=0.001 R=4372.68847901032 G_phys=0.000228692257589393 G_eff=2.28692257589393e-07
Ro1p26f1 htap26n o1p 4386.17958880579
* o1 input 27 w=+0.187160704798257 w+  bank=n alpha=1 R=178100.063094247 G_phys=5.6148211439477e-06 G_eff=5.6148211439477e-06
Ro1p27n1 h27yn o1p 177403.299517172
* o1 input 28 w=+0.0939442280900053 w+  bank=n alpha=1 R=354820.450505992 G_phys=2.81832684270016e-06 G_eff=2.81832684270016e-06
Ro1p28n1 h28yn o1p 355706.450446859
* o1 input 29 w=+0.0315398664392492 w+  bank=f alpha=0.001 R=1056.86349045069 G_phys=0.000946195993177476 G_eff=9.46195993177476e-07
Ro1p29f1 htap29n o1p 1058.04380072583
* o1 input 30 w=+0.183835448783735 w+  bank=n alpha=1 R=181321.576191471 G_phys=5.51506346351205e-06 G_eff=5.51506346351205e-06
Ro1p30n1 h30yn o1p 181139.383938806
* o1 input 31 w=-0.236627512253244 w-  bank=n alpha=1 R=140868.375853351 G_phys=7.09882536759733e-06 G_eff=7.09882536759733e-06
Ro1n31n1 h31y o1p 140576.963567046
* o1 input 32 w=-0.230869865069063 w-  bank=n alpha=1 R=144381.482283805 G_phys=6.92609595207188e-06 G_eff=6.92609595207188e-06
Ro1n32n1 h32y o1p 145027.09840303
* o1 bias w-  bank=n alpha=1 R=411699.330459582 G_phys=2.42895707137462e-06 G_eff=2.42895707137462e-06
Ro1bnn1 vref o1p 411018.620522728
* replica dummy G_tot for o1: same R as weights/biases, dest=0
Ro1dmy000 0 o1rp 289573.013486475
Ro1dmy001 0 o1rp 79739.548431952
Ro1dmy002 0 o1rp 72696.8096364285
Ro1dmy003 0 o1rp 259308.26729913
Ro1dmy004 0 o1rp 128216.864863346
Ro1dmy005 0 o1rp 2760.44958030164
Ro1dmy006 0 o1rp 139000.388295979
Ro1dmy007 0 o1rp 178459.412379317
Ro1dmy008 0 o1rp 133109.03106877
Ro1dmy009 0 o1rp 693845.69955942
Ro1dmy010 0 o1rp 323483.671043549
Ro1dmy011 0 o1rp 1587.82454888261
Ro1dmy012 0 o1rp 1884.65771864194
Ro1dmy013 0 o1rp 205385.500829696
Ro1dmy014 0 o1rp 212668.35404354
Ro1dmy015 0 o1rp 4805.71420707444
Ro1dmy016 0 o1rp 127105.678044489
Ro1dmy017 0 o1rp 82489.472498175
Ro1dmy018 0 o1rp 80342.4999529467
Ro1dmy019 0 o1rp 461952.228184252
Ro1dmy020 0 o1rp 86217.6794954597
Ro1dmy021 0 o1rp 240809.620460323
Ro1dmy022 0 o1rp 283149.148904372
Ro1dmy023 0 o1rp 67166.5609136861
Ro1dmy024 0 o1rp 2416.04532690719
Ro1dmy025 0 o1rp 4384.82790217859
Ro1dmy026 0 o1rp 178804.407268223
Ro1dmy027 0 o1rp 355055.656064939
Ro1dmy028 0 o1rp 1053.6652262701
Ro1dmy029 0 o1rp 180627.539684615
Ro1dmy030 0 o1rp 140382.738305792
Ro1dmy031 0 o1rp 144761.595280924
Ro1dmy032 0 o1rp 413675.364856193
* feedback TIA o1: Rf=33333.3333333333 A=100000 V(o1sig) = -I(o1p)*Rf*A/(A+1)  (uncompensated)
Eo1tia o1sig 0 0 o1p 100000
Ro1f o1sig o1p 33221.2739213156
* feedback TIA o1r: Rf=33333.3333333333 A=100000 V(o1rep) = -I(o1rp)*Rf*A/(A+1)  (uncompensated)
Eo1rtia o1rep 0 0 o1rp 100000
Ro1rf o1rep o1rp 33234.1510609211
* replica null o1: v(o1lin)=v(o1sig)-v(o1rep) Vos_sig=0 Vos_rep=0
Eo1null o1lin 0 o1sig o1rep 1

* o2 input 1 w=-0.195521390350609 w-  bank=n alpha=1 R=170484.330505015 G_phys=5.86564171051827e-06 G_eff=5.86564171051827e-06
Ro2n1n1 h1y o2p 169951.266355546
* o2 input 2 w=+0.386445174905558 w+  bank=n alpha=1 R=86256.3061926689 G_phys=1.15933552471668e-05 G_eff=1.15933552471668e-05
Ro2p2n1 h2yn o2p 85843.0922131246
* o2 input 3 w=+0.296294588630229 w+  bank=n alpha=1 R=112500.648383197 G_phys=8.88883765890688e-06 G_eff=8.88883765890688e-06
Ro2p3n1 h3yn o2p 112008.008752497
* o2 input 4 w=-0.299308681857295 w-  bank=n alpha=1 R=111367.746256108 G_phys=8.97926045571886e-06 G_eff=8.97926045571886e-06
Ro2n4n1 h4y o2p 111556.998789773
* o2 input 5 w=+0.732671792857329 w+  bank=n alpha=1 R=45495.5870531571 G_phys=2.19801537857199e-05 G_eff=2.19801537857199e-05
Ro2p5n1 h5yn o2p 45452.5623723318
* o2 input 6 w=+0.124925987288217 w+  bank=n alpha=1 R=266824.65399637 G_phys=3.7477796186465e-06 G_eff=3.7477796186465e-06
Ro2p6n1 h6yn o2p 267068.884247577
* o2 input 7 w=-0.0857938493267301 w-  bank=n alpha=1 R=388528.240601368 G_phys=2.5738154798019e-06 G_eff=2.5738154798019e-06
Ro2n7n1 h7y o2p 387110.829546175
* o2 input 8 w=-0.0609936542707342 w-  bank=n alpha=1 R=546504.939438057 G_phys=1.82980962812202e-06 G_eff=1.82980962812202e-06
Ro2n8n1 h8y o2p 547624.541432161
* o2 input 9 w=+0.256981204903229 w+  bank=n alpha=1 R=129711.172246568 G_phys=7.70943614709688e-06 G_eff=7.70943614709688e-06
Ro2p9n1 h9yn o2p 129950.181486881
* o2 input 10 w=+0.073638013162671 w+  bank=n alpha=1 R=452664.756987643 G_phys=2.20914039488013e-06 G_eff=2.20914039488013e-06
Ro2p10n1 h10yn o2p 453736.797762799
* o2 input 11 w=-0.149208279345328 w-  bank=n alpha=1 R=223401.365390634 G_phys=4.47624838035983e-06 G_eff=4.47624838035983e-06
Ro2n11n1 h11y o2p 222991.134176234
* o2 input 12 w=-0.475362564845884 w-  bank=n alpha=1 R=70121.9149306388 G_phys=1.42608769453765e-05 G_eff=1.42608769453765e-05
Ro2n12n1 h12y o2p 70339.8423735353
* o2 input 13 w=-0.0533811781970356 w-  bank=n alpha=1 R=624439.820535554 G_phys=1.60143534591107e-06 G_eff=1.60143534591107e-06
Ro2n13n1 h13y o2p 626963.681263037
* o2 input 14 w=+0.279456004632752 w+  bank=n alpha=1 R=119279.359830319 G_phys=8.38368013898257e-06 G_eff=8.38368013898257e-06
Ro2p14n1 h14yn o2p 119870.331340452
* o2 input 15 w=-0.0744870090943736 w-  bank=n alpha=1 R=447505.326614748 G_phys=2.23461027283121e-06 G_eff=2.23461027283121e-06
Ro2n15n1 h15y o2p 445757.997115939
* o2 input 16 w=-0.0222148593491043 w-  bank=f alpha=0.001 R=1500.49715865869 G_phys=0.000666445780473128 G_eff=6.66445780473128e-07
Ro2n16f1 htap16 o2p 1497.29553819567
* o2 input 17 w=+0.0088751960388594 w+  bank=f alpha=0.001 R=3755.78558348297 G_phys=0.000266255881165782 G_eff=2.66255881165782e-07
Ro2p17f1 htap17n o2p 3747.81881563963
* o2 input 18 w=-0.194172060066752 w-  bank=n alpha=1 R=171669.051262443 G_phys=5.82516180200256e-06 G_eff=5.82516180200256e-06
Ro2n18n1 h18y o2p 171343.701662159
* o2 input 19 w=+0.341327626188232 w+  bank=n alpha=1 R=97657.8828546125 G_phys=1.0239828785647e-05 G_eff=1.0239828785647e-05
Ro2p19n1 h19yn o2p 97900.6660973934
* o2 input 20 w=-0.0323870183321868 w-  bank=f alpha=0.001 R=1029.21896024637 G_phys=0.000971610549965604 G_eff=9.71610549965604e-07
Ro2n20f1 htap20 o2p 1030.78007467412
* o2 input 21 w=-0.0999542141187652 w-  bank=n alpha=1 R=333486.022847689 G_phys=2.99862642356296e-06 G_eff=2.99862642356296e-06
Ro2n21n1 h21y o2p 332133.385386479
* o2 input 22 w=+0.693789300406694 w+  bank=n alpha=1 R=48045.3263170729 G_phys=2.08136790122008e-05 G_eff=2.08136790122008e-05
Ro2p22n1 h22yn o2p 48037.4893047717
* o2 input 23 w=+0.0972685864670828 w+  bank=n alpha=1 R=342693.715864925 G_phys=2.91805759401248e-06 G_eff=2.91805759401248e-06
Ro2p23n1 h23yn o2p 341503.36545546
* o2 input 24 w=-0.0293783170287994 w-  bank=f alpha=0.001 R=1134.6236512002 G_phys=0.000881349510863982 G_eff=8.81349510863982e-07
Ro2n24f1 htap24 o2p 1137.92953063482
* o2 input 25 w=+0.0497492024826392 w+  bank=n alpha=1 R=670027.491294269 G_phys=1.49247607447918e-06 G_eff=1.49247607447918e-06
Ro2p25n1 h25yn o2p 669847.634410021
* o2 input 26 w=-0.466063512962686 w-  bank=n alpha=1 R=71521.0103477937 G_phys=1.39819053888806e-05 G_eff=1.39819053888806e-05
Ro2n26n1 h26y o2p 71436.68014227
* o2 input 27 w=+0.194887582685885 w+  bank=n alpha=1 R=171038.774630702 G_phys=5.84662748057655e-06 G_eff=5.84662748057655e-06
Ro2p27n1 h27yn o2p 170712.679658268
* o2 input 28 w=+0.209047565197081 w+  bank=n alpha=1 R=159453.344036359 G_phys=6.27142695591242e-06 G_eff=6.27142695591242e-06
Ro2p28n1 h28yn o2p 159764.717367615
* o2 input 29 w=+0.00919963467526149 w+  bank=f alpha=0.001 R=3623.33228546229 G_phys=0.000275989040257845 G_eff=2.75989040257845e-07
Ro2p29f1 htap29n o2p 3639.47000496346
* o2 input 30 w=-0.379437042796868 w-  bank=n alpha=1 R=87849.4442388387 G_phys=1.13831112839061e-05 G_eff=1.13831112839061e-05
Ro2n30n1 h30y o2p 87821.8644046214
* o2 input 31 w=-0.216631724491884 w-  bank=n alpha=1 R=153870.96885979 G_phys=6.49895173475653e-06 G_eff=6.49895173475653e-06
Ro2n31n1 h31y o2p 154273.755434897
* o2 input 32 w=+0.139103822260271 w+  bank=n alpha=1 R=239629.169002738 G_phys=4.17311466780814e-06 G_eff=4.17311466780814e-06
Ro2p32n1 h32yn o2p 238531.877544698
* o2 bias w+  bank=f alpha=0.001 R=1034.77721072674 G_phys=0.000966391595827364 G_eff=9.66391595827364e-07
Ro2bpf1 taprefn o2p 1031.09772452344
* replica dummy G_tot for o2: same R as weights/biases, dest=0
Ro2dmy000 0 o2rp 169978.966853094
Ro2dmy001 0 o2rp 85904.4596711659
Ro2dmy002 0 o2rp 112765.429955739
Ro2dmy003 0 o2rp 111210.298340659
Ro2dmy004 0 o2rp 45574.2279331025
Ro2dmy005 0 o2rp 266143.608237317
Ro2dmy006 0 o2rp 387922.175702954
Ro2dmy007 0 o2rp 545414.852234959
Ro2dmy008 0 o2rp 129780.635532334
Ro2dmy009 0 o2rp 453476.377753537
Ro2dmy010 0 o2rp 222819.991253615
Ro2dmy011 0 o2rp 70322.5919684726
Ro2dmy012 0 o2rp 624270.17813091
Ro2dmy013 0 o2rp 118928.526898997
Ro2dmy014 0 o2rp 446667.749279775
Ro2dmy015 0 o2rp 1496.7929255496
Ro2dmy016 0 o2rp 3767.9688849719
Ro2dmy017 0 o2rp 172370.219520332
Ro2dmy018 0 o2rp 97257.261540089
Ro2dmy019 0 o2rp 1027.32733198329
Ro2dmy020 0 o2rp 334273.230323166
Ro2dmy021 0 o2rp 47868.8458622816
Ro2dmy022 0 o2rp 342537.89512224
Ro2dmy023 0 o2rp 1128.96839889059
Ro2dmy024 0 o2rp 668273.504161822
Ro2dmy025 0 o2rp 71346.8188067353
Ro2dmy026 0 o2rp 170218.028957752
Ro2dmy027 0 o2rp 160198.391682676
Ro2dmy028 0 o2rp 3612.28892911119
Ro2dmy029 0 o2rp 88002.6957228012
Ro2dmy030 0 o2rp 154565.895346021
Ro2dmy031 0 o2rp 238563.321285521
Ro2dmy032 0 o2rp 1036.24138093387
* feedback TIA o2: Rf=33333.3333333333 A=100000 V(o2sig) = -I(o2p)*Rf*A/(A+1)  (uncompensated)
Eo2tia o2sig 0 0 o2p 100000
Ro2f o2sig o2p 33278.369752346
* feedback TIA o2r: Rf=33333.3333333333 A=100000 V(o2rep) = -I(o2rp)*Rf*A/(A+1)  (uncompensated)
Eo2rtia o2rep 0 0 o2rp 100000
Ro2rf o2rep o2rp 33197.1564996435
* replica null o2: v(o2lin)=v(o2sig)-v(o2rep) Vos_sig=0 Vos_rep=0
Eo2null o2lin 0 o2sig o2rep 1

* o3 input 1 w=-0.100595944434035 w-  bank=n alpha=1 R=331358.620080271 G_phys=3.01787833302104e-06 G_eff=3.01787833302104e-06
Ro3n1n1 h1y o3p 332765.231106409
* o3 input 2 w=-0.265315115107159 w-  bank=n alpha=1 R=125636.767132058 G_phys=7.95945345321476e-06 G_eff=7.95945345321476e-06
Ro3n2n1 h2y o3p 125713.870982033
* o3 input 3 w=-0.0591677372187977 w-  bank=n alpha=1 R=563370.088162562 G_phys=1.77503211656393e-06 G_eff=1.77503211656393e-06
Ro3n3n1 h3y o3p 561115.199645284
* o3 input 4 w=-0.0695954531730398 w-  bank=n alpha=1 R=478958.492452868 G_phys=2.08786359519119e-06 G_eff=2.08786359519119e-06
Ro3n4n1 h4y o3p 479027.605268272
* o3 input 5 w=-0.284313347850547 w-  bank=n alpha=1 R=117241.53503639 G_phys=8.52940043551641e-06 G_eff=8.52940043551641e-06
Ro3n5n1 h5y o3p 117240.199923285
* o3 input 6 w=+0.314440272159438 w+  bank=n alpha=1 R=106008.473737841 G_phys=9.43320816478313e-06 G_eff=9.43320816478313e-06
Ro3p6n1 h6yn o3p 106103.203636909
* o3 input 7 w=-0.349535009995164 w-  bank=n alpha=1 R=95364.7914519193 G_phys=1.04860502998549e-05 G_eff=1.04860502998549e-05
Ro3n7n1 h7y o3p 95504.9603805447
* o3 input 8 w=-0.295696300813859 w-  bank=n alpha=1 R=112728.273034152 G_phys=8.87088902441576e-06 G_eff=8.87088902441576e-06
Ro3n8n1 h8y o3p 113226.807914486
* o3 input 9 w=-0.735854867565559 w-  bank=n alpha=1 R=45298.7875769723 G_phys=2.20756460269668e-05 G_eff=2.20756460269668e-05
Ro3n9n1 h9y o3p 45132.6669061144
* o3 input 10 w=-0.0859238760568894 w-  bank=n alpha=1 R=387940.289277262 G_phys=2.57771628170668e-06 G_eff=2.57771628170668e-06
Ro3n10n1 h10y o3p 389822.046817765
* o3 input 11 w=-0.105996934570411 w-  bank=n alpha=1 R=314474.503139436 G_phys=3.17990803711233e-06 G_eff=3.17990803711233e-06
Ro3n11n1 h11y o3p 313880.139170996
* o3 input 12 w=-0.193541479603888 w-  bank=n alpha=1 R=172228.36883109 G_phys=5.80624438811663e-06 G_eff=5.80624438811663e-06
Ro3n12n1 h12y o3p 171874.679290726
* o3 input 13 w=-0.351950930756974 w-  bank=n alpha=1 R=94710.172414206 G_phys=1.05585279227092e-05 G_eff=1.05585279227092e-05
Ro3n13n1 h13y o3p 94370.1400277132
* o3 input 14 w=+0.0402342325324318 w+  bank=n alpha=1 R=828481.898007229 G_phys=1.20702697597296e-06 G_eff=1.20702697597296e-06
Ro3p14n1 h14yn o3p 825410.351776416
* o3 input 15 w=+0.188158881095559 w+  bank=n alpha=1 R=177155.248475381 G_phys=5.64476643286676e-06 G_eff=5.64476643286676e-06
Ro3p15n1 h15yn o3p 176667.554202742
* o3 input 16 w=+0.204693314484602 w+  bank=n alpha=1 R=162845.246886853 G_phys=6.14079943453807e-06 G_eff=6.14079943453807e-06
Ro3p16n1 h16yn o3p 163600.819680374
* o3 input 17 w=+0.153640089266272 w+  bank=n alpha=1 R=216957.263514496 G_phys=4.60920267798816e-06 G_eff=4.60920267798816e-06
Ro3p17n1 h17yn o3p 217201.473046806
* o3 input 18 w=+0.463153650429953 w+  bank=n alpha=1 R=71970.3564948468 G_phys=1.38946095128986e-05 G_eff=1.38946095128986e-05
Ro3p18n1 h18yn o3p 71853.7097731834
* o3 input 19 w=-0.0426705918571366 w-  bank=n alpha=1 R=781178.134227318 G_phys=1.2801177557141e-06 G_eff=1.2801177557141e-06
Ro3n19n1 h19y o3p 784914.798127463
* o3 input 20 w=+0.210331327799834 w+  bank=n alpha=1 R=158480.116500076 G_phys=6.30993983399502e-06 G_eff=6.30993983399502e-06
Ro3p20n1 h20yn o3p 158468.2128417
* o3 input 21 w=-0.0625815721904128 w-  bank=n alpha=1 R=532638.157953466 G_phys=1.87744716571238e-06 G_eff=1.87744716571238e-06
Ro3n21n1 h21y o3p 534356.102439969
* o3 input 22 w=+0.238697201684848 w+  bank=n alpha=1 R=139646.938037185 G_phys=7.16091605054544e-06 G_eff=7.16091605054544e-06
Ro3p22n1 h22yn o3p 139399.169346951
* o3 input 23 w=-0.0558624260671465 w-  bank=n alpha=1 R=596704.004463873 G_phys=1.67587278201439e-06 G_eff=1.67587278201439e-06
Ro3n23n1 h23y o3p 597933.784374371
* o3 input 24 w=+0.439236044835332 w+  bank=n alpha=1 R=75889.3395140872 G_phys=1.317708134506e-05 G_eff=1.317708134506e-05
Ro3p24n1 h24yn o3p 75762.7784657844
* o3 input 25 w=+0.113742741787302 w+  bank=n alpha=1 R=293058.992684265 G_phys=3.41228225361907e-06 G_eff=3.41228225361907e-06
Ro3p25n1 h25yn o3p 292286.262160095
* o3 input 26 w=-0.433617266896606 w-  bank=n alpha=1 R=76872.7075190056 G_phys=1.30085180068982e-05 G_eff=1.30085180068982e-05
Ro3n26n1 h26y o3p 77176.3583731419
* o3 input 27 w=+0.230315174630548 w+  bank=n alpha=1 R=144729.210252012 G_phys=6.90945523891643e-06 G_eff=6.90945523891643e-06
Ro3p27n1 h27yn o3p 144203.885819741
* o3 input 28 w=-0.12398109066818 w-  bank=n alpha=1 R=268858.203728388 G_phys=3.71943272004541e-06 G_eff=3.71943272004541e-06
Ro3n28n1 h28y o3p 267523.018422005
* o3 input 29 w=-0.26178305647614 w-  bank=n alpha=1 R=127331.897572108 G_phys=7.85349169428421e-06 G_eff=7.85349169428421e-06
Ro3n29n1 h29y o3p 127113.960912123
* o3 input 30 w=-0.44647126763401 w-  bank=n alpha=1 R=74659.5262668906 G_phys=1.33941380290203e-05 G_eff=1.33941380290203e-05
Ro3n30n1 h30y o3p 74821.422043349
* o3 input 31 w=-0.53039390006668 w-  bank=n alpha=1 R=62846.3738537392 G_phys=1.59118170020004e-05 G_eff=1.59118170020004e-05
Ro3n31n1 h31y o3p 62768.7685969286
* o3 input 32 w=+0.288818654520262 w+  bank=n alpha=1 R=115412.674394946 G_phys=8.66455963560785e-06 G_eff=8.66455963560785e-06
Ro3p32n1 h32yn o3p 114931.364917236
* o3 bias w+  bank=n alpha=1 R=524928.575339756 G_phys=1.90502107711084e-06 G_eff=1.90502107711084e-06
Ro3bpn1 vrefn o3p 524316.699550783
* replica dummy G_tot for o3: same R as weights/biases, dest=0
Ro3dmy000 0 o3rp 332682.526249679
Ro3dmy001 0 o3rp 126264.743256928
Ro3dmy002 0 o3rp 563805.750709045
Ro3dmy003 0 o3rp 479188.441037947
Ro3dmy004 0 o3rp 116739.708069239
Ro3dmy005 0 o3rp 105672.936889791
Ro3dmy006 0 o3rp 95229.4374698576
Ro3dmy007 0 o3rp 112378.768526439
Ro3dmy008 0 o3rp 45381.6023889239
Ro3dmy009 0 o3rp 386808.815737148
Ro3dmy010 0 o3rp 313712.928285322
Ro3dmy011 0 o3rp 172309.503387118
Ro3dmy012 0 o3rp 94915.9773433513
Ro3dmy013 0 o3rp 824724.572005359
Ro3dmy014 0 o3rp 176820.709023387
Ro3dmy015 0 o3rp 163344.159365429
Ro3dmy016 0 o3rp 216565.320168349
Ro3dmy017 0 o3rp 71685.0605237092
Ro3dmy018 0 o3rp 779973.524085458
Ro3dmy019 0 o3rp 158507.002212096
Ro3dmy020 0 o3rp 530912.765647678
Ro3dmy021 0 o3rp 140288.877255438
Ro3dmy022 0 o3rp 594161.334257086
Ro3dmy023 0 o3rp 75687.8290934599
Ro3dmy024 0 o3rp 292998.911495783
Ro3dmy025 0 o3rp 77173.1509057473
Ro3dmy026 0 o3rp 144485.715230975
Ro3dmy027 0 o3rp 268041.068323606
Ro3dmy028 0 o3rp 126758.481339994
Ro3dmy029 0 o3rp 74410.2741982188
Ro3dmy030 0 o3rp 63131.0274155267
Ro3dmy031 0 o3rp 115673.240948243
Ro3dmy032 0 o3rp 523424.778475966
* feedback TIA o3: Rf=33333.3333333333 A=100000 V(o3sig) = -I(o3p)*Rf*A/(A+1)  (uncompensated)
Eo3tia o3sig 0 0 o3p 100000
Ro3f o3sig o3p 33434.3960438609
* feedback TIA o3r: Rf=33333.3333333333 A=100000 V(o3rep) = -I(o3rp)*Rf*A/(A+1)  (uncompensated)
Eo3rtia o3rep 0 0 o3rp 100000
Ro3rf o3rep o3rp 33386.062125893
* replica null o3: v(o3lin)=v(o3sig)-v(o3rep) Vos_sig=0 Vos_rep=0
Eo3null o3lin 0 o3sig o3rep 1

* o4 input 1 w=+0.274757256178841 w+  bank=n alpha=1 R=121319.210261863 G_phys=8.24271768536522e-06 G_eff=8.24271768536522e-06
Ro4p1n1 h1yn o4p 120751.976672957
* o4 input 2 w=-0.133159767354893 w-  bank=n alpha=1 R=250325.860396666 G_phys=3.99479302064678e-06 G_eff=3.99479302064678e-06
Ro4n2n1 h2y o4p 250196.880545241
* o4 input 3 w=-0.106623598682841 w-  bank=n alpha=1 R=312626.226699453 G_phys=3.19870796048523e-06 G_eff=3.19870796048523e-06
Ro4n3n1 h3y o4p 311347.859386611
* o4 input 4 w=+0.10049322803724 w+  bank=n alpha=1 R=331697.309205562 G_phys=3.01479684111719e-06 G_eff=3.01479684111719e-06
Ro4p4n1 h4yn o4p 332295.800297047
* o4 input 5 w=-0.195742340683107 w-  bank=n alpha=1 R=170291.890947078 G_phys=5.87227022049321e-06 G_eff=5.87227022049321e-06
Ro4n5n1 h5y o4p 169542.647869119
* o4 input 6 w=-0.202179592890339 w-  bank=n alpha=1 R=164869.920137851 G_phys=6.06538778671016e-06 G_eff=6.06538778671016e-06
Ro4n6n1 h6y o4p 164258.283064064
* o4 input 7 w=-0.112561544712497 w-  bank=n alpha=1 R=296134.291853162 G_phys=3.37684634137491e-06 G_eff=3.37684634137491e-06
Ro4n7n1 h7y o4p 297185.879263158
* o4 input 8 w=+0.0264861793940817 w+  bank=f alpha=0.001 R=1258.5179930021 G_phys=0.000794585381822452 G_eff=7.94585381822452e-07
Ro4p8f1 htap8n o4p 1256.41853743222
* o4 input 9 w=-0.0974936293293829 w-  bank=n alpha=1 R=341902.681873874 G_phys=2.92480887988149e-06 G_eff=2.92480887988149e-06
Ro4n9n1 h9y o4p 341708.787754005
* o4 input 10 w=-0.296895349286464 w-  bank=n alpha=1 R=112273.006005127 G_phys=8.90686047859392e-06 G_eff=8.90686047859392e-06
Ro4n10n1 h10y o4p 112185.451543193
* o4 input 11 w=-0.580818210763829 w-  bank=n alpha=1 R=57390.303395441 G_phys=1.74245463229149e-05 G_eff=1.74245463229149e-05
Ro4n11n1 h11y o4p 57316.4012934496
* o4 input 12 w=-0.276549005245937 w-  bank=n alpha=1 R=120533.188335607 G_phys=8.29647015737811e-06 G_eff=8.29647015737811e-06
Ro4n12n1 h12y o4p 121070.690732428
* o4 input 13 w=-0.164579538023522 w-  bank=n alpha=1 R=202536.316079398 G_phys=4.93738614070565e-06 G_eff=4.93738614070565e-06
Ro4n13n1 h13y o4p 203270.005260105
* o4 input 14 w=-0.00939321676538441 w-  bank=f alpha=0.001 R=3548.66007736267 G_phys=0.000281796502961532 G_eff=2.81796502961532e-07
Ro4n14f1 htap14 o4p 3538.92716096012
* o4 input 15 w=-0.0690593814994067 w-  bank=n alpha=1 R=482676.395438319 G_phys=2.0717814449822e-06 G_eff=2.0717814449822e-06
Ro4n15n1 h15y o4p 483367.385265882
* o4 input 16 w=-0.272869230842632 w-  bank=n alpha=1 R=122158.637052623 G_phys=8.18607692527895e-06 G_eff=8.18607692527895e-06
Ro4n16n1 h16y o4p 122183.09949934
* o4 input 17 w=+0.168866320874711 w+  bank=n alpha=1 R=197394.798208843 G_phys=5.06598962624132e-06 G_eff=5.06598962624132e-06
Ro4p17n1 h17yn o4p 197982.720218301
* o4 input 18 w=-0.0339148293163791 w-  bank=n alpha=1 R=982854.226461786 G_phys=1.01744487949137e-06 G_eff=1.01744487949137e-06
Ro4n18n1 h18y o4p 979634.141991846
* o4 input 19 w=-0.0805852645818897 w-  bank=n alpha=1 R=413640.552106898 G_phys=2.41755793745669e-06 G_eff=2.41755793745669e-06
Ro4n19n1 h19y o4p 414818.955598776
* o4 input 20 w=+0.0499049155841609 w+  bank=n alpha=1 R=667936.874417093 G_phys=1.49714746752483e-06 G_eff=1.49714746752483e-06
Ro4p20n1 h20yn o4p 664807.107142674
* o4 input 21 w=+0.0630428027700635 w+  bank=n alpha=1 R=528741.29747864 G_phys=1.8912840831019e-06 G_eff=1.8912840831019e-06
Ro4p21n1 h21yn o4p 529458.670771065
* o4 input 22 w=+0.077534797791833 w+  bank=n alpha=1 R=429914.493655189 G_phys=2.32604393375499e-06 G_eff=2.32604393375499e-06
Ro4p22n1 h22yn o4p 431059.83687912
* o4 input 23 w=+0.0744829629231984 w+  bank=n alpha=1 R=447529.636645958 G_phys=2.23448888769595e-06 G_eff=2.23448888769595e-06
Ro4p23n1 h23yn o4p 448299.989001004
* o4 input 24 w=-0.00836970221956497 w-  bank=f alpha=0.001 R=3982.61879083506 G_phys=0.000251091066586949 G_eff=2.51091066586949e-07
Ro4n24f1 htap24 o4p 4001.71444309032
* o4 input 25 w=-0.0959555339157937 w-  bank=n alpha=1 R=347383.126048626 G_phys=2.87866601747381e-06 G_eff=2.87866601747381e-06
Ro4n25n1 h25y o4p 347072.409624118
* o4 input 26 w=-0.27047998771669 w-  bank=n alpha=1 R=123237.706474047 G_phys=8.1143996315007e-06 G_eff=8.1143996315007e-06
Ro4n26n1 h26y o4p 123319.422489231
* o4 input 27 w=-0.0478904255869687 w-  bank=n alpha=1 R=696033.349563792 G_phys=1.43671276760906e-06 G_eff=1.43671276760906e-06
Ro4n27n1 h27y o4p 695252.110590083
* o4 input 28 w=-0.311644423649809 w-  bank=n alpha=1 R=106959.505140351 G_phys=9.34933270949427e-06 G_eff=9.34933270949427e-06
Ro4n28n1 h28y o4p 107160.463399404
* o4 input 29 w=-0.0286856006407659 w-  bank=f alpha=0.001 R=1162.02319591532 G_phys=0.000860568019222978 G_eff=8.60568019222978e-07
Ro4n29f1 htap29 o4p 1162.68571493798
* o4 input 30 w=-0.016265879828258 w-  bank=f alpha=0.001 R=2049.27945400314 G_phys=0.000487976394847741 G_eff=4.87976394847741e-07
Ro4n30f1 htap30 o4p 2046.67702185373
* o4 input 31 w=-0.119685509607977 w-  bank=n alpha=1 R=278507.677683913 G_phys=3.59056528823931e-06 G_eff=3.59056528823931e-06
Ro4n31n1 h31y o4p 279660.924584561
* o4 input 32 w=-0.0356690164245122 w-  bank=n alpha=1 R=934517.872223306 G_phys=1.07007049273537e-06 G_eff=1.07007049273537e-06
Ro4n32n1 h32y o4p 937903.626025597
* o4 bias w+  bank=n alpha=1 R=496540.049452281 G_phys=2.01393623959048e-06 G_eff=2.01393623959048e-06
Ro4bpn1 vrefn o4p 496310.122085649
* replica dummy G_tot for o4: same R as weights/biases, dest=0
Ro4dmy000 0 o4rp 121723.261788311
Ro4dmy001 0 o4rp 250259.192779225
Ro4dmy002 0 o4rp 311528.629393839
Ro4dmy003 0 o4rp 331843.055254714
Ro4dmy004 0 o4rp 169542.911258503
Ro4dmy005 0 o4rp 164482.801060272
Ro4dmy006 0 o4rp 296232.667043979
Ro4dmy007 0 o4rp 1263.34837073966
Ro4dmy008 0 o4rp 342148.495365436
Ro4dmy009 0 o4rp 112799.005301643
Ro4dmy010 0 o4rp 57654.9677246057
Ro4dmy011 0 o4rp 120277.367630198
Ro4dmy012 0 o4rp 203063.626773073
Ro4dmy013 0 o4rp 3549.79193785379
Ro4dmy014 0 o4rp 484679.362347029
Ro4dmy015 0 o4rp 121907.792907077
Ro4dmy016 0 o4rp 198073.471310782
Ro4dmy017 0 o4rp 986235.296871376
Ro4dmy018 0 o4rp 414243.93731607
Ro4dmy019 0 o4rp 668099.381569593
Ro4dmy020 0 o4rp 529276.676313807
Ro4dmy021 0 o4rp 428623.790990594
Ro4dmy022 0 o4rp 449016.248631078
Ro4dmy023 0 o4rp 3995.95909438414
Ro4dmy024 0 o4rp 348027.584837379
Ro4dmy025 0 o4rp 123289.278594584
Ro4dmy026 0 o4rp 696994.159502948
Ro4dmy027 0 o4rp 107093.011741256
Ro4dmy028 0 o4rp 1163.1083974295
Ro4dmy029 0 o4rp 2046.6588463601
Ro4dmy030 0 o4rp 277646.885998317
Ro4dmy031 0 o4rp 930867.822833647
Ro4dmy032 0 o4rp 495810.712960045
* feedback TIA o4: Rf=33333.3333333333 A=100000 V(o4sig) = -I(o4p)*Rf*A/(A+1)  (uncompensated)
Eo4tia o4sig 0 0 o4p 100000
Ro4f o4sig o4p 33238.4882063412
* feedback TIA o4r: Rf=33333.3333333333 A=100000 V(o4rep) = -I(o4rp)*Rf*A/(A+1)  (uncompensated)
Eo4rtia o4rep 0 0 o4rp 100000
Ro4rf o4rep o4rp 33292.2470003702
* replica null o4: v(o4lin)=v(o4sig)-v(o4rep) Vos_sig=0 Vos_rep=0
Eo4null o4lin 0 o4sig o4rep 1

* o5 input 1 w=+0.0860510418468527 w+  bank=n alpha=1 R=387366.99309995 G_phys=2.58153125540558e-06 G_eff=2.58153125540558e-06
Ro5p1n1 h1yn o5p 386427.75595605
* o5 input 2 w=-0.140209371980717 w-  bank=n alpha=1 R=237739.695017803 G_phys=4.20628115942151e-06 G_eff=4.20628115942151e-06
Ro5n2n1 h2y o5p 237183.17821575
* o5 input 3 w=-0.298670153474102 w-  bank=n alpha=1 R=111605.839906008 G_phys=8.96010460422305e-06 G_eff=8.96010460422305e-06
Ro5n3n1 h3y o5p 111185.862249341
* o5 input 4 w=+0.194023589749981 w+  bank=n alpha=1 R=171800.415487038 G_phys=5.82070769249943e-06 G_eff=5.82070769249943e-06
Ro5p4n1 h4yn o5p 171079.392389487
* o5 input 5 w=+0.104223096266613 w+  bank=n alpha=1 R=319826.74212694 G_phys=3.1266928879984e-06 G_eff=3.1266928879984e-06
Ro5p5n1 h5yn o5p 319854.316558795
* o5 input 6 w=+0.179601423642336 w+  bank=n alpha=1 R=185596.153178131 G_phys=5.38804270927008e-06 G_eff=5.38804270927008e-06
Ro5p6n1 h6yn o5p 184978.628414722
* o5 input 7 w=-0.15816414054373 w-  bank=n alpha=1 R=210751.521923626 G_phys=4.74492421631189e-06 G_eff=4.74492421631189e-06
Ro5n7n1 h7y o5p 210172.867253289
* o5 input 8 w=-0.249576912278698 w-  bank=n alpha=1 R=133559.362638923 G_phys=7.48730736836095e-06 G_eff=7.48730736836095e-06
Ro5n8n1 h8y o5p 133436.545928182
* o5 input 9 w=-0.031381439286146 w-  bank=f alpha=0.001 R=1062.19899697364 G_phys=0.00094144317858438 G_eff=9.41443178584379e-07
Ro5n9f1 htap9 o5p 1063.88114755088
* o5 input 10 w=+0.375618440651073 w+  bank=n alpha=1 R=88742.5369094113 G_phys=1.12685532195322e-05 G_eff=1.12685532195322e-05
Ro5p10n1 h10yn o5p 88445.705031701
* o5 input 11 w=+0.0953608962368974 w+  bank=n alpha=1 R=349549.287482848 G_phys=2.86082688710692e-06 G_eff=2.86082688710692e-06
Ro5p11n1 h11yn o5p 350701.660072376
* o5 input 12 w=+0.235920649298708 w+  bank=n alpha=1 R=141290.44419138 G_phys=7.07761947896125e-06 G_eff=7.07761947896125e-06
Ro5p12n1 h12yn o5p 141979.672240973
* o5 input 13 w=-0.0940916695355706 w-  bank=n alpha=1 R=354264.447616502 G_phys=2.82275008606712e-06 G_eff=2.82275008606712e-06
Ro5n13n1 h13y o5p 355066.182698071
* o5 input 14 w=+0.00295126144933853 w+  bank=f alpha=0.001 R=11294.6053426762 G_phys=8.85378434801559e-05 G_eff=8.85378434801559e-08
Ro5p14f1 htap14n o5p 11313.4508949711
* o5 input 15 w=+0.529616924207031 w+  bank=n alpha=1 R=62938.572786815 G_phys=1.58885077262109e-05 G_eff=1.58885077262109e-05
Ro5p15n1 h15yn o5p 63034.7843544088
* o5 input 16 w=+0.319042125899952 w+  bank=n alpha=1 R=104479.410796637 G_phys=9.57126377699856e-06 G_eff=9.57126377699856e-06
Ro5p16n1 h16yn o5p 104720.002108954
* o5 input 17 w=-0.466616152697173 w-  bank=n alpha=1 R=71436.3039956017 G_phys=1.39984845809152e-05 G_eff=1.39984845809152e-05
Ro5n17n1 h17y o5p 71730.0638832415
* o5 input 18 w=-0.243973793531226 w-  bank=n alpha=1 R=136626.696051546 G_phys=7.31921380593677e-06 G_eff=7.31921380593677e-06
Ro5n18n1 h18y o5p 136395.89246118
* o5 input 19 w=-0.167620412829882 w-  bank=n alpha=1 R=198862.01668745 G_phys=5.02861238489647e-06 G_eff=5.02861238489647e-06
Ro5n19n1 h19y o5p 199431.212546325
* o5 input 20 w=+0.191248887162316 w+  bank=n alpha=1 R=174292.953166534 G_phys=5.73746661486949e-06 G_eff=5.73746661486949e-06
Ro5p20n1 h20yn o5p 173481.814201438
* o5 input 21 w=+0.174220054558956 w+  bank=n alpha=1 R=191328.91111599 G_phys=5.22660163676868e-06 G_eff=5.22660163676868e-06
Ro5p21n1 h21yn o5p 192003.511698501
* o5 input 22 w=-0.14737880105185 w-  bank=n alpha=1 R=226174.545426015 G_phys=4.4213640315555e-06 G_eff=4.4213640315555e-06
Ro5n22n1 h22y o5p 226601.417942166
* o5 input 23 w=-0.261133636281725 w-  bank=n alpha=1 R=127648.562659203 G_phys=7.83400908845174e-06 G_eff=7.83400908845174e-06
Ro5n23n1 h23y o5p 127700.313801534
* o5 input 24 w=+0.130521837388059 w+  bank=n alpha=1 R=255385.106434174 G_phys=3.91565512164177e-06 G_eff=3.91565512164177e-06
Ro5p24n1 h24yn o5p 255185.363076157
* o5 input 25 w=-0.326372621774105 w-  bank=n alpha=1 R=102132.749837101 G_phys=9.79117865322314e-06 G_eff=9.79117865322314e-06
Ro5n25n1 h25y o5p 102155.424284432
* o5 input 26 w=+0.16696553546102 w+  bank=n alpha=1 R=199641.99941799 G_phys=5.00896606383059e-06 G_eff=5.00896606383059e-06
Ro5p26n1 h26yn o5p 198697.102173663
* o5 input 27 w=-0.105618085709112 w-  bank=n alpha=1 R=315602.513618153 G_phys=3.16854257127337e-06 G_eff=3.16854257127337e-06
Ro5n27n1 h27y o5p 316214.054943431
* o5 input 28 w=+0.0630335864648206 w+  bank=n alpha=1 R=528818.606124163 G_phys=1.89100759394462e-06 G_eff=1.89100759394462e-06
Ro5p28n1 h28yn o5p 526268.748006931
* o5 input 29 w=+0.231531157265063 w+  bank=n alpha=1 R=143969.104318744 G_phys=6.94593471795189e-06 G_eff=6.94593471795189e-06
Ro5p29n1 h29yn o5p 143782.269018425
* o5 input 30 w=-0.0894419530377066 w-  bank=n alpha=1 R=372681.188203491 G_phys=2.6832585911312e-06 G_eff=2.6832585911312e-06
Ro5n30n1 h30y o5p 371341.714956374
* o5 input 31 w=+0.216486138811528 w+  bank=n alpha=1 R=153974.446199316 G_phys=6.49458416434585e-06 G_eff=6.49458416434585e-06
Ro5p31n1 h31yn o5p 154154.863891076
* o5 input 32 w=-0.32037829849107 w-  bank=n alpha=1 R=104043.668033472 G_phys=9.6113489547321e-06 G_eff=9.6113489547321e-06
Ro5n32n1 h32y o5p 103792.377134059
* o5 bias w+  bank=f alpha=0.001 R=14493.185792249 G_phys=6.89979425044561e-05 G_eff=6.89979425044561e-08
Ro5bpf1 taprefn o5p 14565.5404888717
* replica dummy G_tot for o5: same R as weights/biases, dest=0
Ro5dmy000 0 o5rp 386259.982192377
Ro5dmy001 0 o5rp 237814.163804131
Ro5dmy002 0 o5rp 111069.14244918
Ro5dmy003 0 o5rp 172486.441753274
Ro5dmy004 0 o5rp 319588.175966158
Ro5dmy005 0 o5rp 185677.100842779
Ro5dmy006 0 o5rp 211013.209144831
Ro5dmy007 0 o5rp 133815.473642926
Ro5dmy008 0 o5rp 1060.21157651462
Ro5dmy009 0 o5rp 88525.6079558266
Ro5dmy010 0 o5rp 349837.192538535
Ro5dmy011 0 o5rp 141112.540387522
Ro5dmy012 0 o5rp 353251.660586669
Ro5dmy013 0 o5rp 11295.7992168869
Ro5dmy014 0 o5rp 62827.4230062643
Ro5dmy015 0 o5rp 104651.692921613
Ro5dmy016 0 o5rp 71463.1807554361
Ro5dmy017 0 o5rp 136239.601582007
Ro5dmy018 0 o5rp 198309.912918694
Ro5dmy019 0 o5rp 173637.833708617
Ro5dmy020 0 o5rp 190638.704076775
Ro5dmy021 0 o5rp 226261.283077502
Ro5dmy022 0 o5rp 127076.032307354
Ro5dmy023 0 o5rp 254707.078089902
Ro5dmy024 0 o5rp 102579.691689603
Ro5dmy025 0 o5rp 199853.712975285
Ro5dmy026 0 o5rp 316499.131708947
Ro5dmy027 0 o5rp 530950.789952726
Ro5dmy028 0 o5rp 143882.618751661
Ro5dmy029 0 o5rp 372086.22227058
Ro5dmy030 0 o5rp 154373.03801107
Ro5dmy031 0 o5rp 104451.837614429
Ro5dmy032 0 o5rp 14530.5176418663
* feedback TIA o5: Rf=33333.3333333333 A=100000 V(o5sig) = -I(o5p)*Rf*A/(A+1)  (uncompensated)
Eo5tia o5sig 0 0 o5p 100000
Ro5f o5sig o5p 33345.3532469706
* feedback TIA o5r: Rf=33333.3333333333 A=100000 V(o5rep) = -I(o5rp)*Rf*A/(A+1)  (uncompensated)
Eo5rtia o5rep 0 0 o5rp 100000
Ro5rf o5rep o5rp 33405.6340355692
* replica null o5: v(o5lin)=v(o5sig)-v(o5rep) Vos_sig=0 Vos_rep=0
Eo5null o5lin 0 o5sig o5rep 1

* o6 input 1 w=+0.177051530119574 w+  bank=n alpha=1 R=188269.106236028 G_phys=5.31154590358722e-06 G_eff=5.31154590358722e-06
Ro6p1n1 h1yn o6p 187998.371512432
* o6 input 2 w=+0.301592495922723 w+  bank=n alpha=1 R=110524.412191855 G_phys=9.04777487768168e-06 G_eff=9.04777487768168e-06
Ro6p2n1 h2yn o6p 110299.485932883
* o6 input 3 w=+0.171870982949934 w+  bank=n alpha=1 R=193943.92678282 G_phys=5.15612948849803e-06 G_eff=5.15612948849803e-06
Ro6p3n1 h3yn o6p 193459.401509202
* o6 input 4 w=-0.3405205591368 w-  bank=n alpha=1 R=97889.3415946205 G_phys=1.0215616774104e-05 G_eff=1.0215616774104e-05
Ro6n4n1 h4y o6p 97486.1272882704
* o6 input 5 w=-0.19025500833844 w-  bank=n alpha=1 R=175203.447333368 G_phys=5.70765025015321e-06 G_eff=5.70765025015321e-06
Ro6n5n1 h5y o6p 174505.244537266
* o6 input 6 w=+0.141724280050197 w+  bank=n alpha=1 R=235198.466497956 G_phys=4.25172840150592e-06 G_eff=4.25172840150592e-06
Ro6p6n1 h6yn o6p 235596.236999845
* o6 input 7 w=-0.0326153624876146 w-  bank=f alpha=0.001 R=1022.01327199694 G_phys=0.000978460874628438 G_eff=9.78460874628438e-07
Ro6n7f1 htap7 o6p 1022.131596779
* o6 input 8 w=+0.106637930601 w+  bank=n alpha=1 R=312584.210378712 G_phys=3.19913791802999e-06 G_eff=3.19913791802999e-06
Ro6p8n1 h8yn o6p 312584.702438145
* o6 input 9 w=+0.167194950685368 w+  bank=n alpha=1 R=199368.062233296 G_phys=5.01584852056104e-06 G_eff=5.01584852056104e-06
Ro6p9n1 h9yn o6p 199855.733952993
* o6 input 10 w=-0.113695758135469 w-  bank=n alpha=1 R=293180.096425556 G_phys=3.41087274406406e-06 G_eff=3.41087274406406e-06
Ro6n10n1 h10y o6p 292564.063487574
* o6 input 11 w=+0.174899957381211 w+  bank=n alpha=1 R=190585.142686343 G_phys=5.24699872143633e-06 G_eff=5.24699872143633e-06
Ro6p11n1 h11yn o6p 191455.674273375
* o6 input 12 w=-0.244360694504916 w-  bank=n alpha=1 R=136410.372383611 G_phys=7.33082083514748e-06 G_eff=7.33082083514748e-06
Ro6n12n1 h12y o6p 136784.956455717
* o6 input 13 w=+0.255772583539878 w+  bank=n alpha=1 R=130324.106172764 G_phys=7.67317750619635e-06 G_eff=7.67317750619635e-06
Ro6p13n1 h13yn o6p 130384.192471511
* o6 input 14 w=+0.139949769298614 w+  bank=n alpha=1 R=238180.695119327 G_phys=4.19849307895843e-06 G_eff=4.19849307895843e-06
Ro6p14n1 h14yn o6p 237427.310508803
* o6 input 15 w=-0.401168375335584 w-  bank=n alpha=1 R=83090.6307244419 G_phys=1.20350512600675e-05 G_eff=1.20350512600675e-05
Ro6n15n1 h15y o6p 82723.6686008958
* o6 input 16 w=+0.405832076822582 w+  bank=n alpha=1 R=82135.777916603 G_phys=1.21749623046775e-05 G_eff=1.21749623046775e-05
Ro6p16n1 h16yn o6p 82146.3799506476
* o6 input 17 w=-0.113061682974004 w-  bank=n alpha=1 R=294824.315864798 G_phys=3.39185048922012e-06 G_eff=3.39185048922012e-06
Ro6n17n1 h17y o6p 296019.913731782
* o6 input 18 w=-0.197513353657142 w-  bank=n alpha=1 R=168764.960526141 G_phys=5.92540060971425e-06 G_eff=5.92540060971425e-06
Ro6n18n1 h18y o6p 168411.576169523
* o6 input 19 w=-0.228990652840289 w-  bank=n alpha=1 R=145566.349193222 G_phys=6.86971958520868e-06 G_eff=6.86971958520868e-06
Ro6n19n1 h19y o6p 145142.245865044
* o6 input 20 w=-0.216778558754084 w-  bank=n alpha=1 R=153766.744852045 G_phys=6.50335676262251e-06 G_eff=6.50335676262251e-06
Ro6n20n1 h20y o6p 154440.658616716
* o6 input 21 w=-0.139531541535413 w-  bank=n alpha=1 R=238894.610971336 G_phys=4.18594624606239e-06 G_eff=4.18594624606239e-06
Ro6n21n1 h21y o6p 237938.175593439
* o6 input 22 w=-0.394983843934915 w-  bank=n alpha=1 R=84391.6373927081 G_phys=1.18495153180474e-05 G_eff=1.18495153180474e-05
Ro6n22n1 h22y o6p 84619.2856132992
* o6 input 23 w=-0.193849822273603 w-  bank=n alpha=1 R=171954.41781879 G_phys=5.81549466820809e-06 G_eff=5.81549466820809e-06
Ro6n23n1 h23y o6p 172103.591309833
* o6 input 24 w=-0.0741873589980665 w-  bank=n alpha=1 R=449312.844984846 G_phys=2.22562076994199e-06 G_eff=2.22562076994199e-06
Ro6n24n1 h24y o6p 449476.658880779
* o6 input 25 w=-0.172655508406202 w-  bank=n alpha=1 R=193062.669364194 G_phys=5.17966525218605e-06 G_eff=5.17966525218605e-06
Ro6n25n1 h25y o6p 193977.535608551
* o6 input 26 w=+0.0670699610875517 w+  bank=n alpha=1 R=496993.479537295 G_phys=2.01209883262655e-06 G_eff=2.01209883262655e-06
Ro6p26n1 h26yn o6p 494797.577879838
* o6 input 27 w=+0.25363855276468 w+  bank=n alpha=1 R=131420.610037384 G_phys=7.60915658294039e-06 G_eff=7.60915658294039e-06
Ro6p27n1 h27yn o6p 131624.646148047
* o6 input 28 w=-0.179185579156039 w-  bank=n alpha=1 R=186026.874988115 G_phys=5.37556737468116e-06 G_eff=5.37556737468116e-06
Ro6n28n1 h28y o6p 186006.627720054
* o6 input 29 w=-0.129923130427228 w-  bank=n alpha=1 R=256561.962629155 G_phys=3.89769391281685e-06 G_eff=3.89769391281685e-06
Ro6n29n1 h29y o6p 257283.628944648
* o6 input 30 w=-0.169171092451912 w-  bank=n alpha=1 R=197039.179981701 G_phys=5.07513277355737e-06 G_eff=5.07513277355737e-06
Ro6n30n1 h30y o6p 197301.800807292
* o6 input 31 w=+0.218686712022964 w+  bank=n alpha=1 R=152425.051458238 G_phys=6.56060136068893e-06 G_eff=6.56060136068893e-06
Ro6p31n1 h31yn o6p 152786.482066537
* o6 input 32 w=+0.133370937368681 w+  bank=n alpha=1 R=249929.512313385 G_phys=4.00112812106042e-06 G_eff=4.00112812106042e-06
Ro6p32n1 h32yn o6p 249057.716683151
* o6 bias w+  bank=n alpha=1 R=514207.987696552 G_phys=1.94473836254393e-06 G_eff=1.94473836254393e-06
Ro6bpn1 vrefn o6p 512400.338480452
* replica dummy G_tot for o6: same R as weights/biases, dest=0
Ro6dmy000 0 o6rp 188100.960823578
Ro6dmy001 0 o6rp 110704.283313864
Ro6dmy002 0 o6rp 194424.085957686
Ro6dmy003 0 o6rp 97904.3552462821
Ro6dmy004 0 o6rp 174559.637540945
Ro6dmy005 0 o6rp 234967.90826069
Ro6dmy006 0 o6rp 1024.41989394775
Ro6dmy007 0 o6rp 311616.139783312
Ro6dmy008 0 o6rp 199780.586487898
Ro6dmy009 0 o6rp 292105.397220665
Ro6dmy010 0 o6rp 191045.291196148
Ro6dmy011 0 o6rp 136001.585184014
Ro6dmy012 0 o6rp 130095.709572413
Ro6dmy013 0 o6rp 238545.803144472
Ro6dmy014 0 o6rp 83254.3417231822
Ro6dmy015 0 o6rp 82457.2273016323
Ro6dmy016 0 o6rp 293383.248744147
Ro6dmy017 0 o6rp 168519.178909225
Ro6dmy018 0 o6rp 146043.866985646
Ro6dmy019 0 o6rp 153785.08635567
Ro6dmy020 0 o6rp 240061.7039947
Ro6dmy021 0 o6rp 84143.5472870769
Ro6dmy022 0 o6rp 172224.043822846
Ro6dmy023 0 o6rp 450463.407835892
Ro6dmy024 0 o6rp 193125.909466642
Ro6dmy025 0 o6rp 498253.342990066
Ro6dmy026 0 o6rp 131735.040429851
Ro6dmy027 0 o6rp 186091.237090788
Ro6dmy028 0 o6rp 256155.466875401
Ro6dmy029 0 o6rp 196505.92266548
Ro6dmy030 0 o6rp 152868.436513207
Ro6dmy031 0 o6rp 250222.810758062
Ro6dmy032 0 o6rp 516617.764009789
* feedback TIA o6: Rf=33333.3333333333 A=100000 V(o6sig) = -I(o6p)*Rf*A/(A+1)  (uncompensated)
Eo6tia o6sig 0 0 o6p 100000
Ro6f o6sig o6p 33186.8722158943
* feedback TIA o6r: Rf=33333.3333333333 A=100000 V(o6rep) = -I(o6rp)*Rf*A/(A+1)  (uncompensated)
Eo6rtia o6rep 0 0 o6rp 100000
Ro6rf o6rep o6rp 33394.4017360622
* replica null o6: v(o6lin)=v(o6sig)-v(o6rep) Vos_sig=0 Vos_rep=0
Eo6null o6lin 0 o6sig o6rep 1

* o7 input 1 w=+0.130193574665561 w+  bank=n alpha=1 R=256029.020010853 G_phys=3.90580723996683e-06 G_eff=3.90580723996683e-06
Ro7p1n1 h1yn o7p 256308.845673629
* o7 input 2 w=+0.394190134763453 w+  bank=n alpha=1 R=84561.5615249634 G_phys=1.18257040429036e-05 G_eff=1.18257040429036e-05
Ro7p2n1 h2yn o7p 84436.1714037512
* o7 input 3 w=+0.206617853142924 w+  bank=n alpha=1 R=161328.427463021 G_phys=6.19853559428773e-06 G_eff=6.19853559428773e-06
Ro7p3n1 h3yn o7p 161070.670054259
* o7 input 4 w=-0.378033462280536 w-  bank=n alpha=1 R=88175.6158098959 G_phys=1.13410038684161e-05 G_eff=1.13410038684161e-05
Ro7n4n1 h4y o7p 87819.2463725169
* o7 input 5 w=-0.580108461232067 w-  bank=n alpha=1 R=57460.5191286783 G_phys=1.7403253836962e-05 G_eff=1.7403253836962e-05
Ro7n5n1 h5y o7p 57295.6859209549
* o7 input 6 w=+0.107934080055711 w+  bank=n alpha=1 R=308830.476121427 G_phys=3.23802240167132e-06 G_eff=3.23802240167132e-06
Ro7p6n1 h6yn o7p 307286.75539137
* o7 input 7 w=+0.101501144533757 w+  bank=n alpha=1 R=328403.521816913 G_phys=3.04503433601271e-06 G_eff=3.04503433601271e-06
Ro7p7n1 h7yn o7p 327248.213661053
* o7 input 8 w=+0.0692471666647439 w+  bank=n alpha=1 R=481367.468718463 G_phys=2.07741499994232e-06 G_eff=2.07741499994232e-06
Ro7p8n1 h8yn o7p 481248.802543371
* o7 input 9 w=-0.335430638558454 w-  bank=n alpha=1 R=99374.7424999297 G_phys=1.00629191567536e-05 G_eff=1.00629191567536e-05
Ro7n9n1 h9y o7p 99047.8601956834
* o7 input 10 w=+0.101094797691112 w+  bank=n alpha=1 R=329723.527764315 G_phys=3.03284393073337e-06 G_eff=3.03284393073337e-06
Ro7p10n1 h10yn o7p 330904.694528241
* o7 input 11 w=-0.148243371766924 w-  bank=n alpha=1 R=224855.472025703 G_phys=4.44730115300771e-06 G_eff=4.44730115300771e-06
Ro7n11n1 h11y o7p 224117.878980571
* o7 input 12 w=-0.334713947003149 w-  bank=n alpha=1 R=99587.5243077928 G_phys=1.00414184100945e-05 G_eff=1.00414184100945e-05
Ro7n12n1 h12y o7p 99767.3419198974
* o7 input 13 w=-0.322800486422993 w-  bank=n alpha=1 R=103262.958809962 G_phys=9.68401459268979e-06 G_eff=9.68401459268979e-06
Ro7n13n1 h13y o7p 103565.919936009
* o7 input 14 w=-0.104357857187523 w-  bank=n alpha=1 R=319413.73876081 G_phys=3.13073571562568e-06 G_eff=3.13073571562568e-06
Ro7n14n1 h14y o7p 317968.146136407
* o7 input 15 w=+0.182195051802482 w+  bank=n alpha=1 R=182954.108816688 G_phys=5.46585155407446e-06 G_eff=5.46585155407446e-06
Ro7p15n1 h15yn o7p 182410.548283076
* o7 input 16 w=+0.0146234127477982 w+  bank=f alpha=0.001 R=2279.44966802309 G_phys=0.000438702382433947 G_eff=4.38702382433947e-07
Ro7p16f1 htap16n o7p 2289.0777139122
* o7 input 17 w=-0.0268461940667064 w-  bank=f alpha=0.001 R=1241.64092871071 G_phys=0.000805385822001192 G_eff=8.05385822001192e-07
Ro7n17f1 htap17 o7p 1240.30196516505
* o7 input 18 w=+0.263886686193095 w+  bank=n alpha=1 R=126316.843847674 G_phys=7.91660058579284e-06 G_eff=7.91660058579284e-06
Ro7p18n1 h18yn o7p 125945.506216463
* o7 input 19 w=+0.184182739421503 w+  bank=n alpha=1 R=180979.680495738 G_phys=5.52548218264508e-06 G_eff=5.52548218264508e-06
Ro7p19n1 h19yn o7p 180202.021431185
* o7 input 20 w=-0.16994338127458 w-  bank=n alpha=1 R=196143.757311009 G_phys=5.09830143823739e-06 G_eff=5.09830143823739e-06
Ro7n20n1 h20y o7p 197095.085959794
* o7 input 21 w=-0.17515931490212 w-  bank=n alpha=1 R=190302.94421944 G_phys=5.25477944706359e-06 G_eff=5.25477944706359e-06
Ro7n21n1 h21y o7p 190866.014006498
* o7 input 22 w=+0.170460541565249 w+  bank=n alpha=1 R=195548.67670401 G_phys=5.11381624695746e-06 G_eff=5.11381624695746e-06
Ro7p22n1 h22yn o7p 196362.358383724
* o7 input 23 w=-0.342102206419994 w-  bank=n alpha=1 R=97436.7680412165 G_phys=1.02630661925998e-05 G_eff=1.02630661925998e-05
Ro7n23n1 h23y o7p 97801.9906501965
* o7 input 24 w=-0.0940891241579366 w-  bank=n alpha=1 R=354274.031474461 G_phys=2.8226737247381e-06 G_eff=2.8226737247381e-06
Ro7n24n1 h24y o7p 354406.015411413
* o7 input 25 w=-0.147263798833488 w-  bank=n alpha=1 R=226351.171145758 G_phys=4.41791396500465e-06 G_eff=4.41791396500465e-06
Ro7n25n1 h25y o7p 226183.974250772
* o7 input 26 w=-0.0975787524659246 w-  bank=n alpha=1 R=341604.421976738 G_phys=2.92736257397774e-06 G_eff=2.92736257397774e-06
Ro7n26n1 h26y o7p 342395.87130136
* o7 input 27 w=-0.201262065009158 w-  bank=n alpha=1 R=165621.540908947 G_phys=6.03786195027474e-06 G_eff=6.03786195027474e-06
Ro7n27n1 h27y o7p 164828.739506055
* o7 input 28 w=-0.060609790215781 w-  bank=n alpha=1 R=549966.155874506 G_phys=1.81829370647343e-06 G_eff=1.81829370647343e-06
Ro7n28n1 h28y o7p 551871.409454639
* o7 input 29 w=-0.355920486311588 w-  bank=n alpha=1 R=93653.8766811862 G_phys=1.06776145893477e-05 G_eff=1.06776145893477e-05
Ro7n29n1 h29y o7p 93257.9831614776
* o7 input 30 w=+0.0702967455487947 w+  bank=n alpha=1 R=474180.320484337 G_phys=2.10890236646384e-06 G_eff=2.10890236646384e-06
Ro7p30n1 h30yn o7p 472723.686517367
* o7 input 31 w=+0.188674793501044 w+  bank=n alpha=1 R=176670.835116874 G_phys=5.66024380503133e-06 G_eff=5.66024380503133e-06
Ro7p31n1 h31yn o7p 177017.866031772
* o7 input 32 w=-0.221533996080022 w-  bank=n alpha=1 R=150465.995843332 G_phys=6.64601988240065e-06 G_eff=6.64601988240065e-06
Ro7n32n1 h32y o7p 151062.276298778
* o7 bias w+  bank=n alpha=1 R=694833.256669366 G_phys=1.43919421012378e-06 G_eff=1.43919421012378e-06
Ro7bpn1 vrefn o7p 696014.37248273
* replica dummy G_tot for o7: same R as weights/biases, dest=0
Ro7dmy000 0 o7rp 255799.287040123
Ro7dmy001 0 o7rp 84216.6436801252
Ro7dmy002 0 o7rp 160647.835956676
Ro7dmy003 0 o7rp 87795.0428571281
Ro7dmy004 0 o7rp 57364.6348824648
Ro7dmy005 0 o7rp 309179.218238243
Ro7dmy006 0 o7rp 328682.41536549
Ro7dmy007 0 o7rp 483700.991686372
Ro7dmy008 0 o7rp 99484.8288294595
Ro7dmy009 0 o7rp 329164.124117665
Ro7dmy010 0 o7rp 224179.269742869
Ro7dmy011 0 o7rp 99187.8994676472
Ro7dmy012 0 o7rp 102751.89394001
Ro7dmy013 0 o7rp 320291.370814692
Ro7dmy014 0 o7rp 182182.635509196
Ro7dmy015 0 o7rp 2268.56014898765
Ro7dmy016 0 o7rp 1245.62943344702
Ro7dmy017 0 o7rp 126039.35554964
Ro7dmy018 0 o7rp 180754.157474575
Ro7dmy019 0 o7rp 196247.660977504
Ro7dmy020 0 o7rp 190917.627438558
Ro7dmy021 0 o7rp 195206.624497922
Ro7dmy022 0 o7rp 97122.7909924943
Ro7dmy023 0 o7rp 354351.176179961
Ro7dmy024 0 o7rp 227464.212968389
Ro7dmy025 0 o7rp 342662.418406054
Ro7dmy026 0 o7rp 164951.337041701
Ro7dmy027 0 o7rp 547268.064565126
Ro7dmy028 0 o7rp 93384.3807686632
Ro7dmy029 0 o7rp 473322.661115387
Ro7dmy030 0 o7rp 177086.088611819
Ro7dmy031 0 o7rp 150004.996050754
Ro7dmy032 0 o7rp 694020.537497277
* feedback TIA o7: Rf=33333.3333333333 A=100000 V(o7sig) = -I(o7p)*Rf*A/(A+1)  (uncompensated)
Eo7tia o7sig 0 0 o7p 100000
Ro7f o7sig o7p 33343.8651175649
* feedback TIA o7r: Rf=33333.3333333333 A=100000 V(o7rep) = -I(o7rp)*Rf*A/(A+1)  (uncompensated)
Eo7rtia o7rep 0 0 o7rp 100000
Ro7rf o7rep o7rp 33175.6915402713
* replica null o7: v(o7lin)=v(o7sig)-v(o7rep) Vos_sig=0 Vos_rep=0
Eo7null o7lin 0 o7sig o7rep 1

* o8 input 1 w=-0.264579445854062 w-  bank=n alpha=1 R=125986.103061534 G_phys=7.93738337562187e-06 G_eff=7.93738337562187e-06
Ro8n1n1 h1y o8p 125360.242936112
* o8 input 2 w=-0.461651647659873 w-  bank=n alpha=1 R=72204.5150327114 G_phys=1.38495494297962e-05 G_eff=1.38495494297962e-05
Ro8n2n1 h2y o8p 72032.8758302206
* o8 input 3 w=-0.248506615035073 w-  bank=n alpha=1 R=134134.591663199 G_phys=7.45519845105219e-06 G_eff=7.45519845105219e-06
Ro8n3n1 h3y o8p 133576.645866883
* o8 input 4 w=-0.0596907059046396 w-  bank=n alpha=1 R=558434.22905043 G_phys=1.79072117713919e-06 G_eff=1.79072117713919e-06
Ro8n4n1 h4y o8p 559476.32659827
* o8 input 5 w=-0.142952779428107 w-  bank=n alpha=1 R=233177.231437442 G_phys=4.28858338284322e-06 G_eff=4.28858338284322e-06
Ro8n5n1 h5y o8p 232952.465125552
* o8 input 6 w=+0.230947580946818 w+  bank=n alpha=1 R=144332.896654195 G_phys=6.92842742840454e-06 G_eff=6.92842742840454e-06
Ro8p6n1 h6yn o8p 143838.659315935
* o8 input 7 w=+0.224542704495923 w+  bank=n alpha=1 R=148449.861277673 G_phys=6.7362811348777e-06 G_eff=6.7362811348777e-06
Ro8p7n1 h7yn o8p 148695.881737006
* o8 input 8 w=-0.0814289785611842 w-  bank=n alpha=1 R=409354.678424307 G_phys=2.44286935683553e-06 G_eff=2.44286935683553e-06
Ro8n8n1 h8y o8p 408389.482434662
* o8 input 9 w=+0.151871407153412 w+  bank=n alpha=1 R=219483.93024147 G_phys=4.55614221460235e-06 G_eff=4.55614221460235e-06
Ro8p9n1 h9yn o8p 219854.059465515
* o8 input 10 w=-0.0439376442611886 w-  bank=n alpha=1 R=758650.899333209 G_phys=1.31812932783566e-06 G_eff=1.31812932783566e-06
Ro8n10n1 h10y o8p 762438.284098439
* o8 input 11 w=-0.0114777570667242 w-  bank=f alpha=0.001 R=2904.16787352748 G_phys=0.000344332712001725 G_eff=3.44332712001725e-07
Ro8n11f1 htap11 o8p 2893.33558924289
* o8 input 12 w=-0.184091969163629 w-  bank=n alpha=1 R=181068.91617692 G_phys=5.52275907490888e-06 G_eff=5.52275907490888e-06
Ro8n12n1 h12y o8p 181309.461114579
* o8 input 13 w=+0.167375709493599 w+  bank=n alpha=1 R=199152.753014069 G_phys=5.02127128480798e-06 G_eff=5.02127128480798e-06
Ro8p13n1 h13yn o8p 199855.529322783
* o8 input 14 w=+0.639794426458427 w+  bank=n alpha=1 R=52100.068326399 G_phys=1.91938327937528e-05 G_eff=1.91938327937528e-05
Ro8p14n1 h14yn o8p 52263.3599744692
* o8 input 15 w=+0.00251732875304732 w+  bank=f alpha=0.001 R=13241.5495167177 G_phys=7.55198625914195e-05 G_eff=7.55198625914195e-08
Ro8p15f1 htap15n o8p 13261.8976417505
* o8 input 16 w=+0.510552134317183 w+  bank=n alpha=1 R=65288.7944106113 G_phys=1.53165640295155e-05 G_eff=1.53165640295155e-05
Ro8p16n1 h16yn o8p 65288.9419951661
* o8 input 17 w=-0.402994248540282 w-  bank=n alpha=1 R=82714.166403299 G_phys=1.20898274562085e-05 G_eff=1.20898274562085e-05
Ro8n17n1 h17y o8p 82523.4792218962
* o8 input 18 w=+0.141582671709231 w+  bank=n alpha=1 R=235433.707606466 G_phys=4.24748015127692e-06 G_eff=4.24748015127692e-06
Ro8p18n1 h18yn o8p 234571.299565293
* o8 input 19 w=+0.181760587882604 w+  bank=n alpha=1 R=183391.425620073 G_phys=5.45281763647812e-06 G_eff=5.45281763647812e-06
Ro8p19n1 h19yn o8p 184051.14844495
* o8 input 20 w=+0.465247625040388 w+  bank=n alpha=1 R=71646.4341552301 G_phys=1.39574287512116e-05 G_eff=1.39574287512116e-05
Ro8p20n1 h20yn o8p 71859.7936407493
* o8 input 21 w=-0.129997678502292 w-  bank=n alpha=1 R=256414.835382969 G_phys=3.89993035506876e-06 G_eff=3.89993035506876e-06
Ro8n21n1 h21y o8p 255356.709447363
* o8 input 22 w=+0.727771195072513 w+  bank=n alpha=1 R=45801.9409932982 G_phys=2.18331358521754e-05 G_eff=2.18331358521754e-05
Ro8p22n1 h22yn o8p 45832.3466133988
* o8 input 23 w=+0.0590279674258587 w+  bank=n alpha=1 R=564704.068036922 G_phys=1.77083902277576e-06 G_eff=1.77083902277576e-06
Ro8p23n1 h23yn o8p 565654.010696685
* o8 input 24 w=-0.0219880792573176 w-  bank=f alpha=0.001 R=1515.97294803456 G_phys=0.000659642377719527 G_eff=6.59642377719527e-07
Ro8n24f1 htap24 o8p 1508.83466967334
* o8 input 25 w=-0.000673889145733125 w-  bank=f alpha=0.001 R=49464.1196469635 G_phys=2.02166743719938e-05 G_eff=2.02166743719938e-08
Ro8n25f1 htap25 o8p 49327.9050619069
* o8 input 26 w=-0.0895992045192751 w-  bank=n alpha=1 R=372027.112430027 G_phys=2.68797613557825e-06 G_eff=2.68797613557825e-06
Ro8n26n1 h26y o8p 372746.732121587
* o8 input 27 w=-0.161030155307918 w-  bank=n alpha=1 R=207000.56625788 G_phys=4.83090465923753e-06 G_eff=4.83090465923753e-06
Ro8n27n1 h27y o8p 206618.247761209
* o8 input 28 w=-0.0515875057732319 w-  bank=n alpha=1 R=646151.288644577 G_phys=1.54762517319696e-06 G_eff=1.54762517319696e-06
Ro8n28n1 h28y o8p 644569.214613422
* o8 input 29 w=-0.167333727666792 w-  bank=n alpha=1 R=199202.71781496 G_phys=5.02001183000377e-06 G_eff=5.02001183000377e-06
Ro8n29n1 h29y o8p 200159.905336994
* o8 input 30 w=+0.117154510339097 w+  bank=n alpha=1 R=284524.541452582 G_phys=3.5146353101729e-06 G_eff=3.5146353101729e-06
Ro8p30n1 h30yn o8p 284361.135504105
* o8 input 31 w=-0.114263857072683 w-  bank=n alpha=1 R=291722.458766031 G_phys=3.42791571218049e-06 G_eff=3.42791571218049e-06
Ro8n31n1 h31y o8p 292496.140868501
* o8 input 32 w=+0.185068242761295 w+  bank=n alpha=1 R=180113.739861503 G_phys=5.55204728283885e-06 G_eff=5.55204728283885e-06
Ro8p32n1 h32yn o8p 179893.858394768
* o8 bias w+  bank=n alpha=1 R=473927.47001289 G_phys=2.11002751111431e-06 G_eff=2.11002751111431e-06
Ro8bpn1 vrefn o8p 472517.051767266
* replica dummy G_tot for o8: same R as weights/biases, dest=0
Ro8dmy000 0 o8rp 126038.759229243
Ro8dmy001 0 o8rp 72294.7856962089
Ro8dmy002 0 o8rp 133955.625893329
Ro8dmy003 0 o8rp 558407.823303145
Ro8dmy004 0 o8rp 233370.156400847
Ro8dmy005 0 o8rp 144875.674250504
Ro8dmy006 0 o8rp 148295.6835672
Ro8dmy007 0 o8rp 408581.36177724
Ro8dmy008 0 o8rp 220041.964259835
Ro8dmy009 0 o8rp 759647.930823009
Ro8dmy010 0 o8rp 2915.46216948465
Ro8dmy011 0 o8rp 180553.374150494
Ro8dmy012 0 o8rp 198583.065942734
Ro8dmy013 0 o8rp 52229.3511270423
Ro8dmy014 0 o8rp 13261.6059126814
Ro8dmy015 0 o8rp 65154.5093208448
Ro8dmy016 0 o8rp 82494.9656473798
Ro8dmy017 0 o8rp 235355.58795894
Ro8dmy018 0 o8rp 183096.537741278
Ro8dmy019 0 o8rp 71623.0631682551
Ro8dmy020 0 o8rp 256558.318912839
Ro8dmy021 0 o8rp 45842.6135728916
Ro8dmy022 0 o8rp 565696.089212627
Ro8dmy023 0 o8rp 1508.82561257628
Ro8dmy024 0 o8rp 49266.2361092997
Ro8dmy025 0 o8rp 373181.80149922
Ro8dmy026 0 o8rp 207347.958658491
Ro8dmy027 0 o8rp 649131.036574205
Ro8dmy028 0 o8rp 199531.515217969
Ro8dmy029 0 o8rp 283683.24045106
Ro8dmy030 0 o8rp 292313.073418521
Ro8dmy031 0 o8rp 180361.458010555
Ro8dmy032 0 o8rp 474341.590938543
* feedback TIA o8: Rf=33333.3333333333 A=100000 V(o8sig) = -I(o8p)*Rf*A/(A+1)  (uncompensated)
Eo8tia o8sig 0 0 o8p 100000
Ro8f o8sig o8p 33451.2014809102
* feedback TIA o8r: Rf=33333.3333333333 A=100000 V(o8rep) = -I(o8rp)*Rf*A/(A+1)  (uncompensated)
Eo8rtia o8rep 0 0 o8rp 100000
Ro8rf o8rep o8rp 33359.0768564913
* replica null o8: v(o8lin)=v(o8sig)-v(o8rep) Vos_sig=0 Vos_rep=0
Eo8null o8lin 0 o8sig o8rep 1

* o9 input 1 w=-0.342788496026982 w-  bank=n alpha=1 R=97241.6919461309 G_phys=1.02836548808095e-05 G_eff=1.02836548808095e-05
Ro9n1n1 h1y o9p 96925.3903455502
* o9 input 2 w=+0.117901804588507 w+  bank=n alpha=1 R=282721.146208671 G_phys=3.5370541376552e-06 G_eff=3.5370541376552e-06
Ro9p2n1 h2yn o9p 283393.070562439
* o9 input 3 w=-0.555835720214104 w-  bank=n alpha=1 R=59969.7574680763 G_phys=1.66750716064231e-05 G_eff=1.66750716064231e-05
Ro9n3n1 h3y o9p 60244.2294790558
* o9 input 4 w=+0.355136587925528 w+  bank=n alpha=1 R=93860.6003060526 G_phys=1.06540976377658e-05 G_eff=1.06540976377658e-05
Ro9p4n1 h4yn o9p 93588.1016715945
* o9 input 5 w=+0.236432436172994 w+  bank=n alpha=1 R=140984.603774686 G_phys=7.09297308518982e-06 G_eff=7.09297308518982e-06
Ro9p5n1 h5yn o9p 140543.274631716
* o9 input 6 w=-0.00589463242951189 w-  bank=f alpha=0.001 R=5654.86206848924 G_phys=0.000176838972885357 G_eff=1.76838972885357e-07
Ro9n6f1 htap6 o9p 5681.31683956937
* o9 input 7 w=-0.175810166557473 w-  bank=n alpha=1 R=189598.440101794 G_phys=5.27430499672418e-06 G_eff=5.27430499672418e-06
Ro9n7n1 h7y o9p 188734.892961009
* o9 input 8 w=+0.162552656301944 w+  bank=n alpha=1 R=205061.757166343 G_phys=4.87657968905832e-06 G_eff=4.87657968905832e-06
Ro9p8n1 h8yn o9p 204120.541803048
* o9 input 9 w=-0.443497798175432 w-  bank=n alpha=1 R=75160.0875370025 G_phys=1.3304933945263e-05 G_eff=1.3304933945263e-05
Ro9n9n1 h9y o9p 75033.8007139247
* o9 input 10 w=+0.114863161009978 w+  bank=n alpha=1 R=290200.383136224 G_phys=3.44589483029933e-06 G_eff=3.44589483029933e-06
Ro9p10n1 h10yn o9p 289312.80063229
* o9 input 11 w=-0.051706338551111 w-  bank=n alpha=1 R=644666.287874624 G_phys=1.55119015653333e-06 G_eff=1.55119015653333e-06
Ro9n11n1 h11y o9p 647025.087626194
* o9 input 12 w=-0.247913853258797 w-  bank=n alpha=1 R=134455.307338298 G_phys=7.43741559776392e-06 G_eff=7.43741559776392e-06
Ro9n12n1 h12y o9p 133799.14748857
* o9 input 13 w=+0.0720916431840902 w+  bank=n alpha=1 R=462374.442599605 G_phys=2.16274929552271e-06 G_eff=2.16274929552271e-06
Ro9p13n1 h13yn o9p 462291.524033706
* o9 input 14 w=+0.00473033723811417 w+  bank=f alpha=0.001 R=7046.71393505597 G_phys=0.000141910117143425 G_eff=1.41910117143425e-07
Ro9p14f1 htap14n o9p 7027.68347355964
* o9 input 15 w=-0.290577914446662 w-  bank=n alpha=1 R=114713.925856371 G_phys=8.71733743339986e-06 G_eff=8.71733743339986e-06
Ro9n15n1 h15y o9p 115130.280165637
* o9 input 16 w=-0.0531648681945055 w-  bank=n alpha=1 R=626980.456556052 G_phys=1.59494604583516e-06 G_eff=1.59494604583516e-06
Ro9n16n1 h16y o9p 624886.001597855
* o9 input 17 w=+0.0157425177085947 w+  bank=f alpha=0.001 R=2117.40802521917 G_phys=0.000472275531257841 G_eff=4.72275531257841e-07
Ro9p17f1 htap17n o9p 2121.09833500457
* o9 input 18 w=-0.104777957691913 w-  bank=n alpha=1 R=318133.06985183 G_phys=3.14333873075738e-06 G_eff=3.14333873075738e-06
Ro9n18n1 h18y o9p 317402.396813421
* o9 input 19 w=-0.368259428743895 w-  bank=n alpha=1 R=90515.8992046201 G_phys=1.10477828623168e-05 G_eff=1.10477828623168e-05
Ro9n19n1 h19y o9p 90786.569617169
* o9 input 20 w=+0.100989358745228 w+  bank=n alpha=1 R=330067.778897631 G_phys=3.02968076235683e-06 G_eff=3.02968076235683e-06
Ro9p20n1 h20yn o9p 330026.362542741
* o9 input 21 w=+0.084258883556939 w+  bank=n alpha=1 R=395606.15956664 G_phys=2.52776650670817e-06 G_eff=2.52776650670817e-06
Ro9p21n1 h21yn o9p 396888.504040306
* o9 input 22 w=+0.093068688723566 w+  bank=n alpha=1 R=358158.40741391 G_phys=2.79206066170698e-06 G_eff=2.79206066170698e-06
Ro9p22n1 h22yn o9p 359928.202796374
* o9 input 23 w=+0.153137872499505 w+  bank=n alpha=1 R=217668.776438311 G_phys=4.59413617498515e-06 G_eff=4.59413617498515e-06
Ro9p23n1 h23yn o9p 216924.601472276
* o9 input 24 w=+0.0107021071757068 w+  bank=f alpha=0.001 R=3114.65142201137 G_phys=0.000321063215271205 G_eff=3.21063215271205e-07
Ro9p24f1 htap24n o9p 3110.98696551454
* o9 input 25 w=+0.151859492007221 w+  bank=n alpha=1 R=219501.151312611 G_phys=4.55578476021664e-06 G_eff=4.55578476021664e-06
Ro9p25n1 h25yn o9p 219121.976044215
* o9 input 26 w=-0.0745603298060184 w-  bank=n alpha=1 R=447065.261380358 G_phys=2.23680989418055e-06 G_eff=2.23680989418055e-06
Ro9n26n1 h26y o9p 445741.730644421
* o9 input 27 w=+0.475223780202243 w+  bank=n alpha=1 R=70142.3933775947 G_phys=1.42567134060673e-05 G_eff=1.42567134060673e-05
Ro9p27n1 h27yn o9p 70268.7386234489
* o9 input 28 w=+0.715956917954612 w+  bank=n alpha=1 R=46557.736223238 G_phys=2.14787075386384e-05 G_eff=2.14787075386384e-05
Ro9p28n1 h28yn o9p 46621.1915998836
* o9 input 29 w=-0.520384445309866 w-  bank=n alpha=1 R=64055.2069412544 G_phys=1.5611533359296e-05 G_eff=1.5611533359296e-05
Ro9n29n1 h29y o9p 64236.4909372973
* o9 input 30 w=+0.217731604854565 w+  bank=n alpha=1 R=153093.683186685 G_phys=6.53194814563695e-06 G_eff=6.53194814563695e-06
Ro9p30n1 h30yn o9p 153790.335112018
* o9 input 31 w=-0.123913004875871 w-  bank=n alpha=1 R=269005.931756111 G_phys=3.71739014627614e-06 G_eff=3.71739014627614e-06
Ro9n31n1 h31y o9p 269387.51741219
* o9 input 32 w=+0.0869405958454977 w+  bank=n alpha=1 R=383403.552841644 G_phys=2.60821787536493e-06 G_eff=2.60821787536493e-06
Ro9p32n1 h32yn o9p 381837.620946874
* o9 bias w-  bank=f alpha=0.001 R=4242.12569305226 G_phys=0.000235730874650366 G_eff=2.35730874650366e-07
Ro9bnf1 tapref o9p 4260.04637734432
* replica dummy G_tot for o9: same R as weights/biases, dest=0
Ro9dmy000 0 o9rp 96882.2481902144
Ro9dmy001 0 o9rp 283615.701578367
Ro9dmy002 0 o9rp 60173.0556741124
Ro9dmy003 0 o9rp 94075.1540086263
Ro9dmy004 0 o9rp 140400.835361
Ro9dmy005 0 o9rp 5658.39286193697
Ro9dmy006 0 o9rp 189455.502687855
Ro9dmy007 0 o9rp 205216.439240849
Ro9dmy008 0 o9rp 75085.4451576566
Ro9dmy009 0 o9rp 289341.661326768
Ro9dmy010 0 o9rp 641593.948410369
Ro9dmy011 0 o9rp 135048.894617272
Ro9dmy012 0 o9rp 460379.24292415
Ro9dmy013 0 o9rp 7042.50161783431
Ro9dmy014 0 o9rp 114653.634335552
Ro9dmy015 0 o9rp 629228.506903282
Ro9dmy016 0 o9rp 2120.60345623121
Ro9dmy017 0 o9rp 318782.237374713
Ro9dmy018 0 o9rp 90645.7564546398
Ro9dmy019 0 o9rp 330395.902783526
Ro9dmy020 0 o9rp 397362.828177501
Ro9dmy021 0 o9rp 359007.609430492
Ro9dmy022 0 o9rp 218508.813816973
Ro9dmy023 0 o9rp 3107.60486861949
Ro9dmy024 0 o9rp 219684.418106873
Ro9dmy025 0 o9rp 445920.70168739
Ro9dmy026 0 o9rp 70168.5819788084
Ro9dmy027 0 o9rp 46773.1833455233
Ro9dmy028 0 o9rp 63863.5674775578
Ro9dmy029 0 o9rp 153501.663900691
Ro9dmy030 0 o9rp 270230.497708004
Ro9dmy031 0 o9rp 382745.6074692
Ro9dmy032 0 o9rp 4241.17217618382
* feedback TIA o9: Rf=33333.3333333333 A=100000 V(o9sig) = -I(o9p)*Rf*A/(A+1)  (uncompensated)
Eo9tia o9sig 0 0 o9p 100000
Ro9f o9sig o9p 33209.668219502
* feedback TIA o9r: Rf=33333.3333333333 A=100000 V(o9rep) = -I(o9rp)*Rf*A/(A+1)  (uncompensated)
Eo9rtia o9rep 0 0 o9rp 100000
Ro9rf o9rep o9rp 33299.7757904216
* replica null o9: v(o9lin)=v(o9sig)-v(o9rep) Vos_sig=0 Vos_rep=0
Eo9null o9lin 0 o9sig o9rep 1

* o10 input 1 w=-0.0381763956958746 w-  bank=n alpha=1 R=873139.874148344 G_phys=1.14529187087624e-06 G_eff=1.14529187087624e-06
Ro10n1n1 h1y o10p 874738.910325123
* o10 input 2 w=+0.410781186996451 w+  bank=n alpha=1 R=81146.2023785947 G_phys=1.23234356098935e-05 G_eff=1.23234356098935e-05
Ro10p2n1 h2yn o10p 81507.5761449135
* o10 input 3 w=+0.475033421735393 w+  bank=n alpha=1 R=70170.5012913827 G_phys=1.42510026520618e-05 G_eff=1.42510026520618e-05
Ro10p3n1 h3yn o10p 70347.6789004859
* o10 input 4 w=+0.0271427582394968 w+  bank=f alpha=0.001 R=1228.07465030685 G_phys=0.000814282747184905 G_eff=8.14282747184905e-07
Ro10p4f1 htap4n o10p 1227.22007316929
* o10 input 5 w=+0.0212799641995083 w+  bank=f alpha=0.001 R=1566.41867537087 G_phys=0.00063839892598525 G_eff=6.3839892598525e-07
Ro10p5f1 htap5n o10p 1566.77153958939
* o10 input 6 w=+0.0201273268189427 w+  bank=f alpha=0.001 R=1656.12322158758 G_phys=0.00060381980456828 G_eff=6.0381980456828e-07
Ro10p6f1 htap6n o10p 1659.93748128223
* o10 input 7 w=-0.036291550108304 w-  bank=n alpha=1 R=918487.450490747 G_phys=1.08874650324912e-06 G_eff=1.08874650324912e-06
Ro10n7n1 h7y o10p 916720.183687945
* o10 input 8 w=+0.0509688710938526 w+  bank=n alpha=1 R=653993.949992621 G_phys=1.52906613281558e-06 G_eff=1.52906613281558e-06
Ro10p8n1 h8yn o10p 656697.954956766
* o10 input 9 w=-0.135969386219015 w-  bank=n alpha=1 R=245153.223532546 G_phys=4.07908158657046e-06 G_eff=4.07908158657046e-06
Ro10n9n1 h9y o10p 244077.100609113
* o10 input 10 w=+0.542965243347564 w+  bank=n alpha=1 R=61391.2837731971 G_phys=1.62889573004269e-05 G_eff=1.62889573004269e-05
Ro10p10n1 h10yn o10p 61585.7387935119
* o10 input 11 w=+0.200790198383509 w+  bank=n alpha=1 R=166010.759497666 G_phys=6.02370595150528e-06 G_eff=6.02370595150528e-06
Ro10p11n1 h11yn o10p 165245.61151565
* o10 input 12 w=-0.0602452386161185 w-  bank=n alpha=1 R=553294.071017507 G_phys=1.80735715848356e-06 G_eff=1.80735715848356e-06
Ro10n12n1 h12y o10p 550653.039248766
* o10 input 13 w=-0.18784742953156 w-  bank=n alpha=1 R=177448.972373258 G_phys=5.6354228859468e-06 G_eff=5.6354228859468e-06
Ro10n13n1 h13y o10p 176659.950055544
* o10 input 14 w=-0.0121063802780956 w-  bank=f alpha=0.001 R=2753.36909692523 G_phys=0.000363191408342867 G_eff=3.63191408342867e-07
Ro10n14f1 htap14 o10p 2742.18058434743
* o10 input 15 w=+0.162912924713055 w+  bank=n alpha=1 R=204608.280110646 G_phys=4.88738774139165e-06 G_eff=4.88738774139165e-06
Ro10p15n1 h15yn o10p 204175.658022376
* o10 input 16 w=+0.000496602144198326 w+  bank=f alpha=0.001 R=67122.8139522916 G_phys=1.48980643259498e-05 G_eff=1.48980643259498e-08
Ro10p16f1 htap16n o10p 67251.7232233721
* o10 input 17 w=+0.150471984074884 w+  bank=n alpha=1 R=221525.179841748 G_phys=4.51415952224652e-06 G_eff=4.51415952224652e-06
Ro10p17n1 h17yn o10p 221095.486797556
* o10 input 18 w=-0.0993574349593851 w-  bank=n alpha=1 R=335489.068804556 G_phys=2.98072304878155e-06 G_eff=2.98072304878155e-06
Ro10n18n1 h18y o10p 335745.616714245
* o10 input 19 w=-0.0430450321763909 w-  bank=n alpha=1 R=774382.818364248 G_phys=1.29135096529173e-06 G_eff=1.29135096529173e-06
Ro10n19n1 h19y o10p 778217.369328643
* o10 input 20 w=-0.498578232263262 w-  bank=n alpha=1 R=66856.7762816658 G_phys=1.49573469678979e-05 G_eff=1.49573469678979e-05
Ro10n20n1 h20y o10p 66545.1801359719
* o10 input 21 w=-0.135185117923925 w-  bank=n alpha=1 R=246575.465149141 G_phys=4.05555353771776e-06 G_eff=4.05555353771776e-06
Ro10n21n1 h21y o10p 247118.561428387
* o10 input 22 w=+0.00794231626553338 w+  bank=f alpha=0.001 R=4196.92848016985 G_phys=0.000238269487966002 G_eff=2.38269487966002e-07
Ro10p22f1 htap22n o10p 4184.22719882803
* o10 input 23 w=-0.411689837989046 w-  bank=n alpha=1 R=80967.1025550556 G_phys=1.23506951396714e-05 G_eff=1.23506951396714e-05
Ro10n23n1 h23y o10p 80911.0627026275
* o10 input 24 w=+0.321047972853849 w+  bank=n alpha=1 R=103826.643217921 G_phys=9.63143918561547e-06 G_eff=9.63143918561547e-06
Ro10p24n1 h24yn o10p 104157.418609998
* o10 input 25 w=-0.130972309748016 w-  bank=n alpha=1 R=254506.722813891 G_phys=3.92916929244047e-06 G_eff=3.92916929244047e-06
Ro10n25n1 h25y o10p 254434.990396007
* o10 input 26 w=+0.0365278526067883 w+  bank=n alpha=1 R=912545.659120916 G_phys=1.09583557820365e-06 G_eff=1.09583557820365e-06
Ro10p26n1 h26yn o10p 912445.765822983
* o10 input 27 w=-0.205674584301975 w-  bank=n alpha=1 R=162068.315083563 G_phys=6.17023752905924e-06 G_eff=6.17023752905924e-06
Ro10n27n1 h27y o10p 161884.924608597
* o10 input 28 w=-0.0123163999797875 w-  bank=f alpha=0.001 R=2706.41854665624 G_phys=0.000369491999393624 G_eff=3.69491999393624e-07
Ro10n28f1 htap28 o10p 2708.73814384373
* o10 input 29 w=-0.120487475126756 w-  bank=n alpha=1 R=276653.928537102 G_phys=3.61462425380267e-06 G_eff=3.61462425380267e-06
Ro10n29n1 h29y o10p 276569.737358401
* o10 input 30 w=-0.421650115672696 w-  bank=n alpha=1 R=79054.486396034 G_phys=1.26495034701809e-05 G_eff=1.26495034701809e-05
Ro10n30n1 h30y o10p 79377.8018411915
* o10 input 31 w=+0.15176529701113 w+  bank=n alpha=1 R=219637.387398838 G_phys=4.55295891033391e-06 G_eff=4.55295891033391e-06
Ro10p31n1 h31yn o10p 219386.055030093
* o10 input 32 w=+0.00307524765960727 w+  bank=f alpha=0.001 R=10839.2354122107 G_phys=9.22574297882182e-05 G_eff=9.22574297882182e-08
Ro10p32f1 htap32n o10p 10796.1578309904
* o10 bias w-  bank=f alpha=0.001 R=1066.20335663783 G_phys=0.000937907383028131 G_eff=9.37907383028131e-07
Ro10bnf1 tapref o10p 1062.5471706707
* replica dummy G_tot for o10: same R as weights/biases, dest=0
Ro10dmy000 0 o10rp 869199.199490253
Ro10dmy001 0 o10rp 81308.7112740736
Ro10dmy002 0 o10rp 70308.9069873654
Ro10dmy003 0 o10rp 1228.02521137044
Ro10dmy004 0 o10rp 1566.29318676134
Ro10dmy005 0 o10rp 1661.55820178754
Ro10dmy006 0 o10rp 915404.279301428
Ro10dmy007 0 o10rp 651809.147636129
Ro10dmy008 0 o10rp 245304.453604477
Ro10dmy009 0 o10rp 61515.5688360154
Ro10dmy010 0 o10rp 165757.723379566
Ro10dmy011 0 o10rp 553440.093063657
Ro10dmy012 0 o10rp 176959.288593294
Ro10dmy013 0 o10rp 2756.63090536708
Ro10dmy014 0 o10rp 204892.723851907
Ro10dmy015 0 o10rp 66904.9997963664
Ro10dmy016 0 o10rp 222518.145176593
Ro10dmy017 0 o10rp 335236.85141445
Ro10dmy018 0 o10rp 772535.036796456
Ro10dmy019 0 o10rp 66888.626482049
Ro10dmy020 0 o10rp 247744.655425489
Ro10dmy021 0 o10rp 4192.40140715829
Ro10dmy022 0 o10rp 81198.3469581159
Ro10dmy023 0 o10rp 104173.899256117
Ro10dmy024 0 o10rp 253746.120383252
Ro10dmy025 0 o10rp 914154.070586413
Ro10dmy026 0 o10rp 161343.413608496
Ro10dmy027 0 o10rp 2715.77434393777
Ro10dmy028 0 o10rp 278018.95612957
Ro10dmy029 0 o10rp 78712.3415091475
Ro10dmy030 0 o10rp 218836.886041533
Ro10dmy031 0 o10rp 10808.9657276026
Ro10dmy032 0 o10rp 1070.52439769386
* feedback TIA o10: Rf=33333.3333333333 A=100000 V(o10sig) = -I(o10p)*Rf*A/(A+1)  (uncompensated)
Eo10tia o10sig 0 0 o10p 100000
Ro10f o10sig o10p 33272.6897366183
* feedback TIA o10r: Rf=33333.3333333333 A=100000 V(o10rep) = -I(o10rp)*Rf*A/(A+1)  (uncompensated)
Eo10rtia o10rep 0 0 o10rp 100000
Ro10rf o10rep o10rp 33172.7017388802
* replica null o10: v(o10lin)=v(o10sig)-v(o10rep) Vos_sig=0 Vos_rep=0
Eo10null o10lin 0 o10sig o10rep 1

* o11 input 1 w=-0.160102279955593 w-  bank=n alpha=1 R=208200.241386812 G_phys=4.80306839866778e-06 G_eff=4.80306839866778e-06
Ro11n1n1 h1y o11p 208420.306503411
* o11 input 2 w=+0.011469223690656 w+  bank=f alpha=0.001 R=2906.32864371544 G_phys=0.00034407671071968 G_eff=3.4407671071968e-07
Ro11p2f1 htap2n o11p 2899.39715717628
* o11 input 3 w=+0.0176041755498141 w+  bank=f alpha=0.001 R=1893.49016879608 G_phys=0.000528125266494424 G_eff=5.28125266494424e-07
Ro11p3f1 htap3n o11p 1887.62389068275
* o11 input 4 w=-0.0193710750418404 w-  bank=f alpha=0.001 R=1720.77870027013 G_phys=0.000581132251255212 G_eff=5.81132251255212e-07
Ro11n4f1 htap4 o11p 1717.91700609776
* o11 input 5 w=+0.112602634979867 w+  bank=n alpha=1 R=296026.228331984 G_phys=3.37807904939602e-06 G_eff=3.37807904939602e-06
Ro11p5n1 h5yn o11p 294882.589521144
* o11 input 6 w=+0.00163262396170036 w+  bank=f alpha=0.001 R=20417.0305687643 G_phys=4.89787188510109e-05 G_eff=4.89787188510109e-08
Ro11p6f1 htap6n o11p 20471.6709751718
* o11 input 7 w=-0.0344149127536822 w-  bank=n alpha=1 R=968572.361984759 G_phys=1.03244738261047e-06 G_eff=1.03244738261047e-06
Ro11n7n1 h7y o11p 970887.665898448
* o11 input 8 w=+0.0140339587694358 w+  bank=f alpha=0.001 R=2375.19105485255 G_phys=0.000421018763083073 G_eff=4.21018763083073e-07
Ro11p8f1 htap8n o11p 2367.9081814555
* o11 input 9 w=+0.200472625000294 w+  bank=n alpha=1 R=166273.741032146 G_phys=6.01417875000882e-06 G_eff=6.01417875000882e-06
Ro11p9n1 h9yn o11p 165541.750862965
* o11 input 10 w=+0.127220756971711 w+  bank=n alpha=1 R=262011.751280064 G_phys=3.81662270915132e-06 G_eff=3.81662270915132e-06
Ro11p10n1 h10yn o11p 262894.283359861
* o11 input 11 w=-0.215899699488286 w-  bank=n alpha=1 R=154392.680547209 G_phys=6.47699098464857e-06 G_eff=6.47699098464857e-06
Ro11n11n1 h11y o11p 153988.682331183
* o11 input 12 w=-0.0276713436872213 w-  bank=f alpha=0.001 R=1204.61563811687 G_phys=0.000830140310616638 G_eff=8.30140310616639e-07
Ro11n12f1 htap12 o11p 1199.12756868207
* o11 input 13 w=+0.188664634231365 w+  bank=n alpha=1 R=176680.34854087 G_phys=5.65993902694096e-06 G_eff=5.65993902694096e-06
Ro11p13n1 h13yn o11p 176288.416965092
* o11 input 14 w=-0.119078372545684 w-  bank=n alpha=1 R=279927.686453265 G_phys=3.57235117637052e-06 G_eff=3.57235117637052e-06
Ro11n14n1 h14y o11p 280172.669143511
* o11 input 15 w=+0.15422975355602 w+  bank=n alpha=1 R=216127.774082359 G_phys=4.6268926066806e-06 G_eff=4.6268926066806e-06
Ro11p15n1 h15yn o11p 215844.763620705
* o11 input 16 w=-0.104607206722078 w-  bank=n alpha=1 R=318652.360366468 G_phys=3.13821620166235e-06 G_eff=3.13821620166235e-06
Ro11n16n1 h16y o11p 318916.883944616
* o11 input 17 w=+0.106639727219858 w+  bank=n alpha=1 R=312578.944098482 G_phys=3.19919181659573e-06 G_eff=3.19919181659573e-06
Ro11p17n1 h17yn o11p 312127.32887188
* o11 input 18 w=+0.310905721051453 w+  bank=n alpha=1 R=107213.637692492 G_phys=9.32717163154358e-06 G_eff=9.32717163154358e-06
Ro11p18n1 h18yn o11p 107709.534141098
* o11 input 19 w=+0.210141672521531 w+  bank=n alpha=1 R=158623.146629415 G_phys=6.30425017564592e-06 G_eff=6.30425017564592e-06
Ro11p19n1 h19yn o11p 159374.272075185
* o11 input 20 w=+0.009349861892821 w+  bank=f alpha=0.001 R=3565.11504826903 G_phys=0.00028049585678463 G_eff=2.8049585678463e-07
Ro11p20f1 htap20n o11p 3548.13502350374
* o11 input 21 w=-0.148461029214851 w-  bank=n alpha=1 R=224525.81333714 G_phys=4.45383087644554e-06 G_eff=4.45383087644554e-06
Ro11n21n1 h21y o11p 224004.102477299
* o11 input 22 w=-0.118671866129314 w-  bank=n alpha=1 R=280886.56916384 G_phys=3.56015598387941e-06 G_eff=3.56015598387941e-06
Ro11n22n1 h22y o11p 280716.053745807
* o11 input 23 w=-0.109207143921327 w-  bank=n alpha=1 R=305230.336921427 G_phys=3.2762143176398e-06 G_eff=3.2762143176398e-06
Ro11n23n1 h23y o11p 304261.236155301
* o11 input 24 w=-0.0902417819363344 w-  bank=n alpha=1 R=369378.048816124 G_phys=2.70725345809003e-06 G_eff=2.70725345809003e-06
Ro11n24n1 h24y o11p 369868.741397532
* o11 input 25 w=+0.314745464583241 w+  bank=n alpha=1 R=105905.68279505 G_phys=9.44236393749723e-06 G_eff=9.44236393749723e-06
Ro11p25n1 h25yn o11p 105647.203634208
* o11 input 26 w=+0.0956381358816812 w+  bank=n alpha=1 R=348536.000059346 G_phys=2.86914407645044e-06 G_eff=2.86914407645044e-06
Ro11p26n1 h26yn o11p 348669.727530845
* o11 input 27 w=-0.150311342322866 w-  bank=n alpha=1 R=221761.929726726 G_phys=4.50934026968598e-06 G_eff=4.50934026968598e-06
Ro11n27n1 h27y o11p 222790.672239324
* o11 input 28 w=-0.0832874521070705 w-  bank=n alpha=1 R=400220.351205864 G_phys=2.49862356321211e-06 G_eff=2.49862356321211e-06
Ro11n28n1 h28y o11p 401180.226523975
* o11 input 29 w=+0.0404370827831914 w+  bank=n alpha=1 R=824325.86722574 G_phys=1.21311248349574e-06 G_eff=1.21311248349574e-06
Ro11p29n1 h29yn o11p 825059.376599168
* o11 input 30 w=-0.0722629324126473 w-  bank=n alpha=1 R=461278.448305807 G_phys=2.16788797237942e-06 G_eff=2.16788797237942e-06
Ro11n30n1 h30y o11p 462961.84656442
* o11 input 31 w=-0.0830409064130833 w-  bank=n alpha=1 R=401408.592140338 G_phys=2.4912271923925e-06 G_eff=2.4912271923925e-06
Ro11n31n1 h31y o11p 402303.073473246
* o11 input 32 w=-0.390143512242536 w-  bank=n alpha=1 R=85438.6457479045 G_phys=1.17043053672761e-05 G_eff=1.17043053672761e-05
Ro11n32n1 h32y o11p 85735.0856949883
* o11 bias w-  bank=f alpha=0.001 R=23104.9891990359 G_phys=4.32806954110901e-05 G_eff=4.32806954110902e-08
Ro11bnf1 tapref o11p 23053.8377528242
* replica dummy G_tot for o11: same R as weights/biases, dest=0
Ro11dmy000 0 o11rp 208745.085497421
Ro11dmy001 0 o11rp 2897.81597846388
Ro11dmy002 0 o11rp 1889.00276421393
Ro11dmy003 0 o11rp 1718.39921104719
Ro11dmy004 0 o11rp 296795.916362562
Ro11dmy005 0 o11rp 20426.1826934999
Ro11dmy006 0 o11rp 970799.658071974
Ro11dmy007 0 o11rp 2377.42156797529
Ro11dmy008 0 o11rp 165529.356173369
Ro11dmy009 0 o11rp 262995.692342959
Ro11dmy010 0 o11rp 154168.705559089
Ro11dmy011 0 o11rp 1201.93557850129
Ro11dmy012 0 o11rp 176183.099400359
Ro11dmy013 0 o11rp 280276.972705597
Ro11dmy014 0 o11rp 216596.179437877
Ro11dmy015 0 o11rp 317713.846841168
Ro11dmy016 0 o11rp 313721.838342052
Ro11dmy017 0 o11rp 106979.90594707
Ro11dmy018 0 o11rp 159362.170370195
Ro11dmy019 0 o11rp 3577.10544706347
Ro11dmy020 0 o11rp 223433.913406907
Ro11dmy021 0 o11rp 280385.943757789
Ro11dmy022 0 o11rp 306315.384881972
Ro11dmy023 0 o11rp 370616.094572693
Ro11dmy024 0 o11rp 105601.469156929
Ro11dmy025 0 o11rp 349370.739049947
Ro11dmy026 0 o11rp 222024.46248266
Ro11dmy027 0 o11rp 402153.355091773
Ro11dmy028 0 o11rp 820956.476776244
Ro11dmy029 0 o11rp 463267.251499937
Ro11dmy030 0 o11rp 399939.033584585
Ro11dmy031 0 o11rp 85014.7786303199
Ro11dmy032 0 o11rp 23092.2745042421
* feedback TIA o11: Rf=33333.3333333333 A=100000 V(o11sig) = -I(o11p)*Rf*A/(A+1)  (uncompensated)
Eo11tia o11sig 0 0 o11p 100000
Ro11f o11sig o11p 33441.7454301718
* feedback TIA o11r: Rf=33333.3333333333 A=100000 V(o11rep) = -I(o11rp)*Rf*A/(A+1)  (uncompensated)
Eo11rtia o11rep 0 0 o11rp 100000
Ro11rf o11rep o11rp 33172.7127149492
* replica null o11: v(o11lin)=v(o11sig)-v(o11rep) Vos_sig=0 Vos_rep=0
Eo11null o11lin 0 o11sig o11rep 1

* o12 input 1 w=-0.0568819810826339 w-  bank=n alpha=1 R=586008.656852319 G_phys=1.70645943247902e-06 G_eff=1.70645943247902e-06
Ro12n1n1 h1y o12p 583728.639542203
* o12 input 2 w=-0.116449760348513 w-  bank=n alpha=1 R=286246.47430422 G_phys=3.4934928104554e-06 G_eff=3.4934928104554e-06
Ro12n2n1 h2y o12p 286514.89679028
* o12 input 3 w=-0.394245634375715 w-  bank=n alpha=1 R=84549.6574391152 G_phys=1.18273690312714e-05 G_eff=1.18273690312714e-05
Ro12n3n1 h3y o12p 84764.6296382868
* o12 input 4 w=-0.0304757769901363 w-  bank=f alpha=0.001 R=1093.76483966666 G_phys=0.000914273309704088 G_eff=9.14273309704088e-07
Ro12n4f1 htap4 o12p 1091.92345978271
* o12 input 5 w=-0.225077356892672 w-  bank=n alpha=1 R=148097.231074329 G_phys=6.75232070678017e-06 G_eff=6.75232070678017e-06
Ro12n5n1 h5y o12p 147637.551994312
* o12 input 6 w=-0.48876360312342 w-  bank=n alpha=1 R=68199.2953655269 G_phys=1.46629080937026e-05 G_eff=1.46629080937026e-05
Ro12n6n1 h6y o12p 67919.7100681071
* o12 input 7 w=+0.269859073889073 w+  bank=n alpha=1 R=123521.261868093 G_phys=8.09577221667219e-06 G_eff=8.09577221667219e-06
Ro12p7n1 h7yn o12p 123776.031558996
* o12 input 8 w=-0.0167144075003679 w-  bank=f alpha=0.001 R=1994.28746323192 G_phys=0.000501432225011038 G_eff=5.01432225011038e-07
Ro12n8f1 htap8 o12p 1997.1979431644
* o12 input 9 w=-0.271168635938693 w-  bank=n alpha=1 R=122924.737287352 G_phys=8.13505907816079e-06 G_eff=8.13505907816079e-06
Ro12n9n1 h9y o12p 122846.949709413
* o12 input 10 w=-0.229866523415109 w-  bank=n alpha=1 R=145011.691298509 G_phys=6.89599570245327e-06 G_eff=6.89599570245327e-06
Ro12n10n1 h10y o12p 145091.836068554
* o12 input 11 w=+0.111794037161303 w+  bank=n alpha=1 R=298167.363660355 G_phys=3.35382111483908e-06 G_eff=3.35382111483908e-06
Ro12p11n1 h11yn o12p 299003.34370926
* o12 input 12 w=-0.187970289472281 w-  bank=n alpha=1 R=177332.989308658 G_phys=5.63910868416843e-06 G_eff=5.63910868416843e-06
Ro12n12n1 h12y o12p 177119.461846266
* o12 input 13 w=+0.219867348390274 w+  bank=n alpha=1 R=151606.564491628 G_phys=6.59602045170821e-06 G_eff=6.59602045170821e-06
Ro12p13n1 h13yn o12p 152182.47053437
* o12 input 14 w=-0.127058880326711 w-  bank=n alpha=1 R=262345.561739739 G_phys=3.81176640980134e-06 G_eff=3.81176640980134e-06
Ro12n14n1 h14y o12p 261617.1658871
* o12 input 15 w=+0.40629100094033 w+  bank=n alpha=1 R=82043.0018291959 G_phys=1.21887300282099e-05 G_eff=1.21887300282099e-05
Ro12p15n1 h15yn o12p 82351.1920683935
* o12 input 16 w=-0.479164967789437 w-  bank=n alpha=1 R=69565.4640344684 G_phys=1.43749490336831e-05 G_eff=1.43749490336831e-05
Ro12n16n1 h16y o12p 69554.5032793559
* o12 input 17 w=-0.142691971348636 w-  bank=n alpha=1 R=233603.425744892 G_phys=4.28075914045907e-06 G_eff=4.28075914045907e-06
Ro12n17n1 h17y o12p 232551.106280646
* o12 input 18 w=+0.0750962927559542 w+  bank=n alpha=1 R=443874.552391808 G_phys=2.25288878267863e-06 G_eff=2.25288878267863e-06
Ro12p18n1 h18yn o12p 444971.861790578
* o12 input 19 w=-0.0357891000093011 w-  bank=n alpha=1 R=931382.273504235 G_phys=1.07367300027903e-06 G_eff=1.07367300027903e-06
Ro12n19n1 h19y o12p 934759.991921954
* o12 input 20 w=-0.274882313904053 w-  bank=n alpha=1 R=121264.016079871 G_phys=8.24646941712159e-06 G_eff=8.24646941712159e-06
Ro12n20n1 h20y o12p 121021.52378264
* o12 input 21 w=+0.0723735016816067 w+  bank=n alpha=1 R=460573.726002328 G_phys=2.1712050504482e-06 G_eff=2.1712050504482e-06
Ro12p21n1 h21yn o12p 460708.430127468
* o12 input 22 w=-0.42830678611073 w-  bank=n alpha=1 R=77825.8351589968 G_phys=1.28492035833219e-05 G_eff=1.28492035833219e-05
Ro12n22n1 h22y o12p 77689.2745618872
* o12 input 23 w=-0.495732058756383 w-  bank=n alpha=1 R=67240.6247377966 G_phys=1.48719617626915e-05 G_eff=1.48719617626915e-05
Ro12n23n1 h23y o12p 67241.2703641062
* o12 input 24 w=-0.0511653226482421 w-  bank=n alpha=1 R=651482.910847599 G_phys=1.53495967944726e-06 G_eff=1.53495967944726e-06
Ro12n24n1 h24y o12p 653434.428796672
* o12 input 25 w=+0.0558940521557335 w+  bank=n alpha=1 R=596366.376165735 G_phys=1.676821564672e-06 G_eff=1.676821564672e-06
Ro12p25n1 h25yn o12p 596468.586069229
* o12 input 26 w=+0.307817092263132 w+  bank=n alpha=1 R=108289.416576123 G_phys=9.23451276789396e-06 G_eff=9.23451276789396e-06
Ro12p26n1 h26yn o12p 108414.969794471
* o12 input 27 w=-0.124284155438311 w-  bank=n alpha=1 R=268202.597634244 G_phys=3.72852466314934e-06 G_eff=3.72852466314934e-06
Ro12n27n1 h27y o12p 267193.959236546
* o12 input 28 w=+0.511620988407946 w+  bank=n alpha=1 R=65152.3961850343 G_phys=1.53486296522384e-05 G_eff=1.53486296522384e-05
Ro12p28n1 h28yn o12p 65478.1457354219
* o12 input 29 w=-0.110998740438628 w-  bank=n alpha=1 R=300303.70796652 G_phys=3.32996221315884e-06 G_eff=3.32996221315884e-06
Ro12n29n1 h29y o12p 301478.88419653
* o12 input 30 w=+0.0696620617055659 w+  bank=n alpha=1 R=478500.528368227 G_phys=2.08986185116698e-06 G_eff=2.08986185116698e-06
Ro12p30n1 h30yn o12p 479253.758878351
* o12 input 31 w=+0.219973071991933 w+  bank=n alpha=1 R=151533.699245496 G_phys=6.59919215975798e-06 G_eff=6.59919215975798e-06
Ro12p31n1 h31yn o12p 152003.82829386
* o12 input 32 w=+0.138023444689957 w+  bank=n alpha=1 R=241504.864685924 G_phys=4.14070334069872e-06 G_eff=4.14070334069872e-06
Ro12p32n1 h32yn o12p 242004.603510671
* o12 bias w+  bank=f alpha=0.001 R=5330.66503610944 G_phys=0.000187593854280111 G_eff=1.87593854280111e-07
Ro12bpf1 taprefn o12p 5323.84804187196
* replica dummy G_tot for o12: same R as weights/biases, dest=0
Ro12dmy000 0 o12rp 586734.114997473
Ro12dmy001 0 o12rp 286833.515356408
Ro12dmy002 0 o12rp 84507.3401283772
Ro12dmy003 0 o12rp 1094.63677609931
Ro12dmy004 0 o12rp 148815.637649458
Ro12dmy005 0 o12rp 68473.7085060682
Ro12dmy006 0 o12rp 123642.815280566
Ro12dmy007 0 o12rp 2000.86461165554
Ro12dmy008 0 o12rp 122765.317986456
Ro12dmy009 0 o12rp 145215.498505303
Ro12dmy010 0 o12rp 298406.557458614
Ro12dmy011 0 o12rp 176527.984021823
Ro12dmy012 0 o12rp 152005.419835002
Ro12dmy013 0 o12rp 263208.055158002
Ro12dmy014 0 o12rp 82246.1997090285
Ro12dmy015 0 o12rp 69564.6401892842
Ro12dmy016 0 o12rp 232622.675076342
Ro12dmy017 0 o12rp 443358.251126013
Ro12dmy018 0 o12rp 931207.057465559
Ro12dmy019 0 o12rp 121055.339792146
Ro12dmy020 0 o12rp 460334.117641881
Ro12dmy021 0 o12rp 77603.4656554623
Ro12dmy022 0 o12rp 67169.8972579915
Ro12dmy023 0 o12rp 654358.634102718
Ro12dmy024 0 o12rp 594744.145301536
Ro12dmy025 0 o12rp 108095.062674878
Ro12dmy026 0 o12rp 268685.437268614
Ro12dmy027 0 o12rp 65083.7573017996
Ro12dmy028 0 o12rp 301027.247744319
Ro12dmy029 0 o12rp 480196.341803625
Ro12dmy030 0 o12rp 151035.468575376
Ro12dmy031 0 o12rp 240936.916653819
Ro12dmy032 0 o12rp 5343.6395522343
* feedback TIA o12: Rf=33333.3333333333 A=100000 V(o12sig) = -I(o12p)*Rf*A/(A+1)  (uncompensated)
Eo12tia o12sig 0 0 o12p 100000
Ro12f o12sig o12p 33476.7244287596
* feedback TIA o12r: Rf=33333.3333333333 A=100000 V(o12rep) = -I(o12rp)*Rf*A/(A+1)  (uncompensated)
Eo12rtia o12rep 0 0 o12rp 100000
Ro12rf o12rep o12rp 33346.2138976226
* replica null o12: v(o12lin)=v(o12sig)-v(o12rep) Vos_sig=0 Vos_rep=0
Eo12null o12lin 0 o12sig o12rep 1

* o13 input 1 w=+0.00200007413415942 w+  bank=f alpha=0.001 R=16666.0489049035 G_phys=6.00022240247825e-05 G_eff=6.00022240247825e-08
Ro13p1f1 htap1n o13p 16746.3713925365
* o13 input 2 w=-0.0237460165980216 w-  bank=f alpha=0.001 R=1403.74421098108 G_phys=0.000712380497940648 G_eff=7.12380497940648e-07
Ro13n2f1 htap2 o13p 1406.28902059018
* o13 input 3 w=-0.481641955158027 w-  bank=n alpha=1 R=69207.7028929023 G_phys=1.44492586547408e-05 G_eff=1.44492586547408e-05
Ro13n3n1 h3y o13p 69498.4507774434
* o13 input 4 w=-0.401500412219866 w-  bank=n alpha=1 R=83021.9155916573 G_phys=1.2045012366596e-05 G_eff=1.2045012366596e-05
Ro13n4n1 h4y o13p 82916.5322422893
* o13 input 5 w=-0.324731283585407 w-  bank=n alpha=1 R=102648.974762441 G_phys=9.7419385075622e-06 G_eff=9.7419385075622e-06
Ro13n5n1 h5y o13p 102257.642156295
* o13 input 6 w=+0.0791891194793975 w+  bank=n alpha=1 R=420933.248815901 G_phys=2.37567358438193e-06 G_eff=2.37567358438193e-06
Ro13p6n1 h6yn o13p 418990.897963832
* o13 input 7 w=+0.286949833874567 w+  bank=n alpha=1 R=116164.323509956 G_phys=8.60849501623701e-06 G_eff=8.60849501623701e-06
Ro13p7n1 h7yn o13p 115864.550654053
* o13 input 8 w=-0.153846131933853 w-  bank=n alpha=1 R=216666.697526495 G_phys=4.61538395801558e-06 G_eff=4.61538395801558e-06
Ro13n8n1 h8y o13p 217235.676075446
* o13 input 9 w=-0.0455077430770376 w-  bank=n alpha=1 R=732476.081639671 G_phys=1.36523229231113e-06 G_eff=1.36523229231113e-06
Ro13n9n1 h9y o13p 730142.273354301
* o13 input 10 w=+0.122909253832841 w+  bank=n alpha=1 R=271202.796322133 G_phys=3.68727761498523e-06 G_eff=3.68727761498523e-06
Ro13p10n1 h10yn o13p 271969.653199216
* o13 input 11 w=+0.0797228425783465 w+  bank=n alpha=1 R=418115.213347736 G_phys=2.3916852773504e-06 G_eff=2.3916852773504e-06
Ro13p11n1 h11yn o13p 418391.191904112
* o13 input 12 w=-0.0916703213430956 w-  bank=n alpha=1 R=363621.866324394 G_phys=2.75010964029287e-06 G_eff=2.75010964029287e-06
Ro13n12n1 h12y o13p 365291.616502199
* o13 input 13 w=-0.00253109868008519 w-  bank=f alpha=0.001 R=13169.5115625486 G_phys=7.59329604025557e-05 G_eff=7.59329604025556e-08
Ro13n13f1 htap13 o13p 13162.0078277159
* o13 input 14 w=+0.523873822520012 w+  bank=n alpha=1 R=63628.5530988905 G_phys=1.57162146756004e-05 G_eff=1.57162146756004e-05
Ro13p14n1 h14yn o13p 63360.6906592815
* o13 input 15 w=+0.0718975606852002 w+  bank=n alpha=1 R=463622.590469816 G_phys=2.15692682055601e-06 G_eff=2.15692682055601e-06
Ro13p15n1 h15yn o13p 462187.501709552
* o13 input 16 w=+0.212010526629755 w+  bank=n alpha=1 R=157224.897570982 G_phys=6.36031579889266e-06 G_eff=6.36031579889266e-06
Ro13p16n1 h16yn o13p 156770.286931909
* o13 input 17 w=+0.50252589011925 w+  bank=n alpha=1 R=66331.5741312817 G_phys=1.50757767035775e-05 G_eff=1.50757767035775e-05
Ro13p17n1 h17yn o13p 66247.0603848327
* o13 input 18 w=-0.0631368164337741 w-  bank=n alpha=1 R=527953.97703173 G_phys=1.89410449301322e-06 G_eff=1.89410449301322e-06
Ro13n18n1 h18y o13p 530355.010228655
* o13 input 19 w=+0.124615759492256 w+  bank=n alpha=1 R=267488.907254983 G_phys=3.73847278476769e-06 G_eff=3.73847278476769e-06
Ro13p19n1 h19yn o13p 268080.450485355
* o13 input 20 w=-0.0825374863137293 w-  bank=n alpha=1 R=403856.899719863 G_phys=2.47612458941188e-06 G_eff=2.47612458941188e-06
Ro13n20n1 h20y o13p 405791.671763294
* o13 input 21 w=-0.0332297714786912 w-  bank=f alpha=0.001 R=1003.11653827377 G_phys=0.000996893144360737 G_eff=9.96893144360737e-07
Ro13n21f1 htap21 o13p 1000.41896214559
* o13 input 22 w=+0.217350752944783 w+  bank=n alpha=1 R=153361.940925972 G_phys=6.5205225883435e-06 G_eff=6.5205225883435e-06
Ro13p22n1 h22yn o13p 153947.668767864
* o13 input 23 w=+0.00620341639632115 w+  bank=f alpha=0.001 R=5373.38318174179 G_phys=0.000186102491889634 G_eff=1.86102491889634e-07
Ro13p23f1 htap23n o13p 5376.67491550772
* o13 input 24 w=-0.56329887647671 w-  bank=n alpha=1 R=59175.2171455139 G_phys=1.68989662943013e-05 G_eff=1.68989662943013e-05
Ro13n24n1 h24y o13p 59013.7617683919
* o13 input 25 w=+0.121217122487375 w+  bank=n alpha=1 R=274988.653824918 G_phys=3.63651367462124e-06 G_eff=3.63651367462124e-06
Ro13p25n1 h25yn o13p 275643.572502178
* o13 input 26 w=-0.0619389520134905 w-  bank=n alpha=1 R=538164.309368251 G_phys=1.85816856040471e-06 G_eff=1.85816856040471e-06
Ro13n26n1 h26y o13p 538499.815544034
* o13 input 27 w=-0.148385692307615 w-  bank=n alpha=1 R=224639.807349019 G_phys=4.45157076922844e-06 G_eff=4.45157076922844e-06
Ro13n27n1 h27y o13p 223727.946537832
* o13 input 28 w=+0.0960859107643036 w+  bank=n alpha=1 R=346911.769563169 G_phys=2.88257732292911e-06 G_eff=2.88257732292911e-06
Ro13p28n1 h28yn o13p 345529.319499124
* o13 input 29 w=-0.0967464729103534 w-  bank=n alpha=1 R=344543.137652372 G_phys=2.9023941873106e-06 G_eff=2.9023941873106e-06
Ro13n29n1 h29y o13p 345733.688218656
* o13 input 30 w=+0.0502110731232858 w+  bank=n alpha=1 R=663864.188910847 G_phys=1.50633219369857e-06 G_eff=1.50633219369857e-06
Ro13p30n1 h30yn o13p 664198.249579819
* o13 input 31 w=+0.0717291842082243 w+  bank=n alpha=1 R=464710.894195719 G_phys=2.15187552624673e-06 G_eff=2.15187552624673e-06
Ro13p31n1 h31yn o13p 466739.550392049
* o13 input 32 w=+0.117218732023777 w+  bank=n alpha=1 R=284368.656424059 G_phys=3.51656196071332e-06 G_eff=3.51656196071332e-06
Ro13p32n1 h32yn o13p 285433.80469382
* o13 bias w+  bank=f alpha=0.001 R=7028.1846436546 G_phys=0.000142284252719918 G_eff=1.42284252719918e-07
Ro13bpf1 taprefn o13p 7018.05730074605
* replica dummy G_tot for o13: same R as weights/biases, dest=0
Ro13dmy000 0 o13rp 16720.5452322716
Ro13dmy001 0 o13rp 1406.78400651728
Ro13dmy002 0 o13rp 69025.7062685632
Ro13dmy003 0 o13rp 82892.3560961578
Ro13dmy004 0 o13rp 102650.641957122
Ro13dmy005 0 o13rp 421866.101417439
Ro13dmy006 0 o13rp 115762.686227784
Ro13dmy007 0 o13rp 216192.081048343
Ro13dmy008 0 o13rp 734662.751114661
Ro13dmy009 0 o13rp 271883.180301076
Ro13dmy010 0 o13rp 416820.340807144
Ro13dmy011 0 o13rp 363819.175924083
Ro13dmy012 0 o13rp 13109.525447849
Ro13dmy013 0 o13rp 63748.2584276405
Ro13dmy014 0 o13rp 465355.217414096
Ro13dmy015 0 o13rp 156668.168533736
Ro13dmy016 0 o13rp 66340.9262357572
Ro13dmy017 0 o13rp 526820.028903758
Ro13dmy018 0 o13rp 268755.694013687
Ro13dmy019 0 o13rp 404392.251513029
Ro13dmy020 0 o13rp 1006.65804704202
Ro13dmy021 0 o13rp 152772.22166056
Ro13dmy022 0 o13rp 5398.37841971725
Ro13dmy023 0 o13rp 59255.5390673543
Ro13dmy024 0 o13rp 273919.796442128
Ro13dmy025 0 o13rp 538828.82791787
Ro13dmy026 0 o13rp 224969.745887619
Ro13dmy027 0 o13rp 347216.23006883
Ro13dmy028 0 o13rp 344970.91310603
Ro13dmy029 0 o13rp 664979.464134439
Ro13dmy030 0 o13rp 465700.013464888
Ro13dmy031 0 o13rp 284950.079957282
Ro13dmy032 0 o13rp 7037.18333769175
* feedback TIA o13: Rf=33333.3333333333 A=100000 V(o13sig) = -I(o13p)*Rf*A/(A+1)  (uncompensated)
Eo13tia o13sig 0 0 o13p 100000
Ro13f o13sig o13p 33441.8284578707
* feedback TIA o13r: Rf=33333.3333333333 A=100000 V(o13rep) = -I(o13rp)*Rf*A/(A+1)  (uncompensated)
Eo13rtia o13rep 0 0 o13rp 100000
Ro13rf o13rep o13rp 33437.0707234699
* replica null o13: v(o13lin)=v(o13sig)-v(o13rep) Vos_sig=0 Vos_rep=0
Eo13null o13lin 0 o13sig o13rep 1

* o14 input 1 w=-0.25477230027339 w-  bank=n alpha=1 R=130835.782765882 G_phys=7.64316900820172e-06 G_eff=7.64316900820172e-06
Ro14n1n1 h1y o14p 130413.868914207
* o14 input 2 w=+0.102637632071701 w+  bank=n alpha=1 R=324767.170291372 G_phys=3.07912896215104e-06 G_eff=3.07912896215104e-06
Ro14p2n1 h2yn o14p 325400.63472755
* o14 input 3 w=+0.107208211835011 w+  bank=n alpha=1 R=310921.456134648 G_phys=3.21624635505032e-06 G_eff=3.21624635505032e-06
Ro14p3n1 h3yn o14p 311428.113336744
* o14 input 4 w=-0.361346054145307 w-  bank=n alpha=1 R=92247.6749114552 G_phys=1.08403816243592e-05 G_eff=1.08403816243592e-05
Ro14n4n1 h4y o14p 92062.1455871999
* o14 input 5 w=+0.0565127294479513 w+  bank=n alpha=1 R=589837.611082537 G_phys=1.69538188343854e-06 G_eff=1.69538188343854e-06
Ro14p5n1 h5yn o14p 587026.580464359
* o14 input 6 w=-0.166023137794918 w-  bank=n alpha=1 R=200775.22793545 G_phys=4.98069413384754e-06 G_eff=4.98069413384754e-06
Ro14n6n1 h6y o14p 201142.156204584
* o14 input 7 w=+0.0533068959488943 w+  bank=n alpha=1 R=625309.96674971 G_phys=1.59920687846683e-06 G_eff=1.59920687846683e-06
Ro14p7n1 h7yn o14p 625977.966416306
* o14 input 8 w=-0.334728977765226 w-  bank=n alpha=1 R=99583.0524022118 G_phys=1.00418693329568e-05 G_eff=1.00418693329568e-05
Ro14n8n1 h8y o14p 99917.1134784525
* o14 input 9 w=-0.184424571200296 w-  bank=n alpha=1 R=180742.365924394 G_phys=5.53273713600887e-06 G_eff=5.53273713600887e-06
Ro14n9n1 h9y o14p 180170.362784396
* o14 input 10 w=+0.263838736865495 w+  bank=n alpha=1 R=126339.800324039 G_phys=7.91516210596486e-06 G_eff=7.91516210596486e-06
Ro14p10n1 h10yn o14p 126632.637829893
* o14 input 11 w=+0.0215454170832462 w+  bank=f alpha=0.001 R=1547.11942704759 G_phys=0.000646362512497387 G_eff=6.46362512497387e-07
Ro14p11f1 htap11n o14p 1553.25259851838
* o14 input 12 w=-0.0509620245346412 w-  bank=n alpha=1 R=654081.811657133 G_phys=1.52886073603923e-06 G_eff=1.52886073603923e-06
Ro14n12n1 h12y o14p 653302.055885279
* o14 input 13 w=-0.289718223355261 w-  bank=n alpha=1 R=115054.320530121 G_phys=8.69154670065782e-06 G_eff=8.69154670065782e-06
Ro14n13n1 h13y o14p 115435.154960658
* o14 input 14 w=+0.114352462647064 w+  bank=n alpha=1 R=291496.41871914 G_phys=3.43057387941191e-06 G_eff=3.43057387941191e-06
Ro14p14n1 h14yn o14p 292223.734003308
* o14 input 15 w=-0.172686817087866 w-  bank=n alpha=1 R=193027.666474232 G_phys=5.18060451263599e-06 G_eff=5.18060451263599e-06
Ro14n15n1 h15y o14p 193826.859405346
* o14 input 16 w=-0.0880371911025684 w-  bank=n alpha=1 R=378627.860746921 G_phys=2.64111573307705e-06 G_eff=2.64111573307705e-06
Ro14n16n1 h16y o14p 377981.35440335
* o14 input 17 w=-0.0970577820037651 w-  bank=n alpha=1 R=343438.028823286 G_phys=2.91173346011295e-06 G_eff=2.91173346011295e-06
Ro14n17n1 h17y o14p 341842.221251128
* o14 input 18 w=+0.279065168461303 w+  bank=n alpha=1 R=119446.412883145 G_phys=8.3719550538391e-06 G_eff=8.3719550538391e-06
Ro14p18n1 h18yn o14p 119033.450642281
* o14 input 19 w=+0.12574844379754 w+  bank=n alpha=1 R=265079.489866303 G_phys=3.7724533139262e-06 G_eff=3.7724533139262e-06
Ro14p19n1 h19yn o14p 264971.262049131
* o14 input 20 w=+0.196093228285189 w+  bank=n alpha=1 R=169987.172044793 G_phys=5.88279684855566e-06 G_eff=5.88279684855566e-06
Ro14p20n1 h20yn o14p 170709.005127132
* o14 input 21 w=+0.0606582432664274 w+  bank=n alpha=1 R=549526.849746115 G_phys=1.81974729799282e-06 G_eff=1.81974729799282e-06
Ro14p21n1 h21yn o14p 547585.633200079
* o14 input 22 w=+0.471542863591523 w+  bank=n alpha=1 R=70689.9327867011 G_phys=1.41462859077457e-05 G_eff=1.41462859077457e-05
Ro14p22n1 h22yn o14p 70570.1869882804
* o14 input 23 w=+0.132895212526076 w+  bank=n alpha=1 R=250824.184707127 G_phys=3.98685637578228e-06 G_eff=3.98685637578228e-06
Ro14p23n1 h23yn o14p 251201.817230276
* o14 input 24 w=-0.150700282102261 w-  bank=n alpha=1 R=221189.588156937 G_phys=4.52100846306782e-06 G_eff=4.52100846306782e-06
Ro14n24n1 h24y o14p 220613.398849561
* o14 input 25 w=-0.172018927572569 w-  bank=n alpha=1 R=193777.125597247 G_phys=5.16056782717707e-06 G_eff=5.16056782717707e-06
Ro14n25n1 h25y o14p 194732.905609359
* o14 input 26 w=-0.144277203051731 w-  bank=n alpha=1 R=231036.730878278 G_phys=4.32831609155192e-06 G_eff=4.32831609155192e-06
Ro14n26n1 h26y o14p 230095.064885698
* o14 input 27 w=-0.0456897569368309 w-  bank=n alpha=1 R=729558.12348529 G_phys=1.37069270810493e-06 G_eff=1.37069270810493e-06
Ro14n27n1 h27y o14p 731607.364355222
* o14 input 28 w=-0.269930966859316 w-  bank=n alpha=1 R=123488.363418141 G_phys=8.09792900577949e-06 G_eff=8.09792900577949e-06
Ro14n28n1 h28y o14p 123023.308506954
* o14 input 29 w=-0.380176315173873 w-  bank=n alpha=1 R=87678.6164811146 G_phys=1.14052894552162e-05 G_eff=1.14052894552162e-05
Ro14n29n1 h29y o14p 87443.7461072463
* o14 input 30 w=+0.211443520189348 w+  bank=n alpha=1 R=157646.511482042 G_phys=6.34330560568043e-06 G_eff=6.34330560568043e-06
Ro14p30n1 h30yn o14p 157479.830429416
* o14 input 31 w=+0.0784944631218348 w+  bank=n alpha=1 R=424658.402741034 G_phys=2.35483389365504e-06 G_eff=2.35483389365504e-06
Ro14p31n1 h31yn o14p 425724.053977769
* o14 input 32 w=+0.0843025902123393 w+  bank=n alpha=1 R=395401.057658776 G_phys=2.52907770637018e-06 G_eff=2.52907770637018e-06
Ro14p32n1 h32yn o14p 393470.299001911
* o14 bias w-  bank=f alpha=0.001 R=2670.46157164376 G_phys=0.00037446709985213 G_eff=3.74467099852129e-07
Ro14bnf1 tapref o14p 2674.33209230154
* replica dummy G_tot for o14: same R as weights/biases, dest=0
Ro14dmy000 0 o14rp 130354.08537291
Ro14dmy001 0 o14rp 325322.456915265
Ro14dmy002 0 o14rp 311620.285378534
Ro14dmy003 0 o14rp 92107.3781242432
Ro14dmy004 0 o14rp 590388.349653437
Ro14dmy005 0 o14rp 200453.526842852
Ro14dmy006 0 o14rp 625285.859890835
Ro14dmy007 0 o14rp 99697.8861167327
Ro14dmy008 0 o14rp 181606.200442261
Ro14dmy009 0 o14rp 125822.279873385
Ro14dmy010 0 o14rp 1542.52472597157
Ro14dmy011 0 o14rp 651919.431554005
Ro14dmy012 0 o14rp 115233.526633563
Ro14dmy013 0 o14rp 291165.482878796
Ro14dmy014 0 o14rp 192609.704433207
Ro14dmy015 0 o14rp 379461.033344788
Ro14dmy016 0 o14rp 342841.846351103
Ro14dmy017 0 o14rp 118867.617742707
Ro14dmy018 0 o14rp 266393.306260427
Ro14dmy019 0 o14rp 169953.626138661
Ro14dmy020 0 o14rp 551624.119972363
Ro14dmy021 0 o14rp 70927.7913079675
Ro14dmy022 0 o14rp 251483.888579341
Ro14dmy023 0 o14rp 220446.974196779
Ro14dmy024 0 o14rp 193730.043960111
Ro14dmy025 0 o14rp 231011.585179217
Ro14dmy026 0 o14rp 728025.583173894
Ro14dmy027 0 o14rp 123175.729415718
Ro14dmy028 0 o14rp 87933.212128655
Ro14dmy029 0 o14rp 157059.643632858
Ro14dmy030 0 o14rp 425404.565935308
Ro14dmy031 0 o14rp 395123.458939711
Ro14dmy032 0 o14rp 2670.70190982986
* feedback TIA o14: Rf=33333.3333333333 A=100000 V(o14sig) = -I(o14p)*Rf*A/(A+1)  (uncompensated)
Eo14tia o14sig 0 0 o14p 100000
Ro14f o14sig o14p 33220.9188559043
* feedback TIA o14r: Rf=33333.3333333333 A=100000 V(o14rep) = -I(o14rp)*Rf*A/(A+1)  (uncompensated)
Eo14rtia o14rep 0 0 o14rp 100000
Ro14rf o14rep o14rp 33419.9136079788
* replica null o14: v(o14lin)=v(o14sig)-v(o14rep) Vos_sig=0 Vos_rep=0
Eo14null o14lin 0 o14sig o14rep 1

* o15 input 1 w=-0.113449668897813 w-  bank=n alpha=1 R=293816.047743229 G_phys=3.40349006693439e-06 G_eff=3.40349006693439e-06
Ro15n1n1 h1y o15p 293684.973117714
* o15 input 2 w=-0.169978823552936 w-  bank=n alpha=1 R=196102.85938326 G_phys=5.09936470658807e-06 G_eff=5.09936470658807e-06
Ro15n2n1 h2y o15p 195993.780967066
* o15 input 3 w=+0.0133598434574407 w+  bank=f alpha=0.001 R=2495.03921505672 G_phys=0.00040079530372322 G_eff=4.0079530372322e-07
Ro15p3f1 htap3n o15p 2501.55002262156
* o15 input 4 w=-0.169966115485037 w-  bank=n alpha=1 R=196117.52164959 G_phys=5.0989834645511e-06 G_eff=5.0989834645511e-06
Ro15n4n1 h4y o15p 196213.330370987
* o15 input 5 w=-0.0418903282162887 w-  bank=n alpha=1 R=795728.626455878 G_phys=1.25670984648866e-06 G_eff=1.25670984648866e-06
Ro15n5n1 h5y o15p 792178.467773973
* o15 input 6 w=-0.324291927905124 w-  bank=n alpha=1 R=102788.045168628 G_phys=9.72875783715372e-06 G_eff=9.72875783715372e-06
Ro15n6n1 h6y o15p 103007.239744982
* o15 input 7 w=+0.558916704640692 w+  bank=n alpha=1 R=59639.1788911769 G_phys=1.67675011392208e-05 G_eff=1.67675011392208e-05
Ro15p7n1 h7yn o15p 59731.5514909818
* o15 input 8 w=-0.047599242693459 w-  bank=n alpha=1 R=700291.253539501 G_phys=1.42797728080377e-06 G_eff=1.42797728080377e-06
Ro15n8n1 h8y o15p 702576.236292043
* o15 input 9 w=-0.103084990895521 w-  bank=n alpha=1 R=323357.775402217 G_phys=3.09254972686562e-06 G_eff=3.09254972686562e-06
Ro15n9n1 h9y o15p 323027.098120602
* o15 input 10 w=-0.115049291784761 w-  bank=n alpha=1 R=289730.886789766 G_phys=3.45147875354283e-06 G_eff=3.45147875354283e-06
Ro15n10n1 h10y o15p 290012.138362264
* o15 input 11 w=+0.0920546297717411 w+  bank=n alpha=1 R=362103.822653861 G_phys=2.76163889315223e-06 G_eff=2.76163889315223e-06
Ro15p11n1 h11yn o15p 360691.736610997
* o15 input 12 w=+0.0505985364133342 w+  bank=n alpha=1 R=658780.583316418 G_phys=1.51795609240003e-06 G_eff=1.51795609240003e-06
Ro15p12n1 h12yn o15p 661432.906725779
* o15 input 13 w=-0.145296396139138 w-  bank=n alpha=1 R=229416.105416771 G_phys=4.35889188417414e-06 G_eff=4.35889188417414e-06
Ro15n13n1 h13y o15p 229553.72631406
* o15 input 14 w=-0.379881852318272 w-  bank=n alpha=1 R=87746.579969306 G_phys=1.13964555695482e-05 G_eff=1.13964555695482e-05
Ro15n14n1 h14y o15p 87862.8596574473
* o15 input 15 w=+0.223112491519187 w+  bank=n alpha=1 R=149401.466078231 G_phys=6.69337474557561e-06 G_eff=6.69337474557561e-06
Ro15p15n1 h15yn o15p 148942.267001386
* o15 input 16 w=-0.14757878301826 w-  bank=n alpha=1 R=225868.059429714 G_phys=4.42736349054781e-06 G_eff=4.42736349054781e-06
Ro15n16n1 h16y o15p 225883.083589607
* o15 input 17 w=+0.173921977011029 w+  bank=n alpha=1 R=191656.821674811 G_phys=5.21765931033087e-06 G_eff=5.21765931033087e-06
Ro15p17n1 h17yn o15p 192000.857718207
* o15 input 18 w=+0.133725887369399 w+  bank=n alpha=1 R=249266.121833648 G_phys=4.01177662108198e-06 G_eff=4.01177662108198e-06
Ro15p18n1 h18yn o15p 248651.897125585
* o15 input 19 w=+0.209560948195519 w+  bank=n alpha=1 R=159062.714787077 G_phys=6.28682844586558e-06 G_eff=6.28682844586558e-06
Ro15p19n1 h19yn o15p 158692.502894977
* o15 input 20 w=-0.0239329977507233 w-  bank=f alpha=0.001 R=1392.7771890726 G_phys=0.000717989932521699 G_eff=7.179899325217e-07
Ro15n20f1 htap20 o15p 1396.72269759646
* o15 input 21 w=+0.196041920231295 w+  bank=n alpha=1 R=170031.661054972 G_phys=5.88125760693885e-06 G_eff=5.88125760693885e-06
Ro15p21n1 h21yn o15p 169789.488229309
* o15 input 22 w=-0.0995510863910355 w-  bank=n alpha=1 R=334836.459769011 G_phys=2.98653259173107e-06 G_eff=2.98653259173107e-06
Ro15n22n1 h22y o15p 336095.354517115
* o15 input 23 w=+0.102107365264583 w+  bank=n alpha=1 R=326453.760186243 G_phys=3.06322095793749e-06 G_eff=3.06322095793749e-06
Ro15p23n1 h23yn o15p 328029.923691939
* o15 input 24 w=-0.21795159550845 w-  bank=n alpha=1 R=152939.157226958 G_phys=6.53854786525351e-06 G_eff=6.53854786525351e-06
Ro15n24n1 h24y o15p 152977.595410536
* o15 input 25 w=+0.202525001628457 w+  bank=n alpha=1 R=164588.732577744 G_phys=6.07575004885372e-06 G_eff=6.07575004885372e-06
Ro15p25n1 h25yn o15p 164749.88067347
* o15 input 26 w=-0.281017181998367 w-  bank=n alpha=1 R=118616.709114701 G_phys=8.43051545995101e-06 G_eff=8.43051545995101e-06
Ro15n26n1 h26y o15p 118609.992088968
* o15 input 27 w=+0.141610254018665 w+  bank=n alpha=1 R=235387.850719764 G_phys=4.24830762055994e-06 G_eff=4.24830762055994e-06
Ro15p27n1 h27yn o15p 235856.944301663
* o15 input 28 w=+0.444984802739648 w+  bank=n alpha=1 R=74908.9252669063 G_phys=1.33495440821894e-05 G_eff=1.33495440821894e-05
Ro15p28n1 h28yn o15p 74548.7111233341
* o15 input 29 w=-0.120073433142323 w-  bank=n alpha=1 R=277607.897608986 G_phys=3.60220299426968e-06 G_eff=3.60220299426968e-06
Ro15n29n1 h29y o15p 278342.184110247
* o15 input 30 w=-0.0538706707421541 w-  bank=n alpha=1 R=618765.886411172 G_phys=1.61612012226462e-06 G_eff=1.61612012226462e-06
Ro15n30n1 h30y o15p 620825.436047582
* o15 input 31 w=+0.148090323839994 w+  bank=n alpha=1 R=225087.854959036 G_phys=4.44270971519983e-06 G_eff=4.44270971519983e-06
Ro15p31n1 h31yn o15p 225019.361615549
* o15 input 32 w=-0.347735979661958 w-  bank=n alpha=1 R=95858.1662033862 G_phys=1.04320793898588e-05 G_eff=1.04320793898588e-05
Ro15n32n1 h32y o15p 95792.0185869253
* o15 bias w+  bank=n alpha=1 R=468672.189169108 G_phys=2.13368751786374e-06 G_eff=2.13368751786374e-06
Ro15bpn1 vrefn o15p 466460.023361731
* replica dummy G_tot for o15: same R as weights/biases, dest=0
Ro15dmy000 0 o15rp 294487.786839623
Ro15dmy001 0 o15rp 196855.342945379
Ro15dmy002 0 o15rp 2491.96102559009
Ro15dmy003 0 o15rp 196671.954739532
Ro15dmy004 0 o15rp 796770.443167075
Ro15dmy005 0 o15rp 102514.083273674
Ro15dmy006 0 o15rp 59717.5174246959
Ro15dmy007 0 o15rp 700007.01662228
Ro15dmy008 0 o15rp 322484.291543182
Ro15dmy009 0 o15rp 291096.06685741
Ro15dmy010 0 o15rp 361571.019288851
Ro15dmy011 0 o15rp 659620.627141703
Ro15dmy012 0 o15rp 228376.273566518
Ro15dmy013 0 o15rp 87558.4106619274
Ro15dmy014 0 o15rp 149802.712693182
Ro15dmy015 0 o15rp 226336.452471373
Ro15dmy016 0 o15rp 192066.905433367
Ro15dmy017 0 o15rp 248585.539262827
Ro15dmy018 0 o15rp 158782.145071193
Ro15dmy019 0 o15rp 1395.55531180523
Ro15dmy020 0 o15rp 170547.258283272
Ro15dmy021 0 o15rp 334885.917456347
Ro15dmy022 0 o15rp 326750.130717416
Ro15dmy023 0 o15rp 153640.433781752
Ro15dmy024 0 o15rp 164997.333740328
Ro15dmy025 0 o15rp 118609.38707696
Ro15dmy026 0 o15rp 234406.066715805
Ro15dmy027 0 o15rp 75123.985793461
Ro15dmy028 0 o15rp 278535.841185955
Ro15dmy029 0 o15rp 618672.463057681
Ro15dmy030 0 o15rp 226000.166791281
Ro15dmy031 0 o15rp 96042.627662308
Ro15dmy032 0 o15rp 467640.645439408
* feedback TIA o15: Rf=33333.3333333333 A=100000 V(o15sig) = -I(o15p)*Rf*A/(A+1)  (uncompensated)
Eo15tia o15sig 0 0 o15p 100000
Ro15f o15sig o15p 33227.3033070255
* feedback TIA o15r: Rf=33333.3333333333 A=100000 V(o15rep) = -I(o15rp)*Rf*A/(A+1)  (uncompensated)
Eo15rtia o15rep 0 0 o15rp 100000
Ro15rf o15rep o15rp 33263.0631111358
* replica null o15: v(o15lin)=v(o15sig)-v(o15rep) Vos_sig=0 Vos_rep=0
Eo15null o15lin 0 o15sig o15rep 1

* o16 input 1 w=-0.0239168211298723 w-  bank=f alpha=0.001 R=1393.71922181162 G_phys=0.000717504633896169 G_eff=7.17504633896169e-07
Ro16n1f1 htap1 o16p 1390.66161887024
* o16 input 2 w=-0.455843018824687 w-  bank=n alpha=1 R=73124.5888535874 G_phys=1.36752905647406e-05 G_eff=1.36752905647406e-05
Ro16n2n1 h2y o16p 73477.9580479972
* o16 input 3 w=-0.360558107273835 w-  bank=n alpha=1 R=92449.2686778431 G_phys=1.0816743218215e-05 G_eff=1.0816743218215e-05
Ro16n3n1 h3y o16p 92296.6314352522
* o16 input 4 w=+0.281324980833712 w+  bank=n alpha=1 R=118486.930078336 G_phys=8.43974942501135e-06 G_eff=8.43974942501135e-06
Ro16p4n1 h4yn o16p 118364.77532555
* o16 input 5 w=-0.0789059543438914 w-  bank=n alpha=1 R=422443.827091407 G_phys=2.36717863031674e-06 G_eff=2.36717863031674e-06
Ro16n5n1 h5y o16p 423951.189988748
* o16 input 6 w=+0.0459206910877794 w+  bank=n alpha=1 R=725889.191641633 G_phys=1.37762073263338e-06 G_eff=1.37762073263338e-06
Ro16p6n1 h6yn o16p 724581.986284953
* o16 input 7 w=-0.348093944852844 w-  bank=n alpha=1 R=95759.5896918717 G_phys=1.04428183455853e-05 G_eff=1.04428183455853e-05
Ro16n7n1 h7y o16p 95840.3204957614
* o16 input 8 w=-0.0796710739452782 w-  bank=n alpha=1 R=418386.896055 G_phys=2.39013221835835e-06 G_eff=2.39013221835835e-06
Ro16n8n1 h8y o16p 420016.530176935
* o16 input 9 w=-0.173339228342165 w-  bank=n alpha=1 R=192301.15220967 G_phys=5.20017685026494e-06 G_eff=5.20017685026494e-06
Ro16n9n1 h9y o16p 192403.845805735
* o16 input 10 w=+0.194262181446587 w+  bank=n alpha=1 R=171589.411202501 G_phys=5.82786544339762e-06 G_eff=5.82786544339762e-06
Ro16p10n1 h10yn o16p 172374.708946128
* o16 input 11 w=+0.155708231075043 w+  bank=n alpha=1 R=214075.602190025 G_phys=4.67124693225129e-06 G_eff=4.67124693225129e-06
Ro16p11n1 h11yn o16p 213802.992544321
* o16 input 12 w=+0.124882648574468 w+  bank=n alpha=1 R=266917.251626487 G_phys=3.74647945723404e-06 G_eff=3.74647945723404e-06
Ro16p12n1 h12yn o16p 265777.815017889
* o16 input 13 w=+0.270423516346849 w+  bank=n alpha=1 R=123263.441669694 G_phys=8.11270549040547e-06 G_eff=8.11270549040547e-06
Ro16p13n1 h13yn o16p 123869.68272458
* o16 input 14 w=-0.22936067173287 w-  bank=n alpha=1 R=145331.512510374 G_phys=6.88082015198609e-06 G_eff=6.88082015198609e-06
Ro16n14n1 h14y o16p 145594.073337116
* o16 input 15 w=+0.0349795005301705 w+  bank=n alpha=1 R=952939.087983336 G_phys=1.04938501590512e-06 G_eff=1.04938501590512e-06
Ro16p15n1 h15yn o16p 954860.778958792
* o16 input 16 w=+0.104322324768401 w+  bank=n alpha=1 R=319522.531800691 G_phys=3.12966974305203e-06 G_eff=3.12966974305203e-06
Ro16p16n1 h16yn o16p 320182.427432637
* o16 input 17 w=-0.351176137449102 w-  bank=n alpha=1 R=94919.129686494 G_phys=1.05352841234731e-05 G_eff=1.05352841234731e-05
Ro16n17n1 h17y o16p 95114.2469508674
* o16 input 18 w=+0.119462358831177 w+  bank=n alpha=1 R=279027.918580107 G_phys=3.58387076493532e-06 G_eff=3.58387076493532e-06
Ro16p18n1 h18yn o16p 279998.827444531
* o16 input 19 w=+0.230688311648174 w+  bank=n alpha=1 R=144495.111586626 G_phys=6.92064934944523e-06 G_eff=6.92064934944523e-06
Ro16p19n1 h19yn o16p 143797.931252154
* o16 input 20 w=-0.0614748986253126 w-  bank=n alpha=1 R=542226.731214294 G_phys=1.84424695875938e-06 G_eff=1.84424695875938e-06
Ro16n20n1 h20y o16p 539818.336904989
* o16 input 21 w=+0.36727529530057 w+  bank=n alpha=1 R=90758.4413104999 G_phys=1.10182588590171e-05 G_eff=1.10182588590171e-05
Ro16p21n1 h21yn o16p 90914.1337150098
* o16 input 22 w=+0.579638140801163 w+  bank=n alpha=1 R=57507.1427964708 G_phys=1.73891442240349e-05 G_eff=1.73891442240349e-05
Ro16p22n1 h22yn o16p 57285.3579361203
* o16 input 23 w=-0.0387096142803063 w-  bank=n alpha=1 R=861112.515664923 G_phys=1.16128842840919e-06 G_eff=1.16128842840919e-06
Ro16n23n1 h23y o16p 857900.943466116
* o16 input 24 w=+0.0384174368738491 w+  bank=n alpha=1 R=867661.563232072 G_phys=1.15252310621547e-06 G_eff=1.15252310621547e-06
Ro16p24n1 h24yn o16p 870666.308399383
* o16 input 25 w=+0.201641208818347 w+  bank=n alpha=1 R=165310.12449624 G_phys=6.04923626455041e-06 G_eff=6.04923626455041e-06
Ro16p25n1 h25yn o16p 166084.416359113
* o16 input 26 w=-0.606109769372092 w-  bank=n alpha=1 R=54995.5387913735 G_phys=1.81832930811628e-05 G_eff=1.81832930811628e-05
Ro16n26n1 h26y o16p 54872.9253393609
* o16 input 27 w=-0.101484914332963 w-  bank=n alpha=1 R=328456.04248105 G_phys=3.04454742998888e-06 G_eff=3.04454742998888e-06
Ro16n27n1 h27y o16p 327957.180043135
* o16 input 28 w=+0.04265872854179 w+  bank=n alpha=1 R=781395.378455286 G_phys=1.2797618562537e-06 G_eff=1.2797618562537e-06
Ro16p28n1 h28yn o16p 784272.536158421
* o16 input 29 w=+0.0889131834636398 w+  bank=n alpha=1 R=374897.535267812 G_phys=2.66739550390919e-06 G_eff=2.66739550390919e-06
Ro16p29n1 h29yn o16p 373484.239760001
* o16 input 30 w=+0.0420485970959956 w+  bank=n alpha=1 R=792733.54250641 G_phys=1.26145791287987e-06 G_eff=1.26145791287987e-06
Ro16p30n1 h30yn o16p 793022.870904353
* o16 input 31 w=-0.332324220948992 w-  bank=n alpha=1 R=100303.652975236 G_phys=9.96972662846976e-06 G_eff=9.96972662846976e-06
Ro16n31n1 h31y o16p 100575.054309569
* o16 input 32 w=+0.137132637809711 w+  bank=n alpha=1 R=243073.668425948 G_phys=4.11397913429134e-06 G_eff=4.11397913429134e-06
Ro16p32n1 h32yn o16p 243821.059913654
* o16 bias w+  bank=n alpha=1 R=811464.21158382 G_phys=1.23234023845389e-06 G_eff=1.23234023845389e-06
Ro16bpn1 vrefn o16p 813341.227622371
* replica dummy G_tot for o16: same R as weights/biases, dest=0
Ro16dmy000 0 o16rp 1395.19796706772
Ro16dmy001 0 o16rp 73234.1594341034
Ro16dmy002 0 o16rp 92869.4784312332
Ro16dmy003 0 o16rp 118473.849478184
Ro16dmy004 0 o16rp 423107.36587123
Ro16dmy005 0 o16rp 728929.341893178
Ro16dmy006 0 o16rp 95367.1944128012
Ro16dmy007 0 o16rp 417676.801510249
Ro16dmy008 0 o16rp 192663.652303419
Ro16dmy009 0 o16rp 171169.669525913
Ro16dmy010 0 o16rp 213359.918537655
Ro16dmy011 0 o16rp 267923.605331224
Ro16dmy012 0 o16rp 123862.287259224
Ro16dmy013 0 o16rp 144722.309484783
Ro16dmy014 0 o16rp 953426.428256318
Ro16dmy015 0 o16rp 320840.456700863
Ro16dmy016 0 o16rp 94670.3793414619
Ro16dmy017 0 o16rp 279332.999893259
Ro16dmy018 0 o16rp 144857.990625383
Ro16dmy019 0 o16rp 544035.442877314
Ro16dmy020 0 o16rp 91069.8253090339
Ro16dmy021 0 o16rp 57742.2152333373
Ro16dmy022 0 o16rp 859427.920862629
Ro16dmy023 0 o16rp 864822.543709849
Ro16dmy024 0 o16rp 164639.210002715
Ro16dmy025 0 o16rp 55056.6255491912
Ro16dmy026 0 o16rp 327096.48038999
Ro16dmy027 0 o16rp 780536.996283693
Ro16dmy028 0 o16rp 376697.646641059
Ro16dmy029 0 o16rp 794319.13466715
Ro16dmy030 0 o16rp 100178.214729784
Ro16dmy031 0 o16rp 243271.40414771
Ro16dmy032 0 o16rp 811267.542562932
* feedback TIA o16: Rf=33333.3333333333 A=100000 V(o16sig) = -I(o16p)*Rf*A/(A+1)  (uncompensated)
Eo16tia o16sig 0 0 o16p 100000
Ro16f o16sig o16p 33479.2559565931
* feedback TIA o16r: Rf=33333.3333333333 A=100000 V(o16rep) = -I(o16rp)*Rf*A/(A+1)  (uncompensated)
Eo16rtia o16rep 0 0 o16rp 100000
Ro16rf o16rep o16rp 33290.1878382344
* replica null o16: v(o16lin)=v(o16sig)-v(o16rep) Vos_sig=0 Vos_rep=0
Eo16null o16lin 0 o16sig o16rep 1
.control
set numdgt=15
alter Vin1 DC -0.782151215897436
alter Vin2 DC -0.723921984993005
alter Vin3 DC 0.760643797106711
alter Vin4 DC -0.0622366570110018
alter Vin5 DC -0.573735382802652
alter Vin6 DC 0.166728957515316
alter Vin7 DC 0.787403669628254
alter Vin8 DC -0.576110745462346
alter Vin9 DC 0.58320814387168
alter Vin10 DC 0.399481348753702
alter Vin11 DC -0.484316557204155
alter Vin12 DC 0.362124441847494
alter Vin13 DC -0.439344919092307
alter Vin14 DC -0.644168422775057
alter Vin15 DC 0.443935723399375
alter Vin16 DC 0.381596793251469
op
print v(o1lin)
print v(o2lin)
print v(o3lin)
print v(o4lin)
print v(o5lin)
print v(o6lin)
print v(o7lin)
print v(o8lin)
print v(o9lin)
print v(o10lin)
print v(o11lin)
print v(o12lin)
print v(o13lin)
print v(o14lin)
print v(o15lin)
print v(o16lin)
alter Vin1 DC -0.125964085015673
alter Vin2 DC 0.985597619570933
alter Vin3 DC -0.088787469343923
alter Vin4 DC -0.780076066687523
alter Vin5 DC -0.794095231819191
alter Vin6 DC 0.556158074022438
alter Vin7 DC 0.889482033058766
alter Vin8 DC 0.957786295863332
alter Vin9 DC -0.985018721680717
alter Vin10 DC -0.335657919582626
alter Vin11 DC 0.674918603111004
alter Vin12 DC 0.944650701240119
alter Vin13 DC -0.473270343082667
alter Vin14 DC 0.0779859452029252
alter Vin15 DC -0.854080493043433
alter Vin16 DC 0.934724258301633
op
print v(o1lin)
print v(o2lin)
print v(o3lin)
print v(o4lin)
print v(o5lin)
print v(o6lin)
print v(o7lin)
print v(o8lin)
print v(o9lin)
print v(o10lin)
print v(o11lin)
print v(o12lin)
print v(o13lin)
print v(o14lin)
print v(o15lin)
print v(o16lin)
alter Vin1 DC 0.132584361605606
alter Vin2 DC -0.890055834977023
alter Vin3 DC -0.0495526032683273
alter Vin4 DC 0.0555710132367846
alter Vin5 DC 0.661998557847989
alter Vin6 DC -0.927473534291981
alter Vin7 DC 0.954641021322739
alter Vin8 DC 0.724136131942785
alter Vin9 DC -0.727668888358133
alter Vin10 DC -0.139099590496319
alter Vin11 DC 0.687582142215931
alter Vin12 DC -0.395354703205494
alter Vin13 DC -0.270773208926016
alter Vin14 DC 0.0763173336755634
alter Vin15 DC 0.729632842611858
alter Vin16 DC 0.389046589147091
op
print v(o1lin)
print v(o2lin)
print v(o3lin)
print v(o4lin)
print v(o5lin)
print v(o6lin)
print v(o7lin)
print v(o8lin)
print v(o9lin)
print v(o10lin)
print v(o11lin)
print v(o12lin)
print v(o13lin)
print v(o14lin)
print v(o15lin)
print v(o16lin)
alter Vin1 DC 0.677883087307003
alter Vin2 DC 0.0293063431237404
alter Vin3 DC -0.488542174284546
alter Vin4 DC -0.920804539696586
alter Vin5 DC 0.725257259760208
alter Vin6 DC -0.242354308277595
alter Vin7 DC 0.0690844942815507
alter Vin8 DC 0.377973179511884
alter Vin9 DC 0.0224496248160189
alter Vin10 DC -0.846444132971232
alter Vin11 DC 0.657131592246562
alter Vin12 DC -0.43311223132466
alter Vin13 DC -0.851364783402099
alter Vin14 DC -0.719898942975697
alter Vin15 DC -0.565451379826472
alter Vin16 DC -0.114729955093586
op
print v(o1lin)
print v(o2lin)
print v(o3lin)
print v(o4lin)
print v(o5lin)
print v(o6lin)
print v(o7lin)
print v(o8lin)
print v(o9lin)
print v(o10lin)
print v(o11lin)
print v(o12lin)
print v(o13lin)
print v(o14lin)
print v(o15lin)
print v(o16lin)
alter Vin1 DC 0.541712157840402
alter Vin2 DC 0.667605107700116
alter Vin3 DC -0.449972695124181
alter Vin4 DC -0.102088542347196
alter Vin5 DC 0.236344599808728
alter Vin6 DC 0.99895656295784
alter Vin7 DC 0.110319338856463
alter Vin8 DC -0.0280410127063104
alter Vin9 DC 0.022275125697987
alter Vin10 DC -0.955826227117511
alter Vin11 DC 0.882936307847656
alter Vin12 DC 0.222379511521449
alter Vin13 DC -0.685563042932104
alter Vin14 DC 0.573691595163161
alter Vin15 DC 0.282987190158124
alter Vin16 DC -0.618443521582252
op
print v(o1lin)
print v(o2lin)
print v(o3lin)
print v(o4lin)
print v(o5lin)
print v(o6lin)
print v(o7lin)
print v(o8lin)
print v(o9lin)
print v(o10lin)
print v(o11lin)
print v(o12lin)
print v(o13lin)
print v(o14lin)
print v(o15lin)
print v(o16lin)
alter Vin1 DC 0.210693789536692
alter Vin2 DC -0.0584752775390895
alter Vin3 DC -0.584155446477231
alter Vin4 DC -0.0121019152885229
alter Vin5 DC -0.237429491825111
alter Vin6 DC 0.974040717182706
alter Vin7 DC 0.0556971766186274
alter Vin8 DC -0.790138404367563
alter Vin9 DC -0.165677818363489
alter Vin10 DC -0.417152453991301
alter Vin11 DC 0.143934066133012
alter Vin12 DC 0.354364914639381
alter Vin13 DC 0.936490933395991
alter Vin14 DC 0.644762573249259
alter Vin15 DC -0.453462630248051
alter Vin16 DC 0.587748172224975
op
print v(o1lin)
print v(o2lin)
print v(o3lin)
print v(o4lin)
print v(o5lin)
print v(o6lin)
print v(o7lin)
print v(o8lin)
print v(o9lin)
print v(o10lin)
print v(o11lin)
print v(o12lin)
print v(o13lin)
print v(o14lin)
print v(o15lin)
print v(o16lin)
alter Vin1 DC 0.901385518220681
alter Vin2 DC 0.121152754046933
alter Vin3 DC -0.186769468363977
alter Vin4 DC -0.0336355918820463
alter Vin5 DC -0.553211848977293
alter Vin6 DC 0.273643391697961
alter Vin7 DC 0.466634906022457
alter Vin8 DC 0.505338141763423
alter Vin9 DC -0.569296870740712
alter Vin10 DC -0.89529494188354
alter Vin11 DC -0.716662980338159
alter Vin12 DC 0.517359577939294
alter Vin13 DC -0.232259625657887
alter Vin14 DC -0.744279001713334
alter Vin15 DC 0.951098488078453
alter Vin16 DC 0.600106475211065
op
print v(o1lin)
print v(o2lin)
print v(o3lin)
print v(o4lin)
print v(o5lin)
print v(o6lin)
print v(o7lin)
print v(o8lin)
print v(o9lin)
print v(o10lin)
print v(o11lin)
print v(o12lin)
print v(o13lin)
print v(o14lin)
print v(o15lin)
print v(o16lin)
alter Vin1 DC -0.435671795846375
alter Vin2 DC -0.679788554636994
alter Vin3 DC 0.505532998165505
alter Vin4 DC -0.650896460577789
alter Vin5 DC 0.822854480871577
alter Vin6 DC 0.58791924302149
alter Vin7 DC 0.312046314996683
alter Vin8 DC 0.400456134186074
alter Vin9 DC 0.218390487589023
alter Vin10 DC 0.0945442842560902
alter Vin11 DC -0.465640291515506
alter Vin12 DC -0.760308912103303
alter Vin13 DC -0.16697318220343
alter Vin14 DC 0.780666374939576
alter Vin15 DC 0.953894789455211
alter Vin16 DC -0.834065974983535
op
print v(o1lin)
print v(o2lin)
print v(o3lin)
print v(o4lin)
print v(o5lin)
print v(o6lin)
print v(o7lin)
print v(o8lin)
print v(o9lin)
print v(o10lin)
print v(o11lin)
print v(o12lin)
print v(o13lin)
print v(o14lin)
print v(o15lin)
print v(o16lin)
alter Vin1 DC -0.38792132221407
alter Vin2 DC 0.834135026479588
alter Vin3 DC 0.146699270046159
alter Vin4 DC 0.682157407009442
alter Vin5 DC 0.0201042845246406
alter Vin6 DC -0.997971005564787
alter Vin7 DC 0.230958065396657
alter Vin8 DC 0.265777272779289
alter Vin9 DC -0.475511885075746
alter Vin10 DC 0.872795524472271
alter Vin11 DC 0.897904890684354
alter Vin12 DC 0.467902150038458
alter Vin13 DC 0.39505667595247
alter Vin14 DC -0.402608600240559
alter Vin15 DC -0.386998969306971
alter Vin16 DC -0.52766827279409
op
print v(o1lin)
print v(o2lin)
print v(o3lin)
print v(o4lin)
print v(o5lin)
print v(o6lin)
print v(o7lin)
print v(o8lin)
print v(o9lin)
print v(o10lin)
print v(o11lin)
print v(o12lin)
print v(o13lin)
print v(o14lin)
print v(o15lin)
print v(o16lin)
alter Vin1 DC -0.460873899901255
alter Vin2 DC -0.557430574243837
alter Vin3 DC -0.892770333869801
alter Vin4 DC 0.983443128072331
alter Vin5 DC 0.841688378232789
alter Vin6 DC 0.377560931950347
alter Vin7 DC 0.725716820996829
alter Vin8 DC 0.905369945266483
alter Vin9 DC -0.481201282183126
alter Vin10 DC 0.856375106456209
alter Vin11 DC 0.0767014232445515
alter Vin12 DC -0.615799060870604
alter Vin13 DC -0.829469496473362
alter Vin14 DC -0.237817827622445
alter Vin15 DC 0.674963183106483
alter Vin16 DC -0.515221334162314
op
print v(o1lin)
print v(o2lin)
print v(o3lin)
print v(o4lin)
print v(o5lin)
print v(o6lin)
print v(o7lin)
print v(o8lin)
print v(o9lin)
print v(o10lin)
print v(o11lin)
print v(o12lin)
print v(o13lin)
print v(o14lin)
print v(o15lin)
print v(o16lin)
alter Vin1 DC -0.340657723876006
alter Vin2 DC 0.500015391514662
alter Vin3 DC 0.662307165698743
alter Vin4 DC -0.355138251672427
alter Vin5 DC 0.509403373646525
alter Vin6 DC -0.845160523698206
alter Vin7 DC -0.844968190130221
alter Vin8 DC 0.105942952379445
alter Vin9 DC -0.361193687569504
alter Vin10 DC 0.368002243247346
alter Vin11 DC -0.228759047000964
alter Vin12 DC -0.996817774747558
alter Vin13 DC -0.342811378918154
alter Vin14 DC -0.444623692035989
alter Vin15 DC 0.955115852851907
alter Vin16 DC 0.0270628203256456
op
print v(o1lin)
print v(o2lin)
print v(o3lin)
print v(o4lin)
print v(o5lin)
print v(o6lin)
print v(o7lin)
print v(o8lin)
print v(o9lin)
print v(o10lin)
print v(o11lin)
print v(o12lin)
print v(o13lin)
print v(o14lin)
print v(o15lin)
print v(o16lin)
alter Vin1 DC -0.661970708619531
alter Vin2 DC -0.908721853363267
alter Vin3 DC -0.0497983168205629
alter Vin4 DC -0.0469016236770843
alter Vin5 DC 0.814470717592881
alter Vin6 DC 0.444989528503828
alter Vin7 DC 0.958235972411166
alter Vin8 DC 0.536196535186215
alter Vin9 DC 0.564524592958263
alter Vin10 DC 0.199220389313726
alter Vin11 DC -0.758582690666362
alter Vin12 DC 0.933064265488432
alter Vin13 DC -0.678706325737525
alter Vin14 DC -0.881832839742961
alter Vin15 DC 0.0146910516763723
alter Vin16 DC 0.287321146560182
op
print v(o1lin)
print v(o2lin)
print v(o3lin)
print v(o4lin)
print v(o5lin)
print v(o6lin)
print v(o7lin)
print v(o8lin)
print v(o9lin)
print v(o10lin)
print v(o11lin)
print v(o12lin)
print v(o13lin)
print v(o14lin)
print v(o15lin)
print v(o16lin)
alter Vin1 DC 0.259692549981088
alter Vin2 DC -0.384605294948321
alter Vin3 DC -0.0784082503876202
alter Vin4 DC -0.246624151183277
alter Vin5 DC 0.704231532683019
alter Vin6 DC 0.366643843841688
alter Vin7 DC -0.924275950528625
alter Vin8 DC 0.16329487783053
alter Vin9 DC -0.0501122105972713
alter Vin10 DC 0.43402057879396
alter Vin11 DC 0.804451892354864
alter Vin12 DC 0.772321085709411
alter Vin13 DC 0.20970501682477
alter Vin14 DC 0.784369539692618
alter Vin15 DC 0.736702119188367
alter Vin16 DC -0.58218324841503
op
print v(o1lin)
print v(o2lin)
print v(o3lin)
print v(o4lin)
print v(o5lin)
print v(o6lin)
print v(o7lin)
print v(o8lin)
print v(o9lin)
print v(o10lin)
print v(o11lin)
print v(o12lin)
print v(o13lin)
print v(o14lin)
print v(o15lin)
print v(o16lin)
alter Vin1 DC 0.0548413995489108
alter Vin2 DC -0.884387885900156
alter Vin3 DC 0.590996776901403
alter Vin4 DC -0.806138150528657
alter Vin5 DC 0.579100418761814
alter Vin6 DC 0.116009577367219
alter Vin7 DC -0.909614416255837
alter Vin8 DC 0.653033908016766
alter Vin9 DC -0.0575561881849054
alter Vin10 DC -0.406871664008175
alter Vin11 DC -0.0755807639318331
alter Vin12 DC 0.294692038376735
alter Vin13 DC 0.0767415418854629
alter Vin14 DC 0.148521637320637
alter Vin15 DC -0.997403662692795
alter Vin16 DC -0.806639229359815
op
print v(o1lin)
print v(o2lin)
print v(o3lin)
print v(o4lin)
print v(o5lin)
print v(o6lin)
print v(o7lin)
print v(o8lin)
print v(o9lin)
print v(o10lin)
print v(o11lin)
print v(o12lin)
print v(o13lin)
print v(o14lin)
print v(o15lin)
print v(o16lin)
alter Vin1 DC 0.356591378103911
alter Vin2 DC -0.498323200686828
alter Vin3 DC -0.0549213495824541
alter Vin4 DC 0.277764987182694
alter Vin5 DC -0.258209820585712
alter Vin6 DC -0.681937571204447
alter Vin7 DC 0.024221116699791
alter Vin8 DC 0.883335398047004
alter Vin9 DC -0.88444989677691
alter Vin10 DC -0.59514627909154
alter Vin11 DC 0.794883511420824
alter Vin12 DC -0.665555967058652
alter Vin13 DC 0.403125326179655
alter Vin14 DC -0.87574106073159
alter Vin15 DC -0.229319096781161
alter Vin16 DC 0.487019219795556
op
print v(o1lin)
print v(o2lin)
print v(o3lin)
print v(o4lin)
print v(o5lin)
print v(o6lin)
print v(o7lin)
print v(o8lin)
print v(o9lin)
print v(o10lin)
print v(o11lin)
print v(o12lin)
print v(o13lin)
print v(o14lin)
print v(o15lin)
print v(o16lin)
alter Vin1 DC -0.371427424436732
alter Vin2 DC 0.524522387875679
alter Vin3 DC -0.697215644886498
alter Vin4 DC 0.154391440445611
alter Vin5 DC 0.46818475576735
alter Vin6 DC -0.538850892408008
alter Vin7 DC -0.175579974451286
alter Vin8 DC 0.304379079804064
alter Vin9 DC -0.247827536343321
alter Vin10 DC -0.85742713763031
alter Vin11 DC 0.174834336927468
alter Vin12 DC -0.933554738767949
alter Vin13 DC 0.626160220749755
alter Vin14 DC 0.686560853935215
alter Vin15 DC 0.885094988626124
alter Vin16 DC -0.226171532218956
op
print v(o1lin)
print v(o2lin)
print v(o3lin)
print v(o4lin)
print v(o5lin)
print v(o6lin)
print v(o7lin)
print v(o8lin)
print v(o9lin)
print v(o10lin)
print v(o11lin)
print v(o12lin)
print v(o13lin)
print v(o14lin)
print v(o15lin)
print v(o16lin)
alter Vin1 DC -0.712060863565536
alter Vin2 DC -0.387090792640271
alter Vin3 DC -0.045641420079751
alter Vin4 DC -0.949046455290498
alter Vin5 DC 0.827462202083029
alter Vin6 DC -0.45857684096411
alter Vin7 DC -0.377395304510232
alter Vin8 DC 0.497466149169676
alter Vin9 DC -0.422858820531925
alter Vin10 DC 0.0807384148146528
alter Vin11 DC -0.0886691457377919
alter Vin12 DC -0.740265091611919
alter Vin13 DC -0.00210133467031337
alter Vin14 DC -0.701573729597303
alter Vin15 DC -0.347260656234244
alter Vin16 DC 0.129763936162634
op
print v(o1lin)
print v(o2lin)
print v(o3lin)
print v(o4lin)
print v(o5lin)
print v(o6lin)
print v(o7lin)
print v(o8lin)
print v(o9lin)
print v(o10lin)
print v(o11lin)
print v(o12lin)
print v(o13lin)
print v(o14lin)
print v(o15lin)
print v(o16lin)
alter Vin1 DC 0.650715453459496
alter Vin2 DC 0.995772194358668
alter Vin3 DC 0.168192258040452
alter Vin4 DC 0.918850476798035
alter Vin5 DC 0.994345992384587
alter Vin6 DC -0.366301079713938
alter Vin7 DC 0.501624731309458
alter Vin8 DC -0.598744863439338
alter Vin9 DC -0.202912735626473
alter Vin10 DC 0.683325316476078
alter Vin11 DC 0.830951080782547
alter Vin12 DC -0.755068766802807
alter Vin13 DC 0.264401708005855
alter Vin14 DC 0.494039550301885
alter Vin15 DC 0.272521393424273
alter Vin16 DC 0.27106322409194
op
print v(o1lin)
print v(o2lin)
print v(o3lin)
print v(o4lin)
print v(o5lin)
print v(o6lin)
print v(o7lin)
print v(o8lin)
print v(o9lin)
print v(o10lin)
print v(o11lin)
print v(o12lin)
print v(o13lin)
print v(o14lin)
print v(o15lin)
print v(o16lin)
alter Vin1 DC -0.60793823569545
alter Vin2 DC 0.951930375435605
alter Vin3 DC 0.718271652384951
alter Vin4 DC -0.222215746995515
alter Vin5 DC 0.493704896075127
alter Vin6 DC -0.581919850973307
alter Vin7 DC 0.653247780007157
alter Vin8 DC 0.41047740630118
alter Vin9 DC -0.0602558252763912
alter Vin10 DC 0.289190391017828
alter Vin11 DC 0.839688132551
alter Vin12 DC 0.288686009617347
alter Vin13 DC -0.943241939987624
alter Vin14 DC -0.249463291228212
alter Vin15 DC 0.606022037876674
alter Vin16 DC 0.018157608954146
op
print v(o1lin)
print v(o2lin)
print v(o3lin)
print v(o4lin)
print v(o5lin)
print v(o6lin)
print v(o7lin)
print v(o8lin)
print v(o9lin)
print v(o10lin)
print v(o11lin)
print v(o12lin)
print v(o13lin)
print v(o14lin)
print v(o15lin)
print v(o16lin)
alter Vin1 DC -0.27018775995954
alter Vin2 DC 0.26276123201648
alter Vin3 DC -0.0812285883469477
alter Vin4 DC -0.0105727617495157
alter Vin5 DC 0.545390301019538
alter Vin6 DC 0.499852766560388
alter Vin7 DC 0.264324183120353
alter Vin8 DC -0.410643122418609
alter Vin9 DC 0.564580518360778
alter Vin10 DC 0.466433944371466
alter Vin11 DC 0.463598556147311
alter Vin12 DC -0.663935255973979
alter Vin13 DC -0.620884832534028
alter Vin14 DC 0.214737521723306
alter Vin15 DC 0.715685765683473
alter Vin16 DC -0.0806341673718578
op
print v(o1lin)
print v(o2lin)
print v(o3lin)
print v(o4lin)
print v(o5lin)
print v(o6lin)
print v(o7lin)
print v(o8lin)
print v(o9lin)
print v(o10lin)
print v(o11lin)
print v(o12lin)
print v(o13lin)
print v(o14lin)
print v(o15lin)
print v(o16lin)
alter Vin1 DC 0.0496039283137859
alter Vin2 DC -0.907572538685049
alter Vin3 DC 0.325632690696941
alter Vin4 DC 0.254640875075648
alter Vin5 DC -0.396474147040885
alter Vin6 DC -0.93481862218887
alter Vin7 DC 0.98836381311826
alter Vin8 DC 0.371328333841353
alter Vin9 DC -0.91987372978102
alter Vin10 DC -0.935228714281628
alter Vin11 DC 0.743863502126326
alter Vin12 DC -0.440014875265085
alter Vin13 DC -0.483170413951668
alter Vin14 DC -0.894501067144098
alter Vin15 DC 0.467661670289644
alter Vin16 DC -0.592006884740699
op
print v(o1lin)
print v(o2lin)
print v(o3lin)
print v(o4lin)
print v(o5lin)
print v(o6lin)
print v(o7lin)
print v(o8lin)
print v(o9lin)
print v(o10lin)
print v(o11lin)
print v(o12lin)
print v(o13lin)
print v(o14lin)
print v(o15lin)
print v(o16lin)
alter Vin1 DC 0.0112461197291351
alter Vin2 DC -0.380422751120978
alter Vin3 DC -0.372084257697053
alter Vin4 DC -0.0763679598065592
alter Vin5 DC -0.921028596590388
alter Vin6 DC -0.789925315790107
alter Vin7 DC -0.357355336816392
alter Vin8 DC -0.143606490613431
alter Vin9 DC -0.410514383639978
alter Vin10 DC -0.342064999650752
alter Vin11 DC 0.761820979425593
alter Vin12 DC 0.184242883756313
alter Vin13 DC -0.486295931780894
alter Vin14 DC -0.741099063766235
alter Vin15 DC 0.245471353285982
alter Vin16 DC 0.556724313663984
op
print v(o1lin)
print v(o2lin)
print v(o3lin)
print v(o4lin)
print v(o5lin)
print v(o6lin)
print v(o7lin)
print v(o8lin)
print v(o9lin)
print v(o10lin)
print v(o11lin)
print v(o12lin)
print v(o13lin)
print v(o14lin)
print v(o15lin)
print v(o16lin)
alter Vin1 DC 0.189422298099084
alter Vin2 DC -0.370800789010032
alter Vin3 DC -0.845517087203642
alter Vin4 DC -0.241133093616783
alter Vin5 DC 0.566197008376164
alter Vin6 DC 0.553586613986001
alter Vin7 DC 0.367280973461056
alter Vin8 DC 0.0753534580638613
alter Vin9 DC 0.140855665517591
alter Vin10 DC 0.345768783416306
alter Vin11 DC 0.417950863965472
alter Vin12 DC -0.711929314017734
alter Vin13 DC 0.784457905173031
alter Vin14 DC 0.239163662344327
alter Vin15 DC 0.655058616286554
alter Vin16 DC -0.0792664707165434
op
print v(o1lin)
print v(o2lin)
print v(o3lin)
print v(o4lin)
print v(o5lin)
print v(o6lin)
print v(o7lin)
print v(o8lin)
print v(o9lin)
print v(o10lin)
print v(o11lin)
print v(o12lin)
print v(o13lin)
print v(o14lin)
print v(o15lin)
print v(o16lin)
alter Vin1 DC 0.898152905268676
alter Vin2 DC -0.548964431704437
alter Vin3 DC -0.518488730827058
alter Vin4 DC -0.893978846826168
alter Vin5 DC 0.121850231506176
alter Vin6 DC 0.832374864560553
alter Vin7 DC 0.0957803259099708
alter Vin8 DC -0.716465962296889
alter Vin9 DC 0.586331209924975
alter Vin10 DC 0.316865289090831
alter Vin11 DC -0.849222849578084
alter Vin12 DC 0.732383969984693
alter Vin13 DC 0.991916689664294
alter Vin14 DC 0.318910658376555
alter Vin15 DC 0.195177773880277
alter Vin16 DC 0.959506249376628
op
print v(o1lin)
print v(o2lin)
print v(o3lin)
print v(o4lin)
print v(o5lin)
print v(o6lin)
print v(o7lin)
print v(o8lin)
print v(o9lin)
print v(o10lin)
print v(o11lin)
print v(o12lin)
print v(o13lin)
print v(o14lin)
print v(o15lin)
print v(o16lin)
alter Vin1 DC 0.365010735388767
alter Vin2 DC -0.632713818024193
alter Vin3 DC 0.257550228361767
alter Vin4 DC -0.716705750398072
alter Vin5 DC 0.0865525894238828
alter Vin6 DC 0.138111537459521
alter Vin7 DC -0.087692416346568
alter Vin8 DC 0.583194623190785
alter Vin9 DC -0.949458120320712
alter Vin10 DC 0.965078537194827
alter Vin11 DC 0.868687265635781
alter Vin12 DC -0.795018705745223
alter Vin13 DC -0.70144126877884
alter Vin14 DC 0.155811452433045
alter Vin15 DC 0.3410767708144
alter Vin16 DC 0.221702392303302
op
print v(o1lin)
print v(o2lin)
print v(o3lin)
print v(o4lin)
print v(o5lin)
print v(o6lin)
print v(o7lin)
print v(o8lin)
print v(o9lin)
print v(o10lin)
print v(o11lin)
print v(o12lin)
print v(o13lin)
print v(o14lin)
print v(o15lin)
print v(o16lin)
alter Vin1 DC 0.861372134658962
alter Vin2 DC 0.903364947489677
alter Vin3 DC 0.519255628877329
alter Vin4 DC 0.758277462961247
alter Vin5 DC 0.95608191580324
alter Vin6 DC -0.735423531177138
alter Vin7 DC 0.885716710114949
alter Vin8 DC -0.752823260220575
alter Vin9 DC -0.0698016129871644
alter Vin10 DC -0.871487129653925
alter Vin11 DC -0.153345486189612
alter Vin12 DC 0.406664351880795
alter Vin13 DC -0.324183036383626
alter Vin14 DC -0.184627387926418
alter Vin15 DC -0.521529651186641
alter Vin16 DC -0.979031643271915
op
print v(o1lin)
print v(o2lin)
print v(o3lin)
print v(o4lin)
print v(o5lin)
print v(o6lin)
print v(o7lin)
print v(o8lin)
print v(o9lin)
print v(o10lin)
print v(o11lin)
print v(o12lin)
print v(o13lin)
print v(o14lin)
print v(o15lin)
print v(o16lin)
alter Vin1 DC 0.502226000412686
alter Vin2 DC -0.452269346118017
alter Vin3 DC 0.711744025828811
alter Vin4 DC -0.249801629294124
alter Vin5 DC 0.41172585336519
alter Vin6 DC -0.540761564850909
alter Vin7 DC 0.960818629214958
alter Vin8 DC 0.807436316462511
alter Vin9 DC -0.861324284352799
alter Vin10 DC -0.63381311558446
alter Vin11 DC 0.214326365894775
alter Vin12 DC 0.341524396794511
alter Vin13 DC -0.0842452242429912
alter Vin14 DC 0.356192979780496
alter Vin15 DC 0.773592847364512
alter Vin16 DC -0.366646904250596
op
print v(o1lin)
print v(o2lin)
print v(o3lin)
print v(o4lin)
print v(o5lin)
print v(o6lin)
print v(o7lin)
print v(o8lin)
print v(o9lin)
print v(o10lin)
print v(o11lin)
print v(o12lin)
print v(o13lin)
print v(o14lin)
print v(o15lin)
print v(o16lin)
alter Vin1 DC 0.941973383663371
alter Vin2 DC -0.0394168661246121
alter Vin3 DC 0.960220669075445
alter Vin4 DC -0.00230968810642285
alter Vin5 DC -0.592240768536283
alter Vin6 DC -0.209084717524972
alter Vin7 DC 0.114510879916792
alter Vin8 DC 0.85215281201614
alter Vin9 DC 0.397018834481259
alter Vin10 DC -0.151404917542739
alter Vin11 DC -0.00568983772053366
alter Vin12 DC 0.286063438745284
alter Vin13 DC -0.918492156133547
alter Vin14 DC 0.337154421478236
alter Vin15 DC 0.441115204648122
alter Vin16 DC -0.322633778317469
op
print v(o1lin)
print v(o2lin)
print v(o3lin)
print v(o4lin)
print v(o5lin)
print v(o6lin)
print v(o7lin)
print v(o8lin)
print v(o9lin)
print v(o10lin)
print v(o11lin)
print v(o12lin)
print v(o13lin)
print v(o14lin)
print v(o15lin)
print v(o16lin)
alter Vin1 DC -0.873826671882235
alter Vin2 DC 0.847541901384437
alter Vin3 DC -0.31152209269152
alter Vin4 DC 0.243471104178976
alter Vin5 DC -0.402782841670762
alter Vin6 DC 0.582959526284154
alter Vin7 DC -0.198373391768457
alter Vin8 DC 0.727804050440505
alter Vin9 DC 0.353118142285681
alter Vin10 DC -0.454960686673594
alter Vin11 DC -0.291168630014665
alter Vin12 DC -0.693128322493159
alter Vin13 DC 0.921310507210427
alter Vin14 DC 0.510691698826677
alter Vin15 DC -0.568110016568131
alter Vin16 DC 0.684286597811797
op
print v(o1lin)
print v(o2lin)
print v(o3lin)
print v(o4lin)
print v(o5lin)
print v(o6lin)
print v(o7lin)
print v(o8lin)
print v(o9lin)
print v(o10lin)
print v(o11lin)
print v(o12lin)
print v(o13lin)
print v(o14lin)
print v(o15lin)
print v(o16lin)
alter Vin1 DC -0.580198754314302
alter Vin2 DC -0.286281089029865
alter Vin3 DC -0.904708100761234
alter Vin4 DC 0.43626797375924
alter Vin5 DC 0.658415252725797
alter Vin6 DC -0.60535093077957
alter Vin7 DC 0.37753589625197
alter Vin8 DC -0.173830831154759
alter Vin9 DC 0.819525321981797
alter Vin10 DC -0.869179143984755
alter Vin11 DC -0.836615602153781
alter Vin12 DC -0.0115742779884573
alter Vin13 DC -0.590685298940934
alter Vin14 DC -0.472437362768819
alter Vin15 DC 0.0511404387458632
alter Vin16 DC -0.424920518706179
op
print v(o1lin)
print v(o2lin)
print v(o3lin)
print v(o4lin)
print v(o5lin)
print v(o6lin)
print v(o7lin)
print v(o8lin)
print v(o9lin)
print v(o10lin)
print v(o11lin)
print v(o12lin)
print v(o13lin)
print v(o14lin)
print v(o15lin)
print v(o16lin)
alter Vin1 DC -0.179693339770076
alter Vin2 DC -0.183575387343858
alter Vin3 DC 0.910127888305161
alter Vin4 DC 0.37224362521227
alter Vin5 DC 0.633890662937109
alter Vin6 DC -0.110673268404285
alter Vin7 DC 0.631556532364613
alter Vin8 DC 0.566741263864998
alter Vin9 DC -0.918304462509218
alter Vin10 DC -0.173598244522308
alter Vin11 DC -0.664051879894421
alter Vin12 DC 0.681960804695405
alter Vin13 DC -0.646505332595519
alter Vin14 DC -0.266603933422191
alter Vin15 DC -0.0965052566812115
alter Vin16 DC -0.977168749938422
op
print v(o1lin)
print v(o2lin)
print v(o3lin)
print v(o4lin)
print v(o5lin)
print v(o6lin)
print v(o7lin)
print v(o8lin)
print v(o9lin)
print v(o10lin)
print v(o11lin)
print v(o12lin)
print v(o13lin)
print v(o14lin)
print v(o15lin)
print v(o16lin)
alter Vin1 DC -0.238181522012963
alter Vin2 DC 0.386921880216893
alter Vin3 DC 0.988088058479316
alter Vin4 DC -0.274016885639883
alter Vin5 DC 0.655233312590293
alter Vin6 DC 0.422662903766858
alter Vin7 DC -0.106377125980305
alter Vin8 DC 0.493475466298538
alter Vin9 DC 0.80368717118789
alter Vin10 DC 0.801061640201829
alter Vin11 DC 0.295068784515685
alter Vin12 DC -0.672575986564107
alter Vin13 DC 0.891669993356725
alter Vin14 DC 0.619540487383566
alter Vin15 DC -0.56812380507439
alter Vin16 DC -0.555571715255508
op
print v(o1lin)
print v(o2lin)
print v(o3lin)
print v(o4lin)
print v(o5lin)
print v(o6lin)
print v(o7lin)
print v(o8lin)
print v(o9lin)
print v(o10lin)
print v(o11lin)
print v(o12lin)
print v(o13lin)
print v(o14lin)
print v(o15lin)
print v(o16lin)
alter Vin1 DC -0.264900889879486
alter Vin2 DC -0.204557814561241
alter Vin3 DC -0.370838691307676
alter Vin4 DC 0.115911595755644
alter Vin5 DC 0.120207896301793
alter Vin6 DC -0.0803568045477985
alter Vin7 DC 0.613304795749167
alter Vin8 DC -0.583652264553538
alter Vin9 DC -0.930036257419284
alter Vin10 DC 0.217104163402567
alter Vin11 DC -0.984190131963916
alter Vin12 DC -0.416258234100505
alter Vin13 DC -0.34227407773686
alter Vin14 DC -0.147677665585601
alter Vin15 DC 0.872251156462209
alter Vin16 DC -0.328987447969293
op
print v(o1lin)
print v(o2lin)
print v(o3lin)
print v(o4lin)
print v(o5lin)
print v(o6lin)
print v(o7lin)
print v(o8lin)
print v(o9lin)
print v(o10lin)
print v(o11lin)
print v(o12lin)
print v(o13lin)
print v(o14lin)
print v(o15lin)
print v(o16lin)
alter Vin1 DC -0.518145179982731
alter Vin2 DC 0.953334269153714
alter Vin3 DC -0.873633968838334
alter Vin4 DC -0.791672927086889
alter Vin5 DC -0.255180853528739
alter Vin6 DC -0.0760462218269216
alter Vin7 DC -0.381425203648439
alter Vin8 DC -0.973086352798405
alter Vin9 DC 0.467393057956238
alter Vin10 DC -0.804222366998105
alter Vin11 DC 0.24120551290833
alter Vin12 DC 0.362326826709116
alter Vin13 DC 0.231104930252606
alter Vin14 DC 0.279334653834514
alter Vin15 DC 0.751636312317176
alter Vin16 DC 0.482524818602424
op
print v(o1lin)
print v(o2lin)
print v(o3lin)
print v(o4lin)
print v(o5lin)
print v(o6lin)
print v(o7lin)
print v(o8lin)
print v(o9lin)
print v(o10lin)
print v(o11lin)
print v(o12lin)
print v(o13lin)
print v(o14lin)
print v(o15lin)
print v(o16lin)
alter Vin1 DC 0.284453898301181
alter Vin2 DC 0.905668156292134
alter Vin3 DC 0.525868782231565
alter Vin4 DC 0.41558829947085
alter Vin5 DC -0.856399631324468
alter Vin6 DC 0.39293815752912
alter Vin7 DC 0.445028928015566
alter Vin8 DC 0.159401724340743
alter Vin9 DC -0.256768383078056
alter Vin10 DC 0.920025818960049
alter Vin11 DC 0.516759536411676
alter Vin12 DC 0.0828352903138643
alter Vin13 DC 0.868534877882268
alter Vin14 DC 0.456153972012694
alter Vin15 DC 0.711010596021763
alter Vin16 DC -0.885414856953767
op
print v(o1lin)
print v(o2lin)
print v(o3lin)
print v(o4lin)
print v(o5lin)
print v(o6lin)
print v(o7lin)
print v(o8lin)
print v(o9lin)
print v(o10lin)
print v(o11lin)
print v(o12lin)
print v(o13lin)
print v(o14lin)
print v(o15lin)
print v(o16lin)
alter Vin1 DC -0.903828135913484
alter Vin2 DC -0.381322622066517
alter Vin3 DC 0.987515955197945
alter Vin4 DC 0.675369193910013
alter Vin5 DC 0.924996416595671
alter Vin6 DC 0.905072664312427
alter Vin7 DC 0.581124573129717
alter Vin8 DC -0.00869162752461516
alter Vin9 DC 0.536851191365308
alter Vin10 DC 0.648872203375758
alter Vin11 DC -0.899808430334469
alter Vin12 DC -0.842839404824732
alter Vin13 DC 0.334770781240143
alter Vin14 DC -0.273684465876922
alter Vin15 DC 0.854251983899495
alter Vin16 DC -0.170559935137417
op
print v(o1lin)
print v(o2lin)
print v(o3lin)
print v(o4lin)
print v(o5lin)
print v(o6lin)
print v(o7lin)
print v(o8lin)
print v(o9lin)
print v(o10lin)
print v(o11lin)
print v(o12lin)
print v(o13lin)
print v(o14lin)
print v(o15lin)
print v(o16lin)
alter Vin1 DC -0.413346537562353
alter Vin2 DC 0.22406688661002
alter Vin3 DC 0.567947769596209
alter Vin4 DC 0.132641655283897
alter Vin5 DC -0.215721737995065
alter Vin6 DC 0.0767974981487054
alter Vin7 DC -0.9625450556194
alter Vin8 DC 0.434973596070406
alter Vin9 DC 0.83704430448332
alter Vin10 DC 0.547490246218009
alter Vin11 DC 0.100876148125458
alter Vin12 DC 0.877813663861695
alter Vin13 DC -0.633921587093454
alter Vin14 DC -0.00991275864903018
alter Vin15 DC 0.0648404071261819
alter Vin16 DC -0.692179927232238
op
print v(o1lin)
print v(o2lin)
print v(o3lin)
print v(o4lin)
print v(o5lin)
print v(o6lin)
print v(o7lin)
print v(o8lin)
print v(o9lin)
print v(o10lin)
print v(o11lin)
print v(o12lin)
print v(o13lin)
print v(o14lin)
print v(o15lin)
print v(o16lin)
alter Vin1 DC -0.82086050535165
alter Vin2 DC 0.669900661506504
alter Vin3 DC -0.451813738605344
alter Vin4 DC -0.0162908073512746
alter Vin5 DC 0.593339588379846
alter Vin6 DC -0.197034774195835
alter Vin7 DC 0.692869301381219
alter Vin8 DC 0.736354899271658
alter Vin9 DC -0.530811418110088
alter Vin10 DC 0.593398762895415
alter Vin11 DC 0.447557999768101
alter Vin12 DC 0.728323247435287
alter Vin13 DC 0.559329645296618
alter Vin14 DC -0.887493895589616
alter Vin15 DC 0.770835920458297
alter Vin16 DC -0.84344816191552
op
print v(o1lin)
print v(o2lin)
print v(o3lin)
print v(o4lin)
print v(o5lin)
print v(o6lin)
print v(o7lin)
print v(o8lin)
print v(o9lin)
print v(o10lin)
print v(o11lin)
print v(o12lin)
print v(o13lin)
print v(o14lin)
print v(o15lin)
print v(o16lin)
alter Vin1 DC -0.884414084655435
alter Vin2 DC -0.56298373522616
alter Vin3 DC -0.882035857880852
alter Vin4 DC 0.507183521718484
alter Vin5 DC 0.171811695068499
alter Vin6 DC -0.778670124929632
alter Vin7 DC 0.503821951161299
alter Vin8 DC -0.499131911263272
alter Vin9 DC 0.996927288868197
alter Vin10 DC -0.0799992053287821
alter Vin11 DC 0.590569713035246
alter Vin12 DC -0.0164707413976735
alter Vin13 DC -0.10402733353287
alter Vin14 DC 0.348709172186886
alter Vin15 DC 0.0641599419473007
alter Vin16 DC -0.474084391476092
op
print v(o1lin)
print v(o2lin)
print v(o3lin)
print v(o4lin)
print v(o5lin)
print v(o6lin)
print v(o7lin)
print v(o8lin)
print v(o9lin)
print v(o10lin)
print v(o11lin)
print v(o12lin)
print v(o13lin)
print v(o14lin)
print v(o15lin)
print v(o16lin)
alter Vin1 DC -0.935352747889492
alter Vin2 DC -0.0275151790412425
alter Vin3 DC -0.371839071117253
alter Vin4 DC 0.454705243143903
alter Vin5 DC 0.34518213041391
alter Vin6 DC 0.132334452730056
alter Vin7 DC -0.97535482249116
alter Vin8 DC 0.513477707048894
alter Vin9 DC -0.985301348875143
alter Vin10 DC 0.51855803676348
alter Vin11 DC -0.983899442970003
alter Vin12 DC 0.174946976198451
alter Vin13 DC 0.573051492530666
alter Vin14 DC -0.952516638840584
alter Vin15 DC -0.463968288130711
alter Vin16 DC 0.995666109260205
op
print v(o1lin)
print v(o2lin)
print v(o3lin)
print v(o4lin)
print v(o5lin)
print v(o6lin)
print v(o7lin)
print v(o8lin)
print v(o9lin)
print v(o10lin)
print v(o11lin)
print v(o12lin)
print v(o13lin)
print v(o14lin)
print v(o15lin)
print v(o16lin)
.endc

.end
