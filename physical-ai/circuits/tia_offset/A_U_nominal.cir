* Physical AI - Experiment 19 architecture U: unmatched replica-null TIA (replica Vos = 0)
* Same replica topology as N, but replica Vos is forced to 0. Cancellation requires matched offsets.
* Frozen Experiment 9 network A. Weights were not edited.
* Behavioral circuit analysis. Not transistor-level or PCB power.
* A_tia=100000 vos=0 vos_replica=None unmatched=True rout=0 Ileak=0
* shape: 2 -> 4 -> 1

Vin1 in1 0 DC 0
* passive invert in1 -> in1n: R2/R1=1.0000200002 closed-loop -1 at A=100000
Rinv1ia in1 inv1m 10000
Rinv1ib in1n inv1m 10000.200002
Einv1amp in1n 0 0 inv1m 100000
Vin2 in2 0 DC 0
* passive invert in2 -> in2n: R2/R1=1.0000200002 closed-loop -1 at A=100000
Rinv2ia in2 inv2m 10000
Rinv2ib in2n inv2m 10000.200002
Einv2amp in2n 0 0 inv2m 100000
Vref vref 0 DC 1
* passive invert vref -> vrefn: R2/R1=1.0000200002 closed-loop -1 at A=100000
Rinvrefia vref invrefm 10000
Rinvrefib vrefn invrefm 10000.200002
Einvrefamp vrefn 0 0 invrefm 100000
* load-compensated divider vref->tapref: G_load=0.00135041774642313 Ra=425030.827613635 Rb=1000 target beta=0.001 (no tap buffer)
Rdivrefa vref tapref 425030.827613635
Rdivrefb tapref 0 1000
* load-compensated divider vrefn->taprefn: G_load=0.000833646933955897 Ra=544815.897488381 Rb=1000 target beta=0.001 (no tap buffer)
Rdivrefna vrefn taprefn 544815.897488381
Rdivrefnb taprefn 0 1000

* h1 input 1 w=+0.683760795348816 w+  bank=n alpha=1 R=48749.9920441162 G_phys=2.05128238604645e-05 G_eff=2.05128238604645e-05
Rh1p1n1 in1n h1p 48749.9920441162
* h1 input 2 w=+0.309366783045794 w+  bank=n alpha=1 R=107746.969487669 G_phys=9.28100349137382e-06 G_eff=9.28100349137382e-06
Rh1p2n1 in2n h1p 107746.969487669
* h1 bias w-  bank=f alpha=0.001 R=1253.18954325804 G_phys=0.000797963887729386 G_eff=7.97963887729385e-07
Rh1bnf1 tapref h1p 1253.18954325804
* replica dummy G_tot for h1: same R as weights/biases, dest=0
Rh1dmy000 0 h1rp 48749.9920441162
Rh1dmy001 0 h1rp 107746.969487669
Rh1dmy002 0 h1rp 1253.18954325804
* feedback TIA h1: Rf=33333.3333333333 A=100000 V(h1sig) = -I(h1p)*Rf*A/(A+1)  (uncompensated)
Eh1tia h1sig 0 0 h1p 100000
Rh1f h1sig h1p 33333.3333333333
* feedback TIA h1r: Rf=33333.3333333333 A=100000 V(h1rep) = -I(h1rp)*Rf*A/(A+1)  (uncompensated)
Eh1rtia h1rep 0 0 h1rp 100000
Rh1rf h1rep h1rp 33333.3333333333
* replica null h1: v(h1lin)=v(h1sig)-v(h1rep) Vos_sig=0 Vos_rep=0
Eh1null h1lin 0 h1sig h1rep 1
* direct bounded ReLU: y=max(0, min(15, v(h1lin)))
Bh1relu h1y 0 V = max(0, min(15, v(h1lin)))

* h2 input 1 w=-0.884821731731664 w-  bank=n alpha=1 R=37672.3718890781 G_phys=2.65446519519499e-05 G_eff=2.65446519519499e-05
Rh2n1n1 in1 h2p 37672.3718890781
* h2 input 2 w=+0.782653240240456 w+  bank=n alpha=1 R=42590.1684417639 G_phys=2.34795972072137e-05 G_eff=2.34795972072137e-05
Rh2p2n1 in2n h2p 42590.1684417639
* h2 bias w+  bank=f alpha=0.001 R=560963.988396833 G_phys=1.78264562553806e-06 G_eff=1.78264562553806e-09
Rh2bpf1 taprefn h2p 560963.988396833
* replica dummy G_tot for h2: same R as weights/biases, dest=0
Rh2dmy000 0 h2rp 37672.3718890781
Rh2dmy001 0 h2rp 42590.1684417639
Rh2dmy002 0 h2rp 560963.988396833
* feedback TIA h2: Rf=33333.3333333333 A=100000 V(h2sig) = -I(h2p)*Rf*A/(A+1)  (uncompensated)
Eh2tia h2sig 0 0 h2p 100000
Rh2f h2sig h2p 33333.3333333333
* feedback TIA h2r: Rf=33333.3333333333 A=100000 V(h2rep) = -I(h2rp)*Rf*A/(A+1)  (uncompensated)
Eh2rtia h2rep 0 0 h2rp 100000
Rh2rf h2rep h2rp 33333.3333333333
* replica null h2: v(h2lin)=v(h2sig)-v(h2rep) Vos_sig=0 Vos_rep=0
Eh2null h2lin 0 h2sig h2rep 1
* direct bounded ReLU: y=max(0, min(15, v(h2lin)))
Bh2relu h2y 0 V = max(0, min(15, v(h2lin)))

* h3 input 1 w=+0.80723931339229 w+  bank=n alpha=1 R=41293.0004526854 G_phys=2.42171794017687e-05 G_eff=2.42171794017687e-05
Rh3p1n1 in1n h3p 41293.0004526854
* h3 input 2 w=+1.71882311343666 w+  bank=n alpha=1 R=19393.1144355429 G_phys=5.15646934030999e-05 G_eff=5.15646934030999e-05
Rh3p2n1 in2n h3p 19393.1144355429
* h3 bias w+  bank=f alpha=0.001 R=1918.09451080035 G_phys=0.000521350743860236 G_eff=5.21350743860236e-07
Rh3bpf1 taprefn h3p 1918.09451080035
* replica dummy G_tot for h3: same R as weights/biases, dest=0
Rh3dmy000 0 h3rp 41293.0004526854
Rh3dmy001 0 h3rp 19393.1144355429
Rh3dmy002 0 h3rp 1918.09451080035
* feedback TIA h3: Rf=33333.3333333333 A=100000 V(h3sig) = -I(h3p)*Rf*A/(A+1)  (uncompensated)
Eh3tia h3sig 0 0 h3p 100000
Rh3f h3sig h3p 33333.3333333333
* feedback TIA h3r: Rf=33333.3333333333 A=100000 V(h3rep) = -I(h3rp)*Rf*A/(A+1)  (uncompensated)
Eh3rtia h3rep 0 0 h3rp 100000
Rh3rf h3rep h3rp 33333.3333333333
* replica null h3: v(h3lin)=v(h3sig)-v(h3rep) Vos_sig=0 Vos_rep=0
Eh3null h3lin 0 h3sig h3rep 1
* direct bounded ReLU: y=max(0, min(15, v(h3lin)))
Bh3relu h3y 0 V = max(0, min(15, v(h3lin)))

* h4 input 1 w=-2.16286246457598 w-  bank=n alpha=1 R=15411.6749813161 G_phys=6.48858739372794e-05 G_eff=6.48858739372794e-05
Rh4n1n1 in1 h4p 15411.6749813161
* h4 input 2 w=+0.726967919426763 w+  bank=n alpha=1 R=45852.5506319697 G_phys=2.18090375828029e-05 G_eff=2.18090375828029e-05
Rh4p2n1 in2n h4p 45852.5506319697
* h4 bias w-  bank=f alpha=0.001 R=1810.10591973139 G_phys=0.000552453858693748 G_eff=5.52453858693748e-07
Rh4bnf1 tapref h4p 1810.10591973139
* replica dummy G_tot for h4: same R as weights/biases, dest=0
Rh4dmy000 0 h4rp 15411.6749813161
Rh4dmy001 0 h4rp 45852.5506319697
Rh4dmy002 0 h4rp 1810.10591973139
* feedback TIA h4: Rf=33333.3333333333 A=100000 V(h4sig) = -I(h4p)*Rf*A/(A+1)  (uncompensated)
Eh4tia h4sig 0 0 h4p 100000
Rh4f h4sig h4p 33333.3333333333
* feedback TIA h4r: Rf=33333.3333333333 A=100000 V(h4rep) = -I(h4rp)*Rf*A/(A+1)  (uncompensated)
Eh4rtia h4rep 0 0 h4rp 100000
Rh4rf h4rep h4rp 33333.3333333333
* replica null h4: v(h4lin)=v(h4sig)-v(h4rep) Vos_sig=0 Vos_rep=0
Eh4null h4lin 0 h4sig h4rep 1
* direct bounded ReLU: y=max(0, min(15, v(h4lin)))
Bh4relu h4y 0 V = max(0, min(15, v(h4lin)))

* passive invert h1y -> h1yn: R2/R1=1.0000200002 closed-loop -1 at A=100000
Rinvh1ia h1y invh1m 10000
Rinvh1ib h1yn invh1m 10000.200002
Einvh1amp h1yn 0 0 invh1m 100000
* passive invert h2y -> h2yn: R2/R1=1.0000200002 closed-loop -1 at A=100000
Rinvh2ia h2y invh2m 10000
Rinvh2ib h2yn invh2m 10000.200002
Einvh2amp h2yn 0 0 invh2m 100000
* passive invert h3y -> h3yn: R2/R1=1.0000200002 closed-loop -1 at A=100000
Rinvh3ia h3y invh3m 10000
Rinvh3ib h3yn invh3m 10000.200002
Einvh3amp h3yn 0 0 invh3m 100000
* passive invert h4y -> h4yn: R2/R1=1.0000200002 closed-loop -1 at A=100000
Rinvh4ia h4y invh4m 10000
Rinvh4ib h4yn invh4m 10000.200002
Einvh4amp h4yn 0 0 invh4m 100000

* o1 input 1 w=+0.601889648539537 w+  bank=n alpha=1 R=55381.137413171 G_phys=1.80566894561861e-05 G_eff=1.80566894561861e-05
Ro1p1n1 h1yn o1p 55381.137413171
* o1 input 2 w=+0.347315954504283 w+  bank=n alpha=1 R=95974.0918925228 G_phys=1.04194786351285e-05 G_eff=1.04194786351285e-05
Ro1p2n1 h2yn o1p 95974.0918925228
* o1 input 3 w=+0.876922607606196 w+  bank=n alpha=1 R=38011.716249768 G_phys=2.63076782281859e-05 G_eff=2.63076782281859e-05
Ro1p3n1 h3yn o1p 38011.716249768
* o1 input 4 w=+0.929527796434486 w+  bank=n alpha=1 R=35860.5019249499 G_phys=2.78858338930346e-05 G_eff=2.78858338930346e-05
Ro1p4n1 h4yn o1p 35860.5019249499
* o1 bias w+  bank=f alpha=0.001 R=3220.47143452777 G_phys=0.000310513544470123 G_eff=3.10513544470123e-07
Ro1bpf1 taprefn o1p 3220.47143452777
* replica dummy G_tot for o1: same R as weights/biases, dest=0
Ro1dmy000 0 o1rp 55381.137413171
Ro1dmy001 0 o1rp 95974.0918925228
Ro1dmy002 0 o1rp 38011.716249768
Ro1dmy003 0 o1rp 35860.5019249499
Ro1dmy004 0 o1rp 3220.47143452777
* feedback TIA o1: Rf=33333.3333333333 A=100000 V(o1sig) = -I(o1p)*Rf*A/(A+1)  (uncompensated)
Eo1tia o1sig 0 0 o1p 100000
Ro1f o1sig o1p 33333.3333333333
* feedback TIA o1r: Rf=33333.3333333333 A=100000 V(o1rep) = -I(o1rp)*Rf*A/(A+1)  (uncompensated)
Eo1rtia o1rep 0 0 o1rp 100000
Ro1rf o1rep o1rp 33333.3333333333
* replica null o1: v(o1lin)=v(o1sig)-v(o1rep) Vos_sig=0 Vos_rep=0
Eo1null o1lin 0 o1sig o1rep 1
.control
set numdgt=15
alter Vin1 DC -0.576819355687276
alter Vin2 DC -0.803108523867146
op
print v(o1lin)
alter Vin1 DC -0.58503742865517
alter Vin2 DC -0.19367237831133
op
print v(o1lin)
alter Vin1 DC 0.828360288841471
alter Vin2 DC 0.778137282624673
op
print v(o1lin)
alter Vin1 DC 0.94621493284028
alter Vin2 DC 0.564010306396621
op
print v(o1lin)
alter Vin1 DC -0.378844299304408
alter Vin2 DC 0.457038047430159
op
print v(o1lin)
alter Vin1 DC 0.915822959876853
alter Vin2 DC -0.938982187905631
op
print v(o1lin)
alter Vin1 DC -0.929724758030534
alter Vin2 DC -0.50116800428199
op
print v(o1lin)
alter Vin1 DC 0.63744821070711
alter Vin2 DC -0.635476591419519
op
print v(o1lin)
alter Vin1 DC 0.0661535512326592
alter Vin2 DC -0.997916597560871
op
print v(o1lin)
alter Vin1 DC -0.838980081767585
alter Vin2 DC 0.926576611712803
op
print v(o1lin)
alter Vin1 DC 0.329436587897767
alter Vin2 DC 0.0287938191026949
op
print v(o1lin)
alter Vin1 DC -0.922906141343609
alter Vin2 DC 0.390157160967122
op
print v(o1lin)
alter Vin1 DC 0.588389609196755
alter Vin2 DC 0.600787537263617
op
print v(o1lin)
alter Vin1 DC 0.991935200113583
alter Vin2 DC 0.157907337081685
op
print v(o1lin)
alter Vin1 DC -0.468037537467973
alter Vin2 DC -0.815382735452025
op
print v(o1lin)
alter Vin1 DC 0.0826091625625218
alter Vin2 DC -0.587575651318259
op
print v(o1lin)
alter Vin1 DC 0.548982788587194
alter Vin2 DC 0.837211025000147
op
print v(o1lin)
alter Vin1 DC -0.352008896192854
alter Vin2 DC -0.917661417695941
op
print v(o1lin)
alter Vin1 DC 0.619752725018805
alter Vin2 DC -0.389510398535824
op
print v(o1lin)
alter Vin1 DC -0.485435228689451
alter Vin2 DC -0.484269823802436
op
print v(o1lin)
alter Vin1 DC -0.689286492261577
alter Vin2 DC -0.398253095966334
op
print v(o1lin)
alter Vin1 DC -0.192202287276638
alter Vin2 DC 0.387176550551204
op
print v(o1lin)
alter Vin1 DC 0.760066702317971
alter Vin2 DC -0.271266119194386
op
print v(o1lin)
alter Vin1 DC -0.284958002796847
alter Vin2 DC -0.648491137506866
op
print v(o1lin)
alter Vin1 DC 0.542558151684917
alter Vin2 DC -0.713982366843621
op
print v(o1lin)
alter Vin1 DC 0.984419512631735
alter Vin2 DC -0.437907550993657
op
print v(o1lin)
alter Vin1 DC 0.0468457233343429
alter Vin2 DC 0.286920753575186
op
print v(o1lin)
alter Vin1 DC -0.675568165346477
alter Vin2 DC -0.198825131577492
op
print v(o1lin)
alter Vin1 DC -0.635077604670945
alter Vin2 DC 0.846773995648908
op
print v(o1lin)
alter Vin1 DC -0.467288627850798
alter Vin2 DC -0.506111697341267
op
print v(o1lin)
alter Vin1 DC 0.766866475168862
alter Vin2 DC -0.883867685550711
op
print v(o1lin)
alter Vin1 DC 0.902029404068619
alter Vin2 DC 0.517384569378863
op
print v(o1lin)
alter Vin1 DC 0.24639293425821
alter Vin2 DC -0.348939068594785
op
print v(o1lin)
alter Vin1 DC -0.21638996362489
alter Vin2 DC -0.58913036924013
op
print v(o1lin)
alter Vin1 DC 0.998106227136409
alter Vin2 DC 0.859972829136336
op
print v(o1lin)
alter Vin1 DC -0.817433299104242
alter Vin2 DC 0.0986165121033198
op
print v(o1lin)
alter Vin1 DC -0.356998483129498
alter Vin2 DC -0.491978894847507
op
print v(o1lin)
alter Vin1 DC -0.298448778445199
alter Vin2 DC -0.35519679256191
op
print v(o1lin)
alter Vin1 DC -0.140008203995321
alter Vin2 DC -0.34018032440679
op
print v(o1lin)
alter Vin1 DC -0.339684098301025
alter Vin2 DC 0.258208939883986
op
print v(o1lin)
alter Vin1 DC 0.971271955858826
alter Vin2 DC 0.508047600365123
op
print v(o1lin)
alter Vin1 DC -0.261192930519555
alter Vin2 DC 0.462656522207327
op
print v(o1lin)
alter Vin1 DC -0.149264337096681
alter Vin2 DC 0.539769556247427
op
print v(o1lin)
alter Vin1 DC -0.503356321915636
alter Vin2 DC -0.950056916596047
op
print v(o1lin)
alter Vin1 DC 0.357710116705552
alter Vin2 DC 0.508745354614137
op
print v(o1lin)
alter Vin1 DC 0.0115781413214311
alter Vin2 DC 0.933625396303523
op
print v(o1lin)
alter Vin1 DC -0.201289355361049
alter Vin2 DC 0.930141262906679
op
print v(o1lin)
alter Vin1 DC 0.955475541156242
alter Vin2 DC 0.296247041135766
op
print v(o1lin)
alter Vin1 DC -0.251596793259068
alter Vin2 DC 0.681502211558019
op
print v(o1lin)
alter Vin1 DC -0.667066156896411
alter Vin2 DC -0.703348442257623
op
print v(o1lin)
alter Vin1 DC 0.853130905134411
alter Vin2 DC -0.638932496651809
op
print v(o1lin)
alter Vin1 DC 0.286035880986881
alter Vin2 DC 0.701202500045609
op
print v(o1lin)
alter Vin1 DC 0.318787040804478
alter Vin2 DC 0.204340399111903
op
print v(o1lin)
alter Vin1 DC 0.123210893239597
alter Vin2 DC 0.899908835261745
op
print v(o1lin)
alter Vin1 DC 0.244609855979011
alter Vin2 DC -0.409082029618248
op
print v(o1lin)
alter Vin1 DC -0.597171695752737
alter Vin2 DC 0.715763665705381
op
print v(o1lin)
alter Vin1 DC 0.943595534831656
alter Vin2 DC 0.308773455203671
op
print v(o1lin)
alter Vin1 DC -0.492372512441088
alter Vin2 DC 0.63194898658931
op
print v(o1lin)
alter Vin1 DC -0.548596723274124
alter Vin2 DC 0.345666608319109
op
print v(o1lin)
alter Vin1 DC -0.377792622821947
alter Vin2 DC -0.206236087229563
op
print v(o1lin)
alter Vin1 DC 0.576956995016548
alter Vin2 DC -0.648242187629106
op
print v(o1lin)
alter Vin1 DC 0.67574264940509
alter Vin2 DC -0.566806226888394
op
print v(o1lin)
alter Vin1 DC 0.288764945377413
alter Vin2 DC 0.242203597990895
op
print v(o1lin)
alter Vin1 DC -0.175424745184424
alter Vin2 DC -0.27907732224369
op
print v(o1lin)
alter Vin1 DC -0.73089355255761
alter Vin2 DC 0.584191238836738
op
print v(o1lin)
alter Vin1 DC 0.441599816079793
alter Vin2 DC -0.798545912598658
op
print v(o1lin)
alter Vin1 DC -0.585866476399369
alter Vin2 DC -0.822857977968346
op
print v(o1lin)
alter Vin1 DC 0.041013347566534
alter Vin2 DC -0.676280108609711
op
print v(o1lin)
alter Vin1 DC 0.344749358583593
alter Vin2 DC -0.629287825188559
op
print v(o1lin)
alter Vin1 DC -0.950862977330806
alter Vin2 DC -0.528570728863205
op
print v(o1lin)
alter Vin1 DC -0.0171360334962052
alter Vin2 DC 0.497312026049278
op
print v(o1lin)
alter Vin1 DC 0.332276792524773
alter Vin2 DC 0.860232670176412
op
print v(o1lin)
alter Vin1 DC 0.189246921329091
alter Vin2 DC -0.179933105484376
op
print v(o1lin)
alter Vin1 DC 0.310602911066812
alter Vin2 DC -0.607182277011391
op
print v(o1lin)
alter Vin1 DC 0.810042574370817
alter Vin2 DC -0.506793748607064
op
print v(o1lin)
alter Vin1 DC -0.323500814300253
alter Vin2 DC -0.0541448426719053
op
print v(o1lin)
alter Vin1 DC -0.633575806482722
alter Vin2 DC 0.0735944163409927
op
print v(o1lin)
alter Vin1 DC 0.634172007383036
alter Vin2 DC 0.650909499661557
op
print v(o1lin)
alter Vin1 DC 0.501394146094764
alter Vin2 DC -0.822716560792091
op
print v(o1lin)
alter Vin1 DC 0.584450332921951
alter Vin2 DC 0.181383350513685
op
print v(o1lin)
alter Vin1 DC -0.848023047393735
alter Vin2 DC 0.229922804820655
op
print v(o1lin)
alter Vin1 DC -0.165645441098581
alter Vin2 DC 0.010399705037075
op
print v(o1lin)
alter Vin1 DC 0.19654225654685
alter Vin2 DC 0.968124673307182
op
print v(o1lin)
alter Vin1 DC 0.299656553361812
alter Vin2 DC 0.472630942494444
op
print v(o1lin)
alter Vin1 DC 0.403293933233341
alter Vin2 DC -0.249572869542935
op
print v(o1lin)
alter Vin1 DC -0.0853252683844294
alter Vin2 DC -0.904198644995672
op
print v(o1lin)
alter Vin1 DC 0.825484838884778
alter Vin2 DC -0.328148976798206
op
print v(o1lin)
alter Vin1 DC 0.256446179607268
alter Vin2 DC 0.953277469082505
op
print v(o1lin)
alter Vin1 DC 0.947234119137663
alter Vin2 DC 0.115684677545236
op
print v(o1lin)
alter Vin1 DC 0.630694721624116
alter Vin2 DC 0.116951920935749
op
print v(o1lin)
alter Vin1 DC -0.309718082255265
alter Vin2 DC -0.344903848797876
op
print v(o1lin)
alter Vin1 DC -0.368848628944067
alter Vin2 DC -0.712911525281693
op
print v(o1lin)
alter Vin1 DC 0.332524549203439
alter Vin2 DC -0.33835490536849
op
print v(o1lin)
alter Vin1 DC 0.547937814615059
alter Vin2 DC 0.920904703990385
op
print v(o1lin)
alter Vin1 DC -0.166464207861784
alter Vin2 DC -0.0350427597378964
op
print v(o1lin)
alter Vin1 DC 0.894128508212434
alter Vin2 DC -0.418125828017932
op
print v(o1lin)
alter Vin1 DC 0.939175044401369
alter Vin2 DC 0.256983790225926
op
print v(o1lin)
alter Vin1 DC -0.0337966533857168
alter Vin2 DC 0.498234651988571
op
print v(o1lin)
alter Vin1 DC -0.554115512846992
alter Vin2 DC 0.454017527722593
op
print v(o1lin)
alter Vin1 DC 0.661933385726143
alter Vin2 DC 0.275424138327613
op
print v(o1lin)
.endc

.end
