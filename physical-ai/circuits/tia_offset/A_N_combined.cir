* Physical AI - Experiment 19 architecture N: matched replica-null TIA
* Signal TIA plus a replica TIA loaded by dummy G_tot to 0 V. Same A, Rf, Vos. Vlin = Vsig - Vrep. Unity subtractor VCVS.
* Frozen Experiment 9 network A. Weights were not edited.
* Behavioral circuit analysis. Not transistor-level or PCB power.
* A_tia=100000 vos=0.001 vos_replica=None unmatched=False rout=100 Ileak=1e-08
* shape: 2 -> 4 -> 1

Vin1 in1 0 DC 0
* passive invert in1 -> in1n: R2/R1=1.0000200002 closed-loop -1 at A=100000
Rinv1ia in1 inv1m 9971.56529555615
Rinv1ib in1n inv1m 9956.68665658876
Einv1amp in1n 0 0 inv1m 100000
Vin2 in2 0 DC 0
* passive invert in2 -> in2n: R2/R1=1.0000200002 closed-loop -1 at A=100000
Rinv2ia in2 inv2m 9962.47256786384
Rinv2ib in2n inv2m 10042.6763999551
Einv2amp in2n 0 0 inv2m 100000
Vref vref 0 DC 1
* passive invert vref -> vrefn: R2/R1=1.0000200002 closed-loop -1 at A=100000
Rinvrefia vref invrefm 10046.4492505144
Rinvrefib vrefn invrefm 9980.87744785546
Einvrefamp vrefn 0 0 invrefm 100000
* load-compensated divider vref->tapref: G_load=0.00135041774642313 Ra=425030.827613635 Rb=1000 target beta=0.001 (no tap buffer)
Rdivrefa vref tapref 425000.798214801
Rdivrefb tapref 0 997.041736534543
* load-compensated divider vrefn->taprefn: G_load=0.000833646933955897 Ra=544815.897488381 Rb=1000 target beta=0.001 (no tap buffer)
Rdivrefna vrefn taprefn 546940.47299296
Rdivrefnb taprefn 0 1002.07921805393

* h1 input 1 w=+0.683760795348816 w+  bank=n alpha=1 R=48749.9920441162 G_phys=2.05128238604645e-05 G_eff=2.05128238604645e-05
Rh1p1n1 in1n h1p 48812.6080709918
* h1 input 2 w=+0.309366783045794 w+  bank=n alpha=1 R=107746.969487669 G_phys=9.28100349137382e-06 G_eff=9.28100349137382e-06
Rh1p2n1 in2n h1p 108258.112377036
* h1 bias w-  bank=f alpha=0.001 R=1253.18954325804 G_phys=0.000797963887729386 G_eff=7.97963887729385e-07
Rh1bnf1 tapref h1p 1257.68311133434
* replica dummy G_tot for h1: same R as weights/biases, dest=0
Rh1dmy000 0 h1rp 48654.6939253381
Rh1dmy001 0 h1rp 108197.558601086
Rh1dmy002 0 h1rp 1247.33339198753
* feedback TIA h1: Rf=33333.3333333333 A=100000 V(h1sig) = -I(h1p)*Rf*A/(A+1)  (uncompensated)
Bh1tia h1drv 0 V = -(100100) * (v(h1p) - (0.001))
Rh1ro h1drv h1sig 100.278390628682
Rh1f h1sig h1p 33336.8418907088
Bh1leak 0 h1p I = 1e-08
* feedback TIA h1r: Rf=33333.3333333333 A=100000 V(h1rep) = -I(h1rp)*Rf*A/(A+1)  (uncompensated)
Bh1rtia h1rdrv 0 V = -(100100) * (v(h1rp) - (0.001))
Rh1rro h1rdrv h1rep 99.758465071404
Rh1rf h1rep h1rp 33264.0068771024
Bh1rleak 0 h1rp I = 1e-08
* replica null h1: v(h1lin)=v(h1sig)-v(h1rep) Vos_sig=0.001 Vos_rep=0.001
Eh1null h1lin 0 h1sig h1rep 1
* direct bounded ReLU: y=max(0, min(15, v(h1lin)))
Bh1relu h1y 0 V = max(0, min(15, v(h1lin)))

* h2 input 1 w=-0.884821731731664 w-  bank=n alpha=1 R=37672.3718890781 G_phys=2.65446519519499e-05 G_eff=2.65446519519499e-05
Rh2n1n1 in1 h2p 37635.7707183036
* h2 input 2 w=+0.782653240240456 w+  bank=n alpha=1 R=42590.1684417639 G_phys=2.34795972072137e-05 G_eff=2.34795972072137e-05
Rh2p2n1 in2n h2p 42582.4504319263
* h2 bias w+  bank=f alpha=0.001 R=560963.988396833 G_phys=1.78264562553806e-06 G_eff=1.78264562553806e-09
Rh2bpf1 taprefn h2p 559768.238860213
* replica dummy G_tot for h2: same R as weights/biases, dest=0
Rh2dmy000 0 h2rp 37679.9193035032
Rh2dmy001 0 h2rp 42763.0941492987
Rh2dmy002 0 h2rp 558372.810691495
* feedback TIA h2: Rf=33333.3333333333 A=100000 V(h2sig) = -I(h2p)*Rf*A/(A+1)  (uncompensated)
Bh2tia h2drv 0 V = -(100100) * (v(h2p) - (0.001))
Rh2ro h2drv h2sig 100.06031051114
Rh2f h2sig h2p 33336.6995402186
Bh2leak 0 h2p I = 1e-08
* feedback TIA h2r: Rf=33333.3333333333 A=100000 V(h2rep) = -I(h2rp)*Rf*A/(A+1)  (uncompensated)
Bh2rtia h2rdrv 0 V = -(100100) * (v(h2rp) - (0.001))
Rh2rro h2rdrv h2rep 99.9602430851589
Rh2rf h2rep h2rp 33452.8916386796
Bh2rleak 0 h2rp I = 1e-08
* replica null h2: v(h2lin)=v(h2sig)-v(h2rep) Vos_sig=0.001 Vos_rep=0.001
Eh2null h2lin 0 h2sig h2rep 1
* direct bounded ReLU: y=max(0, min(15, v(h2lin)))
Bh2relu h2y 0 V = max(0, min(15, v(h2lin)))

* h3 input 1 w=+0.80723931339229 w+  bank=n alpha=1 R=41293.0004526854 G_phys=2.42171794017687e-05 G_eff=2.42171794017687e-05
Rh3p1n1 in1n h3p 41103.5230407111
* h3 input 2 w=+1.71882311343666 w+  bank=n alpha=1 R=19393.1144355429 G_phys=5.15646934030999e-05 G_eff=5.15646934030999e-05
Rh3p2n1 in2n h3p 19455.3245317821
* h3 bias w+  bank=f alpha=0.001 R=1918.09451080035 G_phys=0.000521350743860236 G_eff=5.21350743860236e-07
Rh3bpf1 taprefn h3p 1926.42274953335
* replica dummy G_tot for h3: same R as weights/biases, dest=0
Rh3dmy000 0 h3rp 41098.5464390155
Rh3dmy001 0 h3rp 19380.2325057762
Rh3dmy002 0 h3rp 1913.57207265734
* feedback TIA h3: Rf=33333.3333333333 A=100000 V(h3sig) = -I(h3p)*Rf*A/(A+1)  (uncompensated)
Bh3tia h3drv 0 V = -(100100) * (v(h3p) - (0.001))
Rh3ro h3drv h3sig 99.8730756699427
Rh3f h3sig h3p 33457.8401651976
Bh3leak 0 h3p I = 1e-08
* feedback TIA h3r: Rf=33333.3333333333 A=100000 V(h3rep) = -I(h3rp)*Rf*A/(A+1)  (uncompensated)
Bh3rtia h3rdrv 0 V = -(100100) * (v(h3rp) - (0.001))
Rh3rro h3rdrv h3rep 100.026288883511
Rh3rf h3rep h3rp 33417.365542667
Bh3rleak 0 h3rp I = 1e-08
* replica null h3: v(h3lin)=v(h3sig)-v(h3rep) Vos_sig=0.001 Vos_rep=0.001
Eh3null h3lin 0 h3sig h3rep 1
* direct bounded ReLU: y=max(0, min(15, v(h3lin)))
Bh3relu h3y 0 V = max(0, min(15, v(h3lin)))

* h4 input 1 w=-2.16286246457598 w-  bank=n alpha=1 R=15411.6749813161 G_phys=6.48858739372794e-05 G_eff=6.48858739372794e-05
Rh4n1n1 in1 h4p 15454.8569992458
* h4 input 2 w=+0.726967919426763 w+  bank=n alpha=1 R=45852.5506319697 G_phys=2.18090375828029e-05 G_eff=2.18090375828029e-05
Rh4p2n1 in2n h4p 46016.1865223485
* h4 bias w-  bank=f alpha=0.001 R=1810.10591973139 G_phys=0.000552453858693748 G_eff=5.52453858693748e-07
Rh4bnf1 tapref h4p 1807.11168962735
* replica dummy G_tot for h4: same R as weights/biases, dest=0
Rh4dmy000 0 h4rp 15362.7039360782
Rh4dmy001 0 h4rp 45732.2223493821
Rh4dmy002 0 h4rp 1803.48581339991
* feedback TIA h4: Rf=33333.3333333333 A=100000 V(h4sig) = -I(h4p)*Rf*A/(A+1)  (uncompensated)
Bh4tia h4drv 0 V = -(100100) * (v(h4p) - (0.001))
Rh4ro h4drv h4sig 99.5486715762779
Rh4f h4sig h4p 33387.0645837092
Bh4leak 0 h4p I = 1e-08
* feedback TIA h4r: Rf=33333.3333333333 A=100000 V(h4rep) = -I(h4rp)*Rf*A/(A+1)  (uncompensated)
Bh4rtia h4rdrv 0 V = -(100100) * (v(h4rp) - (0.001))
Rh4rro h4rdrv h4rep 100.434513849096
Rh4rf h4rep h4rp 33314.3818821828
Bh4rleak 0 h4rp I = 1e-08
* replica null h4: v(h4lin)=v(h4sig)-v(h4rep) Vos_sig=0.001 Vos_rep=0.001
Eh4null h4lin 0 h4sig h4rep 1
* direct bounded ReLU: y=max(0, min(15, v(h4lin)))
Bh4relu h4y 0 V = max(0, min(15, v(h4lin)))

* passive invert h1y -> h1yn: R2/R1=1.0000200002 closed-loop -1 at A=100000
Rinvh1ia h1y invh1m 10009.6566117947
Rinvh1ib h1yn invh1m 10005.8653325766
Einvh1amp h1yn 0 0 invh1m 100000
* passive invert h2y -> h2yn: R2/R1=1.0000200002 closed-loop -1 at A=100000
Rinvh2ia h2y invh2m 10037.270804456
Rinvh2ib h2yn invh2m 10008.661910431
Einvh2amp h2yn 0 0 invh2m 100000
* passive invert h3y -> h3yn: R2/R1=1.0000200002 closed-loop -1 at A=100000
Rinvh3ia h3y invh3m 10044.9954091314
Rinvh3ib h3yn invh3m 10030.7524766697
Einvh3amp h3yn 0 0 invh3m 100000
* passive invert h4y -> h4yn: R2/R1=1.0000200002 closed-loop -1 at A=100000
Rinvh4ia h4y invh4m 10005.5183759847
Rinvh4ib h4yn invh4m 10001.3911083099
Einvh4amp h4yn 0 0 invh4m 100000

* o1 input 1 w=+0.601889648539537 w+  bank=n alpha=1 R=55381.137413171 G_phys=1.80566894561861e-05 G_eff=1.80566894561861e-05
Ro1p1n1 h1yn o1p 55401.3729223788
* o1 input 2 w=+0.347315954504283 w+  bank=n alpha=1 R=95974.0918925228 G_phys=1.04194786351285e-05 G_eff=1.04194786351285e-05
Ro1p2n1 h2yn o1p 96045.9924916761
* o1 input 3 w=+0.876922607606196 w+  bank=n alpha=1 R=38011.716249768 G_phys=2.63076782281859e-05 G_eff=2.63076782281859e-05
Ro1p3n1 h3yn o1p 38103.3638926486
* o1 input 4 w=+0.929527796434486 w+  bank=n alpha=1 R=35860.5019249499 G_phys=2.78858338930346e-05 G_eff=2.78858338930346e-05
Ro1p4n1 h4yn o1p 35736.3038129102
* o1 bias w+  bank=f alpha=0.001 R=3220.47143452777 G_phys=0.000310513544470123 G_eff=3.10513544470123e-07
Ro1bpf1 taprefn o1p 3220.07697670765
* replica dummy G_tot for o1: same R as weights/biases, dest=0
Ro1dmy000 0 o1rp 55300.7394470396
Ro1dmy001 0 o1rp 95557.6940184547
Ro1dmy002 0 o1rp 37984.6048777302
Ro1dmy003 0 o1rp 35962.884970634
Ro1dmy004 0 o1rp 3206.01612905892
* feedback TIA o1: Rf=33333.3333333333 A=100000 V(o1sig) = -I(o1p)*Rf*A/(A+1)  (uncompensated)
Bo1tia o1drv 0 V = -(100100) * (v(o1p) - (0.001))
Ro1ro o1drv o1sig 100.426494340125
Ro1f o1sig o1p 33257.6301014353
Bo1leak 0 o1p I = 1e-08
* feedback TIA o1r: Rf=33333.3333333333 A=100000 V(o1rep) = -I(o1rp)*Rf*A/(A+1)  (uncompensated)
Bo1rtia o1rdrv 0 V = -(100100) * (v(o1rp) - (0.001))
Ro1rro o1rdrv o1rep 99.5980348983137
Ro1rf o1rep o1rp 33456.1438992411
Bo1rleak 0 o1rp I = 1e-08
* replica null o1: v(o1lin)=v(o1sig)-v(o1rep) Vos_sig=0.001 Vos_rep=0.001
Eo1null o1lin 0 o1sig o1rep 1
.control
set numdgt=15
alter Vin1 DC 0.438530325337831
alter Vin2 DC -0.0751945435513142
op
print v(o1lin)
alter Vin1 DC -0.944667854826656
alter Vin2 DC 0.124367102094271
op
print v(o1lin)
alter Vin1 DC 0.931122180276346
alter Vin2 DC -0.278361149873851
op
print v(o1lin)
alter Vin1 DC 0.267244225693779
alter Vin2 DC -0.586909307039872
op
print v(o1lin)
alter Vin1 DC -0.938512371132493
alter Vin2 DC -0.200196149286115
op
print v(o1lin)
alter Vin1 DC -0.067756364469129
alter Vin2 DC -0.907363309265805
op
print v(o1lin)
alter Vin1 DC -0.951703729248973
alter Vin2 DC -0.413678500945367
op
print v(o1lin)
alter Vin1 DC 0.38893484927485
alter Vin2 DC 0.727755436218716
op
print v(o1lin)
.endc

.end
