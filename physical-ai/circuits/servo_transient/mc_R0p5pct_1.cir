* Physical AI - Experiment 17 architecture A: feedback resistor TIA
* Inverting TIA. Vout = I * Rf * A/(A+1). Summing node held by the amplifier, not by a 0 V source. Rf = 1/G_WEIGHT.
* Frozen Experiment 9 network F. Weights were not edited.
* Behavioral circuit analysis. Not transistor-level or PCB power.
* A_tia=100000 A_inv=1e+07 rail=15 vos=0.000214023 rout=0 Ileak=0 clip=False linear=False
* shape: 16 -> 32 -> 16

* Experiment 24 candidate L
* XSPICE limit TIA (programmable Vos)
* source: ngspice built-in analog code model `limit`
* Behavioral. Used as AZ/servo/chopper carrier and feasibility map.
* Weights were not edited. SPICE is not Python-corrected.
* Exp 25 OTA-C servo (LEVEL 2). Finite C. Not an algebraic integrator.
* gm=0.001 C=1e-08 Rleak=1000000000
* tau=C/gm=1e-05 s  DC_gain=gm*R=1000000

.model limtia limit(gain=100000 in_offset=0.0 out_lower_limit=-15 out_upper_limit=15 fraction=false limit_range=0.05)

Vin1 in1 0 DC 0
* passive invert in1 -> in1n: R2/R1=1.0000002 closed-loop -1 at A=1e+07
Rinv1ia in1 inv1m 10037.4669167714
Rinv1ib in1n inv1m 10029.0011213179
Einv1amp in1n 0 0 inv1m 10000000
* load-compensated divider in1->tap1: G_load=0.000710070664287583 Ra=584186.385313021 Rb=1000 target beta=0.001 (no tap buffer)
Rdiv1a in1 tap1 582936.32318486
Rdiv1b tap1 0 997.114030065707
* load-compensated divider in1n->tap1n: G_load=0.00138944868118558 Ra=418088.075239315 Rb=1000 target beta=0.001 (no tap buffer)
Rdiv1na in1n tap1n 418480.552312381
Rdiv1nb tap1n 0 998.37966265946
Vin2 in2 0 DC 0
* passive invert in2 -> in2n: R2/R1=1.0000002 closed-loop -1 at A=1e+07
Rinv2ia in2 inv2m 9975.40003655024
Rinv2ib in2n inv2m 9966.29562554951
Einv2amp in2n 0 0 inv2m 10000000
* load-compensated divider in2->tap2: G_load=0.000564213455228197 Ra=638659.638594056 Rb=1000 target beta=0.001 (no tap buffer)
Rdiv2a in2 tap2 640857.322455665
Rdiv2b tap2 0 997.400538913108
* load-compensated divider in2n->tap2n: G_load=0.000578042323514278 Ra=633062.868539065 Rb=1000 target beta=0.001 (no tap buffer)
Rdiv2na in2n tap2n 633359.367637351
Rdiv2nb tap2n 0 1001.08390274172
Vin3 in3 0 DC 0
* passive invert in3 -> in3n: R2/R1=1.0000002 closed-loop -1 at A=1e+07
Rinv3ia in3 inv3m 9969.63622042812
Rinv3ib in3n inv3m 9982.37434257537
Einv3amp in3n 0 0 inv3m 10000000
* load-compensated divider in3->tap3: G_load=0.000475353763139489 Ra=677125.734152175 Rb=1000 target beta=0.001 (no tap buffer)
Rdiv3a in3 tap3 679949.971238256
Rdiv3b tap3 0 999.599051819025
Vin4 in4 0 DC 0
* passive invert in4 -> in4n: R2/R1=1.0000002 closed-loop -1 at A=1e+07
Rinv4ia in4 inv4m 9958.88708026011
Rinv4ib in4n inv4m 10049.2561694326
Einv4amp in4n 0 0 inv4m 10000000
* load-compensated divider in4->tap4: G_load=0.000604265102392725 Ra=622715.035382877 Rb=1000 target beta=0.001 (no tap buffer)
Rdiv4a in4 tap4 620924.177336035
Rdiv4b tap4 0 999.613725531692
* load-compensated divider in4n->tap4n: G_load=0.000838243797048297 Ra=543453.486204666 Rb=1000 target beta=0.001 (no tap buffer)
Rdiv4na in4n tap4n 543051.338684156
Rdiv4nb tap4n 0 1002.88176172825
Vin5 in5 0 DC 0
* passive invert in5 -> in5n: R2/R1=1.0000002 closed-loop -1 at A=1e+07
Rinv5ia in5 inv5m 9970.40748630872
Rinv5ib in5n inv5m 10020.1500345228
Einv5amp in5n 0 0 inv5m 10000000
* load-compensated divider in5n->tap5n: G_load=0.000124571614130361 Ra=888338.268054662 Rb=1000 target beta=0.001 (no tap buffer)
Rdiv5na in5n tap5n 887961.639357805
Rdiv5nb tap5n 0 1004.54295199178
Vin6 in6 0 DC 0
* passive invert in6 -> in6n: R2/R1=1.0000002 closed-loop -1 at A=1e+07
Rinv6ia in6 inv6m 9958.89470314601
Rinv6ib in6n inv6m 9972.82017495367
Einv6amp in6n 0 0 inv6m 10000000
Vin7 in7 0 DC 0
* passive invert in7 -> in7n: R2/R1=1.0000002 closed-loop -1 at A=1e+07
Rinv7ia in7 inv7m 9956.0928677855
Rinv7ib in7n inv7m 10001.1944748595
Einv7amp in7n 0 0 inv7m 10000000
* load-compensated divider in7->tap7: G_load=0.000876983911873088 Ra=532236.847466142 Rb=1000 target beta=0.001 (no tap buffer)
Rdiv7a in7 tap7 533785.874554317
Rdiv7b tap7 0 1003.47495076411
* load-compensated divider in7n->tap7n: G_load=0.000379458526114055 Ra=724197.198457419 Rb=1000 target beta=0.001 (no tap buffer)
Rdiv7na in7n tap7n 721558.173178709
Rdiv7nb tap7n 0 1001.0808571134
Vin8 in8 0 DC 0
* passive invert in8 -> in8n: R2/R1=1.0000002 closed-loop -1 at A=1e+07
Rinv8ia in8 inv8m 9962.40491175909
Rinv8ib in8n inv8m 10038.181672727
Einv8amp in8n 0 0 inv8m 10000000
* load-compensated divider in8->tap8: G_load=0.00202030909723981 Ra=330760.848587637 Rb=1000 target beta=0.001 (no tap buffer)
Rdiv8a in8 tap8 329764.916718406
Rdiv8b tap8 0 1004.27630992654
Vin9 in9 0 DC 0
* passive invert in9 -> in9n: R2/R1=1.0000002 closed-loop -1 at A=1e+07
Rinv9ia in9 inv9m 9950.2117775705
Rinv9ib in9n inv9m 9971.29884894351
Einv9amp in9n 0 0 inv9m 10000000
* load-compensated divider in9n->tap9n: G_load=0.0021264464173835 Ra=319532.103427525 Rb=1000 target beta=0.001 (no tap buffer)
Rdiv9na in9n tap9n 320234.637665513
Rdiv9nb tap9n 0 1001.1102107947
Vin10 in10 0 DC 0
* passive invert in10 -> in10n: R2/R1=1.0000002 closed-loop -1 at A=1e+07
Rinv10ia in10 inv10m 10009.4557526005
Rinv10ib in10n inv10m 10030.330334145
Einv10amp in10n 0 0 inv10m 10000000
* load-compensated divider in10->tap10: G_load=0.00154386072332109 Ra=392710.178997446 Rb=1000 target beta=0.001 (no tap buffer)
Rdiv10a in10 tap10 394488.385345028
Rdiv10b tap10 0 997.120170721754
* load-compensated divider in10n->tap10n: G_load=0.000661819331650786 Ra=601148.380556888 Rb=1000 target beta=0.001 (no tap buffer)
Rdiv10na in10n tap10n 602777.34961652
Rdiv10nb tap10n 0 995.295961562714
Vin11 in11 0 DC 0
* passive invert in11 -> in11n: R2/R1=1.0000002 closed-loop -1 at A=1e+07
Rinv11ia in11 inv11m 9979.22186885077
Rinv11ib in11n inv11m 9989.83998981305
Einv11amp in11n 0 0 inv11m 10000000
* load-compensated divider in11->tap11: G_load=0.000923704741727117 Ra=519310.462947183 Rb=1000 target beta=0.001 (no tap buffer)
Rdiv11a in11 tap11 516835.207951773
Rdiv11b tap11 0 1003.57742926618
Vin12 in12 0 DC 0
* passive invert in12 -> in12n: R2/R1=1.0000002 closed-loop -1 at A=1e+07
Rinv12ia in12 inv12m 9995.32285294991
Rinv12ib in12n inv12m 10024.8216927117
Einv12amp in12n 0 0 inv12m 10000000
* load-compensated divider in12n->tap12n: G_load=0.000192713812047279 Ra=837585.6721951 Rb=1000 target beta=0.001 (no tap buffer)
Rdiv12na in12n tap12n 833681.701362043
Rdiv12nb tap12n 0 1001.68401810383
Vin13 in13 0 DC 0
* passive invert in13 -> in13n: R2/R1=1.0000002 closed-loop -1 at A=1e+07
Rinv13ia in13 inv13m 10012.3702363964
Rinv13ib in13n inv13m 9975.55221669721
Einv13amp in13n 0 0 inv13m 10000000
* load-compensated divider in13->tap13: G_load=0.00071375434054134 Ra=582930.689870309 Rb=1000 target beta=0.001 (no tap buffer)
Rdiv13a in13 tap13 580202.952241923
Rdiv13b tap13 0 995.166808424308
* load-compensated divider in13n->tap13n: G_load=0.00155701882010588 Ra=390689.341879241 Rb=1000 target beta=0.001 (no tap buffer)
Rdiv13na in13n tap13n 390671.357258051
Rdiv13nb tap13n 0 996.87707482824
Vin14 in14 0 DC 0
* passive invert in14 -> in14n: R2/R1=1.0000002 closed-loop -1 at A=1e+07
Rinv14ia in14 inv14m 10021.0000730265
Rinv14ib in14n inv14m 9972.69717032701
Einv14amp in14n 0 0 inv14m 10000000
* load-compensated divider in14->tap14: G_load=0.000700934410618815 Ra=587324.234117032 Rb=1000 target beta=0.001 (no tap buffer)
Rdiv14a in14 tap14 590102.292861794
Rdiv14b tap14 0 999.877680002437
Vin15 in15 0 DC 0
* passive invert in15 -> in15n: R2/R1=1.0000002 closed-loop -1 at A=1e+07
Rinv15ia in15 inv15m 10046.2809412393
Rinv15ib in15n inv15m 10004.2373212188
Einv15amp in15n 0 0 inv15m 10000000
* load-compensated divider in15->tap15: G_load=0.00161191394702755 Ra=382478.144479797 Rb=1000 target beta=0.001 (no tap buffer)
Rdiv15a in15 tap15 380939.771815753
Rdiv15b tap15 0 1004.86844811419
Vin16 in16 0 DC 0
* passive invert in16 -> in16n: R2/R1=1.0000002 closed-loop -1 at A=1e+07
Rinv16ia in16 inv16m 10038.5989069632
Rinv16ib in16n inv16m 9986.85309759784
Einv16amp in16n 0 0 inv16m 10000000
* load-compensated divider in16n->tap16n: G_load=0.00225822429382311 Ra=306608.726076314 Rb=1000 target beta=0.001 (no tap buffer)
Rdiv16na in16n tap16n 305799.279395826
Rdiv16nb tap16n 0 1001.38351451058
Vref vref 0 DC 1
* passive invert vref -> vrefn: R2/R1=1.0000002 closed-loop -1 at A=1e+07
Rinvrefia vref invrefm 10046.9409868584
Rinvrefib vrefn invrefm 9952.68191604897
Einvrefamp vrefn 0 0 invrefm 10000000
* load-compensated divider vref->tapref: G_load=0.00551473635150906 Ra=153344.655270446 Rb=1000 target beta=0.001 (no tap buffer)
Rdivrefa vref tapref 152721.31499383
Rdivrefb tapref 0 999.612100638221
* load-compensated divider vrefn->taprefn: G_load=0.00666252414777637 Ra=130374.79304909 Rb=1000 target beta=0.001 (no tap buffer)
Rdivrefna vrefn taprefn 130743.258015469
Rdivrefnb taprefn 0 996.246544632854

* h1 input 1 w=-0.0168555731920106 w-  bank=f alpha=0.001 R=1977.58527423636 G_phys=0.000505667195760317 G_eff=5.05667195760317e-07
Rh1n1f1 tap1 h1p 1974.04042070317
* h1 input 2 w=+0.167421682129858 w+  bank=n alpha=1 R=199098.067283059 G_phys=5.02265046389574e-06 G_eff=5.02265046389574e-06
Rh1p2n1 in2n h1p 198322.051997925
* h1 input 3 w=-0.175338604042315 w-  bank=n alpha=1 R=190108.353579049 G_phys=5.26015812126946e-06 G_eff=5.26015812126946e-06
Rh1n3n1 in3 h1p 189800.371593099
* h1 input 4 w=-0.3026243730549 w-  bank=n alpha=1 R=110147.55023478 G_phys=9.078731191647e-06 G_eff=9.078731191647e-06
Rh1n4n1 in4 h1p 110637.487850213
* h1 input 5 w=-0.0731653551060092 w-  bank=n alpha=1 R=455589.032336913 G_phys=2.19496065318027e-06 G_eff=2.19496065318027e-06
Rh1n5n1 in5 h1p 454549.646533314
* h1 input 6 w=+0.135452999280782 w+  bank=n alpha=1 R=246087.820205711 G_phys=4.06358997842346e-06 G_eff=4.06358997842346e-06
Rh1p6n1 in6n h1p 246823.527659983
* h1 input 7 w=+0.21541693193391 w+  bank=n alpha=1 R=154738.687595643 G_phys=6.46250795801731e-06 G_eff=6.46250795801731e-06
Rh1p7n1 in7n h1p 154245.068610555
* h1 input 8 w=-0.0225117532106789 w-  bank=f alpha=0.001 R=1480.70801156087 G_phys=0.000675352596320366 G_eff=6.75352596320366e-07
Rh1n8f1 tap8 h1p 1474.95971137957
* h1 input 9 w=-0.120865686071453 w-  bank=n alpha=1 R=275788.227550601 G_phys=3.62597058214359e-06 G_eff=3.62597058214359e-06
Rh1n9n1 in9 h1p 274782.236320451
* h1 input 10 w=+0.732018397911567 w+  bank=n alpha=1 R=45536.19612353 G_phys=2.1960551937347e-05 G_eff=2.1960551937347e-05
Rh1p10n1 in10n h1p 45740.0499790775
* h1 input 11 w=+0.435334885703784 w+  bank=n alpha=1 R=76569.405365814 G_phys=1.30600465711135e-05 G_eff=1.30600465711135e-05
Rh1p11n1 in11n h1p 76253.6096822906
* h1 input 12 w=+0.385479984810207 w+  bank=n alpha=1 R=86472.2803954274 G_phys=1.15643995443062e-05 G_eff=1.15643995443062e-05
Rh1p12n1 in12n h1p 86265.9737376137
* h1 input 13 w=-0.42800728852471 w-  bank=n alpha=1 R=77880.2936936643 G_phys=1.28402186557413e-05 G_eff=1.28402186557413e-05
Rh1n13n1 in13 h1p 77758.5620680894
* h1 input 14 w=+0.104452911276431 w+  bank=n alpha=1 R=319123.066327159 G_phys=3.13358733829293e-06 G_eff=3.13358733829293e-06
Rh1p14n1 in14n h1p 320333.513073086
* h1 input 15 w=-0.361295245628978 w-  bank=n alpha=1 R=92260.6475911506 G_phys=1.08388573688693e-05 G_eff=1.08388573688693e-05
Rh1n15n1 in15 h1p 92289.3000243874
* h1 input 16 w=+0.0759383856082483 w+  bank=n alpha=1 R=438952.356786904 G_phys=2.27815156824745e-06 G_eff=2.27815156824745e-06
Rh1p16n1 in16n h1p 439870.853748202
* h1 bias w-  bank=n alpha=1 R=365943.245315286 G_phys=2.73266418441043e-06 G_eff=2.73266418441043e-06
Rh1bnn1 vref h1p 366240.88381314
* feedback TIA h1: Rf=33333.3333333333 A=100000 V(h1lin) = -I(h1p)*Rf*A/(A+1)  (uncompensated)
* Exp 24 L TIA h1 -> h1lin, vg=h1p
Vh1os h1osref 0 DC 0.000214023
* servo h1: Vsum>0 discharges C so IN+ falls
Gh1srv h1int 0 h1p 0 0.001
Ch1int h1int 0 1e-08
Rh1int h1int 0 1000000000
Bh1plus h1osp 0 V = v(h1osref) + v(h1int)
Ah1tia %vd(h1osp h1p) h1lin limtia
Rh1f h1lin h1p 33383.4940454327
* direct bounded ReLU: y=max(0, min(15, v(h1lin)))
Bh1relu h1y 0 V = max(0, min(15, v(h1lin)))

* h2 input 1 w=+0.0248542194622879 w+  bank=f alpha=0.001 R=1341.15389879417 G_phys=0.000745626583868636 G_eff=7.45626583868636e-07
Rh2p1f1 tap1n h2p 1338.06841882317
* h2 input 2 w=+0.400223191665755 w+  bank=n alpha=1 R=83286.8610002279 G_phys=1.20066957499727e-05 G_eff=1.20066957499727e-05
Rh2p2n1 in2n h2p 82970.3054056017
* h2 input 3 w=+0.358260577298724 w+  bank=n alpha=1 R=93042.1471004872 G_phys=1.07478173189617e-05 G_eff=1.07478173189617e-05
Rh2p3n1 in3n h2p 93058.6954745218
* h2 input 4 w=+0.348073132477087 w+  bank=n alpha=1 R=95765.315455733 G_phys=1.04421939743126e-05 G_eff=1.04421939743126e-05
Rh2p4n1 in4n h2p 95345.2420360827
* h2 input 5 w=-0.489776715185261 w-  bank=n alpha=1 R=68058.2238800895 G_phys=1.46933014555578e-05 G_eff=1.46933014555578e-05
Rh2n5n1 in5 h2p 68295.326683861
* h2 input 6 w=-0.262585224656684 w-  bank=n alpha=1 R=126942.913017726 G_phys=7.87755673970051e-06 G_eff=7.87755673970051e-06
Rh2n6n1 in6 h2p 126982.41705516
* h2 input 7 w=+0.634452480443638 w+  bank=n alpha=1 R=52538.7390873232 G_phys=1.90335744133091e-05 G_eff=1.90335744133091e-05
Rh2p7n1 in7n h2p 52567.7292345969
* h2 input 8 w=-0.0150494358056585 w-  bank=f alpha=0.001 R=2214.92245714621 G_phys=0.000451483074169756 G_eff=4.51483074169756e-07
Rh2n8f1 tap8 h2p 2205.93287962303
* h2 input 9 w=+0.317089980091076 w+  bank=n alpha=1 R=105122.632142962 G_phys=9.51269940273229e-06 G_eff=9.51269940273229e-06
Rh2p9n1 in9n h2p 105517.818169794
* h2 input 10 w=-0.171694565495531 w-  bank=n alpha=1 R=194143.2056229 G_phys=5.15083696486594e-06 G_eff=5.15083696486594e-06
Rh2n10n1 in10 h2p 193454.009395718
* h2 input 11 w=+0.113535277026032 w+  bank=n alpha=1 R=293594.503897589 G_phys=3.40605831078097e-06 G_eff=3.40605831078097e-06
Rh2p11n1 in11n h2p 292513.541960148
* h2 input 12 w=+0.342235951147447 w+  bank=n alpha=1 R=97398.6900603912 G_phys=1.02670785344234e-05 G_eff=1.02670785344234e-05
Rh2p12n1 in12n h2p 97371.5335665572
* h2 input 13 w=-0.268945400148547 w-  bank=n alpha=1 R=123940.89400645 G_phys=8.0683620044564e-06 G_eff=8.0683620044564e-06
Rh2n13n1 in13 h2p 123525.755291881
* h2 input 14 w=+0.239258603190851 w+  bank=n alpha=1 R=139319.267473714 G_phys=7.17775809572554e-06 G_eff=7.17775809572554e-06
Rh2p14n1 in14n h2p 139087.56748737
* h2 input 15 w=+0.347826837541335 w+  bank=n alpha=1 R=95833.1265320264 G_phys=1.043480512624e-05 G_eff=1.043480512624e-05
Rh2p15n1 in15n h2p 95396.9914720038
* h2 input 16 w=+0.00438097035906581 w+  bank=f alpha=0.001 R=7608.66442849918 G_phys=0.000131429110771974 G_eff=1.31429110771974e-07
Rh2p16f1 tap16n h2p 7634.65474026622
* h2 bias w-  bank=n alpha=1 R=664931.752911819 G_phys=1.50391374095293e-06 G_eff=1.50391374095293e-06
Rh2bnn1 vref h2p 662499.441694338
* feedback TIA h2: Rf=33333.3333333333 A=100000 V(h2lin) = -I(h2p)*Rf*A/(A+1)  (uncompensated)
* Exp 24 L TIA h2 -> h2lin, vg=h2p
Vh2os h2osref 0 DC 0.000214023
* servo h2: Vsum>0 discharges C so IN+ falls
Gh2srv h2int 0 h2p 0 0.001
Ch2int h2int 0 1e-08
Rh2int h2int 0 1000000000
Bh2plus h2osp 0 V = v(h2osref) + v(h2int)
Ah2tia %vd(h2osp h2p) h2lin limtia
Rh2f h2lin h2p 33452.1402366958
* direct bounded ReLU: y=max(0, min(15, v(h2lin)))
Bh2relu h2y 0 V = max(0, min(15, v(h2lin)))

* h3 input 1 w=-0.916033562434709 w-  bank=n alpha=1 R=36388.7686000689 G_phys=2.74810068730413e-05 G_eff=2.74810068730413e-05
Rh3n1n1 in1 h3p 36554.0143938615
* h3 input 2 w=+0.507521982744407 w+  bank=n alpha=1 R=65678.6000738028 G_phys=1.52256594823322e-05 G_eff=1.52256594823322e-05
Rh3p2n1 in2n h3p 65603.1461163505
* h3 input 3 w=+0.0871477019742823 w+  bank=n alpha=1 R=382492.395991924 G_phys=2.61443105922847e-06 G_eff=2.61443105922847e-06
Rh3p3n1 in3n h3p 383363.851145249
* h3 input 4 w=-0.0658557100969535 w-  bank=n alpha=1 R=506157.071030889 G_phys=1.97567130290861e-06 G_eff=1.97567130290861e-06
Rh3n4n1 in4 h3p 503746.749685063
* h3 input 5 w=-0.179053685151098 w-  bank=n alpha=1 R=186163.905563878 G_phys=5.37161055453294e-06 G_eff=5.37161055453294e-06
Rh3n5n1 in5 h3p 186101.714736384
* h3 input 6 w=+0.315007728496672 w+  bank=n alpha=1 R=105817.509597024 G_phys=9.45023185490017e-06 G_eff=9.45023185490017e-06
Rh3p6n1 in6n h3p 105857.48437297
* h3 input 7 w=+0.677608935484657 w+  bank=n alpha=1 R=49192.5823107569 G_phys=2.03282680645397e-05 G_eff=2.03282680645397e-05
Rh3p7n1 in7n h3p 49309.8927112471
* h3 input 8 w=+0.295351776524173 w+  bank=n alpha=1 R=112859.769206789 G_phys=8.8605532957252e-06 G_eff=8.8605532957252e-06
Rh3p8n1 in8n h3p 112984.55594603
* h3 input 9 w=+0.00172302579693755 w+  bank=f alpha=0.001 R=19345.8121129578 G_phys=5.16907739081266e-05 G_eff=5.16907739081266e-08
Rh3p9f1 tap9n h3p 19442.2749288045
* h3 input 10 w=+0.317835264102281 w+  bank=n alpha=1 R=104876.132695604 G_phys=9.53505792306844e-06 G_eff=9.53505792306844e-06
Rh3p10n1 in10n h3p 105094.966553566
* h3 input 11 w=-0.530129158700576 w-  bank=n alpha=1 R=62877.7587240027 G_phys=1.59038747610173e-05 G_eff=1.59038747610173e-05
Rh3n11n1 in11 h3p 63136.7928185516
* h3 input 12 w=-0.291249394999097 w-  bank=n alpha=1 R=114449.450902505 G_phys=8.7374818499729e-06 G_eff=8.7374818499729e-06
Rh3n12n1 in12 h3p 114160.827653475
* h3 input 13 w=-0.395820894073244 w-  bank=n alpha=1 R=84213.1727567804 G_phys=1.18746268221973e-05 G_eff=1.18746268221973e-05
Rh3n13n1 in13 h3p 84157.7339293242
* h3 input 14 w=-0.0451489915790311 w-  bank=n alpha=1 R=738296.297825057 G_phys=1.35446974737093e-06 G_eff=1.35446974737093e-06
Rh3n14n1 in14 h3p 739903.760494853
* h3 input 15 w=+0.0633187763010491 w+  bank=n alpha=1 R=526436.789852823 G_phys=1.89956328903147e-06 G_eff=1.89956328903147e-06
Rh3p15n1 in15n h3p 523996.697355887
* h3 input 16 w=-0.149745176344707 w-  bank=n alpha=1 R=222600.381174225 G_phys=4.49235529034122e-06 G_eff=4.49235529034122e-06
Rh3n16n1 in16 h3p 222608.287022953
* h3 bias w-  bank=n alpha=1 R=602168.780003591 G_phys=1.66066397529616e-06 G_eff=1.66066397529616e-06
Rh3bnn1 vref h3p 601183.456145286
* feedback TIA h3: Rf=33333.3333333333 A=100000 V(h3lin) = -I(h3p)*Rf*A/(A+1)  (uncompensated)
* Exp 24 L TIA h3 -> h3lin, vg=h3p
Vh3os h3osref 0 DC 0.000214023
* servo h3: Vsum>0 discharges C so IN+ falls
Gh3srv h3int 0 h3p 0 0.001
Ch3int h3int 0 1e-08
Rh3int h3int 0 1000000000
Bh3plus h3osp 0 V = v(h3osref) + v(h3int)
Ah3tia %vd(h3osp h3p) h3lin limtia
Rh3f h3lin h3p 33493.226414544
* direct bounded ReLU: y=max(0, min(15, v(h3lin)))
Bh3relu h3y 0 V = max(0, min(15, v(h3lin)))

* h4 input 1 w=+0.0673940677866904 w+  bank=n alpha=1 R=494603.374273786 G_phys=2.02182203360071e-06 G_eff=2.02182203360071e-06
Rh4p1n1 in1n h4p 494602.157804591
* h4 input 2 w=-0.087995350925692 w-  bank=n alpha=1 R=378807.891356463 G_phys=2.63986052777076e-06 G_eff=2.63986052777076e-06
Rh4n2n1 in2 h4p 377535.095853311
* h4 input 3 w=-0.354237391786533 w-  bank=n alpha=1 R=94098.8560389478 G_phys=1.0627121753596e-05 G_eff=1.0627121753596e-05
Rh4n3n1 in3 h4p 94472.6832980565
* h4 input 4 w=-0.0201421700797575 w-  bank=f alpha=0.001 R=1654.90278362969 G_phys=0.000604265102392725 G_eff=6.04265102392725e-07
Rh4n4f1 tap4 h4p 1647.15074060599
* h4 input 5 w=-0.808084436849872 w-  bank=n alpha=1 R=41249.814763511 G_phys=2.42425331054962e-05 G_eff=2.42425331054962e-05
Rh4n5n1 in5 h4p 41181.7109133046
* h4 input 6 w=-0.290030636557288 w-  bank=n alpha=1 R=114930.387110153 G_phys=8.70091909671864e-06 G_eff=8.70091909671864e-06
Rh4n6n1 in6 h4p 114773.811459034
* h4 input 7 w=+0.344262354214072 w+  bank=n alpha=1 R=96825.3801942158 G_phys=1.03278706264222e-05 G_eff=1.03278706264222e-05
Rh4p7n1 in7n h4p 96496.3174403353
* h4 input 8 w=-0.872472737770673 w-  bank=n alpha=1 R=38205.5872811637 G_phys=2.61741821331202e-05 G_eff=2.61741821331202e-05
Rh4n8n1 in8 h4p 38148.1031011362
* h4 input 9 w=+0.163024654235771 w+  bank=n alpha=1 R=204468.051103029 G_phys=4.89073962707314e-06 G_eff=4.89073962707314e-06
Rh4p9n1 in9n h4p 204931.071721974
* h4 input 10 w=-0.143734302026109 w-  bank=n alpha=1 R=231909.383240185 G_phys=4.31202906078326e-06 G_eff=4.31202906078326e-06
Rh4n10n1 in10 h4p 232768.222930305
* h4 input 11 w=-0.110414936368951 w-  bank=n alpha=1 R=301891.523280421 G_phys=3.31244809106853e-06 G_eff=3.31244809106853e-06
Rh4n11n1 in11 h4p 302631.750254466
* h4 input 12 w=+0.321561566587255 w+  bank=n alpha=1 R=103660.812724298 G_phys=9.64684699761765e-06 G_eff=9.64684699761765e-06
Rh4p12n1 in12n h4p 104112.689446633
* h4 input 13 w=-0.501486514423905 w-  bank=n alpha=1 R=66469.0522568205 G_phys=1.50445954327172e-05 G_eff=1.50445954327172e-05
Rh4n13n1 in13 h4p 66218.226250505
* h4 input 14 w=-0.0233644803539605 w-  bank=f alpha=0.001 R=1426.66701028012 G_phys=0.000700934410618815 G_eff=7.00934410618815e-07
Rh4n14f1 tap14 h4p 1433.19255009867
* h4 input 15 w=-0.211065663454959 w-  bank=n alpha=1 R=157928.735483053 G_phys=6.33196990364878e-06 G_eff=6.33196990364878e-06
Rh4n15n1 in15 h4p 157508.661108471
* h4 input 16 w=+0.18002446765288 w+  bank=n alpha=1 R=185160.016124064 G_phys=5.40073402958641e-06 G_eff=5.40073402958641e-06
Rh4p16n1 in16n h4p 184828.636021071
* h4 bias w+  bank=n alpha=1 R=704963.006730694 G_phys=1.41851414961128e-06 G_eff=1.41851414961128e-06
Rh4bpn1 vrefn h4p 706800.288593001
* feedback TIA h4: Rf=33333.3333333333 A=100000 V(h4lin) = -I(h4p)*Rf*A/(A+1)  (uncompensated)
* Exp 24 L TIA h4 -> h4lin, vg=h4p
Vh4os h4osref 0 DC 0.000214023
* servo h4: Vsum>0 discharges C so IN+ falls
Gh4srv h4int 0 h4p 0 0.001
Ch4int h4int 0 1e-08
Rh4int h4int 0 1000000000
Bh4plus h4osp 0 V = v(h4osref) + v(h4int)
Ah4tia %vd(h4osp h4p) h4lin limtia
Rh4f h4lin h4p 33354.7666212045
* direct bounded ReLU: y=max(0, min(15, v(h4lin)))
Bh4relu h4y 0 V = max(0, min(15, v(h4lin)))

* h5 input 1 w=-0.122756848133934 w-  bank=n alpha=1 R=271539.501380525 G_phys=3.68270544401802e-06 G_eff=3.68270544401802e-06
Rh5n1n1 in1 h5p 271421.962866752
* h5 input 2 w=+0.794704720471975 w+  bank=n alpha=1 R=41944.300159104 G_phys=2.38411416141592e-05 G_eff=2.38411416141592e-05
Rh5p2n1 in2n h5p 42084.1218705479
* h5 input 3 w=-0.26372184795707 w-  bank=n alpha=1 R=126395.797661631 G_phys=7.91165543871211e-06 G_eff=7.91165543871211e-06
Rh5n3n1 in3 h5p 127024.09229401
* h5 input 4 w=+0.65217090039031 w+  bank=n alpha=1 R=51111.3472149464 G_phys=1.95651270117093e-05 G_eff=1.95651270117093e-05
Rh5p4n1 in4n h5p 51033.7135912403
* h5 input 5 w=-0.272670344884174 w-  bank=n alpha=1 R=122247.739656077 G_phys=8.18011034652521e-06 G_eff=8.18011034652521e-06
Rh5n5n1 in5 h5p 122658.994530336
* h5 input 6 w=+0.0607101548077554 w+  bank=n alpha=1 R=549056.964833751 G_phys=1.82130464423266e-06 G_eff=1.82130464423266e-06
Rh5p6n1 in6n h5p 548601.607177272
* h5 input 7 w=+0.629980287413506 w+  bank=n alpha=1 R=52911.7085078791 G_phys=1.88994086224052e-05 G_eff=1.88994086224052e-05
Rh5p7n1 in7n h5p 53105.9250625911
* h5 input 8 w=-0.369402487956774 w-  bank=n alpha=1 R=90235.8116690157 G_phys=1.10820746387032e-05 G_eff=1.10820746387032e-05
Rh5n8n1 in8 h5p 90673.9499104931
* h5 input 9 w=-0.0924511829208223 w-  bank=n alpha=1 R=360550.641757401 G_phys=2.77353548762467e-06 G_eff=2.77353548762467e-06
Rh5n9n1 in9 h5p 361574.418740471
* h5 input 10 w=-0.00426485730080124 w-  bank=f alpha=0.001 R=7815.81445340996 G_phys=0.000127945719024037 G_eff=1.27945719024037e-07
Rh5n10f1 tap10 h5p 7793.64166444162
* h5 input 11 w=+0.540478898079688 w+  bank=n alpha=1 R=61673.6998461292 G_phys=1.62143669423906e-05 G_eff=1.62143669423906e-05
Rh5p11n1 in11n h5p 61888.1270752789
* h5 input 12 w=+0.161688921548601 w+  bank=n alpha=1 R=206157.187604928 G_phys=4.85066764645802e-06 G_eff=4.85066764645802e-06
Rh5p12n1 in12n h5p 205663.066424863
* h5 input 13 w=+0.0259557799028364 w+  bank=f alpha=0.001 R=1284.23547503154 G_phys=0.000778673397085092 G_eff=7.78673397085092e-07
Rh5p13f1 tap13n h5p 1290.53537141987
* h5 input 14 w=+0.470073429319239 w+  bank=n alpha=1 R=70910.907220616 G_phys=1.41022028795772e-05 G_eff=1.41022028795772e-05
Rh5p14n1 in14n h5p 71089.1116032386
* h5 input 15 w=+0.188749264833093 w+  bank=n alpha=1 R=176601.129349083 G_phys=5.66247794499279e-06 G_eff=5.66247794499279e-06
Rh5p15n1 in15n h5p 177357.131783269
* h5 input 16 w=+0.031866913791992 w+  bank=f alpha=0.001 R=1046.01699276288 G_phys=0.000956007413759761 G_eff=9.56007413759761e-07
Rh5p16f1 tap16n h5p 1046.79457497805
* h5 bias w+  bank=f alpha=0.001 R=1837.62567566174 G_phys=0.000544180467896375 G_eff=5.44180467896375e-07
Rh5bpf1 taprefn h5p 1846.10244806945
* feedback TIA h5: Rf=33333.3333333333 A=100000 V(h5lin) = -I(h5p)*Rf*A/(A+1)  (uncompensated)
* Exp 24 L TIA h5 -> h5lin, vg=h5p
Vh5os h5osref 0 DC 0.000214023
* servo h5: Vsum>0 discharges C so IN+ falls
Gh5srv h5int 0 h5p 0 0.001
Ch5int h5int 0 1e-08
Rh5int h5int 0 1000000000
Bh5plus h5osp 0 V = v(h5osref) + v(h5int)
Ah5tia %vd(h5osp h5p) h5lin limtia
Rh5f h5lin h5p 33455.3117293323
* direct bounded ReLU: y=max(0, min(15, v(h5lin)))
Bh5relu h5y 0 V = max(0, min(15, v(h5lin)))

* h6 input 1 w=-0.340583473625464 w-  bank=n alpha=1 R=97871.2589266431 G_phys=1.02175042087639e-05 G_eff=1.02175042087639e-05
Rh6n1n1 in1 h6p 97920.3278419644
* h6 input 2 w=-0.593797589144587 w-  bank=n alpha=1 R=56135.8515809279 G_phys=1.78139276743376e-05 G_eff=1.78139276743376e-05
Rh6n2n1 in2 h6p 56265.7544822328
* h6 input 3 w=-0.388639564922933 w-  bank=n alpha=1 R=85769.2740057059 G_phys=1.1659186947688e-05 G_eff=1.1659186947688e-05
Rh6n3n1 in3 h6p 85482.2960518628
* h6 input 4 w=+0.284617429170421 w+  bank=n alpha=1 R=117116.275803947 G_phys=8.53852287511263e-06 G_eff=8.53852287511263e-06
Rh6p4n1 in4n h6p 117186.414590943
* h6 input 5 w=-0.270576674342045 w-  bank=n alpha=1 R=123193.669278364 G_phys=8.11730023026134e-06 G_eff=8.11730023026134e-06
Rh6n5n1 in5 h6p 123474.667501431
* h6 input 6 w=+0.0593082278184784 w+  bank=n alpha=1 R=562035.565037534 G_phys=1.77924683455435e-06 G_eff=1.77924683455435e-06
Rh6p6n1 in6n h6p 559735.982176444
* h6 input 7 w=+0.460681196235491 w+  bank=n alpha=1 R=72356.6179946576 G_phys=1.38204358870647e-05 G_eff=1.38204358870647e-05
Rh6p7n1 in7n h6p 72016.8226155223
* h6 input 8 w=+0.530418434730864 w+  bank=n alpha=1 R=62843.46687582 G_phys=1.59125530419259e-05 G_eff=1.59125530419259e-05
Rh6p8n1 in8n h6p 63043.5322593175
* h6 input 9 w=+0.069052799324409 w+  bank=n alpha=1 R=482722.40458687 G_phys=2.07158397973227e-06 G_eff=2.07158397973227e-06
Rh6p9n1 in9n h6p 481551.112839202
* h6 input 10 w=+0.150678240315211 w+  bank=n alpha=1 R=221221.944612585 G_phys=4.52034720945633e-06 G_eff=4.52034720945633e-06
Rh6p10n1 in10n h6p 220838.374055397
* h6 input 11 w=+0.0896190095447204 w+  bank=n alpha=1 R=371944.897658123 G_phys=2.68857028634161e-06 G_eff=2.68857028634161e-06
Rh6p11n1 in11n h6p 370462.570580211
* h6 input 12 w=-0.177342454994274 w-  bank=n alpha=1 R=187960.256524077 G_phys=5.32027364982823e-06 G_eff=5.32027364982823e-06
Rh6n12n1 in12 h6p 188533.275932108
* h6 input 13 w=+0.643544080066549 w+  bank=n alpha=1 R=51796.5037140678 G_phys=1.93063224019965e-05 G_eff=1.93063224019965e-05
Rh6p13n1 in13n h6p 51730.7295020987
* h6 input 14 w=+0.0993069474158396 w+  bank=n alpha=1 R=335659.63108052 G_phys=2.97920842247519e-06 G_eff=2.97920842247519e-06
Rh6p14n1 in14n h6p 335816.171295893
* h6 input 15 w=-0.324176483950696 w-  bank=n alpha=1 R=102824.649484455 G_phys=9.72529451852089e-06 G_eff=9.72529451852089e-06
Rh6n15n1 in15 h6p 102367.24391144
* h6 input 16 w=+0.0932186969347454 w+  bank=n alpha=1 R=357582.056276406 G_phys=2.79656090804236e-06 G_eff=2.79656090804236e-06
Rh6p16n1 in16n h6p 356185.912760585
* h6 bias w-  bank=f alpha=0.001 R=1678.78030803583 G_phys=0.000595670556304058 G_eff=5.95670556304058e-07
Rh6bnf1 tapref h6p 1674.98269105682
* feedback TIA h6: Rf=33333.3333333333 A=100000 V(h6lin) = -I(h6p)*Rf*A/(A+1)  (uncompensated)
* Exp 24 L TIA h6 -> h6lin, vg=h6p
Vh6os h6osref 0 DC 0.000214023
* servo h6: Vsum>0 discharges C so IN+ falls
Gh6srv h6int 0 h6p 0 0.001
Ch6int h6int 0 1e-08
Rh6int h6int 0 1000000000
Bh6plus h6osp 0 V = v(h6osref) + v(h6int)
Ah6tia %vd(h6osp h6p) h6lin limtia
Rh6f h6lin h6p 33493.3487808546
* direct bounded ReLU: y=max(0, min(15, v(h6lin)))
Bh6relu h6y 0 V = max(0, min(15, v(h6lin)))

* h7 input 1 w=+0.32217720874051 w+  bank=n alpha=1 R=103462.729296227 G_phys=9.6653162622153e-06 G_eff=9.6653162622153e-06
Rh7p1n1 in1n h7p 103396.415263216
* h7 input 2 w=-0.146738476402048 w-  bank=n alpha=1 R=227161.50631143 G_phys=4.40215429206143e-06 G_eff=4.40215429206143e-06
Rh7n2n1 in2 h7p 227404.020032065
* h7 input 3 w=+0.524171111363509 w+  bank=n alpha=1 R=63592.4655340589 G_phys=1.57251333409053e-05 G_eff=1.57251333409053e-05
Rh7p3n1 in3n h7p 63897.4347929272
* h7 input 4 w=-0.439531494343149 w-  bank=n alpha=1 R=75838.3273151968 G_phys=1.31859448302945e-05 G_eff=1.31859448302945e-05
Rh7n4n1 in4 h7p 75784.9103930776
* h7 input 5 w=+0.367500929015048 w+  bank=n alpha=1 R=90702.718555491 G_phys=1.10250278704514e-05 G_eff=1.10250278704514e-05
Rh7p5n1 in5n h7p 90251.7453725646
* h7 input 6 w=-1.05409273633464 w-  bank=n alpha=1 R=31622.7711133294 G_phys=3.16227820900391e-05 G_eff=3.16227820900391e-05
Rh7n6n1 in6 h7p 31713.9393924271
* h7 input 7 w=-0.045065971974084 w-  bank=n alpha=1 R=739656.372051673 G_phys=1.35197915922252e-06 G_eff=1.35197915922252e-06
Rh7n7n1 in7 h7p 742322.523678556
* h7 input 8 w=-0.167915862386558 w-  bank=n alpha=1 R=198512.117077998 G_phys=5.03747587159673e-06 G_eff=5.03747587159673e-06
Rh7n8n1 in8 h7p 198377.181653996
* h7 input 9 w=+0.0197430594045346 w+  bank=f alpha=0.001 R=1688.35703982521 G_phys=0.000592291782136037 G_eff=5.92291782136037e-07
Rh7p9f1 tap9n h7p 1692.64338712837
* h7 input 10 w=-0.287534460104587 w-  bank=n alpha=1 R=115928.133696423 G_phys=8.6260338031376e-06 G_eff=8.6260338031376e-06
Rh7n10n1 in10 h7p 115503.899624455
* h7 input 11 w=-0.517871662481308 w-  bank=n alpha=1 R=64366.0114044885 G_phys=1.55361498744393e-05 G_eff=1.55361498744393e-05
Rh7n11n1 in11 h7p 64234.5928188424
* h7 input 12 w=+0.348150035983652 w+  bank=n alpha=1 R=95744.1616777503 G_phys=1.04445010795096e-05 G_eff=1.04445010795096e-05
Rh7p12n1 in12n h7p 95627.9225000711
* h7 input 13 w=-0.408247593362815 w-  bank=n alpha=1 R=81649.7975132203 G_phys=1.22474278008844e-05 G_eff=1.22474278008844e-05
Rh7n13n1 in13 h7p 81921.3372368709
* h7 input 14 w=-0.41711419269885 w-  bank=n alpha=1 R=79914.1671916195 G_phys=1.25134257809655e-05 G_eff=1.25134257809655e-05
Rh7n14n1 in14 h7p 80147.7120557725
* h7 input 15 w=-0.341449872918214 w-  bank=n alpha=1 R=97622.9191372918 G_phys=1.02434961875464e-05 G_eff=1.02434961875464e-05
Rh7n15n1 in15 h7p 97336.9411973138
* h7 input 16 w=-0.0335582003371702 w-  bank=n alpha=1 R=993299.193592697 G_phys=1.00674601011511e-06 G_eff=1.00674601011511e-06
Rh7n16n1 in16 h7p 990555.928767706
* h7 bias w-  bank=f alpha=0.001 R=1569.92559182808 G_phys=0.000636972863685573 G_eff=6.36972863685573e-07
Rh7bnf1 tapref h7p 1575.19788295765
* feedback TIA h7: Rf=33333.3333333333 A=100000 V(h7lin) = -I(h7p)*Rf*A/(A+1)  (uncompensated)
* Exp 24 L TIA h7 -> h7lin, vg=h7p
Vh7os h7osref 0 DC 0.000214023
* servo h7: Vsum>0 discharges C so IN+ falls
Gh7srv h7int 0 h7p 0 0.001
Ch7int h7int 0 1e-08
Rh7int h7int 0 1000000000
Bh7plus h7osp 0 V = v(h7osref) + v(h7int)
Ah7tia %vd(h7osp h7p) h7lin limtia
Rh7f h7lin h7p 33467.9710959842
* direct bounded ReLU: y=max(0, min(15, v(h7lin)))
Bh7relu h7y 0 V = max(0, min(15, v(h7lin)))

* h8 input 1 w=+0.185544590700454 w+  bank=n alpha=1 R=179651.334525549 G_phys=5.56633772101363e-06 G_eff=5.56633772101363e-06
Rh8p1n1 in1n h8p 179227.066123529
* h8 input 2 w=-0.385658106289114 w-  bank=n alpha=1 R=86432.3419882805 G_phys=1.15697431886734e-05 G_eff=1.15697431886734e-05
Rh8n2n1 in2 h8p 86313.2905576616
* h8 input 3 w=+0.230915543832556 w+  bank=n alpha=1 R=144352.92133259 G_phys=6.92746631497669e-06 G_eff=6.92746631497669e-06
Rh8p3n1 in3n h8p 144829.30262987
* h8 input 4 w=+0.205353187615931 w+  bank=n alpha=1 R=162321.966950307 G_phys=6.16059562847793e-06 G_eff=6.16059562847793e-06
Rh8p4n1 in4n h8p 161783.369838201
* h8 input 5 w=+0.00415238713767869 w+  bank=f alpha=0.001 R=8027.51097817138 G_phys=0.000124571614130361 G_eff=1.24571614130361e-07
Rh8p5f1 tap5n h8p 8052.40442648638
* h8 input 6 w=-0.514726379917983 w-  bank=n alpha=1 R=64759.3257968335 G_phys=1.54417913975395e-05 G_eff=1.54417913975395e-05
Rh8n6n1 in6 h8p 64436.9005786652
* h8 input 7 w=+0.210716479044664 w+  bank=n alpha=1 R=158190.443787113 G_phys=6.32149437133992e-06 G_eff=6.32149437133992e-06
Rh8p7n1 in7n h8p 158808.436684691
* h8 input 8 w=+0.375574589425665 w+  bank=n alpha=1 R=88752.8982839526 G_phys=1.126723768277e-05 G_eff=1.126723768277e-05
Rh8p8n1 in8n h8p 88827.1906755017
* h8 input 9 w=+0.00572491873576676 w+  bank=f alpha=0.001 R=5822.49895096002 G_phys=0.000171747562073003 G_eff=1.71747562073003e-07
Rh8p9f1 tap9n h8p 5823.13075630794
* h8 input 10 w=-0.367556769900021 w-  bank=n alpha=1 R=90688.9385887256 G_phys=1.10267030970006e-05 G_eff=1.10267030970006e-05
Rh8n10n1 in10 h8p 90493.2989380298
* h8 input 11 w=+0.41225604099869 w+  bank=n alpha=1 R=80855.9002618455 G_phys=1.23676812299607e-05 G_eff=1.23676812299607e-05
Rh8p11n1 in11n h8p 80533.658527003
* h8 input 12 w=+0.21126612483399 w+  bank=n alpha=1 R=157778.883668767 G_phys=6.33798374501969e-06 G_eff=6.33798374501969e-06
Rh8p12n1 in12n h8p 157924.003372948
* h8 input 13 w=+0.318427374873886 w+  bank=n alpha=1 R=104681.117151235 G_phys=9.55282124621658e-06 G_eff=9.55282124621658e-06
Rh8p13n1 in13n h8p 104574.586378958
* h8 input 14 w=-0.262828471961964 w-  bank=n alpha=1 R=126825.427566909 G_phys=7.88485415885892e-06 G_eff=7.88485415885892e-06
Rh8n14n1 in14 h8p 127332.715785464
* h8 input 15 w=+0.319620775512722 w+  bank=n alpha=1 R=104290.258603689 G_phys=9.58862326538165e-06 G_eff=9.58862326538165e-06
Rh8p15n1 in15n h8p 104327.897847257
* h8 input 16 w=+0.15331491024055 w+  bank=n alpha=1 R=217417.427183263 G_phys=4.59944730721651e-06 G_eff=4.59944730721651e-06
Rh8p16n1 in16n h8p 217023.885028746
* h8 bias w-  bank=f alpha=0.001 R=1092.27499465772 G_phys=0.00091552036336176 G_eff=9.1552036336176e-07
Rh8bnf1 tapref h8p 1093.66924937256
* feedback TIA h8: Rf=33333.3333333333 A=100000 V(h8lin) = -I(h8p)*Rf*A/(A+1)  (uncompensated)
* Exp 24 L TIA h8 -> h8lin, vg=h8p
Vh8os h8osref 0 DC 0.000214023
* servo h8: Vsum>0 discharges C so IN+ falls
Gh8srv h8int 0 h8p 0 0.001
Ch8int h8int 0 1e-08
Rh8int h8int 0 1000000000
Bh8plus h8osp 0 V = v(h8osref) + v(h8int)
Ah8tia %vd(h8osp h8p) h8lin limtia
Rh8f h8lin h8p 33440.5686418473
* direct bounded ReLU: y=max(0, min(15, v(h8lin)))
Bh8relu h8y 0 V = max(0, min(15, v(h8lin)))

* h9 input 1 w=-0.192368051906404 w-  bank=n alpha=1 R=173278.946285486 G_phys=5.77104155719211e-06 G_eff=5.77104155719211e-06
Rh9n1n1 in1 h9p 173239.828664388
* h9 input 2 w=-0.0188071151742732 w-  bank=f alpha=0.001 R=1772.37885898263 G_phys=0.000564213455228197 G_eff=5.64213455228197e-07
Rh9n2f1 tap2 h9p 1769.35570521077
* h9 input 3 w=+0.675590388456855 w+  bank=n alpha=1 R=49339.5612235861 G_phys=2.02677116537057e-05 G_eff=2.02677116537057e-05
Rh9p3n1 in3n h9p 49415.9491221703
* h9 input 4 w=-0.777819910920126 w-  bank=n alpha=1 R=42854.8213607717 G_phys=2.33345973276038e-05 G_eff=2.33345973276038e-05
Rh9n4n1 in4 h9p 42800.529647785
* h9 input 5 w=-0.0591658911038067 w-  bank=n alpha=1 R=563387.666634648 G_phys=1.7749767331142e-06 G_eff=1.7749767331142e-06
Rh9n5n1 in5 h9p 562579.665124257
* h9 input 6 w=-0.373077376819092 w-  bank=n alpha=1 R=89346.9703725748 G_phys=1.11923213045728e-05 G_eff=1.11923213045728e-05
Rh9n6n1 in6 h9p 89383.3264162599
* h9 input 7 w=+0.173600484730372 w+  bank=n alpha=1 R=192011.752646342 G_phys=5.20801454191117e-06 G_eff=5.20801454191117e-06
Rh9p7n1 in7n h9p 192126.746151063
* h9 input 8 w=+0.21285190098274 w+  bank=n alpha=1 R=156603.409128286 G_phys=6.38555702948219e-06 G_eff=6.38555702948219e-06
Rh9p8n1 in8n h9p 156552.755744529
* h9 input 9 w=+0.47939396555815 w+  bank=n alpha=1 R=69532.2338789223 G_phys=1.43818189667445e-05 G_eff=1.43818189667445e-05
Rh9p9n1 in9n h9p 69836.665489323
* h9 input 10 w=-0.695860852133009 w-  bank=n alpha=1 R=47902.2971778874 G_phys=2.08758255639903e-05 G_eff=2.08758255639903e-05
Rh9n10n1 in10 h9p 47844.5552813161
* h9 input 11 w=+0.426719797848979 w+  bank=n alpha=1 R=78115.2726012736 G_phys=1.28015939354694e-05 G_eff=1.28015939354694e-05
Rh9p11n1 in11n h9p 78444.9783228052
* h9 input 12 w=+0.190883817865507 w+  bank=n alpha=1 R=174626.292087365 G_phys=5.7265145359652e-06 G_eff=5.7265145359652e-06
Rh9p12n1 in12n h9p 174572.586548285
* h9 input 13 w=-0.203891646942192 w-  bank=n alpha=1 R=163485.526912165 G_phys=6.11674940826577e-06 G_eff=6.11674940826577e-06
Rh9n13n1 in13 h9p 163420.779143199
* h9 input 14 w=-0.0564974778722501 w-  bank=n alpha=1 R=589996.838597032 G_phys=1.6949243361675e-06 G_eff=1.6949243361675e-06
Rh9n14n1 in14 h9p 590662.82605932
* h9 input 15 w=-0.251891815788561 w-  bank=n alpha=1 R=132331.942699216 G_phys=7.55675447365683e-06 G_eff=7.55675447365683e-06
Rh9n15n1 in15 h9p 132036.222772152
* h9 input 16 w=-0.340248378281639 w-  bank=n alpha=1 R=97967.6479331866 G_phys=1.02074513484492e-05 G_eff=1.02074513484492e-05
Rh9n16n1 in16 h9p 98306.9516527026
* h9 bias w-  bank=f alpha=0.001 R=1259.76757958347 G_phys=0.000793797218000037 G_eff=7.93797218000037e-07
Rh9bnf1 tapref h9p 1259.90402423212
* feedback TIA h9: Rf=33333.3333333333 A=100000 V(h9lin) = -I(h9p)*Rf*A/(A+1)  (uncompensated)
* Exp 24 L TIA h9 -> h9lin, vg=h9p
Vh9os h9osref 0 DC 0.000214023
* servo h9: Vsum>0 discharges C so IN+ falls
Gh9srv h9int 0 h9p 0 0.001
Ch9int h9int 0 1e-08
Rh9int h9int 0 1000000000
Bh9plus h9osp 0 V = v(h9osref) + v(h9int)
Ah9tia %vd(h9osp h9p) h9lin limtia
Rh9f h9lin h9p 33460.6843859464
* direct bounded ReLU: y=max(0, min(15, v(h9lin)))
Bh9relu h9y 0 V = max(0, min(15, v(h9lin)))

* h10 input 1 w=+0.0856004623316453 w+  bank=n alpha=1 R=389405.996479186 G_phys=2.56801386994936e-06 G_eff=2.56801386994936e-06
Rh10p1n1 in1n h10p 388786.948937543
* h10 input 2 w=+0.717707405140542 w+  bank=n alpha=1 R=46444.1819808254 G_phys=2.15312221542163e-05 G_eff=2.15312221542163e-05
Rh10p2n1 in2n h10p 46282.7129286095
* h10 input 3 w=+0.367326370670395 w+  bank=n alpha=1 R=90745.8216857607 G_phys=1.10197911201119e-05 G_eff=1.10197911201119e-05
Rh10p3n1 in3n h10p 90564.925959685
* h10 input 4 w=+0.5220921972442 w+  bank=n alpha=1 R=63845.6837878046 G_phys=1.5662765917326e-05 G_eff=1.5662765917326e-05
Rh10p4n1 in4n h10p 63632.9809659842
* h10 input 5 w=+0.0909071116243784 w+  bank=n alpha=1 R=366674.649955487 G_phys=2.72721334873135e-06 G_eff=2.72721334873135e-06
Rh10p5n1 in5n h10p 368453.285976191
* h10 input 6 w=-0.0568053629833511 w-  bank=n alpha=1 R=586799.055277631 G_phys=1.70416088950053e-06 G_eff=1.70416088950053e-06
Rh10n6n1 in6 h10p 586551.395721939
* h10 input 7 w=+0.372078007523385 w+  bank=n alpha=1 R=89586.9485950155 G_phys=1.11623402257016e-05 G_eff=1.11623402257016e-05
Rh10p7n1 in7n h10p 89418.2829139056
* h10 input 8 w=+0.384900055079612 w+  bank=n alpha=1 R=86602.568363984 G_phys=1.15470016523884e-05 G_eff=1.15470016523884e-05
Rh10p8n1 in8n h10p 86176.329732222
* h10 input 9 w=+0.617655459577812 w+  bank=n alpha=1 R=53967.5199440765 G_phys=1.85296637873344e-05 G_eff=1.85296637873344e-05
Rh10p9n1 in9n h10p 54048.2126428075
* h10 input 10 w=+0.306521845436409 w+  bank=n alpha=1 R=108747.007202293 G_phys=9.19565536309227e-06 G_eff=9.19565536309227e-06
Rh10p10n1 in10n h10p 108308.406157815
* h10 input 11 w=-0.0307901580575706 w-  bank=f alpha=0.001 R=1082.5970191841 G_phys=0.000923704741727117 G_eff=9.23704741727117e-07
Rh10n11f1 tap11 h10p 1079.23455174846
* h10 input 12 w=+0.163538031424557 w+  bank=n alpha=1 R=203826.186746724 G_phys=4.9061409427367e-06 G_eff=4.9061409427367e-06
Rh10p12n1 in12n h10p 202817.247365148
* h10 input 13 w=-0.0170713095619708 w-  bank=f alpha=0.001 R=1952.59380730749 G_phys=0.000512139286859123 G_eff=5.12139286859123e-07
Rh10n13f1 tap13 h10p 1956.61267080782
* h10 input 14 w=-0.123347220224403 w-  bank=n alpha=1 R=270239.842233093 G_phys=3.7004166067321e-06 G_eff=3.7004166067321e-06
Rh10n14n1 in14 h10p 271069.472573058
* h10 input 15 w=-0.136765368652097 w-  bank=n alpha=1 R=243726.417453869 G_phys=4.10296105956291e-06 G_eff=4.10296105956291e-06
Rh10n15n1 in15 h10p 243097.788361052
* h10 input 16 w=+0.269183781267177 w+  bank=n alpha=1 R=123831.1356517 G_phys=8.07551343801532e-06 G_eff=8.07551343801532e-06
Rh10p16n1 in16n h10p 124177.368491113
* h10 bias w-  bank=n alpha=1 R=519656.094343386 G_phys=1.92434960522027e-06 G_eff=1.92434960522027e-06
Rh10bnn1 vref h10p 517640.144873029
* feedback TIA h10: Rf=33333.3333333333 A=100000 V(h10lin) = -I(h10p)*Rf*A/(A+1)  (uncompensated)
* Exp 24 L TIA h10 -> h10lin, vg=h10p
Vh10os h10osref 0 DC 0.000214023
* servo h10: Vsum>0 discharges C so IN+ falls
Gh10srv h10int 0 h10p 0 0.001
Ch10int h10int 0 1e-08
Rh10int h10int 0 1000000000
Bh10plus h10osp 0 V = v(h10osref) + v(h10int)
Ah10tia %vd(h10osp h10p) h10lin limtia
Rh10f h10lin h10p 33394.5224276517
* direct bounded ReLU: y=max(0, min(15, v(h10lin)))
Bh10relu h10y 0 V = max(0, min(15, v(h10lin)))

* h11 input 1 w=+0.100174494534941 w+  bank=n alpha=1 R=332752.69806035 G_phys=3.00523483604823e-06 G_eff=3.00523483604823e-06
Rh11p1n1 in1n h11p 333835.064405221
* h11 input 2 w=-0.350357054027393 w-  bank=n alpha=1 R=95141.0366943178 G_phys=1.05107116208218e-05 G_eff=1.05107116208218e-05
Rh11n2n1 in2 h11p 94748.04815009
* h11 input 3 w=-0.364058373495884 w-  bank=n alpha=1 R=91560.4083302596 G_phys=1.09217512048765e-05 G_eff=1.09217512048765e-05
Rh11n3n1 in3 h11p 91561.051822683
* h11 input 4 w=+0.201551043415431 w+  bank=n alpha=1 R=165384.077246515 G_phys=6.04653130246294e-06 G_eff=6.04653130246294e-06
Rh11p4n1 in4n h11p 164643.453230171
* h11 input 5 w=+0.30370864041576 w+  bank=n alpha=1 R=109754.313501591 G_phys=9.1112592124728e-06 G_eff=9.1112592124728e-06
Rh11p5n1 in5n h11p 110294.737678481
* h11 input 6 w=+0.221531530750713 w+  bank=n alpha=1 R=150467.670314809 G_phys=6.64594592252139e-06 G_eff=6.64594592252139e-06
Rh11p6n1 in6n h11p 151051.504469242
* h11 input 7 w=-0.554388667333083 w-  bank=n alpha=1 R=60126.2891856812 G_phys=1.66316600199925e-05 G_eff=1.66316600199925e-05
Rh11n7n1 in7 h11p 60129.8566643113
* h11 input 8 w=+0.382929077760783 w+  bank=n alpha=1 R=87048.3211362621 G_phys=1.14878723328235e-05 G_eff=1.14878723328235e-05
Rh11p8n1 in8n h11p 87078.3249327886
* h11 input 9 w=-0.415059943002996 w-  bank=n alpha=1 R=80309.6851316552 G_phys=1.24517982900899e-05 G_eff=1.24517982900899e-05
Rh11n9n1 in9 h11p 80516.994831641
* h11 input 10 w=-0.579957638432045 w-  bank=n alpha=1 R=57475.4622138477 G_phys=1.73987291529614e-05 G_eff=1.73987291529614e-05
Rh11n10n1 in10 h11p 57610.8566657658
* h11 input 11 w=+0.208304459025755 w+  bank=n alpha=1 R=160022.178542092 G_phys=6.24913377077265e-06 G_eff=6.24913377077265e-06
Rh11p11n1 in11n h11p 159808.205781078
* h11 input 12 w=+0.150185585205542 w+  bank=n alpha=1 R=221947.620923232 G_phys=4.50556755616625e-06 G_eff=4.50556755616625e-06
Rh11p12n1 in12n h11p 221338.565178946
* h11 input 13 w=-0.130595100347527 w-  bank=n alpha=1 R=255241.837133476 G_phys=3.9178530104258e-06 G_eff=3.9178530104258e-06
Rh11n13n1 in13 h11p 256427.792170254
* h11 input 14 w=+0.223944918125423 w+  bank=n alpha=1 R=148846.125254178 G_phys=6.71834754376269e-06 G_eff=6.71834754376269e-06
Rh11p14n1 in14n h11p 149133.979523454
* h11 input 15 w=+0.219816736012751 w+  bank=n alpha=1 R=151641.471609331 G_phys=6.59450208038254e-06 G_eff=6.59450208038254e-06
Rh11p15n1 in15n h11p 151225.264190559
* h11 input 16 w=-0.0825561420887272 w-  bank=n alpha=1 R=403765.637419301 G_phys=2.47668426266182e-06 G_eff=2.47668426266182e-06
Rh11n16n1 in16 h11p 404021.144832814
* h11 bias w-  bank=f alpha=0.001 R=2978.62482206369 G_phys=0.000335725396697381 G_eff=3.35725396697381e-07
Rh11bnf1 tapref h11p 2990.25980964905
* feedback TIA h11: Rf=33333.3333333333 A=100000 V(h11lin) = -I(h11p)*Rf*A/(A+1)  (uncompensated)
* Exp 24 L TIA h11 -> h11lin, vg=h11p
Vh11os h11osref 0 DC 0.000214023
* servo h11: Vsum>0 discharges C so IN+ falls
Gh11srv h11int 0 h11p 0 0.001
Ch11int h11int 0 1e-08
Rh11int h11int 0 1000000000
Bh11plus h11osp 0 V = v(h11osref) + v(h11int)
Ah11tia %vd(h11osp h11p) h11lin limtia
Rh11f h11lin h11p 33463.8802026718
* direct bounded ReLU: y=max(0, min(15, v(h11lin)))
Bh11relu h11y 0 V = max(0, min(15, v(h11lin)))

* h12 input 1 w=-0.0647804813106503 w-  bank=n alpha=1 R=514558.284516066 G_phys=1.94341443931951e-06 G_eff=1.94341443931951e-06
Rh12n1n1 in1 h12p 512465.149054937
* h12 input 2 w=-0.668825239918342 w-  bank=n alpha=1 R=49838.6295011879 G_phys=2.00647571975503e-05 G_eff=2.00647571975503e-05
Rh12n2n1 in2 h12p 49773.3059373561
* h12 input 3 w=+0.43152134817872 w+  bank=n alpha=1 R=77246.0817385283 G_phys=1.29456404453616e-05 G_eff=1.29456404453616e-05
Rh12p3n1 in3n h12p 77632.0615801088
* h12 input 4 w=+0.0766102486579458 w+  bank=n alpha=1 R=435102.795216892 G_phys=2.29830745973837e-06 G_eff=2.29830745973837e-06
Rh12p4n1 in4n h12p 436848.348650279
* h12 input 5 w=+0.112143595115044 w+  bank=n alpha=1 R=297237.959057206 G_phys=3.36430785345132e-06 G_eff=3.36430785345132e-06
Rh12p5n1 in5n h12p 298571.694962451
* h12 input 6 w=-0.214387519256146 w-  bank=n alpha=1 R=155481.687781961 G_phys=6.43162557768439e-06 G_eff=6.43162557768439e-06
Rh12n6n1 in6 h12p 155981.457657912
* h12 input 7 w=+0.0362945018752433 w+  bank=n alpha=1 R=918412.751548746 G_phys=1.0888350562573e-06 G_eff=1.0888350562573e-06
Rh12p7n1 in7n h12p 918160.46082557
* h12 input 8 w=-0.654320698371061 w-  bank=n alpha=1 R=50943.4187491196 G_phys=1.96296209511318e-05 G_eff=1.96296209511318e-05
Rh12n8n1 in8 h12p 50944.4490829966
* h12 input 9 w=-0.424313635659581 w-  bank=n alpha=1 R=78558.2421397273 G_phys=1.27294090697874e-05 G_eff=1.27294090697874e-05
Rh12n9n1 in9 h12p 78313.7308630353
* h12 input 10 w=-0.147731830075345 w-  bank=n alpha=1 R=225634.064888609 G_phys=4.43195490226035e-06 G_eff=4.43195490226035e-06
Rh12n10n1 in10 h12p 226454.832948079
* h12 input 11 w=+0.422841356490785 w+  bank=n alpha=1 R=78831.7718256581 G_phys=1.26852406947236e-05 G_eff=1.26852406947236e-05
Rh12p11n1 in11n h12p 78507.6384032318
* h12 input 12 w=+0.250573650346706 w+  bank=n alpha=1 R=133028.086900644 G_phys=7.51720951040119e-06 G_eff=7.51720951040119e-06
Rh12p12n1 in12n h12p 133189.775964372
* h12 input 13 w=+0.0601122436783251 w+  bank=n alpha=1 R=554518.202842467 G_phys=1.80336731034975e-06 G_eff=1.80336731034975e-06
Rh12p13n1 in13n h12p 553454.199356636
* h12 input 14 w=-0.651755086554606 w-  bank=n alpha=1 R=51143.9557910386 G_phys=1.95526525966382e-05 G_eff=1.95526525966382e-05
Rh12n14n1 in14 h12p 51125.5898757969
* h12 input 15 w=+0.130109285988943 w+  bank=n alpha=1 R=256194.88324735 G_phys=3.90327857966829e-06 G_eff=3.90327857966829e-06
Rh12p15n1 in15n h12p 257356.745092322
* h12 input 16 w=-0.0778767908450736 w-  bank=n alpha=1 R=428026.54002071 G_phys=2.33630372535221e-06 G_eff=2.33630372535221e-06
Rh12n16n1 in16 h12p 430094.789570785
* h12 bias w+  bank=f alpha=0.001 R=1892.24272993526 G_phys=0.000528473426891809 G_eff=5.28473426891809e-07
Rh12bpf1 taprefn h12p 1883.71066036415
* feedback TIA h12: Rf=33333.3333333333 A=100000 V(h12lin) = -I(h12p)*Rf*A/(A+1)  (uncompensated)
* Exp 24 L TIA h12 -> h12lin, vg=h12p
Vh12os h12osref 0 DC 0.000214023
* servo h12: Vsum>0 discharges C so IN+ falls
Gh12srv h12int 0 h12p 0 0.001
Ch12int h12int 0 1e-08
Rh12int h12int 0 1000000000
Bh12plus h12osp 0 V = v(h12osref) + v(h12int)
Ah12tia %vd(h12osp h12p) h12lin limtia
Rh12f h12lin h12p 33254.3687453384
* direct bounded ReLU: y=max(0, min(15, v(h12lin)))
Bh12relu h12y 0 V = max(0, min(15, v(h12lin)))

* h13 input 1 w=+0.034343742118514 w+  bank=n alpha=1 R=970579.537264929 G_phys=1.03031226355542e-06 G_eff=1.03031226355542e-06
Rh13p1n1 in1n h13p 966379.675410005
* h13 input 2 w=-0.102232912320493 w-  bank=n alpha=1 R=326052.858876169 G_phys=3.06698736961478e-06 G_eff=3.06698736961478e-06
Rh13n2n1 in2 h13p 324456.325750231
* h13 input 3 w=+1.31993068300228 w+  bank=n alpha=1 R=25253.8514049194 G_phys=3.95979204900683e-05 G_eff=3.95979204900683e-05
Rh13p3n1 in3n h13p 25142.4783745562
* h13 input 4 w=-0.233319639483811 w-  bank=n alpha=1 R=142865.527338714 G_phys=6.99958918451433e-06 G_eff=6.99958918451433e-06
Rh13n4n1 in4 h13p 143203.238437834
* h13 input 5 w=-0.375430599339701 w-  bank=n alpha=1 R=88786.9379639253 G_phys=1.1262917980191e-05 G_eff=1.1262917980191e-05
Rh13n5n1 in5 h13p 88450.3888470359
* h13 input 6 w=+0.442115486842334 w+  bank=n alpha=1 R=75395.0818855177 G_phys=1.326346460527e-05 G_eff=1.326346460527e-05
Rh13p6n1 in6n h13p 75276.2275976978
* h13 input 7 w=-0.102130412545238 w-  bank=n alpha=1 R=326380.090930979 G_phys=3.06391237635715e-06 G_eff=3.06391237635715e-06
Rh13n7n1 in7 h13p 324976.403298132
* h13 input 8 w=-0.136235661297007 w-  bank=n alpha=1 R=244674.067098066 G_phys=4.08706983891021e-06 G_eff=4.08706983891021e-06
Rh13n8n1 in8 h13p 245147.794799543
* h13 input 9 w=+0.0915800560074952 w+  bank=n alpha=1 R=363980.268046628 G_phys=2.74740168022485e-06 G_eff=2.74740168022485e-06
Rh13p9n1 in9n h13p 362191.969330359
* h13 input 10 w=-0.194905587913072 w-  bank=n alpha=1 R=171022.974201232 G_phys=5.84716763739217e-06 G_eff=5.84716763739217e-06
Rh13n10n1 in10 h13p 170968.125984673
* h13 input 11 w=-0.611958537828416 w-  bank=n alpha=1 R=54469.9212002489 G_phys=1.83587561348525e-05 G_eff=1.83587561348525e-05
Rh13n11n1 in11 h13p 54327.45393157
* h13 input 12 w=+0.19411196838682 w+  bank=n alpha=1 R=171722.195237894 G_phys=5.8233590516046e-06 G_eff=5.8233590516046e-06
Rh13p12n1 in12n h13p 171451.492807098
* h13 input 13 w=+0.146421986160596 w+  bank=n alpha=1 R=227652.514539539 G_phys=4.39265958481789e-06 G_eff=4.39265958481789e-06
Rh13p13n1 in13n h13p 228658.846301325
* h13 input 14 w=+0.246088955287688 w+  bank=n alpha=1 R=135452.374505655 G_phys=7.38266865863065e-06 G_eff=7.38266865863065e-06
Rh13p14n1 in14n h13p 136063.448921772
* h13 input 15 w=-0.101801651380703 w-  bank=n alpha=1 R=327434.112131228 G_phys=3.05404954142109e-06 G_eff=3.05404954142109e-06
Rh13n15n1 in15 h13p 328661.638949799
* h13 input 16 w=-0.212672591801914 w-  bank=n alpha=1 R=156735.445084435 G_phys=6.38017775405741e-06 G_eff=6.38017775405741e-06
Rh13n16n1 in16 h13p 156511.349684276
* h13 bias w+  bank=f alpha=0.001 R=1569.64655542844 G_phys=0.000637086098486067 G_eff=6.37086098486067e-07
Rh13bpf1 taprefn h13p 1566.17413200599
* feedback TIA h13: Rf=33333.3333333333 A=100000 V(h13lin) = -I(h13p)*Rf*A/(A+1)  (uncompensated)
* Exp 24 L TIA h13 -> h13lin, vg=h13p
Vh13os h13osref 0 DC 0.000214023
* servo h13: Vsum>0 discharges C so IN+ falls
Gh13srv h13int 0 h13p 0 0.001
Ch13int h13int 0 1e-08
Rh13int h13int 0 1000000000
Bh13plus h13osp 0 V = v(h13osref) + v(h13int)
Ah13tia %vd(h13osp h13p) h13lin limtia
Rh13f h13lin h13p 33339.6162546355
* direct bounded ReLU: y=max(0, min(15, v(h13lin)))
Bh13relu h13y 0 V = max(0, min(15, v(h13lin)))

* h14 input 1 w=-0.089975491938664 w-  bank=n alpha=1 R=370471.254061679 G_phys=2.69926475815992e-06 G_eff=2.69926475815992e-06
Rh14n1n1 in1 h14p 370583.914926961
* h14 input 2 w=-0.0792638889786837 w-  bank=n alpha=1 R=420536.183157725 G_phys=2.37791666936051e-06 G_eff=2.37791666936051e-06
Rh14n2n1 in2 h14p 418470.479952384
* h14 input 3 w=-0.392380373690676 w-  bank=n alpha=1 R=84951.5815987547 G_phys=1.17714112107203e-05 G_eff=1.17714112107203e-05
Rh14n3n1 in3 h14p 84780.6332507739
* h14 input 4 w=+0.471386854681532 w+  bank=n alpha=1 R=70713.3281343902 G_phys=1.4141605640446e-05 G_eff=1.4141605640446e-05
Rh14p4n1 in4n h14p 70405.5124020532
* h14 input 5 w=-0.118903138220599 w-  bank=n alpha=1 R=280340.231823744 G_phys=3.56709414661796e-06 G_eff=3.56709414661796e-06
Rh14n5n1 in5 h14p 280009.534591916
* h14 input 6 w=+0.618408634475196 w+  bank=n alpha=1 R=53901.7915906385 G_phys=1.85522590342559e-05 G_eff=1.85522590342559e-05
Rh14p6n1 in6n h14p 53755.4860937155
* h14 input 7 w=-0.0462466843022721 w-  bank=n alpha=1 R=720772.393442608 G_phys=1.38740052906816e-06 G_eff=1.38740052906816e-06
Rh14n7n1 in7 h14p 717371.35856669
* h14 input 8 w=-0.0297824475583231 w-  bank=f alpha=0.001 R=1119.22746671698 G_phys=0.000893473426749692 G_eff=8.93473426749692e-07
Rh14n8f1 tap8 h14p 1117.55429367315
* h14 input 9 w=+0.0766531636417715 w+  bank=n alpha=1 R=434859.198885937 G_phys=2.29959490925314e-06 G_eff=2.29959490925314e-06
Rh14p9n1 in9n h14p 433896.474956621
* h14 input 10 w=-0.0192124865162136 w-  bank=f alpha=0.001 R=1734.98278347277 G_phys=0.000576374595486407 G_eff=5.76374595486407e-07
Rh14n10f1 tap10 h14p 1732.19851806747
* h14 input 11 w=-0.118584174544602 w-  bank=n alpha=1 R=281094.281436313 G_phys=3.55752523633807e-06 G_eff=3.55752523633807e-06
Rh14n11n1 in11 h14p 280357.559595312
* h14 input 12 w=+0.498792575097448 w+  bank=n alpha=1 R=66828.0463613979 G_phys=1.49637772529234e-05 G_eff=1.49637772529234e-05
Rh14p12n1 in12n h14p 66712.4682221865
* h14 input 13 w=+0.131240430694277 w+  bank=n alpha=1 R=253986.771888785 G_phys=3.93721292082832e-06 G_eff=3.93721292082832e-06
Rh14p13n1 in13n h14p 252826.8344285
* h14 input 14 w=-0.699789872634837 w-  bank=n alpha=1 R=47633.346289833 G_phys=2.09936961790451e-05 G_eff=2.09936961790451e-05
Rh14n14n1 in14 h14p 47776.3143539271
* h14 input 15 w=+0.0882030102342884 w+  bank=n alpha=1 R=377916.051218569 G_phys=2.64609030702865e-06 G_eff=2.64609030702865e-06
Rh14p15n1 in15n h14p 376996.498489845
* h14 input 16 w=-0.409062788225599 w-  bank=n alpha=1 R=81487.082894839 G_phys=1.2271883646768e-05 G_eff=1.2271883646768e-05
Rh14n16n1 in16 h14p 81482.5075770782
* h14 bias w+  bank=n alpha=1 R=404190.380335226 G_phys=2.47408164234543e-06 G_eff=2.47408164234543e-06
Rh14bpn1 vrefn h14p 402863.05777953
* feedback TIA h14: Rf=33333.3333333333 A=100000 V(h14lin) = -I(h14p)*Rf*A/(A+1)  (uncompensated)
* Exp 24 L TIA h14 -> h14lin, vg=h14p
Vh14os h14osref 0 DC 0.000214023
* servo h14: Vsum>0 discharges C so IN+ falls
Gh14srv h14int 0 h14p 0 0.001
Ch14int h14int 0 1e-08
Rh14int h14int 0 1000000000
Bh14plus h14osp 0 V = v(h14osref) + v(h14int)
Ah14tia %vd(h14osp h14p) h14lin limtia
Rh14f h14lin h14p 33360.9743003977
* direct bounded ReLU: y=max(0, min(15, v(h14lin)))
Bh14relu h14y 0 V = max(0, min(15, v(h14lin)))

* h15 input 1 w=-0.104362920527351 w-  bank=n alpha=1 R=319398.241874589 G_phys=3.13088761582053e-06 G_eff=3.13088761582053e-06
Rh15n1n1 in1 h15p 319432.854330935
* h15 input 2 w=+0.0920701784982539 w+  bank=n alpha=1 R=362042.670895501 G_phys=2.76210535494762e-06 G_eff=2.76210535494762e-06
Rh15p2n1 in2n h15p 363296.75103152
* h15 input 3 w=+0.710914651543076 w+  bank=n alpha=1 R=46887.9537944276 G_phys=2.13274395462923e-05 G_eff=2.13274395462923e-05
Rh15p3n1 in3n h15p 46944.776478408
* h15 input 4 w=+0.0431405504557543 w+  bank=n alpha=1 R=772668.243246468 G_phys=1.29421651367263e-06 G_eff=1.29421651367263e-06
Rh15p4n1 in4n h15p 775734.141340206
* h15 input 5 w=-0.544653793286569 w-  bank=n alpha=1 R=61200.9569091444 G_phys=1.63396137985971e-05 G_eff=1.63396137985971e-05
Rh15n5n1 in5 h15p 60959.7933932124
* h15 input 6 w=+0.236607896967987 w+  bank=n alpha=1 R=140880.054133795 G_phys=7.0982369090396e-06 G_eff=7.0982369090396e-06
Rh15p6n1 in6n h15p 140926.726037215
* h15 input 7 w=+0.205722108048513 w+  bank=n alpha=1 R=162030.875774774 G_phys=6.17166324145539e-06 G_eff=6.17166324145539e-06
Rh15p7n1 in7n h15p 162274.726757524
* h15 input 8 w=+0.119910326826568 w+  bank=n alpha=1 R=277985.509801377 G_phys=3.59730980479705e-06 G_eff=3.59730980479705e-06
Rh15p8n1 in8n h15p 277770.730449454
* h15 input 9 w=-0.0351999996705356 w-  bank=n alpha=1 R=946969.705833129 G_phys=1.05599999011607e-06 G_eff=1.05599999011607e-06
Rh15n9n1 in9 h15p 946644.281519786
* h15 input 10 w=-0.0279846802936883 w-  bank=f alpha=0.001 R=1191.12789510236 G_phys=0.000839540408810648 G_eff=8.39540408810648e-07
Rh15n10f1 tap10 h15p 1194.08691808472
* h15 input 11 w=-0.155672537202176 w-  bank=n alpha=1 R=214124.68719542 G_phys=4.67017611606528e-06 G_eff=4.67017611606528e-06
Rh15n11n1 in11 h15p 214048.985355633
* h15 input 12 w=-0.248740189524738 w-  bank=n alpha=1 R=134008.635263254 G_phys=7.46220568574215e-06 G_eff=7.46220568574215e-06
Rh15n12n1 in12 h15p 133553.826667383
* h15 input 13 w=+0.142944744841187 w+  bank=n alpha=1 R=233190.337779587 G_phys=4.28834234523561e-06 G_eff=4.28834234523561e-06
Rh15p13n1 in13n h15p 232522.829208534
* h15 input 14 w=-0.364164748984914 w-  bank=n alpha=1 R=91533.6627892949 G_phys=1.09249424695474e-05 G_eff=1.09249424695474e-05
Rh15n14n1 in14 h15p 91956.4428653165
* h15 input 15 w=-0.240848341925517 w-  bank=n alpha=1 R=138399.679511357 G_phys=7.22545025776552e-06 G_eff=7.22545025776552e-06
Rh15n15n1 in15 h15p 138137.840628362
* h15 input 16 w=-0.736896288827917 w-  bank=n alpha=1 R=45234.7689066968 G_phys=2.21068886648375e-05 G_eff=2.21068886648375e-05
Rh15n16n1 in16 h15p 45239.7879905424
* h15 bias w+  bank=f alpha=0.001 R=23679.3163125671 G_phys=4.22309490189663e-05 G_eff=4.22309490189663e-08
Rh15bpf1 taprefn h15p 23670.1303249326
* feedback TIA h15: Rf=33333.3333333333 A=100000 V(h15lin) = -I(h15p)*Rf*A/(A+1)  (uncompensated)
* Exp 24 L TIA h15 -> h15lin, vg=h15p
Vh15os h15osref 0 DC 0.000214023
* servo h15: Vsum>0 discharges C so IN+ falls
Gh15srv h15int 0 h15p 0 0.001
Ch15int h15int 0 1e-08
Rh15int h15int 0 1000000000
Bh15plus h15osp 0 V = v(h15osref) + v(h15int)
Ah15tia %vd(h15osp h15p) h15lin limtia
Rh15f h15lin h15p 33403.8897313716
* direct bounded ReLU: y=max(0, min(15, v(h15lin)))
Bh15relu h15y 0 V = max(0, min(15, v(h15lin)))

* h16 input 1 w=-0.211528252190937 w-  bank=n alpha=1 R=157583.362922343 G_phys=6.3458475657281e-06 G_eff=6.3458475657281e-06
Rh16n1n1 in1 h16p 157234.973857795
* h16 input 2 w=-0.194947045242045 w-  bank=n alpha=1 R=170986.604551748 G_phys=5.84841135726135e-06 G_eff=5.84841135726135e-06
Rh16n2n1 in2 h16p 171238.403688636
* h16 input 3 w=-0.281660896127353 w-  bank=n alpha=1 R=118345.619827403 G_phys=8.44982688382059e-06 G_eff=8.44982688382059e-06
Rh16n3n1 in3 h16p 118137.513371333
* h16 input 4 w=-0.246854224570453 w-  bank=n alpha=1 R=135032.460519305 G_phys=7.4056267371136e-06 G_eff=7.4056267371136e-06
Rh16n4n1 in4 h16p 134921.838972918
* h16 input 5 w=+0.785179968580328 w+  bank=n alpha=1 R=42453.112238208 G_phys=2.35553990574098e-05 G_eff=2.35553990574098e-05
Rh16p5n1 in5n h16p 42382.8695535013
* h16 input 6 w=-0.342055263707418 w-  bank=n alpha=1 R=97450.1399921314 G_phys=1.02616579112226e-05 G_eff=1.02616579112226e-05
Rh16n6n1 in6 h16p 97845.5114103595
* h16 input 7 w=-0.213390213186068 w-  bank=n alpha=1 R=156208.351056231 G_phys=6.40170639558203e-06 G_eff=6.40170639558203e-06
Rh16n7n1 in7 h16p 155583.239043742
* h16 input 8 w=-0.06183287092446 w-  bank=n alpha=1 R=539087.589415927 G_phys=1.8549861277338e-06 G_eff=1.8549861277338e-06
Rh16n8n1 in8 h16p 537717.726038048
* h16 input 9 w=+0.114369297885863 w+  bank=n alpha=1 R=291453.510247121 G_phys=3.43107893657588e-06 G_eff=3.43107893657588e-06
Rh16p9n1 in9n h16p 291774.712237486
* h16 input 10 w=+0.418702574206734 w+  bank=n alpha=1 R=79611.0064440994 G_phys=1.2561077226202e-05 G_eff=1.2561077226202e-05
Rh16p10n1 in10n h16p 79535.2134080086
* h16 input 11 w=-0.38263995973155 w-  bank=n alpha=1 R=87114.0937729534 G_phys=1.14791987919465e-05 G_eff=1.14791987919465e-05
Rh16n11n1 in11 h16p 87493.7116938378
* h16 input 12 w=-0.447982918675276 w-  bank=n alpha=1 R=74407.5989144918 G_phys=1.34394875602583e-05 G_eff=1.34394875602583e-05
Rh16n12n1 in12 h16p 74598.6491890905
* h16 input 13 w=-0.354860709093241 w-  bank=n alpha=1 R=93933.5702126856 G_phys=1.06458212727972e-05 G_eff=1.06458212727972e-05
Rh16n13n1 in13 h16p 94232.096971425
* h16 input 14 w=-0.245379266072843 w-  bank=n alpha=1 R=135844.131685674 G_phys=7.36137798218528e-06 G_eff=7.36137798218528e-06
Rh16n14n1 in14 h16p 135222.042319226
* h16 input 15 w=-0.0999148922371372 w-  bank=n alpha=1 R=333617.267526249 G_phys=2.99744676711412e-06 G_eff=2.99744676711412e-06
Rh16n15n1 in15 h16p 333580.134300529
* h16 input 16 w=-0.428765175056332 w-  bank=n alpha=1 R=77742.632267077 G_phys=1.286295525169e-05 G_eff=1.286295525169e-05
Rh16n16n1 in16 h16p 77825.4370387593
* h16 bias w+  bank=n alpha=1 R=388758.166916054 G_phys=2.572293227774e-06 G_eff=2.572293227774e-06
Rh16bpn1 vrefn h16p 389331.123641443
* feedback TIA h16: Rf=33333.3333333333 A=100000 V(h16lin) = -I(h16p)*Rf*A/(A+1)  (uncompensated)
* Exp 24 L TIA h16 -> h16lin, vg=h16p
Vh16os h16osref 0 DC 0.000214023
* servo h16: Vsum>0 discharges C so IN+ falls
Gh16srv h16int 0 h16p 0 0.001
Ch16int h16int 0 1e-08
Rh16int h16int 0 1000000000
Bh16plus h16osp 0 V = v(h16osref) + v(h16int)
Ah16tia %vd(h16osp h16p) h16lin limtia
Rh16f h16lin h16p 33332.7188960399
* direct bounded ReLU: y=max(0, min(15, v(h16lin)))
Bh16relu h16y 0 V = max(0, min(15, v(h16lin)))

* h17 input 1 w=+0.690050155404084 w+  bank=n alpha=1 R=48305.667453714 G_phys=2.07015046621225e-05 G_eff=2.07015046621225e-05
Rh17p1n1 in1n h17p 48502.2457812896
* h17 input 2 w=-0.128803090681736 w-  bank=n alpha=1 R=258792.961852894 G_phys=3.86409272045207e-06 G_eff=3.86409272045207e-06
Rh17n2n1 in2 h17p 257857.182430937
* h17 input 3 w=-0.49836012605351 w-  bank=n alpha=1 R=66886.036002315 G_phys=1.49508037816053e-05 G_eff=1.49508037816053e-05
Rh17n3n1 in3 h17p 67188.7659203572
* h17 input 4 w=-0.0597081457071854 w-  bank=n alpha=1 R=558271.119267432 G_phys=1.79124437121556e-06 G_eff=1.79124437121556e-06
Rh17n4n1 in4 h17p 555624.545396562
* h17 input 5 w=+0.0531710366485299 w+  bank=n alpha=1 R=626907.71958562 G_phys=1.5951310994559e-06 G_eff=1.5951310994559e-06
Rh17p5n1 in5n h17p 627897.474114728
* h17 input 6 w=+0.325686197829899 w+  bank=n alpha=1 R=102348.007239603 G_phys=9.77058593489698e-06 G_eff=9.77058593489698e-06
Rh17p6n1 in6n h17p 102098.422618298
* h17 input 7 w=-0.138446110206034 w-  bank=n alpha=1 R=240767.568577601 G_phys=4.15338330618101e-06 G_eff=4.15338330618101e-06
Rh17n7n1 in7 h17p 241896.132861911
* h17 input 8 w=-0.354640771144099 w-  bank=n alpha=1 R=93991.8250961316 G_phys=1.0639223134323e-05 G_eff=1.0639223134323e-05
Rh17n8n1 in8 h17p 93616.533656286
* h17 input 9 w=+0.283153126675736 w+  bank=n alpha=1 R=117721.932738911 G_phys=8.49459380027208e-06 G_eff=8.49459380027208e-06
Rh17p9n1 in9n h17p 117828.3690516
* h17 input 10 w=+0.187509087652136 w+  bank=n alpha=1 R=177769.161754831 G_phys=5.62527262956408e-06 G_eff=5.62527262956408e-06
Rh17p10n1 in10n h17p 178463.509155349
* h17 input 11 w=+0.286891884918939 w+  bank=n alpha=1 R=116187.78740553 G_phys=8.60675654756817e-06 G_eff=8.60675654756817e-06
Rh17p11n1 in11n h17p 115635.782669597
* h17 input 12 w=-0.663420236101193 w-  bank=n alpha=1 R=50244.6737670041 G_phys=1.99026070830358e-05 G_eff=1.99026070830358e-05
Rh17n12n1 in12 h17p 50114.8772068539
* h17 input 13 w=-0.00672050178940724 w-  bank=f alpha=0.001 R=4959.94709589586 G_phys=0.000201615053682217 G_eff=2.01615053682217e-07
Rh17n13f1 tap13 h17p 4984.45701220614
* h17 input 14 w=+0.213870810385993 w+  bank=n alpha=1 R=155857.32935305 G_phys=6.41612431157979e-06 G_eff=6.41612431157979e-06
Rh17p14n1 in14n h17p 156585.13839128
* h17 input 15 w=+0.856655380645102 w+  bank=n alpha=1 R=38911.0184637278 G_phys=2.56996614193531e-05 G_eff=2.56996614193531e-05
Rh17p15n1 in15n h17p 39041.2422303266
* h17 input 16 w=-0.153994690926048 w-  bank=n alpha=1 R=216457.6787218 G_phys=4.61984072778143e-06 G_eff=4.61984072778143e-06
Rh17n16n1 in16 h17p 216947.932416712
* h17 bias w+  bank=n alpha=1 R=358017.249275869 G_phys=2.79316150834244e-06 G_eff=2.79316150834244e-06
Rh17bpn1 vrefn h17p 358423.794812454
* feedback TIA h17: Rf=33333.3333333333 A=100000 V(h17lin) = -I(h17p)*Rf*A/(A+1)  (uncompensated)
* Exp 24 L TIA h17 -> h17lin, vg=h17p
Vh17os h17osref 0 DC 0.000214023
* servo h17: Vsum>0 discharges C so IN+ falls
Gh17srv h17int 0 h17p 0 0.001
Ch17int h17int 0 1e-08
Rh17int h17int 0 1000000000
Bh17plus h17osp 0 V = v(h17osref) + v(h17int)
Ah17tia %vd(h17osp h17p) h17lin limtia
Rh17f h17lin h17p 33391.4737683897
* direct bounded ReLU: y=max(0, min(15, v(h17lin)))
Bh17relu h17y 0 V = max(0, min(15, v(h17lin)))

* h18 input 1 w=+0.00309692999044255 w+  bank=f alpha=0.001 R=10763.3473911917 G_phys=9.29078997132766e-05 G_eff=9.29078997132766e-08
Rh18p1f1 tap1n h18p 10765.8214780762
* h18 input 2 w=-0.290006429631547 w-  bank=n alpha=1 R=114939.98038486 G_phys=8.70019288894641e-06 G_eff=8.70019288894641e-06
Rh18n2n1 in2 h18p 115272.215651248
* h18 input 3 w=+0.161902441115013 w+  bank=n alpha=1 R=205885.304160755 G_phys=4.8570732334504e-06 G_eff=4.8570732334504e-06
Rh18p3n1 in3n h18p 205909.738410585
* h18 input 4 w=-0.201165440039706 w-  bank=n alpha=1 R=165701.093223339 G_phys=6.03496320119118e-06 G_eff=6.03496320119118e-06
Rh18n4n1 in4 h18p 166195.124921205
* h18 input 5 w=+0.167521926893116 w+  bank=n alpha=1 R=198978.927424831 G_phys=5.02565780679349e-06 G_eff=5.02565780679349e-06
Rh18p5n1 in5n h18p 199651.41567052
* h18 input 6 w=+0.306365656745506 w+  bank=n alpha=1 R=108802.447661498 G_phys=9.19096970236517e-06 G_eff=9.19096970236517e-06
Rh18p6n1 in6n h18p 108601.310285625
* h18 input 7 w=+0.567135277617062 w+  bank=n alpha=1 R=58774.9248704654 G_phys=1.70140583285119e-05 G_eff=1.70140583285119e-05
Rh18p7n1 in7n h18p 58499.7323984777
* h18 input 8 w=+0.27754647202065 w+  bank=n alpha=1 R=120100.007363283 G_phys=8.3263941606195e-06 G_eff=8.3263941606195e-06
Rh18p8n1 in8n h18p 120330.43996884
* h18 input 9 w=-0.295299170614896 w-  bank=n alpha=1 R=112879.874548662 G_phys=8.85897511844687e-06 G_eff=8.85897511844687e-06
Rh18n9n1 in9 h18p 113004.237879301
* h18 input 10 w=+0.627786354607437 w+  bank=n alpha=1 R=53096.6197157584 G_phys=1.88335906382231e-05 G_eff=1.88335906382231e-05
Rh18p10n1 in10n h18p 53225.3433350524
* h18 input 11 w=+0.158870042328046 w+  bank=n alpha=1 R=209815.09694889 G_phys=4.76610126984139e-06 G_eff=4.76610126984139e-06
Rh18p11n1 in11n h18p 209514.868357515
* h18 input 12 w=+0.503831351799562 w+  bank=n alpha=1 R=66159.704461175 G_phys=1.51149405539869e-05 G_eff=1.51149405539869e-05
Rh18p12n1 in12n h18p 66443.6823513364
* h18 input 13 w=+0.0259448474340262 w+  bank=f alpha=0.001 R=1284.77661771166 G_phys=0.000778345423020786 G_eff=7.78345423020786e-07
Rh18p13f1 tap13n h18p 1283.76306833703
* h18 input 14 w=-0.0445667146819355 w-  bank=n alpha=1 R=747942.350501428 G_phys=1.33700144045806e-06 G_eff=1.33700144045806e-06
Rh18n14n1 in14 h18p 746638.409259135
* h18 input 15 w=-0.425048584977393 w-  bank=n alpha=1 R=78422.4074880905 G_phys=1.27514575493218e-05 G_eff=1.27514575493218e-05
Rh18n15n1 in15 h18p 78348.9470343205
* h18 input 16 w=-0.290071708244206 w-  bank=n alpha=1 R=114914.113944786 G_phys=8.70215124732617e-06 G_eff=8.70215124732617e-06
Rh18n16n1 in16 h18p 115289.827110826
* h18 bias w+  bank=n alpha=1 R=322935.946819115 G_phys=3.09658930772463e-06 G_eff=3.09658930772463e-06
Rh18bpn1 vrefn h18p 321928.069002135
* feedback TIA h18: Rf=33333.3333333333 A=100000 V(h18lin) = -I(h18p)*Rf*A/(A+1)  (uncompensated)
* Exp 24 L TIA h18 -> h18lin, vg=h18p
Vh18os h18osref 0 DC 0.000214023
* servo h18: Vsum>0 discharges C so IN+ falls
Gh18srv h18int 0 h18p 0 0.001
Ch18int h18int 0 1e-08
Rh18int h18int 0 1000000000
Bh18plus h18osp 0 V = v(h18osref) + v(h18int)
Ah18tia %vd(h18osp h18p) h18lin limtia
Rh18f h18lin h18p 33418.6770933871
* direct bounded ReLU: y=max(0, min(15, v(h18lin)))
Bh18relu h18y 0 V = max(0, min(15, v(h18lin)))

* h19 input 1 w=+0.361917529899694 w+  bank=n alpha=1 R=92102.0138001377 G_phys=1.08575258969908e-05 G_eff=1.08575258969908e-05
Rh19p1n1 in1n h19p 91766.3339786527
* h19 input 2 w=+0.460196491117441 w+  bank=n alpha=1 R=72432.8281000013 G_phys=1.38058947335232e-05 G_eff=1.38058947335232e-05
Rh19p2n1 in2n h19p 72329.9511310171
* h19 input 3 w=+0.284766719035728 w+  bank=n alpha=1 R=117054.877220927 G_phys=8.54300157107185e-06 G_eff=8.54300157107185e-06
Rh19p3n1 in3n h19p 116730.502218216
* h19 input 4 w=-0.664899666016021 w-  bank=n alpha=1 R=50132.8772400529 G_phys=1.99469899804806e-05 G_eff=1.99469899804806e-05
Rh19n4n1 in4 h19p 50110.6020949972
* h19 input 5 w=+0.507213486118456 w+  bank=n alpha=1 R=65718.5470134534 G_phys=1.52164045835537e-05 G_eff=1.52164045835537e-05
Rh19p5n1 in5n h19p 65700.8607437417
* h19 input 6 w=+0.130688397719858 w+  bank=n alpha=1 R=255059.622085094 G_phys=3.92065193159573e-06 G_eff=3.92065193159573e-06
Rh19p6n1 in6n h19p 255137.345449722
* h19 input 7 w=+0.0897047942241856 w+  bank=n alpha=1 R=371589.206815729 G_phys=2.69114382672557e-06 G_eff=2.69114382672557e-06
Rh19p7n1 in7n h19p 370214.947826449
* h19 input 8 w=+0.0897866911799249 w+  bank=n alpha=1 R=371250.269892853 G_phys=2.69360073539775e-06 G_eff=2.69360073539775e-06
Rh19p8n1 in8n h19p 370183.764157699
* h19 input 9 w=-0.272382660879323 w-  bank=n alpha=1 R=122376.854773812 G_phys=8.17147982637969e-06 G_eff=8.17147982637969e-06
Rh19n9n1 in9 h19p 121944.775131097
* h19 input 10 w=+0.0908546616405757 w+  bank=n alpha=1 R=366886.329566679 G_phys=2.72563984921727e-06 G_eff=2.72563984921727e-06
Rh19p10n1 in10n h19p 366947.969871644
* h19 input 11 w=-0.0411180740799587 w-  bank=n alpha=1 R=810673.507434053 G_phys=1.23354222239876e-06 G_eff=1.23354222239876e-06
Rh19n11n1 in11 h19p 807451.423962994
* h19 input 12 w=-0.14910928160707 w-  bank=n alpha=1 R=223549.687679219 G_phys=4.47327844821211e-06 G_eff=4.47327844821211e-06
Rh19n12n1 in12 h19p 223299.966555224
* h19 input 13 w=-0.0351824330179761 w-  bank=n alpha=1 R=947442.529523243 G_phys=1.05547299053928e-06 G_eff=1.05547299053928e-06
Rh19n13n1 in13 h19p 944619.691145885
* h19 input 14 w=+0.491588757414346 w+  bank=n alpha=1 R=67807.3548887889 G_phys=1.47476627224304e-05 G_eff=1.47476627224304e-05
Rh19p14n1 in14n h19p 67528.29140813
* h19 input 15 w=-0.0385925197286318 w-  bank=n alpha=1 R=863725.239184197 G_phys=1.15777559185895e-06 G_eff=1.15777559185895e-06
Rh19n15n1 in15 h19p 865425.258821371
* h19 input 16 w=-0.690622583753164 w-  bank=n alpha=1 R=48265.628894127 G_phys=2.07186775125949e-05 G_eff=2.07186775125949e-05
Rh19n16n1 in16 h19p 48496.8831457548
* h19 bias w+  bank=f alpha=0.001 R=1659.50290630424 G_phys=0.000602590086586248 G_eff=6.02590086586248e-07
Rh19bpf1 taprefn h19p 1653.3984264265
* feedback TIA h19: Rf=33333.3333333333 A=100000 V(h19lin) = -I(h19p)*Rf*A/(A+1)  (uncompensated)
* Exp 24 L TIA h19 -> h19lin, vg=h19p
Vh19os h19osref 0 DC 0.000214023
* servo h19: Vsum>0 discharges C so IN+ falls
Gh19srv h19int 0 h19p 0 0.001
Ch19int h19int 0 1e-08
Rh19int h19int 0 1000000000
Bh19plus h19osp 0 V = v(h19osref) + v(h19int)
Ah19tia %vd(h19osp h19p) h19lin limtia
Rh19f h19lin h19p 33446.9357864693
* direct bounded ReLU: y=max(0, min(15, v(h19lin)))
Bh19relu h19y 0 V = max(0, min(15, v(h19lin)))

* h20 input 1 w=-0.0810043123301717 w-  bank=n alpha=1 R=411500.72600416 G_phys=2.43012936990515e-06 G_eff=2.43012936990515e-06
Rh20n1n1 in1 h20p 411585.206729972
* h20 input 2 w=+0.646296718361532 w+  bank=n alpha=1 R=51575.8975503369 G_phys=1.9388901550846e-05 G_eff=1.9388901550846e-05
Rh20p2n1 in2n h20p 51388.8566919723
* h20 input 3 w=-0.000929252010170944 w-  bank=f alpha=0.001 R=35871.1447147705 G_phys=2.78775603051283e-05 G_eff=2.78775603051283e-08
Rh20n3f1 tap3 h20p 35808.898476398
* h20 input 4 w=+0.269987692172837 w+  bank=n alpha=1 R=123462.418101617 G_phys=8.09963076518511e-06 G_eff=8.09963076518511e-06
Rh20p4n1 in4n h20p 123879.335318693
* h20 input 5 w=+0.140155013181344 w+  bank=n alpha=1 R=237831.901811489 G_phys=4.20465039544031e-06 G_eff=4.20465039544031e-06
Rh20p5n1 in5n h20p 238328.013191522
* h20 input 6 w=+0.15481044132605 w+  bank=n alpha=1 R=215317.087451028 G_phys=4.6443132397815e-06 G_eff=4.6443132397815e-06
Rh20p6n1 in6n h20p 214250.64011627
* h20 input 7 w=-0.803119096824844 w-  bank=n alpha=1 R=41504.8446302892 G_phys=2.40935729047453e-05 G_eff=2.40935729047453e-05
Rh20n7n1 in7 h20p 41325.0673669984
* h20 input 8 w=+0.12095822380885 w+  bank=n alpha=1 R=275577.238849092 G_phys=3.62874671426549e-06 G_eff=3.62874671426549e-06
Rh20p8n1 in8n h20p 275854.680540108
* h20 input 9 w=+0.307944073046154 w+  bank=n alpha=1 R=108244.763419549 G_phys=9.23832219138461e-06 G_eff=9.23832219138461e-06
Rh20p9n1 in9n h20p 108564.870733107
* h20 input 10 w=+0.100067069291622 w+  bank=n alpha=1 R=333109.918870425 G_phys=3.00201207874865e-06 G_eff=3.00201207874865e-06
Rh20p10n1 in10n h20p 331794.254831409
* h20 input 11 w=+0.376050768766317 w+  bank=n alpha=1 R=88640.513733525 G_phys=1.12815230629895e-05 G_eff=1.12815230629895e-05
Rh20p11n1 in11n h20p 88635.6317152178
* h20 input 12 w=-0.859853426992325 w-  bank=n alpha=1 R=38766.2970070722 G_phys=2.57956028097698e-05 G_eff=2.57956028097698e-05
Rh20n12n1 in12 h20p 38840.3069260494
* h20 input 13 w=+0.0677970111280841 w+  bank=n alpha=1 R=491663.758898737 G_phys=2.03391033384252e-06 G_eff=2.03391033384252e-06
Rh20p13n1 in13n h20p 490929.58889409
* h20 input 14 w=-0.43012675419833 w-  bank=n alpha=1 R=77496.5356327578 G_phys=1.29038026259499e-05 G_eff=1.29038026259499e-05
Rh20n14n1 in14 h20p 77394.8708825674
* h20 input 15 w=-0.0800571778528839 w-  bank=n alpha=1 R=416369.078043045 G_phys=2.40171533558652e-06 G_eff=2.40171533558652e-06
Rh20n15n1 in15 h20p 418192.515075002
* h20 input 16 w=-0.127529601563162 w-  bank=n alpha=1 R=261377.224775726 G_phys=3.82588804689485e-06 G_eff=3.82588804689485e-06
Rh20n16n1 in16 h20p 261495.18340776
* h20 bias w+  bank=f alpha=0.001 R=1236.06584989005 G_phys=0.000809018386915995 G_eff=8.09018386915995e-07
Rh20bpf1 taprefn h20p 1240.34496355572
* feedback TIA h20: Rf=33333.3333333333 A=100000 V(h20lin) = -I(h20p)*Rf*A/(A+1)  (uncompensated)
* Exp 24 L TIA h20 -> h20lin, vg=h20p
Vh20os h20osref 0 DC 0.000214023
* servo h20: Vsum>0 discharges C so IN+ falls
Gh20srv h20int 0 h20p 0 0.001
Ch20int h20int 0 1e-08
Rh20int h20int 0 1000000000
Bh20plus h20osp 0 V = v(h20osref) + v(h20int)
Ah20tia %vd(h20osp h20p) h20lin limtia
Rh20f h20lin h20p 33302.0819573705
* direct bounded ReLU: y=max(0, min(15, v(h20lin)))
Bh20relu h20y 0 V = max(0, min(15, v(h20lin)))

* h21 input 1 w=-0.00681344895090886 w-  bank=f alpha=0.001 R=4892.28488736045 G_phys=0.000204403468527266 G_eff=2.04403468527266e-07
Rh21n1f1 tap1 h21p 4886.09117857472
* h21 input 2 w=+0.17215275761211 w+  bank=n alpha=1 R=193626.484964238 G_phys=5.1645827283633e-06 G_eff=5.1645827283633e-06
Rh21p2n1 in2n h21p 193280.299644647
* h21 input 3 w=-0.241244992284912 w-  bank=n alpha=1 R=138172.12542993 G_phys=7.23734976854735e-06 G_eff=7.23734976854735e-06
Rh21n3n1 in3 h21p 137719.29810824
* h21 input 4 w=-0.253516997925259 w-  bank=n alpha=1 R=131483.622818698 G_phys=7.60550993775776e-06 G_eff=7.60550993775776e-06
Rh21n4n1 in4 h21p 131227.529786627
* h21 input 5 w=+0.732528033504134 w+  bank=n alpha=1 R=45504.515607245 G_phys=2.1975841005124e-05 G_eff=2.1975841005124e-05
Rh21p5n1 in5n h21p 45341.212532327
* h21 input 6 w=-0.335745026911547 w-  bank=n alpha=1 R=99281.6889648676 G_phys=1.00723508073464e-05 G_eff=1.00723508073464e-05
Rh21n6n1 in6 h21p 99491.5043389974
* h21 input 7 w=-0.133397447206163 w-  bank=n alpha=1 R=249879.844265815 G_phys=4.00192341618489e-06 G_eff=4.00192341618489e-06
Rh21n7n1 in7 h21p 249995.063313719
* h21 input 8 w=-0.602502751086194 w-  bank=n alpha=1 R=55324.7819586548 G_phys=1.80750825325858e-05 G_eff=1.80750825325858e-05
Rh21n8n1 in8 h21p 55458.838931512
* h21 input 9 w=-0.464313715662176 w-  bank=n alpha=1 R=71790.5420601142 G_phys=1.39294114698653e-05 G_eff=1.39294114698653e-05
Rh21n9n1 in9 h21p 71762.6097272228
* h21 input 10 w=+0.0220606443883595 w+  bank=f alpha=0.001 R=1510.98638582479 G_phys=0.000661819331650786 G_eff=6.61819331650786e-07
Rh21p10f1 tap10n h21p 1515.35262066665
* h21 input 11 w=+0.293613135845564 w+  bank=n alpha=1 R=113528.072364127 G_phys=8.80839407536691e-06 G_eff=8.80839407536691e-06
Rh21p11n1 in11n h21p 113951.690816621
* h21 input 12 w=+0.585788543436 w+  bank=n alpha=1 R=56903.3548143728 G_phys=1.757365630308e-05 G_eff=1.757365630308e-05
Rh21p12n1 in12n h21p 56805.8207138204
* h21 input 13 w=-0.255400978522459 w-  bank=n alpha=1 R=130513.726009089 G_phys=7.66202935567376e-06 G_eff=7.66202935567376e-06
Rh21n13n1 in13 h21p 130303.298271267
* h21 input 14 w=+0.15251581562556 w+  bank=n alpha=1 R=218556.568685111 G_phys=4.57547446876679e-06 G_eff=4.57547446876679e-06
Rh21p14n1 in14n h21p 218779.642313426
* h21 input 15 w=-0.610279514665944 w-  bank=n alpha=1 R=54619.7808254787 G_phys=1.83083854399783e-05 G_eff=1.83083854399783e-05
Rh21n15n1 in15 h21p 54583.7890758179
* h21 input 16 w=+0.0580238118020399 w+  bank=n alpha=1 R=574476.793200985 G_phys=1.7407143540612e-06 G_eff=1.7407143540612e-06
Rh21p16n1 in16n h21p 572756.719382697
* h21 bias w-  bank=f alpha=0.001 R=5534.66769609038 G_phys=0.00018067932076688 G_eff=1.8067932076688e-07
Rh21bnf1 tapref h21p 5525.66704037177
* feedback TIA h21: Rf=33333.3333333333 A=100000 V(h21lin) = -I(h21p)*Rf*A/(A+1)  (uncompensated)
* Exp 24 L TIA h21 -> h21lin, vg=h21p
Vh21os h21osref 0 DC 0.000214023
* servo h21: Vsum>0 discharges C so IN+ falls
Gh21srv h21int 0 h21p 0 0.001
Ch21int h21int 0 1e-08
Rh21int h21int 0 1000000000
Bh21plus h21osp 0 V = v(h21osref) + v(h21int)
Ah21tia %vd(h21osp h21p) h21lin limtia
Rh21f h21lin h21p 33428.049673202
* direct bounded ReLU: y=max(0, min(15, v(h21lin)))
Bh21relu h21y 0 V = max(0, min(15, v(h21lin)))

* h22 input 1 w=+0.733134048211177 w+  bank=n alpha=1 R=45466.901195853 G_phys=2.19940214463353e-05 G_eff=2.19940214463353e-05
Rh22p1n1 in1n h22p 45491.2267529374
* h22 input 2 w=-0.468945077984231 w-  bank=n alpha=1 R=71081.5293693183 G_phys=1.40683523395269e-05 G_eff=1.40683523395269e-05
Rh22n2n1 in2 h22p 70811.0121329143
* h22 input 3 w=+0.0425168801269381 w+  bank=n alpha=1 R=784002.335867861 G_phys=1.27550640380814e-06 G_eff=1.27550640380814e-06
Rh22p3n1 in3n h22p 782974.116436453
* h22 input 4 w=-0.440513463519883 w-  bank=n alpha=1 R=75669.2725506874 G_phys=1.32154039055965e-05 G_eff=1.32154039055965e-05
Rh22n4n1 in4 h22p 75336.428074234
* h22 input 5 w=+0.139436850403416 w+  bank=n alpha=1 R=239056.843559604 G_phys=4.18310551210248e-06 G_eff=4.18310551210248e-06
Rh22p5n1 in5n h22p 238053.654391351
* h22 input 6 w=-0.216633688080034 w-  bank=n alpha=1 R=153869.574158838 G_phys=6.49901064240101e-06 G_eff=6.49901064240101e-06
Rh22n6n1 in6 h22p 153790.141543747
* h22 input 7 w=+0.3413541130964 w+  bank=n alpha=1 R=97650.305224006 G_phys=1.0240623392892e-05 G_eff=1.0240623392892e-05
Rh22p7n1 in7n h22p 97411.4635051192
* h22 input 8 w=+0.375494249585175 w+  bank=n alpha=1 R=88771.88763918 G_phys=1.12648274875552e-05 G_eff=1.12648274875552e-05
Rh22p8n1 in8n h22p 89018.9673643181
* h22 input 9 w=-0.0598723775607 w-  bank=n alpha=1 R=556739.763667131 G_phys=1.796171326821e-06 G_eff=1.796171326821e-06
Rh22n9n1 in9 h22p 554425.60273127
* h22 input 10 w=-0.886177024526985 w-  bank=n alpha=1 R=37614.7568835083 G_phys=2.65853107358095e-05 G_eff=2.65853107358095e-05
Rh22n10n1 in10 h22p 37473.0998554308
* h22 input 11 w=-0.158397755226926 w-  bank=n alpha=1 R=210440.692707917 G_phys=4.75193265680777e-06 G_eff=4.75193265680777e-06
Rh22n11n1 in11 h22p 210057.056747728
* h22 input 12 w=+0.00642379373490928 w+  bank=f alpha=0.001 R=5189.04166430307 G_phys=0.000192713812047279 G_eff=1.92713812047279e-07
Rh22p12f1 tap12n h22p 5201.20678282887
* h22 input 13 w=+0.483338726494796 w+  bank=n alpha=1 R=68964.7477144421 G_phys=1.45001617948439e-05 G_eff=1.45001617948439e-05
Rh22p13n1 in13n h22p 68768.6258484335
* h22 input 14 w=+0.995892890290009 w+  bank=n alpha=1 R=33470.8015875347 G_phys=2.98767867087003e-05 G_eff=2.98767867087003e-05
Rh22p14n1 in14n h22p 33607.0603774633
* h22 input 15 w=-0.0635579626600016 w-  bank=n alpha=1 R=524455.661230796 G_phys=1.90673887980005e-06 G_eff=1.90673887980005e-06
Rh22n15n1 in15 h22p 522508.81836763
* h22 input 16 w=+0.143429643183018 w+  bank=n alpha=1 R=232401.981860887 G_phys=4.30288929549054e-06 G_eff=4.30288929549054e-06
Rh22p16n1 in16n h22p 232144.65221281
* h22 bias w+  bank=f alpha=0.001 R=8748.48537925215 G_phys=0.000114305500512305 G_eff=1.14305500512305e-07
Rh22bpf1 taprefn h22p 8791.0536356574
* feedback TIA h22: Rf=33333.3333333333 A=100000 V(h22lin) = -I(h22p)*Rf*A/(A+1)  (uncompensated)
* Exp 24 L TIA h22 -> h22lin, vg=h22p
Vh22os h22osref 0 DC 0.000214023
* servo h22: Vsum>0 discharges C so IN+ falls
Gh22srv h22int 0 h22p 0 0.001
Ch22int h22int 0 1e-08
Rh22int h22int 0 1000000000
Bh22plus h22osp 0 V = v(h22osref) + v(h22int)
Ah22tia %vd(h22osp h22p) h22lin limtia
Rh22f h22lin h22p 33281.3396423293
* direct bounded ReLU: y=max(0, min(15, v(h22lin)))
Bh22relu h22y 0 V = max(0, min(15, v(h22lin)))

* h23 input 1 w=-0.311855168471888 w-  bank=n alpha=1 R=106887.224273592 G_phys=9.35565505415663e-06 G_eff=9.35565505415663e-06
Rh23n1n1 in1 h23p 106477.263556238
* h23 input 2 w=-0.519305850985266 w-  bank=n alpha=1 R=64188.2491215741 G_phys=1.5579175529558e-05 G_eff=1.5579175529558e-05
Rh23n2n1 in2 h23p 63961.8752373604
* h23 input 3 w=+0.0590711076347425 w+  bank=n alpha=1 R=564291.659121157 G_phys=1.77213322904228e-06 G_eff=1.77213322904228e-06
Rh23p3n1 in3n h23p 562254.519340464
* h23 input 4 w=-0.153433475387477 w-  bank=n alpha=1 R=217249.418675776 G_phys=4.60300426162431e-06 G_eff=4.60300426162431e-06
Rh23n4n1 in4 h23p 216780.266362513
* h23 input 5 w=+0.565735693190981 w+  bank=n alpha=1 R=58920.3292889647 G_phys=1.69720707957294e-05 G_eff=1.69720707957294e-05
Rh23p5n1 in5n h23p 59196.7692525984
* h23 input 6 w=-0.371646754353268 w-  bank=n alpha=1 R=89690.90391046 G_phys=1.1149402630598e-05 G_eff=1.1149402630598e-05
Rh23n6n1 in6 h23p 90126.4660675616
* h23 input 7 w=-0.111660278324499 w-  bank=n alpha=1 R=298524.540987283 G_phys=3.34980834973497e-06 G_eff=3.34980834973497e-06
Rh23n7n1 in7 h23p 299509.681006857
* h23 input 8 w=+0.496809212320021 w+  bank=n alpha=1 R=67094.8374279775 G_phys=1.49042763696006e-05 G_eff=1.49042763696006e-05
Rh23p8n1 in8n h23p 67216.3320863297
* h23 input 9 w=-0.177241184436762 w-  bank=n alpha=1 R=188067.65165365 G_phys=5.31723553310286e-06 G_eff=5.31723553310286e-06
Rh23n9n1 in9 h23p 188475.062146042
* h23 input 10 w=-0.405292848695184 w-  bank=n alpha=1 R=82245.0567303322 G_phys=1.21587854608555e-05 G_eff=1.21587854608555e-05
Rh23n10n1 in10 h23p 82558.3369486528
* h23 input 11 w=-0.16052467280172 w-  bank=n alpha=1 R=207652.398547522 G_phys=4.81574018405159e-06 G_eff=4.81574018405159e-06
Rh23n11n1 in11 h23p 206935.388365692
* h23 input 12 w=+0.846508036935069 w+  bank=n alpha=1 R=39377.4564196963 G_phys=2.53952411080521e-05 G_eff=2.53952411080521e-05
Rh23p12n1 in12n h23p 39257.8360006288
* h23 input 13 w=-0.0538311215013525 w-  bank=n alpha=1 R=619220.488142641 G_phys=1.61493364504058e-06 G_eff=1.61493364504058e-06
Rh23n13n1 in13 h23p 617300.88670896
* h23 input 14 w=+0.31071243911676 w+  bank=n alpha=1 R=107280.331061375 G_phys=9.3213731735028e-06 G_eff=9.3213731735028e-06
Rh23p14n1 in14n h23p 106890.015692708
* h23 input 15 w=+0.331311012578656 w+  bank=n alpha=1 R=100610.399497118 G_phys=9.93933037735967e-06 G_eff=9.93933037735967e-06
Rh23p15n1 in15n h23p 100406.912308205
* h23 input 16 w=-0.486368816876819 w-  bank=n alpha=1 R=68535.0955420638 G_phys=1.45910645063046e-05 G_eff=1.45910645063046e-05
Rh23n16n1 in16 h23p 68842.8820232077
* h23 bias w-  bank=n alpha=1 R=642782.148246781 G_phys=1.55573704516771e-06 G_eff=1.55573704516771e-06
Rh23bnn1 vref h23p 641762.103033591
* feedback TIA h23: Rf=33333.3333333333 A=100000 V(h23lin) = -I(h23p)*Rf*A/(A+1)  (uncompensated)
* Exp 24 L TIA h23 -> h23lin, vg=h23p
Vh23os h23osref 0 DC 0.000214023
* servo h23: Vsum>0 discharges C so IN+ falls
Gh23srv h23int 0 h23p 0 0.001
Ch23int h23int 0 1e-08
Rh23int h23int 0 1000000000
Bh23plus h23osp 0 V = v(h23osref) + v(h23int)
Ah23tia %vd(h23osp h23p) h23lin limtia
Rh23f h23lin h23p 33359.183508765
* direct bounded ReLU: y=max(0, min(15, v(h23lin)))
Bh23relu h23y 0 V = max(0, min(15, v(h23lin)))

* h24 input 1 w=+0.61389120350986 w+  bank=n alpha=1 R=54298.4378058415 G_phys=1.84167361052958e-05 G_eff=1.84167361052958e-05
Rh24p1n1 in1n h24p 54094.2330691351
* h24 input 2 w=-0.0429199313830527 w-  bank=n alpha=1 R=776639.949300928 G_phys=1.28759794149158e-06 G_eff=1.28759794149158e-06
Rh24n2n1 in2 h24p 779997.87560512
* h24 input 3 w=-0.014915873427812 w-  bank=f alpha=0.001 R=2234.75571140073 G_phys=0.000447476202834361 G_eff=4.47476202834361e-07
Rh24n3f1 tap3 h24p 2241.92531286066
* h24 input 4 w=-0.169036355792668 w-  bank=n alpha=1 R=197196.237324345 G_phys=5.07109067378003e-06 G_eff=5.07109067378003e-06
Rh24n4n1 in4 h24p 197024.079453908
* h24 input 5 w=-0.510336523880732 w-  bank=n alpha=1 R=65316.378063357 G_phys=1.5310095716422e-05 G_eff=1.5310095716422e-05
Rh24n5n1 in5 h24p 65459.9066543882
* h24 input 6 w=-0.303361656916169 w-  bank=n alpha=1 R=109879.849919678 G_phys=9.10084970748506e-06 G_eff=9.10084970748506e-06
Rh24n6n1 in6 h24p 110258.345508979
* h24 input 7 w=-0.0292327970624363 w-  bank=f alpha=0.001 R=1140.27177290422 G_phys=0.000876983911873088 G_eff=8.76983911873088e-07
Rh24n7f1 tap7 h24p 1138.31971233698
* h24 input 8 w=-0.329334996951297 w-  bank=n alpha=1 R=101214.063618823 G_phys=9.88004990853891e-06 G_eff=9.88004990853891e-06
Rh24n8n1 in8 h24p 101712.249305423
* h24 input 9 w=+0.0109599477370603 w+  bank=f alpha=0.001 R=3041.37703326988 G_phys=0.000328798432111809 G_eff=3.28798432111809e-07
Rh24p9f1 tap9n h24p 3033.3456691169
* h24 input 10 w=+0.0571459019805778 w+  bank=n alpha=1 R=583302.252271078 G_phys=1.71437705941734e-06 G_eff=1.71437705941734e-06
Rh24p10n1 in10n h24p 580890.915159326
* h24 input 11 w=+0.243568584743939 w+  bank=n alpha=1 R=136853.992760915 G_phys=7.30705754231816e-06 G_eff=7.30705754231816e-06
Rh24p11n1 in11n h24p 136799.650859694
* h24 input 12 w=-0.323004255102081 w-  bank=n alpha=1 R=103197.814910515 G_phys=9.69012765306243e-06 G_eff=9.69012765306243e-06
Rh24n12n1 in12 h24p 102801.88956717
* h24 input 13 w=+0.243938800887145 w+  bank=n alpha=1 R=136646.294939994 G_phys=7.31816402661434e-06 G_eff=7.31816402661434e-06
Rh24p13n1 in13n h24p 136817.122243746
* h24 input 14 w=+0.0840399613598874 w+  bank=n alpha=1 R=396636.704657547 G_phys=2.52119884079662e-06 G_eff=2.52119884079662e-06
Rh24p14n1 in14n h24p 394737.396407071
* h24 input 15 w=-0.352451854106752 w-  bank=n alpha=1 R=94575.5652720646 G_phys=1.05735556232026e-05 G_eff=1.05735556232026e-05
Rh24n15n1 in15 h24p 94444.5359048371
* h24 input 16 w=+0.406056698737055 w+  bank=n alpha=1 R=82090.3421542089 G_phys=1.21817009621116e-05 G_eff=1.21817009621116e-05
Rh24p16n1 in16n h24p 81819.8435909054
* h24 bias w+  bank=f alpha=0.001 R=1792.9894089827 G_phys=0.000557727778530147 G_eff=5.57727778530147e-07
Rh24bpf1 taprefn h24p 1796.26964447561
* feedback TIA h24: Rf=33333.3333333333 A=100000 V(h24lin) = -I(h24p)*Rf*A/(A+1)  (uncompensated)
* Exp 24 L TIA h24 -> h24lin, vg=h24p
Vh24os h24osref 0 DC 0.000214023
* servo h24: Vsum>0 discharges C so IN+ falls
Gh24srv h24int 0 h24p 0 0.001
Ch24int h24int 0 1e-08
Rh24int h24int 0 1000000000
Bh24plus h24osp 0 V = v(h24osref) + v(h24int)
Ah24tia %vd(h24osp h24p) h24lin limtia
Rh24f h24lin h24p 33254.9153272693
* direct bounded ReLU: y=max(0, min(15, v(h24lin)))
Bh24relu h24y 0 V = max(0, min(15, v(h24lin)))

* h25 input 1 w=-0.507226781565224 w-  bank=n alpha=1 R=65716.824396519 G_phys=1.52168034469567e-05 G_eff=1.52168034469567e-05
Rh25n1n1 in1 h25p 65495.7101515998
* h25 input 2 w=-0.323616844242374 w-  bank=n alpha=1 R=103002.467042068 G_phys=9.70850532727122e-06 G_eff=9.70850532727122e-06
Rh25n2n1 in2 h25p 103448.906827095
* h25 input 3 w=+0.251581142719107 w+  bank=n alpha=1 R=132495.35705683 G_phys=7.5474342815732e-06 G_eff=7.5474342815732e-06
Rh25p3n1 in3n h25p 132138.633795383
* h25 input 4 w=+0.0279414599016099 w+  bank=f alpha=0.001 R=1192.97035483149 G_phys=0.000838243797048297 G_eff=8.38243797048297e-07
Rh25p4f1 tap4n h25p 1196.03698872967
* h25 input 5 w=+0.310516223746861 w+  bank=n alpha=1 R=107348.121560654 G_phys=9.31548671240582e-06 G_eff=9.31548671240582e-06
Rh25p5n1 in5n h25p 106990.745985171
* h25 input 6 w=-0.583310440311788 w-  bank=n alpha=1 R=57145.0998125736 G_phys=1.74993132093536e-05 G_eff=1.74993132093536e-05
Rh25n6n1 in6 h25p 57375.2270292701
* h25 input 7 w=-0.128366308561082 w-  bank=n alpha=1 R=259673.536670037 G_phys=3.85098925683245e-06 G_eff=3.85098925683245e-06
Rh25n7n1 in7 h25p 258620.434040913
* h25 input 8 w=-0.237966635841971 w-  bank=n alpha=1 R=140075.658990571 G_phys=7.13899907525912e-06 G_eff=7.13899907525912e-06
Rh25n8n1 in8 h25p 139678.883771295
* h25 input 9 w=+0.869293927250567 w+  bank=n alpha=1 R=38345.2964393311 G_phys=2.6078817817517e-05 G_eff=2.6078817817517e-05
Rh25p9n1 in9n h25p 38165.016564578
* h25 input 10 w=-0.700407093798758 w-  bank=n alpha=1 R=47591.3702594662 G_phys=2.10122128139627e-05 G_eff=2.10122128139627e-05
Rh25n10n1 in10 h25p 47676.7765226794
* h25 input 11 w=+0.176416664646434 w+  bank=n alpha=1 R=188946.624742841 G_phys=5.29249993939301e-06 G_eff=5.29249993939301e-06
Rh25p11n1 in11n h25p 189135.611885106
* h25 input 12 w=+0.165054591787149 w+  bank=n alpha=1 R=201953.383861743 G_phys=4.95163775361447e-06 G_eff=4.95163775361447e-06
Rh25p12n1 in12n h25p 201009.896273799
* h25 input 13 w=+0.414882742059982 w+  bank=n alpha=1 R=80343.9862738715 G_phys=1.24464822617995e-05 G_eff=1.24464822617995e-05
Rh25p13n1 in13n h25p 80011.185179422
* h25 input 14 w=-0.441614461314228 w-  bank=n alpha=1 R=75480.619982721 G_phys=1.32484338394269e-05 G_eff=1.32484338394269e-05
Rh25n14n1 in14 h25p 75801.4431767109
* h25 input 15 w=+0.152726206779301 w+  bank=n alpha=1 R=218255.491550983 G_phys=4.58178620337902e-06 G_eff=4.58178620337902e-06
Rh25p15n1 in15n h25p 218993.950399245
* h25 input 16 w=-0.0538945970745783 w-  bank=n alpha=1 R=618491.187292992 G_phys=1.61683791223735e-06 G_eff=1.61683791223735e-06
Rh25n16n1 in16 h25p 616985.18478754
* h25 bias w+  bank=n alpha=1 R=396065.019631007 G_phys=2.52483796961329e-06 G_eff=2.52483796961329e-06
Rh25bpn1 vrefn h25p 397584.899691316
* feedback TIA h25: Rf=33333.3333333333 A=100000 V(h25lin) = -I(h25p)*Rf*A/(A+1)  (uncompensated)
* Exp 24 L TIA h25 -> h25lin, vg=h25p
Vh25os h25osref 0 DC 0.000214023
* servo h25: Vsum>0 discharges C so IN+ falls
Gh25srv h25int 0 h25p 0 0.001
Ch25int h25int 0 1e-08
Rh25int h25int 0 1000000000
Bh25plus h25osp 0 V = v(h25osref) + v(h25int)
Ah25tia %vd(h25osp h25p) h25lin limtia
Rh25f h25lin h25p 33412.9832144128
* direct bounded ReLU: y=max(0, min(15, v(h25lin)))
Bh25relu h25y 0 V = max(0, min(15, v(h25lin)))

* h26 input 1 w=-0.733410608571861 w-  bank=n alpha=1 R=45449.7561717056 G_phys=2.20023182571558e-05 G_eff=2.20023182571558e-05
Rh26n1n1 in1 h26p 45438.6514045401
* h26 input 2 w=+0.207000343516658 w+  bank=n alpha=1 R=161030.328583251 G_phys=6.21001030549975e-06 G_eff=6.21001030549975e-06
Rh26p2n1 in2n h26p 160350.994142444
* h26 input 3 w=-0.0671817515718929 w-  bank=n alpha=1 R=496166.482019488 G_phys=2.01545254715679e-06 G_eff=2.01545254715679e-06
Rh26n3n1 in3 h26p 495461.731527224
* h26 input 4 w=+0.312724326896377 w+  bank=n alpha=1 R=106590.151345592 G_phys=9.38172980689131e-06 G_eff=9.38172980689131e-06
Rh26p4n1 in4n h26p 106431.455835166
* h26 input 5 w=+0.0982363551813243 w+  bank=n alpha=1 R=339317.692231219 G_phys=2.94709065543973e-06 G_eff=2.94709065543973e-06
Rh26p5n1 in5n h26p 338884.243268785
* h26 input 6 w=+0.0433697195878843 w+  bank=n alpha=1 R=768585.401291025 G_phys=1.30109158763653e-06 G_eff=1.30109158763653e-06
Rh26p6n1 in6n h26p 769308.646951647
* h26 input 7 w=-0.253243820471769 w-  bank=n alpha=1 R=131625.45593901 G_phys=7.59731461415306e-06 G_eff=7.59731461415306e-06
Rh26n7n1 in7 h26p 131772.993078411
* h26 input 8 w=+0.388367135047654 w+  bank=n alpha=1 R=85829.4390158508 G_phys=1.16510140514296e-05 G_eff=1.16510140514296e-05
Rh26p8n1 in8n h26p 85433.8703524493
* h26 input 9 w=+0.190562655499984 w+  bank=n alpha=1 R=174920.596304013 G_phys=5.71687966499952e-06 G_eff=5.71687966499952e-06
Rh26p9n1 in9n h26p 174515.962964334
* h26 input 10 w=-0.282938574156096 w-  bank=n alpha=1 R=117811.201363245 G_phys=8.48815722468287e-06 G_eff=8.48815722468287e-06
Rh26n10n1 in10 h26p 118028.576209385
* h26 input 11 w=+0.123317846030254 w+  bank=n alpha=1 R=270304.21310761 G_phys=3.69953538090763e-06 G_eff=3.69953538090763e-06
Rh26p11n1 in11n h26p 269649.861992717
* h26 input 12 w=-0.494646699470857 w-  bank=n alpha=1 R=67388.1648639146 G_phys=1.48394009841257e-05 G_eff=1.48394009841257e-05
Rh26n12n1 in12 h26p 67303.2261006616
* h26 input 13 w=-0.136127092468903 w-  bank=n alpha=1 R=244869.208096457 G_phys=4.08381277406708e-06 G_eff=4.08381277406708e-06
Rh26n13n1 in13 h26p 244950.504251854
* h26 input 14 w=+0.481522107274068 w+  bank=n alpha=1 R=69224.928263493 G_phys=1.4445663218222e-05 G_eff=1.4445663218222e-05
Rh26p14n1 in14n h26p 69559.7022574844
* h26 input 15 w=+0.0644124429905188 w+  bank=n alpha=1 R=517498.355686336 G_phys=1.93237328971556e-06 G_eff=1.93237328971556e-06
Rh26p15n1 in15n h26p 518650.268029103
* h26 input 16 w=+0.0297993400818282 w+  bank=f alpha=0.001 R=1118.5930037981 G_phys=0.000893980202454845 G_eff=8.93980202454845e-07
Rh26p16f1 tap16n h26p 1113.48014192807
* h26 bias w-  bank=f alpha=0.001 R=2150.60895252505 G_phys=0.000464984579751652 G_eff=4.64984579751652e-07
Rh26bnf1 tapref h26p 2153.89647656599
* feedback TIA h26: Rf=33333.3333333333 A=100000 V(h26lin) = -I(h26p)*Rf*A/(A+1)  (uncompensated)
* Exp 24 L TIA h26 -> h26lin, vg=h26p
Vh26os h26osref 0 DC 0.000214023
* servo h26: Vsum>0 discharges C so IN+ falls
Gh26srv h26int 0 h26p 0 0.001
Ch26int h26int 0 1e-08
Rh26int h26int 0 1000000000
Bh26plus h26osp 0 V = v(h26osref) + v(h26int)
Ah26tia %vd(h26osp h26p) h26lin limtia
Rh26f h26lin h26p 33290.510472982
* direct bounded ReLU: y=max(0, min(15, v(h26lin)))
Bh26relu h26y 0 V = max(0, min(15, v(h26lin)))

* h27 input 1 w=-0.473232380174693 w-  bank=n alpha=1 R=70437.5582267393 G_phys=1.41969714052408e-05 G_eff=1.41969714052408e-05
Rh27n1n1 in1 h27p 70325.6868809818
* h27 input 2 w=+0.0192680774504759 w+  bank=f alpha=0.001 R=1729.97713025645 G_phys=0.000578042323514278 G_eff=5.78042323514278e-07
Rh27p2f1 tap2n h27p 1732.37539024163
* h27 input 3 w=-0.33925202928177 w-  bank=n alpha=1 R=98255.3690361212 G_phys=1.01775608784531e-05 G_eff=1.01775608784531e-05
Rh27n3n1 in3 h27p 97936.8506392019
* h27 input 4 w=+0.300608725256371 w+  bank=n alpha=1 R=110886.113850838 G_phys=9.01826175769113e-06 G_eff=9.01826175769113e-06
Rh27p4n1 in4n h27p 111383.941255885
* h27 input 5 w=-0.265937781386581 w-  bank=n alpha=1 R=125342.60141427 G_phys=7.97813344159742e-06 G_eff=7.97813344159742e-06
Rh27n5n1 in5 h27p 125427.262596988
* h27 input 6 w=-0.0714924370091341 w-  bank=n alpha=1 R=466249.784282421 G_phys=2.14477311027402e-06 G_eff=2.14477311027402e-06
Rh27n6n1 in6 h27p 464674.998996201
* h27 input 7 w=+0.32365049129675 w+  bank=n alpha=1 R=102991.758794429 G_phys=9.7095147389025e-06 G_eff=9.7095147389025e-06
Rh27p7n1 in7n h27p 103438.566103911
* h27 input 8 w=+0.264468500812474 w+  bank=n alpha=1 R=126038.954472574 G_phys=7.93405502437422e-06 G_eff=7.93405502437422e-06
Rh27p8n1 in8n h27p 125847.339499038
* h27 input 9 w=-0.251852607935664 w-  bank=n alpha=1 R=132352.543841231 G_phys=7.55557823806993e-06 G_eff=7.55557823806993e-06
Rh27n9n1 in9 h27p 131751.163862194
* h27 input 10 w=-0.0922567674902895 w-  bank=n alpha=1 R=361310.440850226 G_phys=2.76770302470868e-06 G_eff=2.76770302470868e-06
Rh27n10n1 in10 h27p 362573.604089354
* h27 input 11 w=-0.519972660308657 w-  bank=n alpha=1 R=64105.9345573026 G_phys=1.55991798092597e-05 G_eff=1.55991798092597e-05
Rh27n11n1 in11 h27p 64017.7178117822
* h27 input 12 w=+0.109096005067641 w+  bank=n alpha=1 R=305541.282768935 G_phys=3.27288015202924e-06 G_eff=3.27288015202924e-06
Rh27p12n1 in12n h27p 306198.751061059
* h27 input 13 w=+0.0733868764952063 w+  bank=n alpha=1 R=454213.817582367 G_phys=2.20160629485619e-06 G_eff=2.20160629485619e-06
Rh27p13n1 in13n h27p 455890.600747491
* h27 input 14 w=-0.779894486957924 w-  bank=n alpha=1 R=42740.8244201779 G_phys=2.33968346087377e-05 G_eff=2.33968346087377e-05
Rh27n14n1 in14 h27p 42573.9806104323
* h27 input 15 w=+0.520337169546291 w+  bank=n alpha=1 R=64061.0267423301 G_phys=1.56101150863887e-05 G_eff=1.56101150863887e-05
Rh27p15n1 in15n h27p 64132.5259253365
* h27 input 16 w=+0.00922691889455085 w+  bank=f alpha=0.001 R=3612.61800545565 G_phys=0.000276807566836526 G_eff=2.76807566836526e-07
Rh27p16f1 tap16n h27p 3599.94656589137
* h27 bias w+  bank=f alpha=0.001 R=2714.58121636714 G_phys=0.000368380947297011 G_eff=3.68380947297011e-07
Rh27bpf1 taprefn h27p 2705.04850052436
* feedback TIA h27: Rf=33333.3333333333 A=100000 V(h27lin) = -I(h27p)*Rf*A/(A+1)  (uncompensated)
* Exp 24 L TIA h27 -> h27lin, vg=h27p
Vh27os h27osref 0 DC 0.000214023
* servo h27: Vsum>0 discharges C so IN+ falls
Gh27srv h27int 0 h27p 0 0.001
Ch27int h27int 0 1e-08
Rh27int h27int 0 1000000000
Bh27plus h27osp 0 V = v(h27osref) + v(h27int)
Ah27tia %vd(h27osp h27p) h27lin limtia
Rh27f h27lin h27p 33368.8368284439
* direct bounded ReLU: y=max(0, min(15, v(h27lin)))
Bh27relu h27y 0 V = max(0, min(15, v(h27lin)))

* h28 input 1 w=+0.0928477001370985 w+  bank=n alpha=1 R=359010.86708786 G_phys=2.78543100411296e-06 G_eff=2.78543100411296e-06
Rh28p1n1 in1n h28p 359252.551588575
* h28 input 2 w=+0.628866123797832 w+  bank=n alpha=1 R=53005.4523083984 G_phys=1.8865983713935e-05 G_eff=1.8865983713935e-05
Rh28p2n1 in2n h28p 53185.34093501
* h28 input 3 w=-0.429442295580587 w-  bank=n alpha=1 R=77620.0520451022 G_phys=1.28832688674176e-05 G_eff=1.28832688674176e-05
Rh28n3n1 in3 h28p 77785.4405767478
* h28 input 4 w=+0.0390774584408687 w+  bank=n alpha=1 R=853006.686291349 G_phys=1.17232375322606e-06 G_eff=1.17232375322606e-06
Rh28p4n1 in4n h28p 855093.685044028
* h28 input 5 w=-0.500231352741198 w-  bank=n alpha=1 R=66635.8339009967 G_phys=1.50069405822359e-05 G_eff=1.50069405822359e-05
Rh28n5n1 in5 h28p 66478.4915867536
* h28 input 6 w=-0.374880121408735 w-  bank=n alpha=1 R=88917.3136416848 G_phys=1.1246403642262e-05 G_eff=1.1246403642262e-05
Rh28n6n1 in6 h28p 88993.5428697661
* h28 input 7 w=-0.575469641796179 w-  bank=n alpha=1 R=57923.7042449224 G_phys=1.72640892538854e-05 G_eff=1.72640892538854e-05
Rh28n7n1 in7 h28p 57728.2948007455
* h28 input 8 w=+0.475130253886277 w+  bank=n alpha=1 R=70156.2004538479 G_phys=1.42539076165883e-05 G_eff=1.42539076165883e-05
Rh28p8n1 in8n h28p 69970.957375293
* h28 input 9 w=-0.381841652824232 w-  bank=n alpha=1 R=87296.221056002 G_phys=1.1455249584727e-05 G_eff=1.1455249584727e-05
Rh28n9n1 in9 h28p 87544.9470431019
* h28 input 10 w=+0.758567082707225 w+  bank=n alpha=1 R=43942.4990791469 G_phys=2.27570124812167e-05 G_eff=2.27570124812167e-05
Rh28p10n1 in10n h28p 43886.7051810154
* h28 input 11 w=-0.0530277840915393 w-  bank=n alpha=1 R=628601.287125096 G_phys=1.59083352274618e-06 G_eff=1.59083352274618e-06
Rh28n11n1 in11 h28p 626063.076399657
* h28 input 12 w=+0.0401492881024246 w+  bank=n alpha=1 R=830234.729151284 G_phys=1.20447864307274e-06 G_eff=1.20447864307274e-06
Rh28p12n1 in12n h28p 831315.363180521
* h28 input 13 w=-0.344979802042177 w-  bank=n alpha=1 R=96624.0143220269 G_phys=1.03493940612653e-05 G_eff=1.03493940612653e-05
Rh28n13n1 in13 h28p 97081.9810038892
* h28 input 14 w=+0.139059200435423 w+  bank=n alpha=1 R=239706.062086937 G_phys=4.1717760130627e-06 G_eff=4.1717760130627e-06
Rh28p14n1 in14n h28p 240022.384733833
* h28 input 15 w=-0.317012120275182 w-  bank=n alpha=1 R=105148.450804967 G_phys=9.51036360825546e-06 G_eff=9.51036360825546e-06
Rh28n15n1 in15 h28p 105199.843687529
* h28 input 16 w=-0.398313118116402 w-  bank=n alpha=1 R=83686.2554037001 G_phys=1.1949393543492e-05 G_eff=1.1949393543492e-05
Rh28n16n1 in16 h28p 83989.0481584079
* h28 bias w-  bank=n alpha=1 R=393235.409243175 G_phys=2.54300598698528e-06 G_eff=2.54300598698528e-06
Rh28bnn1 vref h28p 394913.880987992
* feedback TIA h28: Rf=33333.3333333333 A=100000 V(h28lin) = -I(h28p)*Rf*A/(A+1)  (uncompensated)
* Exp 24 L TIA h28 -> h28lin, vg=h28p
Vh28os h28osref 0 DC 0.000214023
* servo h28: Vsum>0 discharges C so IN+ falls
Gh28srv h28int 0 h28p 0 0.001
Ch28int h28int 0 1e-08
Rh28int h28int 0 1000000000
Bh28plus h28osp 0 V = v(h28osref) + v(h28int)
Ah28tia %vd(h28osp h28p) h28lin limtia
Rh28f h28lin h28p 33222.0892932088
* direct bounded ReLU: y=max(0, min(15, v(h28lin)))
Bh28relu h28y 0 V = max(0, min(15, v(h28lin)))

* h29 input 1 w=+0.125932002984804 w+  bank=n alpha=1 R=264693.108529018 G_phys=3.77796008954411e-06 G_eff=3.77796008954411e-06
Rh29p1n1 in1n h29p 263423.072129075
* h29 input 2 w=-0.650061827874195 w-  bank=n alpha=1 R=51277.1738072033 G_phys=1.95018548362258e-05 G_eff=1.95018548362258e-05
Rh29n2n1 in2 h29p 51433.4166941991
* h29 input 3 w=-0.0394473233812264 w-  bank=n alpha=1 R=845008.747772155 G_phys=1.18341970143679e-06 G_eff=1.18341970143679e-06
Rh29n3n1 in3 h29p 843447.965375853
* h29 input 4 w=-0.231823015010513 w-  bank=n alpha=1 R=143787.85183094 G_phys=6.9546904503154e-06 G_eff=6.9546904503154e-06
Rh29n4n1 in4 h29p 144498.305930956
* h29 input 5 w=+0.19053303604273 w+  bank=n alpha=1 R=174947.788717637 G_phys=5.71599108128189e-06 G_eff=5.71599108128189e-06
Rh29p5n1 in5n h29p 175469.537522675
* h29 input 6 w=+0.447719174196915 w+  bank=n alpha=1 R=74451.4312864178 G_phys=1.34315752259074e-05 G_eff=1.34315752259074e-05
Rh29p6n1 in6n h29p 74682.6289576079
* h29 input 7 w=+0.0126486175371352 w+  bank=f alpha=0.001 R=2635.33411738237 G_phys=0.000379458526114055 G_eff=3.79458526114055e-07
Rh29p7f1 tap7n h29p 2645.61926057419
* h29 input 8 w=+0.108364236263017 w+  bank=n alpha=1 R=307604.561088107 G_phys=3.25092708789052e-06 G_eff=3.25092708789052e-06
Rh29p8n1 in8n h29p 308444.372710641
* h29 input 9 w=+0.430118110319429 w+  bank=n alpha=1 R=77498.0930437414 G_phys=1.29035433095829e-05 G_eff=1.29035433095829e-05
Rh29p9n1 in9n h29p 77717.0098307054
* h29 input 10 w=+0.849664650654267 w+  bank=n alpha=1 R=39231.1640924048 G_phys=2.5489939519628e-05 G_eff=2.5489939519628e-05
Rh29p10n1 in10n h29p 39130.8598100331
* h29 input 11 w=+0.430581993177771 w+  bank=n alpha=1 R=77414.6013104902 G_phys=1.29174597953331e-05 G_eff=1.29174597953331e-05
Rh29p11n1 in11n h29p 77138.8011891693
* h29 input 12 w=-0.974573192285427 w-  bank=n alpha=1 R=34203.006605553 G_phys=2.92371957685628e-05 G_eff=2.92371957685628e-05
Rh29n12n1 in12 h29p 34068.4878573465
* h29 input 13 w=+0.16029064712382 w+  bank=n alpha=1 R=207955.572776396 G_phys=4.80871941371461e-06 G_eff=4.80871941371461e-06
Rh29p13n1 in13n h29p 208267.157085155
* h29 input 14 w=+0.466636118473806 w+  bank=n alpha=1 R=71433.2474784727 G_phys=1.39990835542142e-05 G_eff=1.39990835542142e-05
Rh29p14n1 in14n h29p 71456.0600219371
* h29 input 15 w=-0.0331745755104183 w-  bank=f alpha=0.001 R=1004.78552688233 G_phys=0.000995237265312548 G_eff=9.95237265312548e-07
Rh29n15f1 tap15 h29p 1002.80088349462
* h29 input 16 w=-0.589046477086867 w-  bank=n alpha=1 R=56588.6303202822 G_phys=1.7671394312606e-05 G_eff=1.7671394312606e-05
Rh29n16n1 in16 h29p 56806.9478063995
* h29 bias w-  bank=n alpha=1 R=500623.285959049 G_phys=1.99750996017752e-06 G_eff=1.99750996017752e-06
Rh29bnn1 vref h29p 502017.718323587
* feedback TIA h29: Rf=33333.3333333333 A=100000 V(h29lin) = -I(h29p)*Rf*A/(A+1)  (uncompensated)
* Exp 24 L TIA h29 -> h29lin, vg=h29p
Vh29os h29osref 0 DC 0.000214023
* servo h29: Vsum>0 discharges C so IN+ falls
Gh29srv h29int 0 h29p 0 0.001
Ch29int h29int 0 1e-08
Rh29int h29int 0 1000000000
Bh29plus h29osp 0 V = v(h29osref) + v(h29int)
Ah29tia %vd(h29osp h29p) h29lin limtia
Rh29f h29lin h29p 33316.8447418442
* direct bounded ReLU: y=max(0, min(15, v(h29lin)))
Bh29relu h29y 0 V = max(0, min(15, v(h29lin)))

* h30 input 1 w=-0.507901838841989 w-  bank=n alpha=1 R=65629.4795256756 G_phys=1.52370551652597e-05 G_eff=1.52370551652597e-05
Rh30n1n1 in1 h30p 65777.8575566027
* h30 input 2 w=-0.0392944483392576 w-  bank=n alpha=1 R=848296.254105474 G_phys=1.17883345017773e-06 G_eff=1.17883345017773e-06
Rh30n2n1 in2 h30p 845018.833361599
* h30 input 3 w=+0.205776196534446 w+  bank=n alpha=1 R=161988.285791615 G_phys=6.17328589603337e-06 G_eff=6.17328589603337e-06
Rh30p3n1 in3n h30p 162563.557726017
* h30 input 4 w=+0.172383143604269 w+  bank=n alpha=1 R=193367.707749053 G_phys=5.17149430812806e-06 G_eff=5.17149430812806e-06
Rh30p4n1 in4n h30p 192571.889618835
* h30 input 5 w=-0.0737740397875715 w-  bank=n alpha=1 R=451830.121128177 G_phys=2.21322119362714e-06 G_eff=2.21322119362714e-06
Rh30n5n1 in5 h30p 451072.680787536
* h30 input 6 w=-0.113337981854853 w-  bank=n alpha=1 R=294105.583916448 G_phys=3.40013945564559e-06 G_eff=3.40013945564559e-06
Rh30n6n1 in6 h30p 293889.941740901
* h30 input 7 w=-0.199472534274412 w-  bank=n alpha=1 R=167107.383753781 G_phys=5.98417602823235e-06 G_eff=5.98417602823235e-06
Rh30n7n1 in7 h30p 166312.512683497
* h30 input 8 w=+0.667476408484971 w+  bank=n alpha=1 R=49939.3430383448 G_phys=2.00242922545491e-05 G_eff=2.00242922545491e-05
Rh30p8n1 in8n h30p 49910.0427636817
* h30 input 9 w=+0.0327305955718174 w+  bank=f alpha=0.001 R=1018.41511744549 G_phys=0.000981917867154523 G_eff=9.81917867154523e-07
Rh30p9f1 tap9n h30p 1021.82153299111
* h30 input 10 w=-0.112124407230259 w-  bank=n alpha=1 R=297288.825481859 G_phys=3.36373221690776e-06 G_eff=3.36373221690776e-06
Rh30n10n1 in10 h30p 298144.939136869
* h30 input 11 w=+0.283868618501327 w+  bank=n alpha=1 R=117425.214204076 G_phys=8.51605855503981e-06 G_eff=8.51605855503981e-06
Rh30p11n1 in11n h30p 117631.334637269
* h30 input 12 w=-0.058671072800694 w-  bank=n alpha=1 R=568139.148342606 G_phys=1.76013218402082e-06 G_eff=1.76013218402082e-06
Rh30n12n1 in12 h30p 567281.415258937
* h30 input 13 w=-0.679698898194489 w-  bank=n alpha=1 R=49041.323182777 G_phys=2.03909669458347e-05 G_eff=2.03909669458347e-05
Rh30n13n1 in13 h30p 49285.9598589048
* h30 input 14 w=+0.213421552049108 w+  bank=n alpha=1 R=156185.413390975 G_phys=6.40264656147323e-06 G_eff=6.40264656147323e-06
Rh30p14n1 in14n h30p 155427.558695769
* h30 input 15 w=+0.353043376484901 w+  bank=n alpha=1 R=94417.1043944198 G_phys=1.0591301294547e-05 G_eff=1.0591301294547e-05
Rh30p15n1 in15n h30p 94100.3408567104
* h30 input 16 w=-0.0402310971621178 w-  bank=n alpha=1 R=828546.464915216 G_phys=1.20693291486354e-06 G_eff=1.20693291486354e-06
Rh30n16n1 in16 h30p 827744.578498374
* h30 bias w+  bank=f alpha=0.001 R=1174.50422834716 G_phys=0.000851423073552715 G_eff=8.51423073552714e-07
Rh30bpf1 taprefn h30p 1174.73356085444
* feedback TIA h30: Rf=33333.3333333333 A=100000 V(h30lin) = -I(h30p)*Rf*A/(A+1)  (uncompensated)
* Exp 24 L TIA h30 -> h30lin, vg=h30p
Vh30os h30osref 0 DC 0.000214023
* servo h30: Vsum>0 discharges C so IN+ falls
Gh30srv h30int 0 h30p 0 0.001
Ch30int h30int 0 1e-08
Rh30int h30int 0 1000000000
Bh30plus h30osp 0 V = v(h30osref) + v(h30int)
Ah30tia %vd(h30osp h30p) h30lin limtia
Rh30f h30lin h30p 33181.8522699208
* direct bounded ReLU: y=max(0, min(15, v(h30lin)))
Bh30relu h30y 0 V = max(0, min(15, v(h30lin)))

* h31 input 1 w=+0.786523739677983 w+  bank=n alpha=1 R=42380.5813502598 G_phys=2.35957121903395e-05 G_eff=2.35957121903395e-05
Rh31p1n1 in1n h31p 42576.4812804978
* h31 input 2 w=+0.575951127580127 w+  bank=n alpha=1 R=57875.2809693839 G_phys=1.72785338274038e-05 G_eff=1.72785338274038e-05
Rh31p2n1 in2n h31p 58032.855049672
* h31 input 3 w=+0.131568206508636 w+  bank=n alpha=1 R=253354.014756941 G_phys=3.94704619525908e-06 G_eff=3.94704619525908e-06
Rh31p3n1 in3n h31p 253862.570699175
* h31 input 4 w=+0.217046331869883 w+  bank=n alpha=1 R=153577.040653773 G_phys=6.51138995609649e-06 G_eff=6.51138995609649e-06
Rh31p4n1 in4n h31p 153071.463295286
* h31 input 5 w=+0.0670548023806797 w+  bank=n alpha=1 R=497105.832093803 G_phys=2.01164407142039e-06 G_eff=2.01164407142039e-06
Rh31p5n1 in5n h31p 497456.428402153
* h31 input 6 w=-0.0924541633789126 w-  bank=n alpha=1 R=360539.018634786 G_phys=2.77362490136738e-06 G_eff=2.77362490136738e-06
Rh31n6n1 in6 h31p 360829.121662453
* h31 input 7 w=+0.532768880755568 w+  bank=n alpha=1 R=62566.2168669842 G_phys=1.59830664226671e-05 G_eff=1.59830664226671e-05
Rh31p7n1 in7n h31p 62406.4976922134
* h31 input 8 w=-0.213038536483163 w-  bank=n alpha=1 R=156466.214439883 G_phys=6.39115609449489e-06 G_eff=6.39115609449489e-06
Rh31n8n1 in8 h31p 156706.350717158
* h31 input 9 w=+0.217996086164886 w+  bank=n alpha=1 R=152907.943989971 G_phys=6.53988258494657e-06 G_eff=6.53988258494657e-06
Rh31p9n1 in9n h31p 152595.46976102
* h31 input 10 w=-0.173189336412784 w-  bank=n alpha=1 R=192467.58503587 G_phys=5.19568009238351e-06 G_eff=5.19568009238351e-06
Rh31n10n1 in10 h31p 191713.232546165
* h31 input 11 w=+0.227561810267943 w+  bank=n alpha=1 R=146480.348763639 G_phys=6.8268543080383e-06 G_eff=6.8268543080383e-06
Rh31p11n1 in11n h31p 147095.570001081
* h31 input 12 w=+0.400647928830177 w+  bank=n alpha=1 R=83198.5664587384 G_phys=1.20194378649053e-05 G_eff=1.20194378649053e-05
Rh31p12n1 in12n h31p 83374.2235277528
* h31 input 13 w=+0.0924404555732517 w+  bank=n alpha=1 R=360592.482226781 G_phys=2.77321366719755e-06 G_eff=2.77321366719755e-06
Rh31p13n1 in13n h31p 359525.785720217
* h31 input 14 w=+0.340918137300815 w+  bank=n alpha=1 R=97775.1832074605 G_phys=1.02275441190244e-05 G_eff=1.02275441190244e-05
Rh31p14n1 in14n h31p 97383.803629945
* h31 input 15 w=+0.631456773568415 w+  bank=n alpha=1 R=52787.9891840638 G_phys=1.89437032070525e-05 G_eff=1.89437032070525e-05
Rh31p15n1 in15n h31p 52864.0592916966
* h31 input 16 w=+0.19173700817347 w+  bank=n alpha=1 R=173849.240951834 G_phys=5.75211024520409e-06 G_eff=5.75211024520409e-06
Rh31p16n1 in16n h31p 174084.800918413
* h31 bias w-  bank=n alpha=1 R=620531.31238591 G_phys=1.61152222303666e-06 G_eff=1.61152222303666e-06
Rh31bnn1 vref h31p 623011.284047763
* feedback TIA h31: Rf=33333.3333333333 A=100000 V(h31lin) = -I(h31p)*Rf*A/(A+1)  (uncompensated)
* Exp 24 L TIA h31 -> h31lin, vg=h31p
Vh31os h31osref 0 DC 0.000214023
* servo h31: Vsum>0 discharges C so IN+ falls
Gh31srv h31int 0 h31p 0 0.001
Ch31int h31int 0 1e-08
Rh31int h31int 0 1000000000
Bh31plus h31osp 0 V = v(h31osref) + v(h31int)
Ah31tia %vd(h31osp h31p) h31lin limtia
Rh31f h31lin h31p 33172.3938826612
* direct bounded ReLU: y=max(0, min(15, v(h31lin)))
Bh31relu h31y 0 V = max(0, min(15, v(h31lin)))

* h32 input 1 w=+0.018363806586789 w+  bank=f alpha=0.001 R=1815.16469234181 G_phys=0.000550914197603669 G_eff=5.50914197603669e-07
Rh32p1f1 tap1n h32p 1811.20297155455
* h32 input 2 w=+0.274234487929714 w+  bank=n alpha=1 R=121550.478880237 G_phys=8.22703463789143e-06 G_eff=8.22703463789143e-06
Rh32p2n1 in2n h32p 121502.691746564
* h32 input 3 w=+0.286642259390481 w+  bank=n alpha=1 R=116288.970803585 G_phys=8.59926778171444e-06 G_eff=8.59926778171444e-06
Rh32p3n1 in3n h32p 115940.04863011
* h32 input 4 w=-0.106012181190002 w-  bank=n alpha=1 R=314429.275571559 G_phys=3.18036543570007e-06 G_eff=3.18036543570007e-06
Rh32n4n1 in4 h32p 315246.505985891
* h32 input 5 w=-0.539184466126997 w-  bank=n alpha=1 R=61821.7612476287 G_phys=1.61755339838099e-05 G_eff=1.61755339838099e-05
Rh32n5n1 in5 h32p 62062.2476055314
* h32 input 6 w=-0.141969883388357 w-  bank=n alpha=1 R=234791.580705539 G_phys=4.25909650165071e-06 G_eff=4.25909650165071e-06
Rh32n6n1 in6 h32p 233678.019739756
* h32 input 7 w=-0.343812430494534 w-  bank=n alpha=1 R=96952.0889206571 G_phys=1.0314372914836e-05 G_eff=1.0314372914836e-05
Rh32n7n1 in7 h32p 97151.2069841163
* h32 input 8 w=-0.197072814561277 w-  bank=n alpha=1 R=169142.219882229 G_phys=5.91218443683832e-06 G_eff=5.91218443683832e-06
Rh32n8n1 in8 h32p 168636.685209257
* h32 input 9 w=-0.180430465047897 w-  bank=n alpha=1 R=184743.376482927 G_phys=5.41291395143692e-06 G_eff=5.41291395143692e-06
Rh32n9n1 in9 h32p 185223.882012215
* h32 input 10 w=+0.113268490856906 w+  bank=n alpha=1 R=294286.019714378 G_phys=3.39805472570718e-06 G_eff=3.39805472570718e-06
Rh32p10n1 in10n h32p 294034.686628715
* h32 input 11 w=+0.0737822862098911 w+  bank=n alpha=1 R=451779.621446112 G_phys=2.21346858629673e-06 G_eff=2.21346858629673e-06
Rh32p11n1 in11n h32p 450317.972968217
* h32 input 12 w=+0.131260687318804 w+  bank=n alpha=1 R=253947.575730529 G_phys=3.93782061956414e-06 G_eff=3.93782061956414e-06
Rh32p12n1 in12n h32p 254583.545686238
* h32 input 13 w=-0.105796213840622 w-  bank=n alpha=1 R=315071.136511074 G_phys=3.17388641521865e-06 G_eff=3.17388641521865e-06
Rh32n13n1 in13 h32p 316644.824389144
* h32 input 14 w=-0.365435123738796 w-  bank=n alpha=1 R=91215.4611529876 G_phys=1.09630537121639e-05 G_eff=1.09630537121639e-05
Rh32n14n1 in14 h32p 91373.5318825975
* h32 input 15 w=-0.0205558893905 w-  bank=f alpha=0.001 R=1621.59528591055 G_phys=0.000616676681714999 G_eff=6.16676681714999e-07
Rh32n15f1 tap15 h32p 1625.851999942
* h32 input 16 w=-0.212152037098157 w-  bank=n alpha=1 R=157120.024814614 G_phys=6.36456111294471e-06 G_eff=6.36456111294471e-06
Rh32n16n1 in16 h32p 156522.514038361
* h32 bias w+  bank=f alpha=0.001 R=4134.96891231251 G_phys=0.000241839786756884 G_eff=2.41839786756884e-07
Rh32bpf1 taprefn h32p 4120.84583134523
* feedback TIA h32: Rf=33333.3333333333 A=100000 V(h32lin) = -I(h32p)*Rf*A/(A+1)  (uncompensated)
* Exp 24 L TIA h32 -> h32lin, vg=h32p
Vh32os h32osref 0 DC 0.000214023
* servo h32: Vsum>0 discharges C so IN+ falls
Gh32srv h32int 0 h32p 0 0.001
Ch32int h32int 0 1e-08
Rh32int h32int 0 1000000000
Bh32plus h32osp 0 V = v(h32osref) + v(h32int)
Ah32tia %vd(h32osp h32p) h32lin limtia
Rh32f h32lin h32p 33317.2500134161
* direct bounded ReLU: y=max(0, min(15, v(h32lin)))
Bh32relu h32y 0 V = max(0, min(15, v(h32lin)))

* passive invert h1y -> h1yn: R2/R1=1.0000002 closed-loop -1 at A=1e+07
Rinvh1ia h1y invh1m 9989.28440970061
Rinvh1ib h1yn invh1m 10035.6959635409
Einvh1amp h1yn 0 0 invh1m 10000000
* load-compensated divider h1y->htap1: G_load=0.000717504633896169 Ra=581657.819306003 Rb=1000 target beta=0.001 (no tap buffer)
Rdivh1a h1y htap1 584108.992025599
Rdivh1b htap1 0 997.953438139025
* load-compensated divider h1yn->htap1n: G_load=6.00022240247825e-05 Ra=942450.852798063 Rb=1000 target beta=0.001 (no tap buffer)
Rdivh1na h1yn htap1n 939223.054623897
Rdivh1nb htap1n 0 1000.97139172914
* passive invert h2y -> h2yn: R2/R1=1.0000002 closed-loop -1 at A=1e+07
Rinvh2ia h2y invh2m 9969.79185429523
Rinvh2ib h2yn invh2m 10015.4610608311
Einvh2amp h2yn 0 0 invh2m 10000000
* load-compensated divider h2y->htap2: G_load=0.000712380497940648 Ra=583398.375069923 Rb=1000 target beta=0.001 (no tap buffer)
Rdivh2a h2y htap2 582185.776090815
Rdivh2b htap2 0 1002.30665636563
* load-compensated divider h2yn->htap2n: G_load=0.00034407671071968 Ra=743261.148736882 Rb=1000 target beta=0.001 (no tap buffer)
Rdivh2na h2yn htap2n 743747.827867729
Rdivh2nb htap2n 0 995.34927093203
* passive invert h3y -> h3yn: R2/R1=1.0000002 closed-loop -1 at A=1e+07
Rinvh3ia h3y invh3m 9961.15861873107
Rinvh3ib h3yn invh3m 10048.5825568913
Einvh3amp h3yn 0 0 invh3m 10000000
* load-compensated divider h3yn->htap3n: G_load=0.000928920570217644 Ra=517906.240114014 Rb=1000 target beta=0.001 (no tap buffer)
Rdivh3na h3yn htap3n 516857.167059915
Rdivh3nb htap3n 0 996.803683941643
* passive invert h4y -> h4yn: R2/R1=1.0000002 closed-loop -1 at A=1e+07
Rinvh4ia h4y invh4m 9969.16508231567
Rinvh4ib h4yn invh4m 10004.4902069793
Einvh4amp h4yn 0 0 invh4m 10000000
* load-compensated divider h4y->htap4: G_load=0.0014954055609593 Ra=400335.727237843 Rb=1000 target beta=0.001 (no tap buffer)
Rdivh4a h4y htap4 400747.539533942
Rdivh4b htap4 0 1003.63189542153
* load-compensated divider h4yn->htap4n: G_load=0.000814282747184905 Ra=550630.821766937 Rb=1000 target beta=0.001 (no tap buffer)
Rdivh4na h4yn htap4n 548798.410746559
Rdivh4nb htap4n 0 999.272398415236
* passive invert h5y -> h5yn: R2/R1=1.0000002 closed-loop -1 at A=1e+07
Rinvh5ia h5y invh5m 9969.12402693712
Rinvh5ib h5yn invh5m 10044.7356311271
Einvh5amp h5yn 0 0 invh5m 10000000
* load-compensated divider h5yn->htap5n: G_load=0.00063839892598525 Ra=609741.610639333 Rb=1000 target beta=0.001 (no tap buffer)
Rdivh5na h5yn htap5n 612688.603946356
Rdivh5nb htap5n 0 999.67097086615
* passive invert h6y -> h6yn: R2/R1=1.0000002 closed-loop -1 at A=1e+07
Rinvh6ia h6y invh6m 10020.2314864597
Rinvh6ib h6yn invh6m 10032.2527864952
Einvh6amp h6yn 0 0 invh6m 10000000
* load-compensated divider h6y->htap6: G_load=0.000176838972885357 Ra=848884.191480051 Rb=1000 target beta=0.001 (no tap buffer)
Rdivh6a h6y htap6 847589.738292195
Rdivh6b htap6 0 999.593791137672
* load-compensated divider h6yn->htap6n: G_load=0.00101622287932375 Ra=495480.93628174 Rb=1000 target beta=0.001 (no tap buffer)
Rdivh6na h6yn htap6n 497274.73565494
Rdivh6nb htap6n 0 996.073625872237
* passive invert h7y -> h7yn: R2/R1=1.0000002 closed-loop -1 at A=1e+07
Rinvh7ia h7y invh7m 10029.0809599962
Rinvh7ib h7yn invh7m 10040.0804052677
Einvh7amp h7yn 0 0 invh7m 10000000
* load-compensated divider h7y->htap7: G_load=0.000978460874628438 Ra=504937.961023675 Rb=1000 target beta=0.001 (no tap buffer)
Rdivh7a h7y htap7 503987.465073721
Rdivh7b htap7 0 997.084798816042
* passive invert h8y -> h8yn: R2/R1=1.0000002 closed-loop -1 at A=1e+07
Rinvh8ia h8y invh8m 9989.80450823364
Rinvh8ib h8yn invh8m 10017.4858834163
Einvh8amp h8yn 0 0 invh8m 10000000
* load-compensated divider h8y->htap8: G_load=0.000501432225011038 Ra=665364.698691381 Rb=1000 target beta=0.001 (no tap buffer)
Rdivh8a h8y htap8 662419.90051943
Rdivh8b htap8 0 1000.40189627111
* load-compensated divider h8yn->htap8n: G_load=0.00121560414490552 Ra=450892.819593727 Rb=1000 target beta=0.001 (no tap buffer)
Rdivh8na h8yn htap8n 451949.415043862
Rdivh8nb htap8n 0 1000.93332220956
* passive invert h9y -> h9yn: R2/R1=1.0000002 closed-loop -1 at A=1e+07
Rinvh9ia h9y invh9m 9968.241578365
Rinvh9ib h9yn invh9m 9966.54803028837
Einvh9amp h9yn 0 0 invh9m 10000000
* load-compensated divider h9y->htap9: G_load=0.00094144317858438 Ra=514565.664872268 Rb=1000 target beta=0.001 (no tap buffer)
Rdivh9a h9y htap9 514996.857029401
Rdivh9b htap9 0 1000.08505841889
* passive invert h10y -> h10yn: R2/R1=1.0000002 closed-loop -1 at A=1e+07
Rinvh10ia h10y invh10m 10027.5639567382
Rinvh10ib h10yn invh10m 9960.29882075244
Einvh10amp h10yn 0 0 invh10m 10000000
* passive invert h11y -> h11yn: R2/R1=1.0000002 closed-loop -1 at A=1e+07
Rinvh11ia h11y invh11m 9997.48245946095
Rinvh11ib h11yn invh11m 10036.0715362879
Einvh11amp h11yn 0 0 invh11m 10000000
* load-compensated divider h11y->htap11: G_load=0.000344332712001725 Ra=743119.609514284 Rb=1000 target beta=0.001 (no tap buffer)
Rdivh11a h11y htap11 743803.803692707
Rdivh11b htap11 0 996.485918028921
* load-compensated divider h11yn->htap11n: G_load=0.000646362512497387 Ra=606792.241937412 Rb=1000 target beta=0.001 (no tap buffer)
Rdivh11na h11yn htap11n 608601.86307048
Rdivh11nb htap11n 0 1000.26838329739
* passive invert h12y -> h12yn: R2/R1=1.0000002 closed-loop -1 at A=1e+07
Rinvh12ia h12y invh12m 10013.9419411493
Rinvh12ib h12yn invh12m 9964.85450254629
Einvh12amp h12yn 0 0 invh12m 10000000
* load-compensated divider h12y->htap12: G_load=0.0014576014431314 Ra=406493.901927036 Rb=1000 target beta=0.001 (no tap buffer)
Rdivh12a h12y htap12 407475.266416102
Rdivh12b htap12 0 996.705231752078
* passive invert h13y -> h13yn: R2/R1=1.0000002 closed-loop -1 at A=1e+07
Rinvh13ia h13y invh13m 10009.4367853663
Rinvh13ib h13yn invh13m 10002.1168269275
Einvh13amp h13yn 0 0 invh13m 10000000
* load-compensated divider h13y->htap13: G_load=0.000608857399561785 Ra=620937.567414057 Rb=1000 target beta=0.001 (no tap buffer)
Rdivh13a h13y htap13 618386.999806426
Rdivh13b htap13 0 1004.69328387689
* passive invert h14y -> h14yn: R2/R1=1.0000002 closed-loop -1 at A=1e+07
Rinvh14ia h14y invh14m 9984.59255677929
Rinvh14ib h14yn invh14m 9977.04831998425
Einvh14amp h14yn 0 0 invh14m 10000000
* load-compensated divider h14y->htap14: G_load=0.000644987911304399 Ra=607299.295718131 Rb=1000 target beta=0.001 (no tap buffer)
Rdivh14a h14y htap14 609915.654159843
Rdivh14b htap14 0 998.134169875306
* load-compensated divider h14yn->htap14n: G_load=0.000230447960623581 Ra=811899.431727056 Rb=1000 target beta=0.001 (no tap buffer)
Rdivh14na h14yn htap14n 808521.372081163
Rdivh14nb htap14n 0 997.03166057901
* passive invert h15y -> h15yn: R2/R1=1.0000002 closed-loop -1 at A=1e+07
Rinvh15ia h15y invh15m 10028.2508426213
Rinvh15ib h15yn invh15m 10049.2609184397
Einvh15amp h15yn 0 0 invh15m 10000000
* load-compensated divider h15yn->htap15n: G_load=7.55198625914195e-05 Ra=928853.138604946 Rb=1000 target beta=0.001 (no tap buffer)
Rdivh15na h15yn htap15n 932442.251079611
Rdivh15nb htap15n 0 999.309605720318
* passive invert h16y -> h16yn: R2/R1=1.0000002 closed-loop -1 at A=1e+07
Rinvh16ia h16y invh16m 10009.2878663134
Rinvh16ib h16yn invh16m 10011.4240353513
Einvh16amp h16yn 0 0 invh16m 10000000
* load-compensated divider h16y->htap16: G_load=0.000874717171138128 Ra=532880.380774191 Rb=1000 target beta=0.001 (no tap buffer)
Rdivh16a h16y htap16 535051.152881376
Rdivh16b htap16 0 1000.07482877877
* load-compensated divider h16yn->htap16n: G_load=0.000453600446759896 Ra=687259.007264885 Rb=1000 target beta=0.001 (no tap buffer)
Rdivh16na h16yn htap16n 684388.133760704
Rdivh16nb htap16n 0 999.849849500014
* passive invert h17y -> h17yn: R2/R1=1.0000002 closed-loop -1 at A=1e+07
Rinvh17ia h17y invh17m 9983.07371227047
Rinvh17ib h17yn invh17m 10018.8045499659
Einvh17amp h17yn 0 0 invh17m 10000000
* load-compensated divider h17y->htap17: G_load=0.000805385822001192 Ra=553344.325531842 Rb=1000 target beta=0.001 (no tap buffer)
Rdivh17a h17y htap17 554832.240358557
Rdivh17b htap17 0 996.746421564981
* load-compensated divider h17yn->htap17n: G_load=0.000738531412423623 Ra=574622.921887463 Rb=1000 target beta=0.001 (no tap buffer)
Rdivh17na h17yn htap17n 572277.711002114
Rdivh17nb htap17n 0 1004.73405121166
* passive invert h18y -> h18yn: R2/R1=1.0000002 closed-loop -1 at A=1e+07
Rinvh18ia h18y invh18m 9968.05634030893
Rinvh18ib h18yn invh18m 9999.91215960762
Einvh18amp h18yn 0 0 invh18m 10000000
* passive invert h19y -> h19yn: R2/R1=1.0000002 closed-loop -1 at A=1e+07
Rinvh19ia h19y invh19m 10016.6276874161
Rinvh19ib h19yn invh19m 10005.5045627005
Einvh19amp h19yn 0 0 invh19m 10000000
* passive invert h20y -> h20yn: R2/R1=1.0000002 closed-loop -1 at A=1e+07
Rinvh20ia h20y invh20m 10000.0411923863
Rinvh20ib h20yn invh20m 10011.7796996507
Einvh20amp h20yn 0 0 invh20m 10000000
* load-compensated divider h20y->htap20: G_load=0.0016896004824873 Ra=371430.629383342 Rb=1000 target beta=0.001 (no tap buffer)
Rdivh20a h20y htap20 371915.76460707
Rdivh20b htap20 0 1002.4228770753
* load-compensated divider h20yn->htap20n: G_load=0.00028049585678463 Ra=780166.522762927 Rb=1000 target beta=0.001 (no tap buffer)
Rdivh20na h20yn htap20n 783240.038802974
Rdivh20nb htap20n 0 1000.78501933272
* passive invert h21y -> h21yn: R2/R1=1.0000002 closed-loop -1 at A=1e+07
Rinvh21ia h21y invh21m 9966.77719929731
Rinvh21ib h21yn invh21m 9974.65440429047
Einvh21amp h21yn 0 0 invh21m 10000000
* load-compensated divider h21y->htap21: G_load=0.000996893144360737 Ra=500277.144433689 Rb=1000 target beta=0.001 (no tap buffer)
Rdivh21a h21y htap21 500855.731477509
Rdivh21b htap21 0 1001.00489475038
* passive invert h22y -> h22yn: R2/R1=1.0000002 closed-loop -1 at A=1e+07
Rinvh22ia h22y invh22m 10021.223753479
Rinvh22ib h22yn invh22m 9960.92404095116
Einvh22amp h22yn 0 0 invh22m 10000000
* load-compensated divider h22yn->htap22n: G_load=0.000238269487966002 Ra=806771.070198113 Rb=1000 target beta=0.001 (no tap buffer)
Rdivh22na h22yn htap22n 804034.995417567
Rdivh22nb htap22n 0 1003.7846071026
* passive invert h23y -> h23yn: R2/R1=1.0000002 closed-loop -1 at A=1e+07
Rinvh23ia h23y invh23m 10000.4592902002
Rinvh23ib h23yn invh23m 10017.5740708166
Einvh23amp h23yn 0 0 invh23m 10000000
* load-compensated divider h23yn->htap23n: G_load=0.000186102491889634 Ra=842254.364046101 Rb=1000 target beta=0.001 (no tap buffer)
Rdivh23na h23yn htap23n 838568.334882928
Rdivh23nb htap23n 0 997.717390870282
* passive invert h24y -> h24yn: R2/R1=1.0000002 closed-loop -1 at A=1e+07
Rinvh24ia h24y invh24m 10040.9264586972
Rinvh24ib h24yn invh24m 9987.36648508345
Einvh24amp h24yn 0 0 invh24m 10000000
* load-compensated divider h24y->htap24: G_load=0.00179208295517046 Ra=357797.392140525 Rb=1000 target beta=0.001 (no tap buffer)
Rdivh24a h24y htap24 356488.989131728
Rdivh24b htap24 0 1002.40506071805
* load-compensated divider h24yn->htap24n: G_load=0.000321063215271205 Ra=756209.0810279 Rb=1000 target beta=0.001 (no tap buffer)
Rdivh24na h24yn htap24n 752730.935239905
Rdivh24nb htap24n 0 995.422481340087
* passive invert h25y -> h25yn: R2/R1=1.0000002 closed-loop -1 at A=1e+07
Rinvh25ia h25y invh25m 9978.12510367494
Rinvh25ib h25yn invh25m 10037.8037528484
Einvh25amp h25yn 0 0 invh25m 10000000
* load-compensated divider h25y->htap25: G_load=0.00043215997093136 Ra=697547.774184983 Rb=1000 target beta=0.001 (no tap buffer)
Rdivh25a h25y htap25 694877.027089382
Rdivh25b htap25 0 995.816983838668
* passive invert h26y -> h26yn: R2/R1=1.0000002 closed-loop -1 at A=1e+07
Rinvh26ia h26y invh26m 10007.8133546851
Rinvh26ib h26yn invh26m 10044.7461326196
Einvh26amp h26yn 0 0 invh26m 10000000
* load-compensated divider h26yn->htap26n: G_load=0.000228692257589393 Ra=813059.571124804 Rb=1000 target beta=0.001 (no tap buffer)
Rdivh26na h26yn htap26n 809942.400662436
Rdivh26nb htap26n 0 1003.18009023287
* passive invert h27y -> h27yn: R2/R1=1.0000002 closed-loop -1 at A=1e+07
Rinvh27ia h27y invh27m 9966.37948976982
Rinvh27ib h27yn invh27m 10001.8551879909
Einvh27amp h27yn 0 0 invh27m 10000000
* passive invert h28y -> h28yn: R2/R1=1.0000002 closed-loop -1 at A=1e+07
Rinvh28ia h28y invh28m 9984.60488638471
Rinvh28ib h28yn invh28m 10015.7018223139
Einvh28amp h28yn 0 0 invh28m 10000000
* load-compensated divider h28y->htap28: G_load=0.000369491999393624 Ra=729467.569319376 Rb=1000 target beta=0.001 (no tap buffer)
Rdivh28a h28y htap28 732765.513913158
Rdivh28b htap28 0 1001.08453821163
* passive invert h29y -> h29yn: R2/R1=1.0000002 closed-loop -1 at A=1e+07
Rinvh29ia h29y invh29m 10030.692476512
Rinvh29ib h29yn invh29m 10032.8361815179
Einvh29amp h29yn 0 0 invh29m 10000000
* load-compensated divider h29y->htap29: G_load=0.000860568019222978 Ra=536932.802068268 Rb=1000 target beta=0.001 (no tap buffer)
Rdivh29a h29y htap29 536153.651094408
Rdivh29b htap29 0 1001.33622793667
* load-compensated divider h29yn->htap29n: G_load=0.00122218503343532 Ra=449557.523324521 Rb=1000 target beta=0.001 (no tap buffer)
Rdivh29na h29yn htap29n 451051.033858819
Rdivh29nb htap29n 0 998.944662942917
* passive invert h30y -> h30yn: R2/R1=1.0000002 closed-loop -1 at A=1e+07
Rinvh30ia h30y invh30m 9983.73454429419
Rinvh30ib h30yn invh30m 10010.5816400621
Einvh30amp h30yn 0 0 invh30m 10000000
* load-compensated divider h30y->htap30: G_load=0.000487976394847741 Ra=671381.618323471 Rb=1000 target beta=0.001 (no tap buffer)
Rdivh30a h30y htap30 672318.029109272
Rdivh30b htap30 0 1002.00925344214
* passive invert h31y -> h31yn: R2/R1=1.0000002 closed-loop -1 at A=1e+07
Rinvh31ia h31y invh31m 9984.73380113163
Rinvh31ib h31yn invh31m 9965.31329069421
Einvh31amp h31yn 0 0 invh31m 10000000
* passive invert h32y -> h32yn: R2/R1=1.0000002 closed-loop -1 at A=1e+07
Rinvh32ia h32y invh32m 10039.829998433
Rinvh32ib h32yn invh32m 9959.56060529803
Einvh32amp h32yn 0 0 invh32m 10000000
* load-compensated divider h32yn->htap32n: G_load=9.22574297882182e-05 Ra=914619.550991473 Rb=1000 target beta=0.001 (no tap buffer)
Rdivh32na h32yn htap32n 911086.035268035
Rdivh32nb htap32n 0 1000.41303128015

* o1 input 1 w=+0.115109951768787 w+  bank=n alpha=1 R=289578.206064126 G_phys=3.4532985530636e-06 G_eff=3.4532985530636e-06
Ro1p1n1 h1yn o1p 290413.444343948
* o1 input 2 w=+0.416557305918275 w+  bank=n alpha=1 R=80021.0027762017 G_phys=1.24967191775482e-05 G_eff=1.24967191775482e-05
Ro1p2n1 h2yn o1p 80215.8094292084
* o1 input 3 w=+0.460762298204741 w+  bank=n alpha=1 R=72343.8820042555 G_phys=1.38228689461422e-05 G_eff=1.38228689461422e-05
Ro1p3n1 h3yn o1p 72561.6763937457
* o1 input 4 w=+0.128235529120638 w+  bank=n alpha=1 R=259938.361559493 G_phys=3.84706587361914e-06 G_eff=3.84706587361914e-06
Ro1p4n1 h4yn o1p 261125.399999742
* o1 input 5 w=+0.25946188501651 w+  bank=n alpha=1 R=128471.021210735 G_phys=7.78385655049531e-06 G_eff=7.78385655049531e-06
Ro1p5n1 h5yn o1p 128778.969183607
* o1 input 6 w=+0.0121141451968155 w+  bank=f alpha=0.001 R=2751.60424378073 G_phys=0.000363424355904464 G_eff=3.63424355904464e-07
Ro1p6f1 htap6n o1p 2744.10172810837
* o1 input 7 w=-0.240253536162518 w-  bank=n alpha=1 R=138742.321406604 G_phys=7.20760608487554e-06 G_eff=7.20760608487554e-06
Ro1n7n1 h7y o1p 138611.748724227
* o1 input 8 w=+0.187475674056081 w+  bank=n alpha=1 R=177800.845369208 G_phys=5.62427022168244e-06 G_eff=5.62427022168244e-06
Ro1p8n1 h8yn o1p 178372.28167167
* o1 input 9 w=-0.249792136720497 w-  bank=n alpha=1 R=133444.28600101 G_phys=7.4937641016149e-06 G_eff=7.4937641016149e-06
Ro1n9n1 h9y o1p 133159.499074892
* o1 input 10 w=-0.0478130377197742 w-  bank=n alpha=1 R=697159.915433434 G_phys=1.43439113159322e-06 G_eff=1.43439113159322e-06
Ro1n10n1 h10y o1p 693890.156848126
* o1 input 11 w=+0.103135444855694 w+  bank=n alpha=1 R=323199.588463238 G_phys=3.09406334567083e-06 G_eff=3.09406334567083e-06
Ro1p11n1 h11yn o1p 323757.868762498
* o1 input 12 w=-0.0209153710838255 w-  bank=f alpha=0.001 R=1593.72421362923 G_phys=0.000627461132514765 G_eff=6.27461132514765e-07
Ro1n12f1 htap12 o1p 1586.17400445838
* o1 input 13 w=-0.0177641479719743 w-  bank=f alpha=0.001 R=1876.43862153827 G_phys=0.00053292443915923 G_eff=5.3292443915923e-07
Ro1n13f1 htap13 o1p 1872.92785807427
* o1 input 14 w=-0.162077236015947 w-  bank=n alpha=1 R=205663.263717389 G_phys=4.86231708047842e-06 G_eff=4.86231708047842e-06
Ro1n14n1 h14y o1p 204828.586071628
* o1 input 15 w=+0.156787201998635 w+  bank=n alpha=1 R=212602.386600556 G_phys=4.70361605995906e-06 G_eff=4.70361605995906e-06
Ro1p15n1 h15yn o1p 212056.207430037
* o1 input 16 w=-0.00694237968883333 w-  bank=f alpha=0.001 R=4801.42758353441 G_phys=0.000208271390665 G_eff=2.08271390665e-07
Ro1n16f1 htap16 o1p 4822.35722688015
* o1 input 17 w=+0.263424706628807 w+  bank=n alpha=1 R=126538.37128612 G_phys=7.90274119886422e-06 G_eff=7.90274119886422e-06
Ro1p17n1 h17yn o1p 127077.829942642
* o1 input 18 w=+0.403807796552332 w+  bank=n alpha=1 R=82547.5229005725 G_phys=1.211423389657e-05 G_eff=1.211423389657e-05
Ro1p18n1 h18yn o1p 82926.9298777396
* o1 input 19 w=+0.415931315874452 w+  bank=n alpha=1 R=80141.4369659891 G_phys=1.24779394762336e-05 G_eff=1.24779394762336e-05
Ro1p19n1 h19yn o1p 79803.0976017692
* o1 input 20 w=+0.0719298844689274 w+  bank=n alpha=1 R=463414.248186827 G_phys=2.15789653406782e-06 G_eff=2.15789653406782e-06
Ro1p20n1 h20yn o1p 461321.791927538
* o1 input 21 w=-0.387164693396724 w-  bank=n alpha=1 R=86096.0048833198 G_phys=1.16149408019017e-05 G_eff=1.16149408019017e-05
Ro1n21n1 h21y o1p 85869.4615077613
* o1 input 22 w=+0.13881898843949 w+  bank=n alpha=1 R=240120.848797735 G_phys=4.1645696531847e-06 G_eff=4.1645696531847e-06
Ro1p22n1 h22yn o1p 239304.872257789
* o1 input 23 w=-0.118143194098524 w-  bank=n alpha=1 R=282143.491952108 G_phys=3.54429582295573e-06 G_eff=3.54429582295573e-06
Ro1n23n1 h23y o1p 282141.097232283
* o1 input 24 w=-0.494956544406075 w-  bank=n alpha=1 R=67345.9795815646 G_phys=1.48486963321823e-05 G_eff=1.48486963321823e-05
Ro1n24n1 h24y o1p 67263.4738756722
* o1 input 25 w=-0.0137314432186455 w-  bank=f alpha=0.001 R=2427.51856469617 G_phys=0.000411943296559366 G_eff=4.11943296559366e-07
Ro1n25f1 htap25 o1p 2439.35328600898
* o1 input 26 w=+0.00762307525297978 w+  bank=f alpha=0.001 R=4372.68847901032 G_phys=0.000228692257589393 G_eff=2.28692257589393e-07
Ro1p26f1 htap26n o1p 4373.4207671248
* o1 input 27 w=+0.187160704798257 w+  bank=n alpha=1 R=178100.063094247 G_phys=5.6148211439477e-06 G_eff=5.6148211439477e-06
Ro1p27n1 h27yn o1p 177956.228532701
* o1 input 28 w=+0.0939442280900053 w+  bank=n alpha=1 R=354820.450505992 G_phys=2.81832684270016e-06 G_eff=2.81832684270016e-06
Ro1p28n1 h28yn o1p 353910.749731251
* o1 input 29 w=+0.0315398664392492 w+  bank=f alpha=0.001 R=1056.86349045069 G_phys=0.000946195993177476 G_eff=9.46195993177476e-07
Ro1p29f1 htap29n o1p 1061.2189386177
* o1 input 30 w=+0.183835448783735 w+  bank=n alpha=1 R=181321.576191471 G_phys=5.51506346351205e-06 G_eff=5.51506346351205e-06
Ro1p30n1 h30yn o1p 180896.817823911
* o1 input 31 w=-0.236627512253244 w-  bank=n alpha=1 R=140868.375853351 G_phys=7.09882536759733e-06 G_eff=7.09882536759733e-06
Ro1n31n1 h31y o1p 141504.86008804
* o1 input 32 w=-0.230869865069063 w-  bank=n alpha=1 R=144381.482283805 G_phys=6.92609595207188e-06 G_eff=6.92609595207188e-06
Ro1n32n1 h32y o1p 144731.548606352
* o1 bias w-  bank=n alpha=1 R=411699.330459582 G_phys=2.42895707137462e-06 G_eff=2.42895707137462e-06
Ro1bnn1 vref o1p 411449.560925846
* feedback TIA o1: Rf=33333.3333333333 A=100000 V(o1lin) = -I(o1p)*Rf*A/(A+1)  (uncompensated)
* Exp 24 L TIA o1 -> o1lin, vg=o1p
Vo1os o1osref 0 DC 0.000214023
* servo o1: Vsum>0 discharges C so IN+ falls
Go1srv o1int 0 o1p 0 0.001
Co1int o1int 0 1e-08
Ro1int o1int 0 1000000000
Bo1plus o1osp 0 V = v(o1osref) + v(o1int)
Ao1tia %vd(o1osp o1p) o1lin limtia
Ro1f o1lin o1p 33349.8110428072

* o2 input 1 w=-0.195521390350609 w-  bank=n alpha=1 R=170484.330505015 G_phys=5.86564171051827e-06 G_eff=5.86564171051827e-06
Ro2n1n1 h1y o2p 170301.53189583
* o2 input 2 w=+0.386445174905558 w+  bank=n alpha=1 R=86256.3061926689 G_phys=1.15933552471668e-05 G_eff=1.15933552471668e-05
Ro2p2n1 h2yn o2p 86408.4209397563
* o2 input 3 w=+0.296294588630229 w+  bank=n alpha=1 R=112500.648383197 G_phys=8.88883765890688e-06 G_eff=8.88883765890688e-06
Ro2p3n1 h3yn o2p 112521.189957284
* o2 input 4 w=-0.299308681857295 w-  bank=n alpha=1 R=111367.746256108 G_phys=8.97926045571886e-06 G_eff=8.97926045571886e-06
Ro2n4n1 h4y o2p 111363.720113677
* o2 input 5 w=+0.732671792857329 w+  bank=n alpha=1 R=45495.5870531571 G_phys=2.19801537857199e-05 G_eff=2.19801537857199e-05
Ro2p5n1 h5yn o2p 45408.1752114237
* o2 input 6 w=+0.124925987288217 w+  bank=n alpha=1 R=266824.65399637 G_phys=3.7477796186465e-06 G_eff=3.7477796186465e-06
Ro2p6n1 h6yn o2p 266962.108531634
* o2 input 7 w=-0.0857938493267301 w-  bank=n alpha=1 R=388528.240601368 G_phys=2.5738154798019e-06 G_eff=2.5738154798019e-06
Ro2n7n1 h7y o2p 388055.687049179
* o2 input 8 w=-0.0609936542707342 w-  bank=n alpha=1 R=546504.939438057 G_phys=1.82980962812202e-06 G_eff=1.82980962812202e-06
Ro2n8n1 h8y o2p 544487.089218971
* o2 input 9 w=+0.256981204903229 w+  bank=n alpha=1 R=129711.172246568 G_phys=7.70943614709688e-06 G_eff=7.70943614709688e-06
Ro2p9n1 h9yn o2p 129874.106055452
* o2 input 10 w=+0.073638013162671 w+  bank=n alpha=1 R=452664.756987643 G_phys=2.20914039488013e-06 G_eff=2.20914039488013e-06
Ro2p10n1 h10yn o2p 453086.354415438
* o2 input 11 w=-0.149208279345328 w-  bank=n alpha=1 R=223401.365390634 G_phys=4.47624838035983e-06 G_eff=4.47624838035983e-06
Ro2n11n1 h11y o2p 222847.84037163
* o2 input 12 w=-0.475362564845884 w-  bank=n alpha=1 R=70121.9149306388 G_phys=1.42608769453765e-05 G_eff=1.42608769453765e-05
Ro2n12n1 h12y o2p 70047.1725780954
* o2 input 13 w=-0.0533811781970356 w-  bank=n alpha=1 R=624439.820535554 G_phys=1.60143534591107e-06 G_eff=1.60143534591107e-06
Ro2n13n1 h13y o2p 621546.847227309
* o2 input 14 w=+0.279456004632752 w+  bank=n alpha=1 R=119279.359830319 G_phys=8.38368013898257e-06 G_eff=8.38368013898257e-06
Ro2p14n1 h14yn o2p 119829.485359259
* o2 input 15 w=-0.0744870090943736 w-  bank=n alpha=1 R=447505.326614748 G_phys=2.23461027283121e-06 G_eff=2.23461027283121e-06
Ro2n15n1 h15y o2p 447640.442141826
* o2 input 16 w=-0.0222148593491043 w-  bank=f alpha=0.001 R=1500.49715865869 G_phys=0.000666445780473128 G_eff=6.66445780473128e-07
Ro2n16f1 htap16 o2p 1506.29880564515
* o2 input 17 w=+0.0088751960388594 w+  bank=f alpha=0.001 R=3755.78558348297 G_phys=0.000266255881165782 G_eff=2.66255881165782e-07
Ro2p17f1 htap17n o2p 3765.35138487515
* o2 input 18 w=-0.194172060066752 w-  bank=n alpha=1 R=171669.051262443 G_phys=5.82516180200256e-06 G_eff=5.82516180200256e-06
Ro2n18n1 h18y o2p 172447.504372077
* o2 input 19 w=+0.341327626188232 w+  bank=n alpha=1 R=97657.8828546125 G_phys=1.0239828785647e-05 G_eff=1.0239828785647e-05
Ro2p19n1 h19yn o2p 97995.6249726296
* o2 input 20 w=-0.0323870183321868 w-  bank=f alpha=0.001 R=1029.21896024637 G_phys=0.000971610549965604 G_eff=9.71610549965604e-07
Ro2n20f1 htap20 o2p 1028.01182308276
* o2 input 21 w=-0.0999542141187652 w-  bank=n alpha=1 R=333486.022847689 G_phys=2.99862642356296e-06 G_eff=2.99862642356296e-06
Ro2n21n1 h21y o2p 332030.006305946
* o2 input 22 w=+0.693789300406694 w+  bank=n alpha=1 R=48045.3263170729 G_phys=2.08136790122008e-05 G_eff=2.08136790122008e-05
Ro2p22n1 h22yn o2p 48116.7683853699
* o2 input 23 w=+0.0972685864670828 w+  bank=n alpha=1 R=342693.715864925 G_phys=2.91805759401248e-06 G_eff=2.91805759401248e-06
Ro2p23n1 h23yn o2p 343428.504652353
* o2 input 24 w=-0.0293783170287994 w-  bank=f alpha=0.001 R=1134.6236512002 G_phys=0.000881349510863982 G_eff=8.81349510863982e-07
Ro2n24f1 htap24 o2p 1135.05347380068
* o2 input 25 w=+0.0497492024826392 w+  bank=n alpha=1 R=670027.491294269 G_phys=1.49247607447918e-06 G_eff=1.49247607447918e-06
Ro2p25n1 h25yn o2p 667816.061276575
* o2 input 26 w=-0.466063512962686 w-  bank=n alpha=1 R=71521.0103477937 G_phys=1.39819053888806e-05 G_eff=1.39819053888806e-05
Ro2n26n1 h26y o2p 71250.3692502364
* o2 input 27 w=+0.194887582685885 w+  bank=n alpha=1 R=171038.774630702 G_phys=5.84662748057655e-06 G_eff=5.84662748057655e-06
Ro2p27n1 h27yn o2p 171190.748355198
* o2 input 28 w=+0.209047565197081 w+  bank=n alpha=1 R=159453.344036359 G_phys=6.27142695591242e-06 G_eff=6.27142695591242e-06
Ro2p28n1 h28yn o2p 159144.167449436
* o2 input 29 w=+0.00919963467526149 w+  bank=f alpha=0.001 R=3623.33228546229 G_phys=0.000275989040257845 G_eff=2.75989040257845e-07
Ro2p29f1 htap29n o2p 3616.10010862296
* o2 input 30 w=-0.379437042796868 w-  bank=n alpha=1 R=87849.4442388387 G_phys=1.13831112839061e-05 G_eff=1.13831112839061e-05
Ro2n30n1 h30y o2p 87938.2837210092
* o2 input 31 w=-0.216631724491884 w-  bank=n alpha=1 R=153870.96885979 G_phys=6.49895173475653e-06 G_eff=6.49895173475653e-06
Ro2n31n1 h31y o2p 154583.098021606
* o2 input 32 w=+0.139103822260271 w+  bank=n alpha=1 R=239629.169002738 G_phys=4.17311466780814e-06 G_eff=4.17311466780814e-06
Ro2p32n1 h32yn o2p 240152.021364044
* o2 bias w+  bank=f alpha=0.001 R=1034.77721072674 G_phys=0.000966391595827364 G_eff=9.66391595827364e-07
Ro2bpf1 taprefn o2p 1036.87395680637
* feedback TIA o2: Rf=33333.3333333333 A=100000 V(o2lin) = -I(o2p)*Rf*A/(A+1)  (uncompensated)
* Exp 24 L TIA o2 -> o2lin, vg=o2p
Vo2os o2osref 0 DC 0.000214023
* servo o2: Vsum>0 discharges C so IN+ falls
Go2srv o2int 0 o2p 0 0.001
Co2int o2int 0 1e-08
Ro2int o2int 0 1000000000
Bo2plus o2osp 0 V = v(o2osref) + v(o2int)
Ao2tia %vd(o2osp o2p) o2lin limtia
Ro2f o2lin o2p 33410.7318785157

* o3 input 1 w=-0.100595944434035 w-  bank=n alpha=1 R=331358.620080271 G_phys=3.01787833302104e-06 G_eff=3.01787833302104e-06
Ro3n1n1 h1y o3p 332605.791613458
* o3 input 2 w=-0.265315115107159 w-  bank=n alpha=1 R=125636.767132058 G_phys=7.95945345321476e-06 G_eff=7.95945345321476e-06
Ro3n2n1 h2y o3p 125297.807050261
* o3 input 3 w=-0.0591677372187977 w-  bank=n alpha=1 R=563370.088162562 G_phys=1.77503211656393e-06 G_eff=1.77503211656393e-06
Ro3n3n1 h3y o3p 561738.365907064
* o3 input 4 w=-0.0695954531730398 w-  bank=n alpha=1 R=478958.492452868 G_phys=2.08786359519119e-06 G_eff=2.08786359519119e-06
Ro3n4n1 h4y o3p 476598.444314946
* o3 input 5 w=-0.284313347850547 w-  bank=n alpha=1 R=117241.53503639 G_phys=8.52940043551641e-06 G_eff=8.52940043551641e-06
Ro3n5n1 h5y o3p 117478.380778687
* o3 input 6 w=+0.314440272159438 w+  bank=n alpha=1 R=106008.473737841 G_phys=9.43320816478313e-06 G_eff=9.43320816478313e-06
Ro3p6n1 h6yn o3p 105836.376320022
* o3 input 7 w=-0.349535009995164 w-  bank=n alpha=1 R=95364.7914519193 G_phys=1.04860502998549e-05 G_eff=1.04860502998549e-05
Ro3n7n1 h7y o3p 95488.0082757098
* o3 input 8 w=-0.295696300813859 w-  bank=n alpha=1 R=112728.273034152 G_phys=8.87088902441576e-06 G_eff=8.87088902441576e-06
Ro3n8n1 h8y o3p 112214.365550223
* o3 input 9 w=-0.735854867565559 w-  bank=n alpha=1 R=45298.7875769723 G_phys=2.20756460269668e-05 G_eff=2.20756460269668e-05
Ro3n9n1 h9y o3p 45506.5115134114
* o3 input 10 w=-0.0859238760568894 w-  bank=n alpha=1 R=387940.289277262 G_phys=2.57771628170668e-06 G_eff=2.57771628170668e-06
Ro3n10n1 h10y o3p 388715.905980417
* o3 input 11 w=-0.105996934570411 w-  bank=n alpha=1 R=314474.503139436 G_phys=3.17990803711233e-06 G_eff=3.17990803711233e-06
Ro3n11n1 h11y o3p 313964.04981466
* o3 input 12 w=-0.193541479603888 w-  bank=n alpha=1 R=172228.36883109 G_phys=5.80624438811663e-06 G_eff=5.80624438811663e-06
Ro3n12n1 h12y o3p 171442.851130947
* o3 input 13 w=-0.351950930756974 w-  bank=n alpha=1 R=94710.172414206 G_phys=1.05585279227092e-05 G_eff=1.05585279227092e-05
Ro3n13n1 h13y o3p 95118.716765038
* o3 input 14 w=+0.0402342325324318 w+  bank=n alpha=1 R=828481.898007229 G_phys=1.20702697597296e-06 G_eff=1.20702697597296e-06
Ro3p14n1 h14yn o3p 828607.693511078
* o3 input 15 w=+0.188158881095559 w+  bank=n alpha=1 R=177155.248475381 G_phys=5.64476643286676e-06 G_eff=5.64476643286676e-06
Ro3p15n1 h15yn o3p 176937.596960729
* o3 input 16 w=+0.204693314484602 w+  bank=n alpha=1 R=162845.246886853 G_phys=6.14079943453807e-06 G_eff=6.14079943453807e-06
Ro3p16n1 h16yn o3p 163322.864962342
* o3 input 17 w=+0.153640089266272 w+  bank=n alpha=1 R=216957.263514496 G_phys=4.60920267798816e-06 G_eff=4.60920267798816e-06
Ro3p17n1 h17yn o3p 217240.593858453
* o3 input 18 w=+0.463153650429953 w+  bank=n alpha=1 R=71970.3564948468 G_phys=1.38946095128986e-05 G_eff=1.38946095128986e-05
Ro3p18n1 h18yn o3p 71649.4584738855
* o3 input 19 w=-0.0426705918571366 w-  bank=n alpha=1 R=781178.134227318 G_phys=1.2801177557141e-06 G_eff=1.2801177557141e-06
Ro3n19n1 h19y o3p 780958.42595311
* o3 input 20 w=+0.210331327799834 w+  bank=n alpha=1 R=158480.116500076 G_phys=6.30993983399502e-06 G_eff=6.30993983399502e-06
Ro3p20n1 h20yn o3p 158200.174517686
* o3 input 21 w=-0.0625815721904128 w-  bank=n alpha=1 R=532638.157953466 G_phys=1.87744716571238e-06 G_eff=1.87744716571238e-06
Ro3n21n1 h21y o3p 530464.000534295
* o3 input 22 w=+0.238697201684848 w+  bank=n alpha=1 R=139646.938037185 G_phys=7.16091605054544e-06 G_eff=7.16091605054544e-06
Ro3p22n1 h22yn o3p 138975.549867527
* o3 input 23 w=-0.0558624260671465 w-  bank=n alpha=1 R=596704.004463873 G_phys=1.67587278201439e-06 G_eff=1.67587278201439e-06
Ro3n23n1 h23y o3p 597126.278638035
* o3 input 24 w=+0.439236044835332 w+  bank=n alpha=1 R=75889.3395140872 G_phys=1.317708134506e-05 G_eff=1.317708134506e-05
Ro3p24n1 h24yn o3p 75708.7497528335
* o3 input 25 w=+0.113742741787302 w+  bank=n alpha=1 R=293058.992684265 G_phys=3.41228225361907e-06 G_eff=3.41228225361907e-06
Ro3p25n1 h25yn o3p 294189.517794991
* o3 input 26 w=-0.433617266896606 w-  bank=n alpha=1 R=76872.7075190056 G_phys=1.30085180068982e-05 G_eff=1.30085180068982e-05
Ro3n26n1 h26y o3p 76961.0476945927
* o3 input 27 w=+0.230315174630548 w+  bank=n alpha=1 R=144729.210252012 G_phys=6.90945523891643e-06 G_eff=6.90945523891643e-06
Ro3p27n1 h27yn o3p 144069.003329319
* o3 input 28 w=-0.12398109066818 w-  bank=n alpha=1 R=268858.203728388 G_phys=3.71943272004541e-06 G_eff=3.71943272004541e-06
Ro3n28n1 h28y o3p 268677.803204288
* o3 input 29 w=-0.26178305647614 w-  bank=n alpha=1 R=127331.897572108 G_phys=7.85349169428421e-06 G_eff=7.85349169428421e-06
Ro3n29n1 h29y o3p 126927.876909186
* o3 input 30 w=-0.44647126763401 w-  bank=n alpha=1 R=74659.5262668906 G_phys=1.33941380290203e-05 G_eff=1.33941380290203e-05
Ro3n30n1 h30y o3p 74621.693231701
* o3 input 31 w=-0.53039390006668 w-  bank=n alpha=1 R=62846.3738537392 G_phys=1.59118170020004e-05 G_eff=1.59118170020004e-05
Ro3n31n1 h31y o3p 63102.7444857374
* o3 input 32 w=+0.288818654520262 w+  bank=n alpha=1 R=115412.674394946 G_phys=8.66455963560785e-06 G_eff=8.66455963560785e-06
Ro3p32n1 h32yn o3p 114905.69104498
* o3 bias w+  bank=n alpha=1 R=524928.575339756 G_phys=1.90502107711084e-06 G_eff=1.90502107711084e-06
Ro3bpn1 vrefn o3p 527172.355529257
* feedback TIA o3: Rf=33333.3333333333 A=100000 V(o3lin) = -I(o3p)*Rf*A/(A+1)  (uncompensated)
* Exp 24 L TIA o3 -> o3lin, vg=o3p
Vo3os o3osref 0 DC 0.000214023
* servo o3: Vsum>0 discharges C so IN+ falls
Go3srv o3int 0 o3p 0 0.001
Co3int o3int 0 1e-08
Ro3int o3int 0 1000000000
Bo3plus o3osp 0 V = v(o3osref) + v(o3int)
Ao3tia %vd(o3osp o3p) o3lin limtia
Ro3f o3lin o3p 33246.8719019107

* o4 input 1 w=+0.274757256178841 w+  bank=n alpha=1 R=121319.210261863 G_phys=8.24271768536522e-06 G_eff=8.24271768536522e-06
Ro4p1n1 h1yn o4p 121791.300667987
* o4 input 2 w=-0.133159767354893 w-  bank=n alpha=1 R=250325.860396666 G_phys=3.99479302064678e-06 G_eff=3.99479302064678e-06
Ro4n2n1 h2y o4p 249774.978953896
* o4 input 3 w=-0.106623598682841 w-  bank=n alpha=1 R=312626.226699453 G_phys=3.19870796048523e-06 G_eff=3.19870796048523e-06
Ro4n3n1 h3y o4p 312622.865650943
* o4 input 4 w=+0.10049322803724 w+  bank=n alpha=1 R=331697.309205562 G_phys=3.01479684111719e-06 G_eff=3.01479684111719e-06
Ro4p4n1 h4yn o4p 331614.54406358
* o4 input 5 w=-0.195742340683107 w-  bank=n alpha=1 R=170291.890947078 G_phys=5.87227022049321e-06 G_eff=5.87227022049321e-06
Ro4n5n1 h5y o4p 169480.678800769
* o4 input 6 w=-0.202179592890339 w-  bank=n alpha=1 R=164869.920137851 G_phys=6.06538778671016e-06 G_eff=6.06538778671016e-06
Ro4n6n1 h6y o4p 165002.648037274
* o4 input 7 w=-0.112561544712497 w-  bank=n alpha=1 R=296134.291853162 G_phys=3.37684634137491e-06 G_eff=3.37684634137491e-06
Ro4n7n1 h7y o4p 296545.42770328
* o4 input 8 w=+0.0264861793940817 w+  bank=f alpha=0.001 R=1258.5179930021 G_phys=0.000794585381822452 G_eff=7.94585381822452e-07
Ro4p8f1 htap8n o4p 1256.75851742596
* o4 input 9 w=-0.0974936293293829 w-  bank=n alpha=1 R=341902.681873874 G_phys=2.92480887988149e-06 G_eff=2.92480887988149e-06
Ro4n9n1 h9y o4p 341324.870667504
* o4 input 10 w=-0.296895349286464 w-  bank=n alpha=1 R=112273.006005127 G_phys=8.90686047859392e-06 G_eff=8.90686047859392e-06
Ro4n10n1 h10y o4p 112113.186511968
* o4 input 11 w=-0.580818210763829 w-  bank=n alpha=1 R=57390.303395441 G_phys=1.74245463229149e-05 G_eff=1.74245463229149e-05
Ro4n11n1 h11y o4p 57165.6063635945
* o4 input 12 w=-0.276549005245937 w-  bank=n alpha=1 R=120533.188335607 G_phys=8.29647015737811e-06 G_eff=8.29647015737811e-06
Ro4n12n1 h12y o4p 120756.258395437
* o4 input 13 w=-0.164579538023522 w-  bank=n alpha=1 R=202536.316079398 G_phys=4.93738614070565e-06 G_eff=4.93738614070565e-06
Ro4n13n1 h13y o4p 202909.528394724
* o4 input 14 w=-0.00939321676538441 w-  bank=f alpha=0.001 R=3548.66007736267 G_phys=0.000281796502961532 G_eff=2.81796502961532e-07
Ro4n14f1 htap14 o4p 3556.58085846614
* o4 input 15 w=-0.0690593814994067 w-  bank=n alpha=1 R=482676.395438319 G_phys=2.0717814449822e-06 G_eff=2.0717814449822e-06
Ro4n15n1 h15y o4p 484421.013047401
* o4 input 16 w=-0.272869230842632 w-  bank=n alpha=1 R=122158.637052623 G_phys=8.18607692527895e-06 G_eff=8.18607692527895e-06
Ro4n16n1 h16y o4p 121565.809410541
* o4 input 17 w=+0.168866320874711 w+  bank=n alpha=1 R=197394.798208843 G_phys=5.06598962624132e-06 G_eff=5.06598962624132e-06
Ro4p17n1 h17yn o4p 197166.051688161
* o4 input 18 w=-0.0339148293163791 w-  bank=n alpha=1 R=982854.226461786 G_phys=1.01744487949137e-06 G_eff=1.01744487949137e-06
Ro4n18n1 h18y o4p 978845.313977149
* o4 input 19 w=-0.0805852645818897 w-  bank=n alpha=1 R=413640.552106898 G_phys=2.41755793745669e-06 G_eff=2.41755793745669e-06
Ro4n19n1 h19y o4p 415194.011003191
* o4 input 20 w=+0.0499049155841609 w+  bank=n alpha=1 R=667936.874417093 G_phys=1.49714746752483e-06 G_eff=1.49714746752483e-06
Ro4p20n1 h20yn o4p 671210.504900877
* o4 input 21 w=+0.0630428027700635 w+  bank=n alpha=1 R=528741.29747864 G_phys=1.8912840831019e-06 G_eff=1.8912840831019e-06
Ro4p21n1 h21yn o4p 527540.092054481
* o4 input 22 w=+0.077534797791833 w+  bank=n alpha=1 R=429914.493655189 G_phys=2.32604393375499e-06 G_eff=2.32604393375499e-06
Ro4p22n1 h22yn o4p 430092.527781476
* o4 input 23 w=+0.0744829629231984 w+  bank=n alpha=1 R=447529.636645958 G_phys=2.23448888769595e-06 G_eff=2.23448888769595e-06
Ro4p23n1 h23yn o4p 447854.19021285
* o4 input 24 w=-0.00836970221956497 w-  bank=f alpha=0.001 R=3982.61879083506 G_phys=0.000251091066586949 G_eff=2.51091066586949e-07
Ro4n24f1 htap24 o4p 3987.9115251326
* o4 input 25 w=-0.0959555339157937 w-  bank=n alpha=1 R=347383.126048626 G_phys=2.87866601747381e-06 G_eff=2.87866601747381e-06
Ro4n25n1 h25y o4p 348623.649401093
* o4 input 26 w=-0.27047998771669 w-  bank=n alpha=1 R=123237.706474047 G_phys=8.1143996315007e-06 G_eff=8.1143996315007e-06
Ro4n26n1 h26y o4p 123512.10793819
* o4 input 27 w=-0.0478904255869687 w-  bank=n alpha=1 R=696033.349563792 G_phys=1.43671276760906e-06 G_eff=1.43671276760906e-06
Ro4n27n1 h27y o4p 697187.381708977
* o4 input 28 w=-0.311644423649809 w-  bank=n alpha=1 R=106959.505140351 G_phys=9.34933270949427e-06 G_eff=9.34933270949427e-06
Ro4n28n1 h28y o4p 106755.300342175
* o4 input 29 w=-0.0286856006407659 w-  bank=f alpha=0.001 R=1162.02319591532 G_phys=0.000860568019222978 G_eff=8.60568019222978e-07
Ro4n29f1 htap29 o4p 1161.79654824379
* o4 input 30 w=-0.016265879828258 w-  bank=f alpha=0.001 R=2049.27945400314 G_phys=0.000487976394847741 G_eff=4.87976394847741e-07
Ro4n30f1 htap30 o4p 2039.67390139449
* o4 input 31 w=-0.119685509607977 w-  bank=n alpha=1 R=278507.677683913 G_phys=3.59056528823931e-06 G_eff=3.59056528823931e-06
Ro4n31n1 h31y o4p 278197.13284007
* o4 input 32 w=-0.0356690164245122 w-  bank=n alpha=1 R=934517.872223306 G_phys=1.07007049273537e-06 G_eff=1.07007049273537e-06
Ro4n32n1 h32y o4p 934455.058479814
* o4 bias w+  bank=n alpha=1 R=496540.049452281 G_phys=2.01393623959048e-06 G_eff=2.01393623959048e-06
Ro4bpn1 vrefn o4p 496883.017963949
* feedback TIA o4: Rf=33333.3333333333 A=100000 V(o4lin) = -I(o4p)*Rf*A/(A+1)  (uncompensated)
* Exp 24 L TIA o4 -> o4lin, vg=o4p
Vo4os o4osref 0 DC 0.000214023
* servo o4: Vsum>0 discharges C so IN+ falls
Go4srv o4int 0 o4p 0 0.001
Co4int o4int 0 1e-08
Ro4int o4int 0 1000000000
Bo4plus o4osp 0 V = v(o4osref) + v(o4int)
Ao4tia %vd(o4osp o4p) o4lin limtia
Ro4f o4lin o4p 33378.4925505071

* o5 input 1 w=+0.0860510418468527 w+  bank=n alpha=1 R=387366.99309995 G_phys=2.58153125540558e-06 G_eff=2.58153125540558e-06
Ro5p1n1 h1yn o5p 385977.18498352
* o5 input 2 w=-0.140209371980717 w-  bank=n alpha=1 R=237739.695017803 G_phys=4.20628115942151e-06 G_eff=4.20628115942151e-06
Ro5n2n1 h2y o5p 238918.476248573
* o5 input 3 w=-0.298670153474102 w-  bank=n alpha=1 R=111605.839906008 G_phys=8.96010460422305e-06 G_eff=8.96010460422305e-06
Ro5n3n1 h3y o5p 111973.458249013
* o5 input 4 w=+0.194023589749981 w+  bank=n alpha=1 R=171800.415487038 G_phys=5.82070769249943e-06 G_eff=5.82070769249943e-06
Ro5p4n1 h4yn o5p 172481.526123431
* o5 input 5 w=+0.104223096266613 w+  bank=n alpha=1 R=319826.74212694 G_phys=3.1266928879984e-06 G_eff=3.1266928879984e-06
Ro5p5n1 h5yn o5p 318728.448404892
* o5 input 6 w=+0.179601423642336 w+  bank=n alpha=1 R=185596.153178131 G_phys=5.38804270927008e-06 G_eff=5.38804270927008e-06
Ro5p6n1 h6yn o5p 184671.890413253
* o5 input 7 w=-0.15816414054373 w-  bank=n alpha=1 R=210751.521923626 G_phys=4.74492421631189e-06 G_eff=4.74492421631189e-06
Ro5n7n1 h7y o5p 211797.444494271
* o5 input 8 w=-0.249576912278698 w-  bank=n alpha=1 R=133559.362638923 G_phys=7.48730736836095e-06 G_eff=7.48730736836095e-06
Ro5n8n1 h8y o5p 133270.361342429
* o5 input 9 w=-0.031381439286146 w-  bank=f alpha=0.001 R=1062.19899697364 G_phys=0.00094144317858438 G_eff=9.41443178584379e-07
Ro5n9f1 htap9 o5p 1060.32231032304
* o5 input 10 w=+0.375618440651073 w+  bank=n alpha=1 R=88742.5369094113 G_phys=1.12685532195322e-05 G_eff=1.12685532195322e-05
Ro5p10n1 h10yn o5p 89097.4875207308
* o5 input 11 w=+0.0953608962368974 w+  bank=n alpha=1 R=349549.287482848 G_phys=2.86082688710692e-06 G_eff=2.86082688710692e-06
Ro5p11n1 h11yn o5p 348774.986435457
* o5 input 12 w=+0.235920649298708 w+  bank=n alpha=1 R=141290.44419138 G_phys=7.07761947896125e-06 G_eff=7.07761947896125e-06
Ro5p12n1 h12yn o5p 141733.739957503
* o5 input 13 w=-0.0940916695355706 w-  bank=n alpha=1 R=354264.447616502 G_phys=2.82275008606712e-06 G_eff=2.82275008606712e-06
Ro5n13n1 h13y o5p 353839.629929113
* o5 input 14 w=+0.00295126144933853 w+  bank=f alpha=0.001 R=11294.6053426762 G_phys=8.85378434801559e-05 G_eff=8.85378434801559e-08
Ro5p14f1 htap14n o5p 11315.6231918785
* o5 input 15 w=+0.529616924207031 w+  bank=n alpha=1 R=62938.572786815 G_phys=1.58885077262109e-05 G_eff=1.58885077262109e-05
Ro5p15n1 h15yn o5p 62921.5163096372
* o5 input 16 w=+0.319042125899952 w+  bank=n alpha=1 R=104479.410796637 G_phys=9.57126377699856e-06 G_eff=9.57126377699856e-06
Ro5p16n1 h16yn o5p 104784.262597884
* o5 input 17 w=-0.466616152697173 w-  bank=n alpha=1 R=71436.3039956017 G_phys=1.39984845809152e-05 G_eff=1.39984845809152e-05
Ro5n17n1 h17y o5p 71271.6610024451
* o5 input 18 w=-0.243973793531226 w-  bank=n alpha=1 R=136626.696051546 G_phys=7.31921380593677e-06 G_eff=7.31921380593677e-06
Ro5n18n1 h18y o5p 136398.065199652
* o5 input 19 w=-0.167620412829882 w-  bank=n alpha=1 R=198862.01668745 G_phys=5.02861238489647e-06 G_eff=5.02861238489647e-06
Ro5n19n1 h19y o5p 198216.752174967
* o5 input 20 w=+0.191248887162316 w+  bank=n alpha=1 R=174292.953166534 G_phys=5.73746661486949e-06 G_eff=5.73746661486949e-06
Ro5p20n1 h20yn o5p 174390.833043428
* o5 input 21 w=+0.174220054558956 w+  bank=n alpha=1 R=191328.91111599 G_phys=5.22660163676868e-06 G_eff=5.22660163676868e-06
Ro5p21n1 h21yn o5p 190433.496892787
* o5 input 22 w=-0.14737880105185 w-  bank=n alpha=1 R=226174.545426015 G_phys=4.4213640315555e-06 G_eff=4.4213640315555e-06
Ro5n22n1 h22y o5p 225075.436892867
* o5 input 23 w=-0.261133636281725 w-  bank=n alpha=1 R=127648.562659203 G_phys=7.83400908845174e-06 G_eff=7.83400908845174e-06
Ro5n23n1 h23y o5p 128020.516247218
* o5 input 24 w=+0.130521837388059 w+  bank=n alpha=1 R=255385.106434174 G_phys=3.91565512164177e-06 G_eff=3.91565512164177e-06
Ro5p24n1 h24yn o5p 254661.357254377
* o5 input 25 w=-0.326372621774105 w-  bank=n alpha=1 R=102132.749837101 G_phys=9.79117865322314e-06 G_eff=9.79117865322314e-06
Ro5n25n1 h25y o5p 101980.731641432
* o5 input 26 w=+0.16696553546102 w+  bank=n alpha=1 R=199641.99941799 G_phys=5.00896606383059e-06 G_eff=5.00896606383059e-06
Ro5p26n1 h26yn o5p 200136.91412038
* o5 input 27 w=-0.105618085709112 w-  bank=n alpha=1 R=315602.513618153 G_phys=3.16854257127337e-06 G_eff=3.16854257127337e-06
Ro5n27n1 h27y o5p 317063.826203694
* o5 input 28 w=+0.0630335864648206 w+  bank=n alpha=1 R=528818.606124163 G_phys=1.89100759394462e-06 G_eff=1.89100759394462e-06
Ro5p28n1 h28yn o5p 526592.716665763
* o5 input 29 w=+0.231531157265063 w+  bank=n alpha=1 R=143969.104318744 G_phys=6.94593471795189e-06 G_eff=6.94593471795189e-06
Ro5p29n1 h29yn o5p 144051.497580584
* o5 input 30 w=-0.0894419530377066 w-  bank=n alpha=1 R=372681.188203491 G_phys=2.6832585911312e-06 G_eff=2.6832585911312e-06
Ro5n30n1 h30y o5p 371833.933194519
* o5 input 31 w=+0.216486138811528 w+  bank=n alpha=1 R=153974.446199316 G_phys=6.49458416434585e-06 G_eff=6.49458416434585e-06
Ro5p31n1 h31yn o5p 154058.629007947
* o5 input 32 w=-0.32037829849107 w-  bank=n alpha=1 R=104043.668033472 G_phys=9.6113489547321e-06 G_eff=9.6113489547321e-06
Ro5n32n1 h32y o5p 104387.547854064
* o5 bias w+  bank=f alpha=0.001 R=14493.185792249 G_phys=6.89979425044561e-05 G_eff=6.89979425044561e-08
Ro5bpf1 taprefn o5p 14450.933627598
* feedback TIA o5: Rf=33333.3333333333 A=100000 V(o5lin) = -I(o5p)*Rf*A/(A+1)  (uncompensated)
* Exp 24 L TIA o5 -> o5lin, vg=o5p
Vo5os o5osref 0 DC 0.000214023
* servo o5: Vsum>0 discharges C so IN+ falls
Go5srv o5int 0 o5p 0 0.001
Co5int o5int 0 1e-08
Ro5int o5int 0 1000000000
Bo5plus o5osp 0 V = v(o5osref) + v(o5int)
Ao5tia %vd(o5osp o5p) o5lin limtia
Ro5f o5lin o5p 33299.8739626645

* o6 input 1 w=+0.177051530119574 w+  bank=n alpha=1 R=188269.106236028 G_phys=5.31154590358722e-06 G_eff=5.31154590358722e-06
Ro6p1n1 h1yn o6p 188745.704739424
* o6 input 2 w=+0.301592495922723 w+  bank=n alpha=1 R=110524.412191855 G_phys=9.04777487768168e-06 G_eff=9.04777487768168e-06
Ro6p2n1 h2yn o6p 110276.295667528
* o6 input 3 w=+0.171870982949934 w+  bank=n alpha=1 R=193943.92678282 G_phys=5.15612948849803e-06 G_eff=5.15612948849803e-06
Ro6p3n1 h3yn o6p 194753.894243962
* o6 input 4 w=-0.3405205591368 w-  bank=n alpha=1 R=97889.3415946205 G_phys=1.0215616774104e-05 G_eff=1.0215616774104e-05
Ro6n4n1 h4y o6p 97608.3212718957
* o6 input 5 w=-0.19025500833844 w-  bank=n alpha=1 R=175203.447333368 G_phys=5.70765025015321e-06 G_eff=5.70765025015321e-06
Ro6n5n1 h5y o6p 174503.414853292
* o6 input 6 w=+0.141724280050197 w+  bank=n alpha=1 R=235198.466497956 G_phys=4.25172840150592e-06 G_eff=4.25172840150592e-06
Ro6p6n1 h6yn o6p 235316.612765002
* o6 input 7 w=-0.0326153624876146 w-  bank=f alpha=0.001 R=1022.01327199694 G_phys=0.000978460874628438 G_eff=9.78460874628438e-07
Ro6n7f1 htap7 o6p 1023.98312229063
* o6 input 8 w=+0.106637930601 w+  bank=n alpha=1 R=312584.210378712 G_phys=3.19913791802999e-06 G_eff=3.19913791802999e-06
Ro6p8n1 h8yn o6p 313946.310599979
* o6 input 9 w=+0.167194950685368 w+  bank=n alpha=1 R=199368.062233296 G_phys=5.01584852056104e-06 G_eff=5.01584852056104e-06
Ro6p9n1 h9yn o6p 198679.514641358
* o6 input 10 w=-0.113695758135469 w-  bank=n alpha=1 R=293180.096425556 G_phys=3.41087274406406e-06 G_eff=3.41087274406406e-06
Ro6n10n1 h10y o6p 292656.815831186
* o6 input 11 w=+0.174899957381211 w+  bank=n alpha=1 R=190585.142686343 G_phys=5.24699872143633e-06 G_eff=5.24699872143633e-06
Ro6p11n1 h11yn o6p 190422.239029946
* o6 input 12 w=-0.244360694504916 w-  bank=n alpha=1 R=136410.372383611 G_phys=7.33082083514748e-06 G_eff=7.33082083514748e-06
Ro6n12n1 h12y o6p 135984.173762082
* o6 input 13 w=+0.255772583539878 w+  bank=n alpha=1 R=130324.106172764 G_phys=7.67317750619635e-06 G_eff=7.67317750619635e-06
Ro6p13n1 h13yn o6p 129803.493134067
* o6 input 14 w=+0.139949769298614 w+  bank=n alpha=1 R=238180.695119327 G_phys=4.19849307895843e-06 G_eff=4.19849307895843e-06
Ro6p14n1 h14yn o6p 239182.854468684
* o6 input 15 w=-0.401168375335584 w-  bank=n alpha=1 R=83090.6307244419 G_phys=1.20350512600675e-05 G_eff=1.20350512600675e-05
Ro6n15n1 h15y o6p 82916.2627360138
* o6 input 16 w=+0.405832076822582 w+  bank=n alpha=1 R=82135.777916603 G_phys=1.21749623046775e-05 G_eff=1.21749623046775e-05
Ro6p16n1 h16yn o6p 81855.7275587071
* o6 input 17 w=-0.113061682974004 w-  bank=n alpha=1 R=294824.315864798 G_phys=3.39185048922012e-06 G_eff=3.39185048922012e-06
Ro6n17n1 h17y o6p 296157.251908438
* o6 input 18 w=-0.197513353657142 w-  bank=n alpha=1 R=168764.960526141 G_phys=5.92540060971425e-06 G_eff=5.92540060971425e-06
Ro6n18n1 h18y o6p 168620.175677153
* o6 input 19 w=-0.228990652840289 w-  bank=n alpha=1 R=145566.349193222 G_phys=6.86971958520868e-06 G_eff=6.86971958520868e-06
Ro6n19n1 h19y o6p 146174.492983353
* o6 input 20 w=-0.216778558754084 w-  bank=n alpha=1 R=153766.744852045 G_phys=6.50335676262251e-06 G_eff=6.50335676262251e-06
Ro6n20n1 h20y o6p 153469.26872139
* o6 input 21 w=-0.139531541535413 w-  bank=n alpha=1 R=238894.610971336 G_phys=4.18594624606239e-06 G_eff=4.18594624606239e-06
Ro6n21n1 h21y o6p 239195.268209524
* o6 input 22 w=-0.394983843934915 w-  bank=n alpha=1 R=84391.6373927081 G_phys=1.18495153180474e-05 G_eff=1.18495153180474e-05
Ro6n22n1 h22y o6p 84480.4198217684
* o6 input 23 w=-0.193849822273603 w-  bank=n alpha=1 R=171954.41781879 G_phys=5.81549466820809e-06 G_eff=5.81549466820809e-06
Ro6n23n1 h23y o6p 172089.286989567
* o6 input 24 w=-0.0741873589980665 w-  bank=n alpha=1 R=449312.844984846 G_phys=2.22562076994199e-06 G_eff=2.22562076994199e-06
Ro6n24n1 h24y o6p 449174.131444125
* o6 input 25 w=-0.172655508406202 w-  bank=n alpha=1 R=193062.669364194 G_phys=5.17966525218605e-06 G_eff=5.17966525218605e-06
Ro6n25n1 h25y o6p 193660.95935437
* o6 input 26 w=+0.0670699610875517 w+  bank=n alpha=1 R=496993.479537295 G_phys=2.01209883262655e-06 G_eff=2.01209883262655e-06
Ro6p26n1 h26yn o6p 496760.450670793
* o6 input 27 w=+0.25363855276468 w+  bank=n alpha=1 R=131420.610037384 G_phys=7.60915658294039e-06 G_eff=7.60915658294039e-06
Ro6p27n1 h27yn o6p 131595.77754662
* o6 input 28 w=-0.179185579156039 w-  bank=n alpha=1 R=186026.874988115 G_phys=5.37556737468116e-06 G_eff=5.37556737468116e-06
Ro6n28n1 h28y o6p 186838.817840239
* o6 input 29 w=-0.129923130427228 w-  bank=n alpha=1 R=256561.962629155 G_phys=3.89769391281685e-06 G_eff=3.89769391281685e-06
Ro6n29n1 h29y o6p 255897.017611621
* o6 input 30 w=-0.169171092451912 w-  bank=n alpha=1 R=197039.179981701 G_phys=5.07513277355737e-06 G_eff=5.07513277355737e-06
Ro6n30n1 h30y o6p 196349.808429324
* o6 input 31 w=+0.218686712022964 w+  bank=n alpha=1 R=152425.051458238 G_phys=6.56060136068893e-06 G_eff=6.56060136068893e-06
Ro6p31n1 h31yn o6p 153163.73011383
* o6 input 32 w=+0.133370937368681 w+  bank=n alpha=1 R=249929.512313385 G_phys=4.00112812106042e-06 G_eff=4.00112812106042e-06
Ro6p32n1 h32yn o6p 248902.688986514
* o6 bias w+  bank=n alpha=1 R=514207.987696552 G_phys=1.94473836254393e-06 G_eff=1.94473836254393e-06
Ro6bpn1 vrefn o6p 515416.281162013
* feedback TIA o6: Rf=33333.3333333333 A=100000 V(o6lin) = -I(o6p)*Rf*A/(A+1)  (uncompensated)
* Exp 24 L TIA o6 -> o6lin, vg=o6p
Vo6os o6osref 0 DC 0.000214023
* servo o6: Vsum>0 discharges C so IN+ falls
Go6srv o6int 0 o6p 0 0.001
Co6int o6int 0 1e-08
Ro6int o6int 0 1000000000
Bo6plus o6osp 0 V = v(o6osref) + v(o6int)
Ao6tia %vd(o6osp o6p) o6lin limtia
Ro6f o6lin o6p 33433.3612002804

* o7 input 1 w=+0.130193574665561 w+  bank=n alpha=1 R=256029.020010853 G_phys=3.90580723996683e-06 G_eff=3.90580723996683e-06
Ro7p1n1 h1yn o7p 256381.435412102
* o7 input 2 w=+0.394190134763453 w+  bank=n alpha=1 R=84561.5615249634 G_phys=1.18257040429036e-05 G_eff=1.18257040429036e-05
Ro7p2n1 h2yn o7p 84862.3057712847
* o7 input 3 w=+0.206617853142924 w+  bank=n alpha=1 R=161328.427463021 G_phys=6.19853559428773e-06 G_eff=6.19853559428773e-06
Ro7p3n1 h3yn o7p 161459.341854694
* o7 input 4 w=-0.378033462280536 w-  bank=n alpha=1 R=88175.6158098959 G_phys=1.13410038684161e-05 G_eff=1.13410038684161e-05
Ro7n4n1 h4y o7p 88076.0553324815
* o7 input 5 w=-0.580108461232067 w-  bank=n alpha=1 R=57460.5191286783 G_phys=1.7403253836962e-05 G_eff=1.7403253836962e-05
Ro7n5n1 h5y o7p 57616.3415410494
* o7 input 6 w=+0.107934080055711 w+  bank=n alpha=1 R=308830.476121427 G_phys=3.23802240167132e-06 G_eff=3.23802240167132e-06
Ro7p6n1 h6yn o7p 307549.387932372
* o7 input 7 w=+0.101501144533757 w+  bank=n alpha=1 R=328403.521816913 G_phys=3.04503433601271e-06 G_eff=3.04503433601271e-06
Ro7p7n1 h7yn o7p 326994.388686143
* o7 input 8 w=+0.0692471666647439 w+  bank=n alpha=1 R=481367.468718463 G_phys=2.07741499994232e-06 G_eff=2.07741499994232e-06
Ro7p8n1 h8yn o7p 483376.636922771
* o7 input 9 w=-0.335430638558454 w-  bank=n alpha=1 R=99374.7424999297 G_phys=1.00629191567536e-05 G_eff=1.00629191567536e-05
Ro7n9n1 h9y o7p 99050.039948658
* o7 input 10 w=+0.101094797691112 w+  bank=n alpha=1 R=329723.527764315 G_phys=3.03284393073337e-06 G_eff=3.03284393073337e-06
Ro7p10n1 h10yn o7p 329180.091688734
* o7 input 11 w=-0.148243371766924 w-  bank=n alpha=1 R=224855.472025703 G_phys=4.44730115300771e-06 G_eff=4.44730115300771e-06
Ro7n11n1 h11y o7p 224271.94282583
* o7 input 12 w=-0.334713947003149 w-  bank=n alpha=1 R=99587.5243077928 G_phys=1.00414184100945e-05 G_eff=1.00414184100945e-05
Ro7n12n1 h12y o7p 99337.9826185139
* o7 input 13 w=-0.322800486422993 w-  bank=n alpha=1 R=103262.958809962 G_phys=9.68401459268979e-06 G_eff=9.68401459268979e-06
Ro7n13n1 h13y o7p 103279.760484663
* o7 input 14 w=-0.104357857187523 w-  bank=n alpha=1 R=319413.73876081 G_phys=3.13073571562568e-06 G_eff=3.13073571562568e-06
Ro7n14n1 h14y o7p 318966.962740568
* o7 input 15 w=+0.182195051802482 w+  bank=n alpha=1 R=182954.108816688 G_phys=5.46585155407446e-06 G_eff=5.46585155407446e-06
Ro7p15n1 h15yn o7p 182045.502255078
* o7 input 16 w=+0.0146234127477982 w+  bank=f alpha=0.001 R=2279.44966802309 G_phys=0.000438702382433947 G_eff=4.38702382433947e-07
Ro7p16f1 htap16n o7p 2282.68355454631
* o7 input 17 w=-0.0268461940667064 w-  bank=f alpha=0.001 R=1241.64092871071 G_phys=0.000805385822001192 G_eff=8.05385822001192e-07
Ro7n17f1 htap17 o7p 1246.69017419881
* o7 input 18 w=+0.263886686193095 w+  bank=n alpha=1 R=126316.843847674 G_phys=7.91660058579284e-06 G_eff=7.91660058579284e-06
Ro7p18n1 h18yn o7p 125834.193347796
* o7 input 19 w=+0.184182739421503 w+  bank=n alpha=1 R=180979.680495738 G_phys=5.52548218264508e-06 G_eff=5.52548218264508e-06
Ro7p19n1 h19yn o7p 181096.20566428
* o7 input 20 w=-0.16994338127458 w-  bank=n alpha=1 R=196143.757311009 G_phys=5.09830143823739e-06 G_eff=5.09830143823739e-06
Ro7n20n1 h20y o7p 196685.429161122
* o7 input 21 w=-0.17515931490212 w-  bank=n alpha=1 R=190302.94421944 G_phys=5.25477944706359e-06 G_eff=5.25477944706359e-06
Ro7n21n1 h21y o7p 191150.015846301
* o7 input 22 w=+0.170460541565249 w+  bank=n alpha=1 R=195548.67670401 G_phys=5.11381624695746e-06 G_eff=5.11381624695746e-06
Ro7p22n1 h22yn o7p 194785.230782319
* o7 input 23 w=-0.342102206419994 w-  bank=n alpha=1 R=97436.7680412165 G_phys=1.02630661925998e-05 G_eff=1.02630661925998e-05
Ro7n23n1 h23y o7p 97457.1932102257
* o7 input 24 w=-0.0940891241579366 w-  bank=n alpha=1 R=354274.031474461 G_phys=2.8226737247381e-06 G_eff=2.8226737247381e-06
Ro7n24n1 h24y o7p 355931.789861695
* o7 input 25 w=-0.147263798833488 w-  bank=n alpha=1 R=226351.171145758 G_phys=4.41791396500465e-06 G_eff=4.41791396500465e-06
Ro7n25n1 h25y o7p 226933.388544516
* o7 input 26 w=-0.0975787524659246 w-  bank=n alpha=1 R=341604.421976738 G_phys=2.92736257397774e-06 G_eff=2.92736257397774e-06
Ro7n26n1 h26y o7p 340060.604601959
* o7 input 27 w=-0.201262065009158 w-  bank=n alpha=1 R=165621.540908947 G_phys=6.03786195027474e-06 G_eff=6.03786195027474e-06
Ro7n27n1 h27y o7p 165054.587938474
* o7 input 28 w=-0.060609790215781 w-  bank=n alpha=1 R=549966.155874506 G_phys=1.81829370647343e-06 G_eff=1.81829370647343e-06
Ro7n28n1 h28y o7p 551044.9306183
* o7 input 29 w=-0.355920486311588 w-  bank=n alpha=1 R=93653.8766811862 G_phys=1.06776145893477e-05 G_eff=1.06776145893477e-05
Ro7n29n1 h29y o7p 93276.8068012851
* o7 input 30 w=+0.0702967455487947 w+  bank=n alpha=1 R=474180.320484337 G_phys=2.10890236646384e-06 G_eff=2.10890236646384e-06
Ro7p30n1 h30yn o7p 473804.153566653
* o7 input 31 w=+0.188674793501044 w+  bank=n alpha=1 R=176670.835116874 G_phys=5.66024380503133e-06 G_eff=5.66024380503133e-06
Ro7p31n1 h31yn o7p 177293.413636829
* o7 input 32 w=-0.221533996080022 w-  bank=n alpha=1 R=150465.995843332 G_phys=6.64601988240065e-06 G_eff=6.64601988240065e-06
Ro7n32n1 h32y o7p 149953.515483325
* o7 bias w+  bank=n alpha=1 R=694833.256669366 G_phys=1.43919421012378e-06 G_eff=1.43919421012378e-06
Ro7bpn1 vrefn o7p 692570.209288943
* feedback TIA o7: Rf=33333.3333333333 A=100000 V(o7lin) = -I(o7p)*Rf*A/(A+1)  (uncompensated)
* Exp 24 L TIA o7 -> o7lin, vg=o7p
Vo7os o7osref 0 DC 0.000214023
* servo o7: Vsum>0 discharges C so IN+ falls
Go7srv o7int 0 o7p 0 0.001
Co7int o7int 0 1e-08
Ro7int o7int 0 1000000000
Bo7plus o7osp 0 V = v(o7osref) + v(o7int)
Ao7tia %vd(o7osp o7p) o7lin limtia
Ro7f o7lin o7p 33171.1088798021

* o8 input 1 w=-0.264579445854062 w-  bank=n alpha=1 R=125986.103061534 G_phys=7.93738337562187e-06 G_eff=7.93738337562187e-06
Ro8n1n1 h1y o8p 125443.755614386
* o8 input 2 w=-0.461651647659873 w-  bank=n alpha=1 R=72204.5150327114 G_phys=1.38495494297962e-05 G_eff=1.38495494297962e-05
Ro8n2n1 h2y o8p 72545.1696968227
* o8 input 3 w=-0.248506615035073 w-  bank=n alpha=1 R=134134.591663199 G_phys=7.45519845105219e-06 G_eff=7.45519845105219e-06
Ro8n3n1 h3y o8p 134160.950290627
* o8 input 4 w=-0.0596907059046396 w-  bank=n alpha=1 R=558434.22905043 G_phys=1.79072117713919e-06 G_eff=1.79072117713919e-06
Ro8n4n1 h4y o8p 558576.20158854
* o8 input 5 w=-0.142952779428107 w-  bank=n alpha=1 R=233177.231437442 G_phys=4.28858338284322e-06 G_eff=4.28858338284322e-06
Ro8n5n1 h5y o8p 232775.624177273
* o8 input 6 w=+0.230947580946818 w+  bank=n alpha=1 R=144332.896654195 G_phys=6.92842742840454e-06 G_eff=6.92842742840454e-06
Ro8p6n1 h6yn o8p 143765.77330541
* o8 input 7 w=+0.224542704495923 w+  bank=n alpha=1 R=148449.861277673 G_phys=6.7362811348777e-06 G_eff=6.7362811348777e-06
Ro8p7n1 h7yn o8p 149085.474724666
* o8 input 8 w=-0.0814289785611842 w-  bank=n alpha=1 R=409354.678424307 G_phys=2.44286935683553e-06 G_eff=2.44286935683553e-06
Ro8n8n1 h8y o8p 408721.258887512
* o8 input 9 w=+0.151871407153412 w+  bank=n alpha=1 R=219483.93024147 G_phys=4.55614221460235e-06 G_eff=4.55614221460235e-06
Ro8p9n1 h9yn o8p 220522.709327665
* o8 input 10 w=-0.0439376442611886 w-  bank=n alpha=1 R=758650.899333209 G_phys=1.31812932783566e-06 G_eff=1.31812932783566e-06
Ro8n10n1 h10y o8p 756855.93615741
* o8 input 11 w=-0.0114777570667242 w-  bank=f alpha=0.001 R=2904.16787352748 G_phys=0.000344332712001725 G_eff=3.44332712001725e-07
Ro8n11f1 htap11 o8p 2904.51584497163
* o8 input 12 w=-0.184091969163629 w-  bank=n alpha=1 R=181068.91617692 G_phys=5.52275907490888e-06 G_eff=5.52275907490888e-06
Ro8n12n1 h12y o8p 180340.545351614
* o8 input 13 w=+0.167375709493599 w+  bank=n alpha=1 R=199152.753014069 G_phys=5.02127128480798e-06 G_eff=5.02127128480798e-06
Ro8p13n1 h13yn o8p 198719.252750078
* o8 input 14 w=+0.639794426458427 w+  bank=n alpha=1 R=52100.068326399 G_phys=1.91938327937528e-05 G_eff=1.91938327937528e-05
Ro8p14n1 h14yn o8p 52171.3697180624
* o8 input 15 w=+0.00251732875304732 w+  bank=f alpha=0.001 R=13241.5495167177 G_phys=7.55198625914195e-05 G_eff=7.55198625914195e-08
Ro8p15f1 htap15n o8p 13253.3400731003
* o8 input 16 w=+0.510552134317183 w+  bank=n alpha=1 R=65288.7944106113 G_phys=1.53165640295155e-05 G_eff=1.53165640295155e-05
Ro8p16n1 h16yn o8p 65540.0364514479
* o8 input 17 w=-0.402994248540282 w-  bank=n alpha=1 R=82714.166403299 G_phys=1.20898274562085e-05 G_eff=1.20898274562085e-05
Ro8n17n1 h17y o8p 83064.6761291001
* o8 input 18 w=+0.141582671709231 w+  bank=n alpha=1 R=235433.707606466 G_phys=4.24748015127692e-06 G_eff=4.24748015127692e-06
Ro8p18n1 h18yn o8p 234345.598450229
* o8 input 19 w=+0.181760587882604 w+  bank=n alpha=1 R=183391.425620073 G_phys=5.45281763647812e-06 G_eff=5.45281763647812e-06
Ro8p19n1 h19yn o8p 184173.500604781
* o8 input 20 w=+0.465247625040388 w+  bank=n alpha=1 R=71646.4341552301 G_phys=1.39574287512116e-05 G_eff=1.39574287512116e-05
Ro8p20n1 h20yn o8p 71936.2498762337
* o8 input 21 w=-0.129997678502292 w-  bank=n alpha=1 R=256414.835382969 G_phys=3.89993035506876e-06 G_eff=3.89993035506876e-06
Ro8n21n1 h21y o8p 255433.174343522
* o8 input 22 w=+0.727771195072513 w+  bank=n alpha=1 R=45801.9409932982 G_phys=2.18331358521754e-05 G_eff=2.18331358521754e-05
Ro8p22n1 h22yn o8p 45665.9283315131
* o8 input 23 w=+0.0590279674258587 w+  bank=n alpha=1 R=564704.068036922 G_phys=1.77083902277576e-06 G_eff=1.77083902277576e-06
Ro8p23n1 h23yn o8p 565197.044681582
* o8 input 24 w=-0.0219880792573176 w-  bank=f alpha=0.001 R=1515.97294803456 G_phys=0.000659642377719527 G_eff=6.59642377719527e-07
Ro8n24f1 htap24 o8p 1521.01206953096
* o8 input 25 w=-0.000673889145733125 w-  bank=f alpha=0.001 R=49464.1196469635 G_phys=2.02166743719938e-05 G_eff=2.02166743719938e-08
Ro8n25f1 htap25 o8p 49449.1468026232
* o8 input 26 w=-0.0895992045192751 w-  bank=n alpha=1 R=372027.112430027 G_phys=2.68797613557825e-06 G_eff=2.68797613557825e-06
Ro8n26n1 h26y o8p 371947.462482509
* o8 input 27 w=-0.161030155307918 w-  bank=n alpha=1 R=207000.56625788 G_phys=4.83090465923753e-06 G_eff=4.83090465923753e-06
Ro8n27n1 h27y o8p 207146.693483927
* o8 input 28 w=-0.0515875057732319 w-  bank=n alpha=1 R=646151.288644577 G_phys=1.54762517319696e-06 G_eff=1.54762517319696e-06
Ro8n28n1 h28y o8p 647865.221242425
* o8 input 29 w=-0.167333727666792 w-  bank=n alpha=1 R=199202.71781496 G_phys=5.02001183000377e-06 G_eff=5.02001183000377e-06
Ro8n29n1 h29y o8p 199532.211021195
* o8 input 30 w=+0.117154510339097 w+  bank=n alpha=1 R=284524.541452582 G_phys=3.5146353101729e-06 G_eff=3.5146353101729e-06
Ro8p30n1 h30yn o8p 284324.729891502
* o8 input 31 w=-0.114263857072683 w-  bank=n alpha=1 R=291722.458766031 G_phys=3.42791571218049e-06 G_eff=3.42791571218049e-06
Ro8n31n1 h31y o8p 290943.669084887
* o8 input 32 w=+0.185068242761295 w+  bank=n alpha=1 R=180113.739861503 G_phys=5.55204728283885e-06 G_eff=5.55204728283885e-06
Ro8p32n1 h32yn o8p 180664.01213489
* o8 bias w+  bank=n alpha=1 R=473927.47001289 G_phys=2.11002751111431e-06 G_eff=2.11002751111431e-06
Ro8bpn1 vrefn o8p 475499.747956479
* feedback TIA o8: Rf=33333.3333333333 A=100000 V(o8lin) = -I(o8p)*Rf*A/(A+1)  (uncompensated)
* Exp 24 L TIA o8 -> o8lin, vg=o8p
Vo8os o8osref 0 DC 0.000214023
* servo o8: Vsum>0 discharges C so IN+ falls
Go8srv o8int 0 o8p 0 0.001
Co8int o8int 0 1e-08
Ro8int o8int 0 1000000000
Bo8plus o8osp 0 V = v(o8osref) + v(o8int)
Ao8tia %vd(o8osp o8p) o8lin limtia
Ro8f o8lin o8p 33434.381593408

* o9 input 1 w=-0.342788496026982 w-  bank=n alpha=1 R=97241.6919461309 G_phys=1.02836548808095e-05 G_eff=1.02836548808095e-05
Ro9n1n1 h1y o9p 97039.8017540289
* o9 input 2 w=+0.117901804588507 w+  bank=n alpha=1 R=282721.146208671 G_phys=3.5370541376552e-06 G_eff=3.5370541376552e-06
Ro9p2n1 h2yn o9p 281647.886280079
* o9 input 3 w=-0.555835720214104 w-  bank=n alpha=1 R=59969.7574680763 G_phys=1.66750716064231e-05 G_eff=1.66750716064231e-05
Ro9n3n1 h3y o9p 60101.8661815903
* o9 input 4 w=+0.355136587925528 w+  bank=n alpha=1 R=93860.6003060526 G_phys=1.06540976377658e-05 G_eff=1.06540976377658e-05
Ro9p4n1 h4yn o9p 93693.3352406833
* o9 input 5 w=+0.236432436172994 w+  bank=n alpha=1 R=140984.603774686 G_phys=7.09297308518982e-06 G_eff=7.09297308518982e-06
Ro9p5n1 h5yn o9p 141039.599645271
* o9 input 6 w=-0.00589463242951189 w-  bank=f alpha=0.001 R=5654.86206848924 G_phys=0.000176838972885357 G_eff=1.76838972885357e-07
Ro9n6f1 htap6 o9p 5647.48886370465
* o9 input 7 w=-0.175810166557473 w-  bank=n alpha=1 R=189598.440101794 G_phys=5.27430499672418e-06 G_eff=5.27430499672418e-06
Ro9n7n1 h7y o9p 188771.579527595
* o9 input 8 w=+0.162552656301944 w+  bank=n alpha=1 R=205061.757166343 G_phys=4.87657968905832e-06 G_eff=4.87657968905832e-06
Ro9p8n1 h8yn o9p 206048.3119146
* o9 input 9 w=-0.443497798175432 w-  bank=n alpha=1 R=75160.0875370025 G_phys=1.3304933945263e-05 G_eff=1.3304933945263e-05
Ro9n9n1 h9y o9p 75112.3116050671
* o9 input 10 w=+0.114863161009978 w+  bank=n alpha=1 R=290200.383136224 G_phys=3.44589483029933e-06 G_eff=3.44589483029933e-06
Ro9p10n1 h10yn o9p 289538.160916637
* o9 input 11 w=-0.051706338551111 w-  bank=n alpha=1 R=644666.287874624 G_phys=1.55119015653333e-06 G_eff=1.55119015653333e-06
Ro9n11n1 h11y o9p 642701.371194088
* o9 input 12 w=-0.247913853258797 w-  bank=n alpha=1 R=134455.307338298 G_phys=7.43741559776392e-06 G_eff=7.43741559776392e-06
Ro9n12n1 h12y o9p 134739.799487322
* o9 input 13 w=+0.0720916431840902 w+  bank=n alpha=1 R=462374.442599605 G_phys=2.16274929552271e-06 G_eff=2.16274929552271e-06
Ro9p13n1 h13yn o9p 460130.276154472
* o9 input 14 w=+0.00473033723811417 w+  bank=f alpha=0.001 R=7046.71393505597 G_phys=0.000141910117143425 G_eff=1.41910117143425e-07
Ro9p14f1 htap14n o9p 7079.09863166304
* o9 input 15 w=-0.290577914446662 w-  bank=n alpha=1 R=114713.925856371 G_phys=8.71733743339986e-06 G_eff=8.71733743339986e-06
Ro9n15n1 h15y o9p 115285.846181568
* o9 input 16 w=-0.0531648681945055 w-  bank=n alpha=1 R=626980.456556052 G_phys=1.59494604583516e-06 G_eff=1.59494604583516e-06
Ro9n16n1 h16y o9p 624812.001895534
* o9 input 17 w=+0.0157425177085947 w+  bank=f alpha=0.001 R=2117.40802521917 G_phys=0.000472275531257841 G_eff=4.72275531257841e-07
Ro9p17f1 htap17n o9p 2123.66103391741
* o9 input 18 w=-0.104777957691913 w-  bank=n alpha=1 R=318133.06985183 G_phys=3.14333873075738e-06 G_eff=3.14333873075738e-06
Ro9n18n1 h18y o9p 317200.416753557
* o9 input 19 w=-0.368259428743895 w-  bank=n alpha=1 R=90515.8992046201 G_phys=1.10477828623168e-05 G_eff=1.10477828623168e-05
Ro9n19n1 h19y o9p 90567.2351656367
* o9 input 20 w=+0.100989358745228 w+  bank=n alpha=1 R=330067.778897631 G_phys=3.02968076235683e-06 G_eff=3.02968076235683e-06
Ro9p20n1 h20yn o9p 330875.134160713
* o9 input 21 w=+0.084258883556939 w+  bank=n alpha=1 R=395606.15956664 G_phys=2.52776650670817e-06 G_eff=2.52776650670817e-06
Ro9p21n1 h21yn o9p 394395.451959754
* o9 input 22 w=+0.093068688723566 w+  bank=n alpha=1 R=358158.40741391 G_phys=2.79206066170698e-06 G_eff=2.79206066170698e-06
Ro9p22n1 h22yn o9p 357116.78816432
* o9 input 23 w=+0.153137872499505 w+  bank=n alpha=1 R=217668.776438311 G_phys=4.59413617498515e-06 G_eff=4.59413617498515e-06
Ro9p23n1 h23yn o9p 217472.418619598
* o9 input 24 w=+0.0107021071757068 w+  bank=f alpha=0.001 R=3114.65142201137 G_phys=0.000321063215271205 G_eff=3.21063215271205e-07
Ro9p24f1 htap24n o9p 3100.06580012901
* o9 input 25 w=+0.151859492007221 w+  bank=n alpha=1 R=219501.151312611 G_phys=4.55578476021664e-06 G_eff=4.55578476021664e-06
Ro9p25n1 h25yn o9p 219262.044237277
* o9 input 26 w=-0.0745603298060184 w-  bank=n alpha=1 R=447065.261380358 G_phys=2.23680989418055e-06 G_eff=2.23680989418055e-06
Ro9n26n1 h26y o9p 445725.688369842
* o9 input 27 w=+0.475223780202243 w+  bank=n alpha=1 R=70142.3933775947 G_phys=1.42567134060673e-05 G_eff=1.42567134060673e-05
Ro9p27n1 h27yn o9p 70094.2435819044
* o9 input 28 w=+0.715956917954612 w+  bank=n alpha=1 R=46557.736223238 G_phys=2.14787075386384e-05 G_eff=2.14787075386384e-05
Ro9p28n1 h28yn o9p 46434.9289060868
* o9 input 29 w=-0.520384445309866 w-  bank=n alpha=1 R=64055.2069412544 G_phys=1.5611533359296e-05 G_eff=1.5611533359296e-05
Ro9n29n1 h29y o9p 63993.9939775555
* o9 input 30 w=+0.217731604854565 w+  bank=n alpha=1 R=153093.683186685 G_phys=6.53194814563695e-06 G_eff=6.53194814563695e-06
Ro9p30n1 h30yn o9p 152770.167792811
* o9 input 31 w=-0.123913004875871 w-  bank=n alpha=1 R=269005.931756111 G_phys=3.71739014627614e-06 G_eff=3.71739014627614e-06
Ro9n31n1 h31y o9p 269571.15565098
* o9 input 32 w=+0.0869405958454977 w+  bank=n alpha=1 R=383403.552841644 G_phys=2.60821787536493e-06 G_eff=2.60821787536493e-06
Ro9p32n1 h32yn o9p 382459.675087327
* o9 bias w-  bank=f alpha=0.001 R=4242.12569305226 G_phys=0.000235730874650366 G_eff=2.35730874650366e-07
Ro9bnf1 tapref o9p 4234.65079494525
* feedback TIA o9: Rf=33333.3333333333 A=100000 V(o9lin) = -I(o9p)*Rf*A/(A+1)  (uncompensated)
* Exp 24 L TIA o9 -> o9lin, vg=o9p
Vo9os o9osref 0 DC 0.000214023
* servo o9: Vsum>0 discharges C so IN+ falls
Go9srv o9int 0 o9p 0 0.001
Co9int o9int 0 1e-08
Ro9int o9int 0 1000000000
Bo9plus o9osp 0 V = v(o9osref) + v(o9int)
Ao9tia %vd(o9osp o9p) o9lin limtia
Ro9f o9lin o9p 33302.8730655025

* o10 input 1 w=-0.0381763956958746 w-  bank=n alpha=1 R=873139.874148344 G_phys=1.14529187087624e-06 G_eff=1.14529187087624e-06
Ro10n1n1 h1y o10p 874352.455789785
* o10 input 2 w=+0.410781186996451 w+  bank=n alpha=1 R=81146.2023785947 G_phys=1.23234356098935e-05 G_eff=1.23234356098935e-05
Ro10p2n1 h2yn o10p 81360.9602940415
* o10 input 3 w=+0.475033421735393 w+  bank=n alpha=1 R=70170.5012913827 G_phys=1.42510026520618e-05 G_eff=1.42510026520618e-05
Ro10p3n1 h3yn o10p 70438.677715174
* o10 input 4 w=+0.0271427582394968 w+  bank=f alpha=0.001 R=1228.07465030685 G_phys=0.000814282747184905 G_eff=8.14282747184905e-07
Ro10p4f1 htap4n o10p 1231.71673744807
* o10 input 5 w=+0.0212799641995083 w+  bank=f alpha=0.001 R=1566.41867537087 G_phys=0.00063839892598525 G_eff=6.3839892598525e-07
Ro10p5f1 htap5n o10p 1567.43489976699
* o10 input 6 w=+0.0201273268189427 w+  bank=f alpha=0.001 R=1656.12322158758 G_phys=0.00060381980456828 G_eff=6.0381980456828e-07
Ro10p6f1 htap6n o10p 1652.14217435097
* o10 input 7 w=-0.036291550108304 w-  bank=n alpha=1 R=918487.450490747 G_phys=1.08874650324912e-06 G_eff=1.08874650324912e-06
Ro10n7n1 h7y o10p 919244.474507308
* o10 input 8 w=+0.0509688710938526 w+  bank=n alpha=1 R=653993.949992621 G_phys=1.52906613281558e-06 G_eff=1.52906613281558e-06
Ro10p8n1 h8yn o10p 653991.259101128
* o10 input 9 w=-0.135969386219015 w-  bank=n alpha=1 R=245153.223532546 G_phys=4.07908158657046e-06 G_eff=4.07908158657046e-06
Ro10n9n1 h9y o10p 243999.429910404
* o10 input 10 w=+0.542965243347564 w+  bank=n alpha=1 R=61391.2837731971 G_phys=1.62889573004269e-05 G_eff=1.62889573004269e-05
Ro10p10n1 h10yn o10p 61619.99906977
* o10 input 11 w=+0.200790198383509 w+  bank=n alpha=1 R=166010.759497666 G_phys=6.02370595150528e-06 G_eff=6.02370595150528e-06
Ro10p11n1 h11yn o10p 165523.682413614
* o10 input 12 w=-0.0602452386161185 w-  bank=n alpha=1 R=553294.071017507 G_phys=1.80735715848356e-06 G_eff=1.80735715848356e-06
Ro10n12n1 h12y o10p 551398.453790038
* o10 input 13 w=-0.18784742953156 w-  bank=n alpha=1 R=177448.972373258 G_phys=5.6354228859468e-06 G_eff=5.6354228859468e-06
Ro10n13n1 h13y o10p 177642.579195338
* o10 input 14 w=-0.0121063802780956 w-  bank=f alpha=0.001 R=2753.36909692523 G_phys=0.000363191408342867 G_eff=3.63191408342867e-07
Ro10n14f1 htap14 o10p 2748.49964353702
* o10 input 15 w=+0.162912924713055 w+  bank=n alpha=1 R=204608.280110646 G_phys=4.88738774139165e-06 G_eff=4.88738774139165e-06
Ro10p15n1 h15yn o10p 204110.554447106
* o10 input 16 w=+0.000496602144198326 w+  bank=f alpha=0.001 R=67122.8139522916 G_phys=1.48980643259498e-05 G_eff=1.48980643259498e-08
Ro10p16f1 htap16n o10p 67178.4699354786
* o10 input 17 w=+0.150471984074884 w+  bank=n alpha=1 R=221525.179841748 G_phys=4.51415952224652e-06 G_eff=4.51415952224652e-06
Ro10p17n1 h17yn o10p 221160.735495217
* o10 input 18 w=-0.0993574349593851 w-  bank=n alpha=1 R=335489.068804556 G_phys=2.98072304878155e-06 G_eff=2.98072304878155e-06
Ro10n18n1 h18y o10p 336726.826806682
* o10 input 19 w=-0.0430450321763909 w-  bank=n alpha=1 R=774382.818364248 G_phys=1.29135096529173e-06 G_eff=1.29135096529173e-06
Ro10n19n1 h19y o10p 774351.659074922
* o10 input 20 w=-0.498578232263262 w-  bank=n alpha=1 R=66856.7762816658 G_phys=1.49573469678979e-05 G_eff=1.49573469678979e-05
Ro10n20n1 h20y o10p 66523.9787251599
* o10 input 21 w=-0.135185117923925 w-  bank=n alpha=1 R=246575.465149141 G_phys=4.05555353771776e-06 G_eff=4.05555353771776e-06
Ro10n21n1 h21y o10p 247298.041970416
* o10 input 22 w=+0.00794231626553338 w+  bank=f alpha=0.001 R=4196.92848016985 G_phys=0.000238269487966002 G_eff=2.38269487966002e-07
Ro10p22f1 htap22n o10p 4205.68964531726
* o10 input 23 w=-0.411689837989046 w-  bank=n alpha=1 R=80967.1025550556 G_phys=1.23506951396714e-05 G_eff=1.23506951396714e-05
Ro10n23n1 h23y o10p 81169.7796323373
* o10 input 24 w=+0.321047972853849 w+  bank=n alpha=1 R=103826.643217921 G_phys=9.63143918561547e-06 G_eff=9.63143918561547e-06
Ro10p24n1 h24yn o10p 103886.740291517
* o10 input 25 w=-0.130972309748016 w-  bank=n alpha=1 R=254506.722813891 G_phys=3.92916929244047e-06 G_eff=3.92916929244047e-06
Ro10n25n1 h25y o10p 254719.596982629
* o10 input 26 w=+0.0365278526067883 w+  bank=n alpha=1 R=912545.659120916 G_phys=1.09583557820365e-06 G_eff=1.09583557820365e-06
Ro10p26n1 h26yn o10p 909895.725720366
* o10 input 27 w=-0.205674584301975 w-  bank=n alpha=1 R=162068.315083563 G_phys=6.17023752905924e-06 G_eff=6.17023752905924e-06
Ro10n27n1 h27y o10p 162211.89424054
* o10 input 28 w=-0.0123163999797875 w-  bank=f alpha=0.001 R=2706.41854665624 G_phys=0.000369491999393624 G_eff=3.69491999393624e-07
Ro10n28f1 htap28 o10p 2715.456700475
* o10 input 29 w=-0.120487475126756 w-  bank=n alpha=1 R=276653.928537102 G_phys=3.61462425380267e-06 G_eff=3.61462425380267e-06
Ro10n29n1 h29y o10p 275725.543332612
* o10 input 30 w=-0.421650115672696 w-  bank=n alpha=1 R=79054.486396034 G_phys=1.26495034701809e-05 G_eff=1.26495034701809e-05
Ro10n30n1 h30y o10p 78785.742099171
* o10 input 31 w=+0.15176529701113 w+  bank=n alpha=1 R=219637.387398838 G_phys=4.55295891033391e-06 G_eff=4.55295891033391e-06
Ro10p31n1 h31yn o10p 219560.180156554
* o10 input 32 w=+0.00307524765960727 w+  bank=f alpha=0.001 R=10839.2354122107 G_phys=9.22574297882182e-05 G_eff=9.22574297882182e-08
Ro10p32f1 htap32n o10p 10820.6265202358
* o10 bias w-  bank=f alpha=0.001 R=1066.20335663783 G_phys=0.000937907383028131 G_eff=9.37907383028131e-07
Ro10bnf1 tapref o10p 1065.43405661615
* feedback TIA o10: Rf=33333.3333333333 A=100000 V(o10lin) = -I(o10p)*Rf*A/(A+1)  (uncompensated)
* Exp 24 L TIA o10 -> o10lin, vg=o10p
Vo10os o10osref 0 DC 0.000214023
* servo o10: Vsum>0 discharges C so IN+ falls
Go10srv o10int 0 o10p 0 0.001
Co10int o10int 0 1e-08
Ro10int o10int 0 1000000000
Bo10plus o10osp 0 V = v(o10osref) + v(o10int)
Ao10tia %vd(o10osp o10p) o10lin limtia
Ro10f o10lin o10p 33393.9354517077

* o11 input 1 w=-0.160102279955593 w-  bank=n alpha=1 R=208200.241386812 G_phys=4.80306839866778e-06 G_eff=4.80306839866778e-06
Ro11n1n1 h1y o11p 208444.367753089
* o11 input 2 w=+0.011469223690656 w+  bank=f alpha=0.001 R=2906.32864371544 G_phys=0.00034407671071968 G_eff=3.4407671071968e-07
Ro11p2f1 htap2n o11p 2917.99688853016
* o11 input 3 w=+0.0176041755498141 w+  bank=f alpha=0.001 R=1893.49016879608 G_phys=0.000528125266494424 G_eff=5.28125266494424e-07
Ro11p3f1 htap3n o11p 1887.81400014904
* o11 input 4 w=-0.0193710750418404 w-  bank=f alpha=0.001 R=1720.77870027013 G_phys=0.000581132251255212 G_eff=5.81132251255212e-07
Ro11n4f1 htap4 o11p 1723.61687758861
* o11 input 5 w=+0.112602634979867 w+  bank=n alpha=1 R=296026.228331984 G_phys=3.37807904939602e-06 G_eff=3.37807904939602e-06
Ro11p5n1 h5yn o11p 295572.312844819
* o11 input 6 w=+0.00163262396170036 w+  bank=f alpha=0.001 R=20417.0305687643 G_phys=4.89787188510109e-05 G_eff=4.89787188510109e-08
Ro11p6f1 htap6n o11p 20356.5641508566
* o11 input 7 w=-0.0344149127536822 w-  bank=n alpha=1 R=968572.361984759 G_phys=1.03244738261047e-06 G_eff=1.03244738261047e-06
Ro11n7n1 h7y o11p 966370.424130306
* o11 input 8 w=+0.0140339587694358 w+  bank=f alpha=0.001 R=2375.19105485255 G_phys=0.000421018763083073 G_eff=4.21018763083073e-07
Ro11p8f1 htap8n o11p 2370.06248544526
* o11 input 9 w=+0.200472625000294 w+  bank=n alpha=1 R=166273.741032146 G_phys=6.01417875000882e-06 G_eff=6.01417875000882e-06
Ro11p9n1 h9yn o11p 166652.941086214
* o11 input 10 w=+0.127220756971711 w+  bank=n alpha=1 R=262011.751280064 G_phys=3.81662270915132e-06 G_eff=3.81662270915132e-06
Ro11p10n1 h10yn o11p 261617.842532983
* o11 input 11 w=-0.215899699488286 w-  bank=n alpha=1 R=154392.680547209 G_phys=6.47699098464857e-06 G_eff=6.47699098464857e-06
Ro11n11n1 h11y o11p 154024.457128478
* o11 input 12 w=-0.0276713436872213 w-  bank=f alpha=0.001 R=1204.61563811687 G_phys=0.000830140310616638 G_eff=8.30140310616639e-07
Ro11n12f1 htap12 o11p 1200.81186241542
* o11 input 13 w=+0.188664634231365 w+  bank=n alpha=1 R=176680.34854087 G_phys=5.65993902694096e-06 G_eff=5.65993902694096e-06
Ro11p13n1 h13yn o11p 176450.176452632
* o11 input 14 w=-0.119078372545684 w-  bank=n alpha=1 R=279927.686453265 G_phys=3.57235117637052e-06 G_eff=3.57235117637052e-06
Ro11n14n1 h14y o11p 281015.897308193
* o11 input 15 w=+0.15422975355602 w+  bank=n alpha=1 R=216127.774082359 G_phys=4.6268926066806e-06 G_eff=4.6268926066806e-06
Ro11p15n1 h15yn o11p 215498.166169319
* o11 input 16 w=-0.104607206722078 w-  bank=n alpha=1 R=318652.360366468 G_phys=3.13821620166235e-06 G_eff=3.13821620166235e-06
Ro11n16n1 h16y o11p 317333.272287418
* o11 input 17 w=+0.106639727219858 w+  bank=n alpha=1 R=312578.944098482 G_phys=3.19919181659573e-06 G_eff=3.19919181659573e-06
Ro11p17n1 h17yn o11p 311593.577875956
* o11 input 18 w=+0.310905721051453 w+  bank=n alpha=1 R=107213.637692492 G_phys=9.32717163154358e-06 G_eff=9.32717163154358e-06
Ro11p18n1 h18yn o11p 107598.716978123
* o11 input 19 w=+0.210141672521531 w+  bank=n alpha=1 R=158623.146629415 G_phys=6.30425017564592e-06 G_eff=6.30425017564592e-06
Ro11p19n1 h19yn o11p 158399.20338417
* o11 input 20 w=+0.009349861892821 w+  bank=f alpha=0.001 R=3565.11504826903 G_phys=0.00028049585678463 G_eff=2.8049585678463e-07
Ro11p20f1 htap20n o11p 3578.72646014321
* o11 input 21 w=-0.148461029214851 w-  bank=n alpha=1 R=224525.81333714 G_phys=4.45383087644554e-06 G_eff=4.45383087644554e-06
Ro11n21n1 h21y o11p 224053.126966701
* o11 input 22 w=-0.118671866129314 w-  bank=n alpha=1 R=280886.56916384 G_phys=3.56015598387941e-06 G_eff=3.56015598387941e-06
Ro11n22n1 h22y o11p 281015.668716715
* o11 input 23 w=-0.109207143921327 w-  bank=n alpha=1 R=305230.336921427 G_phys=3.2762143176398e-06 G_eff=3.2762143176398e-06
Ro11n23n1 h23y o11p 304050.591565447
* o11 input 24 w=-0.0902417819363344 w-  bank=n alpha=1 R=369378.048816124 G_phys=2.70725345809003e-06 G_eff=2.70725345809003e-06
Ro11n24n1 h24y o11p 367745.458075739
* o11 input 25 w=+0.314745464583241 w+  bank=n alpha=1 R=105905.68279505 G_phys=9.44236393749723e-06 G_eff=9.44236393749723e-06
Ro11p25n1 h25yn o11p 106198.72355595
* o11 input 26 w=+0.0956381358816812 w+  bank=n alpha=1 R=348536.000059346 G_phys=2.86914407645044e-06 G_eff=2.86914407645044e-06
Ro11p26n1 h26yn o11p 348710.41707835
* o11 input 27 w=-0.150311342322866 w-  bank=n alpha=1 R=221761.929726726 G_phys=4.50934026968598e-06 G_eff=4.50934026968598e-06
Ro11n27n1 h27y o11p 222302.987950887
* o11 input 28 w=-0.0832874521070705 w-  bank=n alpha=1 R=400220.351205864 G_phys=2.49862356321211e-06 G_eff=2.49862356321211e-06
Ro11n28n1 h28y o11p 400778.696174929
* o11 input 29 w=+0.0404370827831914 w+  bank=n alpha=1 R=824325.86722574 G_phys=1.21311248349574e-06 G_eff=1.21311248349574e-06
Ro11p29n1 h29yn o11p 826592.814881544
* o11 input 30 w=-0.0722629324126473 w-  bank=n alpha=1 R=461278.448305807 G_phys=2.16788797237942e-06 G_eff=2.16788797237942e-06
Ro11n30n1 h30y o11p 463292.763615479
* o11 input 31 w=-0.0830409064130833 w-  bank=n alpha=1 R=401408.592140338 G_phys=2.4912271923925e-06 G_eff=2.4912271923925e-06
Ro11n31n1 h31y o11p 401695.500626781
* o11 input 32 w=-0.390143512242536 w-  bank=n alpha=1 R=85438.6457479045 G_phys=1.17043053672761e-05 G_eff=1.17043053672761e-05
Ro11n32n1 h32y o11p 85238.452673089
* o11 bias w-  bank=f alpha=0.001 R=23104.9891990359 G_phys=4.32806954110901e-05 G_eff=4.32806954110902e-08
Ro11bnf1 tapref o11p 23155.9964529288
* feedback TIA o11: Rf=33333.3333333333 A=100000 V(o11lin) = -I(o11p)*Rf*A/(A+1)  (uncompensated)
* Exp 24 L TIA o11 -> o11lin, vg=o11p
Vo11os o11osref 0 DC 0.000214023
* servo o11: Vsum>0 discharges C so IN+ falls
Go11srv o11int 0 o11p 0 0.001
Co11int o11int 0 1e-08
Ro11int o11int 0 1000000000
Bo11plus o11osp 0 V = v(o11osref) + v(o11int)
Ao11tia %vd(o11osp o11p) o11lin limtia
Ro11f o11lin o11p 33240.4281110312

* o12 input 1 w=-0.0568819810826339 w-  bank=n alpha=1 R=586008.656852319 G_phys=1.70645943247902e-06 G_eff=1.70645943247902e-06
Ro12n1n1 h1y o12p 585311.841018771
* o12 input 2 w=-0.116449760348513 w-  bank=n alpha=1 R=286246.47430422 G_phys=3.4934928104554e-06 G_eff=3.4934928104554e-06
Ro12n2n1 h2y o12p 287089.645784238
* o12 input 3 w=-0.394245634375715 w-  bank=n alpha=1 R=84549.6574391152 G_phys=1.18273690312714e-05 G_eff=1.18273690312714e-05
Ro12n3n1 h3y o12p 84591.0982200715
* o12 input 4 w=-0.0304757769901363 w-  bank=f alpha=0.001 R=1093.76483966666 G_phys=0.000914273309704088 G_eff=9.14273309704088e-07
Ro12n4f1 htap4 o12p 1095.44362286441
* o12 input 5 w=-0.225077356892672 w-  bank=n alpha=1 R=148097.231074329 G_phys=6.75232070678017e-06 G_eff=6.75232070678017e-06
Ro12n5n1 h5y o12p 148168.456629618
* o12 input 6 w=-0.48876360312342 w-  bank=n alpha=1 R=68199.2953655269 G_phys=1.46629080937026e-05 G_eff=1.46629080937026e-05
Ro12n6n1 h6y o12p 68354.7903947095
* o12 input 7 w=+0.269859073889073 w+  bank=n alpha=1 R=123521.261868093 G_phys=8.09577221667219e-06 G_eff=8.09577221667219e-06
Ro12p7n1 h7yn o12p 123020.301597739
* o12 input 8 w=-0.0167144075003679 w-  bank=f alpha=0.001 R=1994.28746323192 G_phys=0.000501432225011038 G_eff=5.01432225011038e-07
Ro12n8f1 htap8 o12p 2002.79999888081
* o12 input 9 w=-0.271168635938693 w-  bank=n alpha=1 R=122924.737287352 G_phys=8.13505907816079e-06 G_eff=8.13505907816079e-06
Ro12n9n1 h9y o12p 123251.304211739
* o12 input 10 w=-0.229866523415109 w-  bank=n alpha=1 R=145011.691298509 G_phys=6.89599570245327e-06 G_eff=6.89599570245327e-06
Ro12n10n1 h10y o12p 145006.372659221
* o12 input 11 w=+0.111794037161303 w+  bank=n alpha=1 R=298167.363660355 G_phys=3.35382111483908e-06 G_eff=3.35382111483908e-06
Ro12p11n1 h11yn o12p 296953.837792921
* o12 input 12 w=-0.187970289472281 w-  bank=n alpha=1 R=177332.989308658 G_phys=5.63910868416843e-06 G_eff=5.63910868416843e-06
Ro12n12n1 h12y o12p 177270.724580394
* o12 input 13 w=+0.219867348390274 w+  bank=n alpha=1 R=151606.564491628 G_phys=6.59602045170821e-06 G_eff=6.59602045170821e-06
Ro12p13n1 h13yn o12p 151391.815228023
* o12 input 14 w=-0.127058880326711 w-  bank=n alpha=1 R=262345.561739739 G_phys=3.81176640980134e-06 G_eff=3.81176640980134e-06
Ro12n14n1 h14y o12p 262470.818102379
* o12 input 15 w=+0.40629100094033 w+  bank=n alpha=1 R=82043.0018291959 G_phys=1.21887300282099e-05 G_eff=1.21887300282099e-05
Ro12p15n1 h15yn o12p 81857.2582866617
* o12 input 16 w=-0.479164967789437 w-  bank=n alpha=1 R=69565.4640344684 G_phys=1.43749490336831e-05 G_eff=1.43749490336831e-05
Ro12n16n1 h16y o12p 69805.5735279415
* o12 input 17 w=-0.142691971348636 w-  bank=n alpha=1 R=233603.425744892 G_phys=4.28075914045907e-06 G_eff=4.28075914045907e-06
Ro12n17n1 h17y o12p 234108.367506505
* o12 input 18 w=+0.0750962927559542 w+  bank=n alpha=1 R=443874.552391808 G_phys=2.25288878267863e-06 G_eff=2.25288878267863e-06
Ro12p18n1 h18yn o12p 444719.098207972
* o12 input 19 w=-0.0357891000093011 w-  bank=n alpha=1 R=931382.273504235 G_phys=1.07367300027903e-06 G_eff=1.07367300027903e-06
Ro12n19n1 h19y o12p 930454.956592703
* o12 input 20 w=-0.274882313904053 w-  bank=n alpha=1 R=121264.016079871 G_phys=8.24646941712159e-06 G_eff=8.24646941712159e-06
Ro12n20n1 h20y o12p 121605.42042638
* o12 input 21 w=+0.0723735016816067 w+  bank=n alpha=1 R=460573.726002328 G_phys=2.1712050504482e-06 G_eff=2.1712050504482e-06
Ro12p21n1 h21yn o12p 458665.544425202
* o12 input 22 w=-0.42830678611073 w-  bank=n alpha=1 R=77825.8351589968 G_phys=1.28492035833219e-05 G_eff=1.28492035833219e-05
Ro12n22n1 h22y o12p 77492.2910529103
* o12 input 23 w=-0.495732058756383 w-  bank=n alpha=1 R=67240.6247377966 G_phys=1.48719617626915e-05 G_eff=1.48719617626915e-05
Ro12n23n1 h23y o12p 67542.8277072382
* o12 input 24 w=-0.0511653226482421 w-  bank=n alpha=1 R=651482.910847599 G_phys=1.53495967944726e-06 G_eff=1.53495967944726e-06
Ro12n24n1 h24y o12p 649962.611372175
* o12 input 25 w=+0.0558940521557335 w+  bank=n alpha=1 R=596366.376165735 G_phys=1.676821564672e-06 G_eff=1.676821564672e-06
Ro12p25n1 h25yn o12p 595450.962820795
* o12 input 26 w=+0.307817092263132 w+  bank=n alpha=1 R=108289.416576123 G_phys=9.23451276789396e-06 G_eff=9.23451276789396e-06
Ro12p26n1 h26yn o12p 107754.10847784
* o12 input 27 w=-0.124284155438311 w-  bank=n alpha=1 R=268202.597634244 G_phys=3.72852466314934e-06 G_eff=3.72852466314934e-06
Ro12n27n1 h27y o12p 267749.067015064
* o12 input 28 w=+0.511620988407946 w+  bank=n alpha=1 R=65152.3961850343 G_phys=1.53486296522384e-05 G_eff=1.53486296522384e-05
Ro12p28n1 h28yn o12p 64890.8815580804
* o12 input 29 w=-0.110998740438628 w-  bank=n alpha=1 R=300303.70796652 G_phys=3.32996221315884e-06 G_eff=3.32996221315884e-06
Ro12n29n1 h29y o12p 299978.795856306
* o12 input 30 w=+0.0696620617055659 w+  bank=n alpha=1 R=478500.528368227 G_phys=2.08986185116698e-06 G_eff=2.08986185116698e-06
Ro12p30n1 h30yn o12p 478223.550188238
* o12 input 31 w=+0.219973071991933 w+  bank=n alpha=1 R=151533.699245496 G_phys=6.59919215975798e-06 G_eff=6.59919215975798e-06
Ro12p31n1 h31yn o12p 151668.868571708
* o12 input 32 w=+0.138023444689957 w+  bank=n alpha=1 R=241504.864685924 G_phys=4.14070334069872e-06 G_eff=4.14070334069872e-06
Ro12p32n1 h32yn o12p 240387.2671847
* o12 bias w+  bank=f alpha=0.001 R=5330.66503610944 G_phys=0.000187593854280111 G_eff=1.87593854280111e-07
Ro12bpf1 taprefn o12p 5319.24727315659
* feedback TIA o12: Rf=33333.3333333333 A=100000 V(o12lin) = -I(o12p)*Rf*A/(A+1)  (uncompensated)
* Exp 24 L TIA o12 -> o12lin, vg=o12p
Vo12os o12osref 0 DC 0.000214023
* servo o12: Vsum>0 discharges C so IN+ falls
Go12srv o12int 0 o12p 0 0.001
Co12int o12int 0 1e-08
Ro12int o12int 0 1000000000
Bo12plus o12osp 0 V = v(o12osref) + v(o12int)
Ao12tia %vd(o12osp o12p) o12lin limtia
Ro12f o12lin o12p 33356.2624954348

* o13 input 1 w=+0.00200007413415942 w+  bank=f alpha=0.001 R=16666.0489049035 G_phys=6.00022240247825e-05 G_eff=6.00022240247825e-08
Ro13p1f1 htap1n o13p 16734.8817583981
* o13 input 2 w=-0.0237460165980216 w-  bank=f alpha=0.001 R=1403.74421098108 G_phys=0.000712380497940648 G_eff=7.12380497940648e-07
Ro13n2f1 htap2 o13p 1407.58908669457
* o13 input 3 w=-0.481641955158027 w-  bank=n alpha=1 R=69207.7028929023 G_phys=1.44492586547408e-05 G_eff=1.44492586547408e-05
Ro13n3n1 h3y o13p 69174.5983631217
* o13 input 4 w=-0.401500412219866 w-  bank=n alpha=1 R=83021.9155916573 G_phys=1.2045012366596e-05 G_eff=1.2045012366596e-05
Ro13n4n1 h4y o13p 82764.848221996
* o13 input 5 w=-0.324731283585407 w-  bank=n alpha=1 R=102648.974762441 G_phys=9.7419385075622e-06 G_eff=9.7419385075622e-06
Ro13n5n1 h5y o13p 102927.112556096
* o13 input 6 w=+0.0791891194793975 w+  bank=n alpha=1 R=420933.248815901 G_phys=2.37567358438193e-06 G_eff=2.37567358438193e-06
Ro13p6n1 h6yn o13p 418832.855074038
* o13 input 7 w=+0.286949833874567 w+  bank=n alpha=1 R=116164.323509956 G_phys=8.60849501623701e-06 G_eff=8.60849501623701e-06
Ro13p7n1 h7yn o13p 115976.979818747
* o13 input 8 w=-0.153846131933853 w-  bank=n alpha=1 R=216666.697526495 G_phys=4.61538395801558e-06 G_eff=4.61538395801558e-06
Ro13n8n1 h8y o13p 215692.673102673
* o13 input 9 w=-0.0455077430770376 w-  bank=n alpha=1 R=732476.081639671 G_phys=1.36523229231113e-06 G_eff=1.36523229231113e-06
Ro13n9n1 h9y o13p 735546.430854163
* o13 input 10 w=+0.122909253832841 w+  bank=n alpha=1 R=271202.796322133 G_phys=3.68727761498523e-06 G_eff=3.68727761498523e-06
Ro13p10n1 h10yn o13p 272305.20147543
* o13 input 11 w=+0.0797228425783465 w+  bank=n alpha=1 R=418115.213347736 G_phys=2.3916852773504e-06 G_eff=2.3916852773504e-06
Ro13p11n1 h11yn o13p 417292.536971618
* o13 input 12 w=-0.0916703213430956 w-  bank=n alpha=1 R=363621.866324394 G_phys=2.75010964029287e-06 G_eff=2.75010964029287e-06
Ro13n12n1 h12y o13p 364130.362552835
* o13 input 13 w=-0.00253109868008519 w-  bank=f alpha=0.001 R=13169.5115625486 G_phys=7.59329604025557e-05 G_eff=7.59329604025556e-08
Ro13n13f1 htap13 o13p 13163.8374578488
* o13 input 14 w=+0.523873822520012 w+  bank=n alpha=1 R=63628.5530988905 G_phys=1.57162146756004e-05 G_eff=1.57162146756004e-05
Ro13p14n1 h14yn o13p 63911.6714842594
* o13 input 15 w=+0.0718975606852002 w+  bank=n alpha=1 R=463622.590469816 G_phys=2.15692682055601e-06 G_eff=2.15692682055601e-06
Ro13p15n1 h15yn o13p 465928.065098667
* o13 input 16 w=+0.212010526629755 w+  bank=n alpha=1 R=157224.897570982 G_phys=6.36031579889266e-06 G_eff=6.36031579889266e-06
Ro13p16n1 h16yn o13p 156930.047471671
* o13 input 17 w=+0.50252589011925 w+  bank=n alpha=1 R=66331.5741312817 G_phys=1.50757767035775e-05 G_eff=1.50757767035775e-05
Ro13p17n1 h17yn o13p 66552.4889080443
* o13 input 18 w=-0.0631368164337741 w-  bank=n alpha=1 R=527953.97703173 G_phys=1.89410449301322e-06 G_eff=1.89410449301322e-06
Ro13n18n1 h18y o13p 526934.270277706
* o13 input 19 w=+0.124615759492256 w+  bank=n alpha=1 R=267488.907254983 G_phys=3.73847278476769e-06 G_eff=3.73847278476769e-06
Ro13p19n1 h19yn o13p 267205.325650048
* o13 input 20 w=-0.0825374863137293 w-  bank=n alpha=1 R=403856.899719863 G_phys=2.47612458941188e-06 G_eff=2.47612458941188e-06
Ro13n20n1 h20y o13p 405017.10016976
* o13 input 21 w=-0.0332297714786912 w-  bank=f alpha=0.001 R=1003.11653827377 G_phys=0.000996893144360737 G_eff=9.96893144360737e-07
Ro13n21f1 htap21 o13p 1006.88985780012
* o13 input 22 w=+0.217350752944783 w+  bank=n alpha=1 R=153361.940925972 G_phys=6.5205225883435e-06 G_eff=6.5205225883435e-06
Ro13p22n1 h22yn o13p 154104.439857462
* o13 input 23 w=+0.00620341639632115 w+  bank=f alpha=0.001 R=5373.38318174179 G_phys=0.000186102491889634 G_eff=1.86102491889634e-07
Ro13p23f1 htap23n o13p 5393.5997597272
* o13 input 24 w=-0.56329887647671 w-  bank=n alpha=1 R=59175.2171455139 G_phys=1.68989662943013e-05 G_eff=1.68989662943013e-05
Ro13n24n1 h24y o13p 59147.5635708131
* o13 input 25 w=+0.121217122487375 w+  bank=n alpha=1 R=274988.653824918 G_phys=3.63651367462124e-06 G_eff=3.63651367462124e-06
Ro13p25n1 h25yn o13p 276150.1224285
* o13 input 26 w=-0.0619389520134905 w-  bank=n alpha=1 R=538164.309368251 G_phys=1.85816856040471e-06 G_eff=1.85816856040471e-06
Ro13n26n1 h26y o13p 538409.341288958
* o13 input 27 w=-0.148385692307615 w-  bank=n alpha=1 R=224639.807349019 G_phys=4.45157076922844e-06 G_eff=4.45157076922844e-06
Ro13n27n1 h27y o13p 225547.314667427
* o13 input 28 w=+0.0960859107643036 w+  bank=n alpha=1 R=346911.769563169 G_phys=2.88257732292911e-06 G_eff=2.88257732292911e-06
Ro13p28n1 h28yn o13p 346528.505360178
* o13 input 29 w=-0.0967464729103534 w-  bank=n alpha=1 R=344543.137652372 G_phys=2.9023941873106e-06 G_eff=2.9023941873106e-06
Ro13n29n1 h29y o13p 343578.749990685
* o13 input 30 w=+0.0502110731232858 w+  bank=n alpha=1 R=663864.188910847 G_phys=1.50633219369857e-06 G_eff=1.50633219369857e-06
Ro13p30n1 h30yn o13p 665050.898003999
* o13 input 31 w=+0.0717291842082243 w+  bank=n alpha=1 R=464710.894195719 G_phys=2.15187552624673e-06 G_eff=2.15187552624673e-06
Ro13p31n1 h31yn o13p 464604.13580087
* o13 input 32 w=+0.117218732023777 w+  bank=n alpha=1 R=284368.656424059 G_phys=3.51656196071332e-06 G_eff=3.51656196071332e-06
Ro13p32n1 h32yn o13p 285279.645455837
* o13 bias w+  bank=f alpha=0.001 R=7028.1846436546 G_phys=0.000142284252719918 G_eff=1.42284252719918e-07
Ro13bpf1 taprefn o13p 7021.39322031494
* feedback TIA o13: Rf=33333.3333333333 A=100000 V(o13lin) = -I(o13p)*Rf*A/(A+1)  (uncompensated)
* Exp 24 L TIA o13 -> o13lin, vg=o13p
Vo13os o13osref 0 DC 0.000214023
* servo o13: Vsum>0 discharges C so IN+ falls
Go13srv o13int 0 o13p 0 0.001
Co13int o13int 0 1e-08
Ro13int o13int 0 1000000000
Bo13plus o13osp 0 V = v(o13osref) + v(o13int)
Ao13tia %vd(o13osp o13p) o13lin limtia
Ro13f o13lin o13p 33173.2002635609

* o14 input 1 w=-0.25477230027339 w-  bank=n alpha=1 R=130835.782765882 G_phys=7.64316900820172e-06 G_eff=7.64316900820172e-06
Ro14n1n1 h1y o14p 130601.438059895
* o14 input 2 w=+0.102637632071701 w+  bank=n alpha=1 R=324767.170291372 G_phys=3.07912896215104e-06 G_eff=3.07912896215104e-06
Ro14p2n1 h2yn o14p 324853.848855996
* o14 input 3 w=+0.107208211835011 w+  bank=n alpha=1 R=310921.456134648 G_phys=3.21624635505032e-06 G_eff=3.21624635505032e-06
Ro14p3n1 h3yn o14p 312128.662720192
* o14 input 4 w=-0.361346054145307 w-  bank=n alpha=1 R=92247.6749114552 G_phys=1.08403816243592e-05 G_eff=1.08403816243592e-05
Ro14n4n1 h4y o14p 92306.663104002
* o14 input 5 w=+0.0565127294479513 w+  bank=n alpha=1 R=589837.611082537 G_phys=1.69538188343854e-06 G_eff=1.69538188343854e-06
Ro14p5n1 h5yn o14p 592008.30815195
* o14 input 6 w=-0.166023137794918 w-  bank=n alpha=1 R=200775.22793545 G_phys=4.98069413384754e-06 G_eff=4.98069413384754e-06
Ro14n6n1 h6y o14p 201071.371486863
* o14 input 7 w=+0.0533068959488943 w+  bank=n alpha=1 R=625309.96674971 G_phys=1.59920687846683e-06 G_eff=1.59920687846683e-06
Ro14p7n1 h7yn o14p 624277.123604503
* o14 input 8 w=-0.334728977765226 w-  bank=n alpha=1 R=99583.0524022118 G_phys=1.00418693329568e-05 G_eff=1.00418693329568e-05
Ro14n8n1 h8y o14p 99271.9094613795
* o14 input 9 w=-0.184424571200296 w-  bank=n alpha=1 R=180742.365924394 G_phys=5.53273713600887e-06 G_eff=5.53273713600887e-06
Ro14n9n1 h9y o14p 179992.570171519
* o14 input 10 w=+0.263838736865495 w+  bank=n alpha=1 R=126339.800324039 G_phys=7.91516210596486e-06 G_eff=7.91516210596486e-06
Ro14p10n1 h10yn o14p 126035.275923539
* o14 input 11 w=+0.0215454170832462 w+  bank=f alpha=0.001 R=1547.11942704759 G_phys=0.000646362512497387 G_eff=6.46362512497387e-07
Ro14p11f1 htap11n o14p 1540.25865100097
* o14 input 12 w=-0.0509620245346412 w-  bank=n alpha=1 R=654081.811657133 G_phys=1.52886073603923e-06 G_eff=1.52886073603923e-06
Ro14n12n1 h12y o14p 656187.298909213
* o14 input 13 w=-0.289718223355261 w-  bank=n alpha=1 R=115054.320530121 G_phys=8.69154670065782e-06 G_eff=8.69154670065782e-06
Ro14n13n1 h13y o14p 114746.249143129
* o14 input 14 w=+0.114352462647064 w+  bank=n alpha=1 R=291496.41871914 G_phys=3.43057387941191e-06 G_eff=3.43057387941191e-06
Ro14p14n1 h14yn o14p 291172.791599194
* o14 input 15 w=-0.172686817087866 w-  bank=n alpha=1 R=193027.666474232 G_phys=5.18060451263599e-06 G_eff=5.18060451263599e-06
Ro14n15n1 h15y o14p 193842.504977995
* o14 input 16 w=-0.0880371911025684 w-  bank=n alpha=1 R=378627.860746921 G_phys=2.64111573307705e-06 G_eff=2.64111573307705e-06
Ro14n16n1 h16y o14p 379516.581546075
* o14 input 17 w=-0.0970577820037651 w-  bank=n alpha=1 R=343438.028823286 G_phys=2.91173346011295e-06 G_eff=2.91173346011295e-06
Ro14n17n1 h17y o14p 344888.767370559
* o14 input 18 w=+0.279065168461303 w+  bank=n alpha=1 R=119446.412883145 G_phys=8.3719550538391e-06 G_eff=8.3719550538391e-06
Ro14p18n1 h18yn o14p 119246.915047554
* o14 input 19 w=+0.12574844379754 w+  bank=n alpha=1 R=265079.489866303 G_phys=3.7724533139262e-06 G_eff=3.7724533139262e-06
Ro14p19n1 h19yn o14p 265890.506588607
* o14 input 20 w=+0.196093228285189 w+  bank=n alpha=1 R=169987.172044793 G_phys=5.88279684855566e-06 G_eff=5.88279684855566e-06
Ro14p20n1 h20yn o14p 170105.025723413
* o14 input 21 w=+0.0606582432664274 w+  bank=n alpha=1 R=549526.849746115 G_phys=1.81974729799282e-06 G_eff=1.81974729799282e-06
Ro14p21n1 h21yn o14p 549218.121034313
* o14 input 22 w=+0.471542863591523 w+  bank=n alpha=1 R=70689.9327867011 G_phys=1.41462859077457e-05 G_eff=1.41462859077457e-05
Ro14p22n1 h22yn o14p 70415.0073736217
* o14 input 23 w=+0.132895212526076 w+  bank=n alpha=1 R=250824.184707127 G_phys=3.98685637578228e-06 G_eff=3.98685637578228e-06
Ro14p23n1 h23yn o14p 249962.223075362
* o14 input 24 w=-0.150700282102261 w-  bank=n alpha=1 R=221189.588156937 G_phys=4.52100846306782e-06 G_eff=4.52100846306782e-06
Ro14n24n1 h24y o14p 221561.284714774
* o14 input 25 w=-0.172018927572569 w-  bank=n alpha=1 R=193777.125597247 G_phys=5.16056782717707e-06 G_eff=5.16056782717707e-06
Ro14n25n1 h25y o14p 193503.434536346
* o14 input 26 w=-0.144277203051731 w-  bank=n alpha=1 R=231036.730878278 G_phys=4.32831609155192e-06 G_eff=4.32831609155192e-06
Ro14n26n1 h26y o14p 230241.392111856
* o14 input 27 w=-0.0456897569368309 w-  bank=n alpha=1 R=729558.12348529 G_phys=1.37069270810493e-06 G_eff=1.37069270810493e-06
Ro14n27n1 h27y o14p 732769.4809919
* o14 input 28 w=-0.269930966859316 w-  bank=n alpha=1 R=123488.363418141 G_phys=8.09792900577949e-06 G_eff=8.09792900577949e-06
Ro14n28n1 h28y o14p 123787.958636876
* o14 input 29 w=-0.380176315173873 w-  bank=n alpha=1 R=87678.6164811146 G_phys=1.14052894552162e-05 G_eff=1.14052894552162e-05
Ro14n29n1 h29y o14p 87773.9617827385
* o14 input 30 w=+0.211443520189348 w+  bank=n alpha=1 R=157646.511482042 G_phys=6.34330560568043e-06 G_eff=6.34330560568043e-06
Ro14p30n1 h30yn o14p 157615.455485171
* o14 input 31 w=+0.0784944631218348 w+  bank=n alpha=1 R=424658.402741034 G_phys=2.35483389365504e-06 G_eff=2.35483389365504e-06
Ro14p31n1 h31yn o14p 424512.703357178
* o14 input 32 w=+0.0843025902123393 w+  bank=n alpha=1 R=395401.057658776 G_phys=2.52907770637018e-06 G_eff=2.52907770637018e-06
Ro14p32n1 h32yn o14p 397032.672874428
* o14 bias w-  bank=f alpha=0.001 R=2670.46157164376 G_phys=0.00037446709985213 G_eff=3.74467099852129e-07
Ro14bnf1 tapref o14p 2682.91611555699
* feedback TIA o14: Rf=33333.3333333333 A=100000 V(o14lin) = -I(o14p)*Rf*A/(A+1)  (uncompensated)
* Exp 24 L TIA o14 -> o14lin, vg=o14p
Vo14os o14osref 0 DC 0.000214023
* servo o14: Vsum>0 discharges C so IN+ falls
Go14srv o14int 0 o14p 0 0.001
Co14int o14int 0 1e-08
Ro14int o14int 0 1000000000
Bo14plus o14osp 0 V = v(o14osref) + v(o14int)
Ao14tia %vd(o14osp o14p) o14lin limtia
Ro14f o14lin o14p 33336.5778228109

* o15 input 1 w=-0.113449668897813 w-  bank=n alpha=1 R=293816.047743229 G_phys=3.40349006693439e-06 G_eff=3.40349006693439e-06
Ro15n1n1 h1y o15p 292698.120675938
* o15 input 2 w=-0.169978823552936 w-  bank=n alpha=1 R=196102.85938326 G_phys=5.09936470658807e-06 G_eff=5.09936470658807e-06
Ro15n2n1 h2y o15p 196294.500749761
* o15 input 3 w=+0.0133598434574407 w+  bank=f alpha=0.001 R=2495.03921505672 G_phys=0.00040079530372322 G_eff=4.0079530372322e-07
Ro15p3f1 htap3n o15p 2485.27014378302
* o15 input 4 w=-0.169966115485037 w-  bank=n alpha=1 R=196117.52164959 G_phys=5.0989834645511e-06 G_eff=5.0989834645511e-06
Ro15n4n1 h4y o15p 195302.909252745
* o15 input 5 w=-0.0418903282162887 w-  bank=n alpha=1 R=795728.626455878 G_phys=1.25670984648866e-06 G_eff=1.25670984648866e-06
Ro15n5n1 h5y o15p 793451.545000904
* o15 input 6 w=-0.324291927905124 w-  bank=n alpha=1 R=102788.045168628 G_phys=9.72875783715372e-06 G_eff=9.72875783715372e-06
Ro15n6n1 h6y o15p 102671.072498939
* o15 input 7 w=+0.558916704640692 w+  bank=n alpha=1 R=59639.1788911769 G_phys=1.67675011392208e-05 G_eff=1.67675011392208e-05
Ro15p7n1 h7yn o15p 59612.795288012
* o15 input 8 w=-0.047599242693459 w-  bank=n alpha=1 R=700291.253539501 G_phys=1.42797728080377e-06 G_eff=1.42797728080377e-06
Ro15n8n1 h8y o15p 702370.248323645
* o15 input 9 w=-0.103084990895521 w-  bank=n alpha=1 R=323357.775402217 G_phys=3.09254972686562e-06 G_eff=3.09254972686562e-06
Ro15n9n1 h9y o15p 324769.493599864
* o15 input 10 w=-0.115049291784761 w-  bank=n alpha=1 R=289730.886789766 G_phys=3.45147875354283e-06 G_eff=3.45147875354283e-06
Ro15n10n1 h10y o15p 288896.708146827
* o15 input 11 w=+0.0920546297717411 w+  bank=n alpha=1 R=362103.822653861 G_phys=2.76163889315223e-06 G_eff=2.76163889315223e-06
Ro15p11n1 h11yn o15p 363298.111266836
* o15 input 12 w=+0.0505985364133342 w+  bank=n alpha=1 R=658780.583316418 G_phys=1.51795609240003e-06 G_eff=1.51795609240003e-06
Ro15p12n1 h12yn o15p 661664.707286523
* o15 input 13 w=-0.145296396139138 w-  bank=n alpha=1 R=229416.105416771 G_phys=4.35889188417414e-06 G_eff=4.35889188417414e-06
Ro15n13n1 h13y o15p 228833.280871361
* o15 input 14 w=-0.379881852318272 w-  bank=n alpha=1 R=87746.579969306 G_phys=1.13964555695482e-05 G_eff=1.13964555695482e-05
Ro15n14n1 h14y o15p 88180.3707241224
* o15 input 15 w=+0.223112491519187 w+  bank=n alpha=1 R=149401.466078231 G_phys=6.69337474557561e-06 G_eff=6.69337474557561e-06
Ro15p15n1 h15yn o15p 149886.112079106
* o15 input 16 w=-0.14757878301826 w-  bank=n alpha=1 R=225868.059429714 G_phys=4.42736349054781e-06 G_eff=4.42736349054781e-06
Ro15n16n1 h16y o15p 225959.463155674
* o15 input 17 w=+0.173921977011029 w+  bank=n alpha=1 R=191656.821674811 G_phys=5.21765931033087e-06 G_eff=5.21765931033087e-06
Ro15p17n1 h17yn o15p 190928.489776048
* o15 input 18 w=+0.133725887369399 w+  bank=n alpha=1 R=249266.121833648 G_phys=4.01177662108198e-06 G_eff=4.01177662108198e-06
Ro15p18n1 h18yn o15p 248966.683897356
* o15 input 19 w=+0.209560948195519 w+  bank=n alpha=1 R=159062.714787077 G_phys=6.28682844586558e-06 G_eff=6.28682844586558e-06
Ro15p19n1 h19yn o15p 159044.316946188
* o15 input 20 w=-0.0239329977507233 w-  bank=f alpha=0.001 R=1392.7771890726 G_phys=0.000717989932521699 G_eff=7.179899325217e-07
Ro15n20f1 htap20 o15p 1391.7865219264
* o15 input 21 w=+0.196041920231295 w+  bank=n alpha=1 R=170031.661054972 G_phys=5.88125760693885e-06 G_eff=5.88125760693885e-06
Ro15p21n1 h21yn o15p 169589.959461722
* o15 input 22 w=-0.0995510863910355 w-  bank=n alpha=1 R=334836.459769011 G_phys=2.98653259173107e-06 G_eff=2.98653259173107e-06
Ro15n22n1 h22y o15p 334946.652635035
* o15 input 23 w=+0.102107365264583 w+  bank=n alpha=1 R=326453.760186243 G_phys=3.06322095793749e-06 G_eff=3.06322095793749e-06
Ro15p23n1 h23yn o15p 327215.148516317
* o15 input 24 w=-0.21795159550845 w-  bank=n alpha=1 R=152939.157226958 G_phys=6.53854786525351e-06 G_eff=6.53854786525351e-06
Ro15n24n1 h24y o15p 153421.43881336
* o15 input 25 w=+0.202525001628457 w+  bank=n alpha=1 R=164588.732577744 G_phys=6.07575004885372e-06 G_eff=6.07575004885372e-06
Ro15p25n1 h25yn o15p 165042.296437692
* o15 input 26 w=-0.281017181998367 w-  bank=n alpha=1 R=118616.709114701 G_phys=8.43051545995101e-06 G_eff=8.43051545995101e-06
Ro15n26n1 h26y o15p 118952.454317338
* o15 input 27 w=+0.141610254018665 w+  bank=n alpha=1 R=235387.850719764 G_phys=4.24830762055994e-06 G_eff=4.24830762055994e-06
Ro15p27n1 h27yn o15p 236270.348696476
* o15 input 28 w=+0.444984802739648 w+  bank=n alpha=1 R=74908.9252669063 G_phys=1.33495440821894e-05 G_eff=1.33495440821894e-05
Ro15p28n1 h28yn o15p 74588.1064219373
* o15 input 29 w=-0.120073433142323 w-  bank=n alpha=1 R=277607.897608986 G_phys=3.60220299426968e-06 G_eff=3.60220299426968e-06
Ro15n29n1 h29y o15p 277272.563207695
* o15 input 30 w=-0.0538706707421541 w-  bank=n alpha=1 R=618765.886411172 G_phys=1.61612012226462e-06 G_eff=1.61612012226462e-06
Ro15n30n1 h30y o15p 617836.371002942
* o15 input 31 w=+0.148090323839994 w+  bank=n alpha=1 R=225087.854959036 G_phys=4.44270971519983e-06 G_eff=4.44270971519983e-06
Ro15p31n1 h31yn o15p 225648.345687227
* o15 input 32 w=-0.347735979661958 w-  bank=n alpha=1 R=95858.1662033862 G_phys=1.04320793898588e-05 G_eff=1.04320793898588e-05
Ro15n32n1 h32y o15p 95596.3657979056
* o15 bias w+  bank=n alpha=1 R=468672.189169108 G_phys=2.13368751786374e-06 G_eff=2.13368751786374e-06
Ro15bpn1 vrefn o15p 468053.101114039
* feedback TIA o15: Rf=33333.3333333333 A=100000 V(o15lin) = -I(o15p)*Rf*A/(A+1)  (uncompensated)
* Exp 24 L TIA o15 -> o15lin, vg=o15p
Vo15os o15osref 0 DC 0.000214023
* servo o15: Vsum>0 discharges C so IN+ falls
Go15srv o15int 0 o15p 0 0.001
Co15int o15int 0 1e-08
Ro15int o15int 0 1000000000
Bo15plus o15osp 0 V = v(o15osref) + v(o15int)
Ao15tia %vd(o15osp o15p) o15lin limtia
Ro15f o15lin o15p 33485.9435119961

* o16 input 1 w=-0.0239168211298723 w-  bank=f alpha=0.001 R=1393.71922181162 G_phys=0.000717504633896169 G_eff=7.17504633896169e-07
Ro16n1f1 htap1 o16p 1394.62055621271
* o16 input 2 w=-0.455843018824687 w-  bank=n alpha=1 R=73124.5888535874 G_phys=1.36752905647406e-05 G_eff=1.36752905647406e-05
Ro16n2n1 h2y o16p 73301.4585743871
* o16 input 3 w=-0.360558107273835 w-  bank=n alpha=1 R=92449.2686778431 G_phys=1.0816743218215e-05 G_eff=1.0816743218215e-05
Ro16n3n1 h3y o16p 92396.2671682443
* o16 input 4 w=+0.281324980833712 w+  bank=n alpha=1 R=118486.930078336 G_phys=8.43974942501135e-06 G_eff=8.43974942501135e-06
Ro16p4n1 h4yn o16p 118543.689296759
* o16 input 5 w=-0.0789059543438914 w-  bank=n alpha=1 R=422443.827091407 G_phys=2.36717863031674e-06 G_eff=2.36717863031674e-06
Ro16n5n1 h5y o16p 423599.077454727
* o16 input 6 w=+0.0459206910877794 w+  bank=n alpha=1 R=725889.191641633 G_phys=1.37762073263338e-06 G_eff=1.37762073263338e-06
Ro16p6n1 h6yn o16p 723325.839291596
* o16 input 7 w=-0.348093944852844 w-  bank=n alpha=1 R=95759.5896918717 G_phys=1.04428183455853e-05 G_eff=1.04428183455853e-05
Ro16n7n1 h7y o16p 96139.7841672857
* o16 input 8 w=-0.0796710739452782 w-  bank=n alpha=1 R=418386.896055 G_phys=2.39013221835835e-06 G_eff=2.39013221835835e-06
Ro16n8n1 h8y o16p 416621.806083836
* o16 input 9 w=-0.173339228342165 w-  bank=n alpha=1 R=192301.15220967 G_phys=5.20017685026494e-06 G_eff=5.20017685026494e-06
Ro16n9n1 h9y o16p 193147.209253927
* o16 input 10 w=+0.194262181446587 w+  bank=n alpha=1 R=171589.411202501 G_phys=5.82786544339762e-06 G_eff=5.82786544339762e-06
Ro16p10n1 h10yn o16p 172403.355686974
* o16 input 11 w=+0.155708231075043 w+  bank=n alpha=1 R=214075.602190025 G_phys=4.67124693225129e-06 G_eff=4.67124693225129e-06
Ro16p11n1 h11yn o16p 214672.364045027
* o16 input 12 w=+0.124882648574468 w+  bank=n alpha=1 R=266917.251626487 G_phys=3.74647945723404e-06 G_eff=3.74647945723404e-06
Ro16p12n1 h12yn o16p 268241.590875464
* o16 input 13 w=+0.270423516346849 w+  bank=n alpha=1 R=123263.441669694 G_phys=8.11270549040547e-06 G_eff=8.11270549040547e-06
Ro16p13n1 h13yn o16p 123509.628524779
* o16 input 14 w=-0.22936067173287 w-  bank=n alpha=1 R=145331.512510374 G_phys=6.88082015198609e-06 G_eff=6.88082015198609e-06
Ro16n14n1 h14y o16p 145988.721519795
* o16 input 15 w=+0.0349795005301705 w+  bank=n alpha=1 R=952939.087983336 G_phys=1.04938501590512e-06 G_eff=1.04938501590512e-06
Ro16p15n1 h15yn o16p 956527.205229159
* o16 input 16 w=+0.104322324768401 w+  bank=n alpha=1 R=319522.531800691 G_phys=3.12966974305203e-06 G_eff=3.12966974305203e-06
Ro16p16n1 h16yn o16p 319076.880933176
* o16 input 17 w=-0.351176137449102 w-  bank=n alpha=1 R=94919.129686494 G_phys=1.05352841234731e-05 G_eff=1.05352841234731e-05
Ro16n17n1 h17y o16p 95220.1741441461
* o16 input 18 w=+0.119462358831177 w+  bank=n alpha=1 R=279027.918580107 G_phys=3.58387076493532e-06 G_eff=3.58387076493532e-06
Ro16p18n1 h18yn o16p 279966.30444371
* o16 input 19 w=+0.230688311648174 w+  bank=n alpha=1 R=144495.111586626 G_phys=6.92064934944523e-06 G_eff=6.92064934944523e-06
Ro16p19n1 h19yn o16p 144884.327955771
* o16 input 20 w=-0.0614748986253126 w-  bank=n alpha=1 R=542226.731214294 G_phys=1.84424695875938e-06 G_eff=1.84424695875938e-06
Ro16n20n1 h20y o16p 541637.918024128
* o16 input 21 w=+0.36727529530057 w+  bank=n alpha=1 R=90758.4413104999 G_phys=1.10182588590171e-05 G_eff=1.10182588590171e-05
Ro16p21n1 h21yn o16p 90358.8282715071
* o16 input 22 w=+0.579638140801163 w+  bank=n alpha=1 R=57507.1427964708 G_phys=1.73891442240349e-05 G_eff=1.73891442240349e-05
Ro16p22n1 h22yn o16p 57476.8881539946
* o16 input 23 w=-0.0387096142803063 w-  bank=n alpha=1 R=861112.515664923 G_phys=1.16128842840919e-06 G_eff=1.16128842840919e-06
Ro16n23n1 h23y o16p 861801.776328203
* o16 input 24 w=+0.0384174368738491 w+  bank=n alpha=1 R=867661.563232072 G_phys=1.15252310621547e-06 G_eff=1.15252310621547e-06
Ro16p24n1 h24yn o16p 866731.073503055
* o16 input 25 w=+0.201641208818347 w+  bank=n alpha=1 R=165310.12449624 G_phys=6.04923626455041e-06 G_eff=6.04923626455041e-06
Ro16p25n1 h25yn o16p 165960.193321352
* o16 input 26 w=-0.606109769372092 w-  bank=n alpha=1 R=54995.5387913735 G_phys=1.81832930811628e-05 G_eff=1.81832930811628e-05
Ro16n26n1 h26y o16p 54731.7247572999
* o16 input 27 w=-0.101484914332963 w-  bank=n alpha=1 R=328456.04248105 G_phys=3.04454742998888e-06 G_eff=3.04454742998888e-06
Ro16n27n1 h27y o16p 326832.114023123
* o16 input 28 w=+0.04265872854179 w+  bank=n alpha=1 R=781395.378455286 G_phys=1.2797618562537e-06 G_eff=1.2797618562537e-06
Ro16p28n1 h28yn o16p 778976.705671371
* o16 input 29 w=+0.0889131834636398 w+  bank=n alpha=1 R=374897.535267812 G_phys=2.66739550390919e-06 G_eff=2.66739550390919e-06
Ro16p29n1 h29yn o16p 373304.541497027
* o16 input 30 w=+0.0420485970959956 w+  bank=n alpha=1 R=792733.54250641 G_phys=1.26145791287987e-06 G_eff=1.26145791287987e-06
Ro16p30n1 h30yn o16p 794370.321859603
* o16 input 31 w=-0.332324220948992 w-  bank=n alpha=1 R=100303.652975236 G_phys=9.96972662846976e-06 G_eff=9.96972662846976e-06
Ro16n31n1 h31y o16p 100744.093081515
* o16 input 32 w=+0.137132637809711 w+  bank=n alpha=1 R=243073.668425948 G_phys=4.11397913429134e-06 G_eff=4.11397913429134e-06
Ro16p32n1 h32yn o16p 243384.608857011
* o16 bias w+  bank=n alpha=1 R=811464.21158382 G_phys=1.23234023845389e-06 G_eff=1.23234023845389e-06
Ro16bpn1 vrefn o16p 815041.766242819
* feedback TIA o16: Rf=33333.3333333333 A=100000 V(o16lin) = -I(o16p)*Rf*A/(A+1)  (uncompensated)
* Exp 24 L TIA o16 -> o16lin, vg=o16p
Vo16os o16osref 0 DC 0.000214023
* servo o16: Vsum>0 discharges C so IN+ falls
Go16srv o16int 0 o16p 0 0.001
Co16int o16int 0 1e-08
Ro16int o16int 0 1000000000
Bo16plus o16osp 0 V = v(o16osref) + v(o16int)
Ao16tia %vd(o16osp o16p) o16lin limtia
Ro16f o16lin o16p 33231.5120922404

.ic v(h1int)=0
.ic v(h2int)=0
.ic v(h3int)=0
.ic v(h4int)=0
.ic v(h5int)=0
.ic v(h6int)=0
.ic v(h7int)=0
.ic v(h8int)=0
.ic v(h9int)=0
.ic v(h10int)=0
.ic v(h11int)=0
.ic v(h12int)=0
.ic v(h13int)=0
.ic v(h14int)=0
.ic v(h15int)=0
.ic v(h16int)=0
.ic v(h17int)=0
.ic v(h18int)=0
.ic v(h19int)=0
.ic v(h20int)=0
.ic v(h21int)=0
.ic v(h22int)=0
.ic v(h23int)=0
.ic v(h24int)=0
.ic v(h25int)=0
.ic v(h26int)=0
.ic v(h27int)=0
.ic v(h28int)=0
.ic v(h29int)=0
.ic v(h30int)=0
.ic v(h31int)=0
.ic v(h32int)=0
.ic v(o1int)=0
.ic v(o2int)=0
.ic v(o3int)=0
.ic v(o4int)=0
.ic v(o5int)=0
.ic v(o6int)=0
.ic v(o7int)=0
.ic v(o8int)=0
.ic v(o9int)=0
.ic v(o10int)=0
.ic v(o11int)=0
.ic v(o12int)=0
.ic v(o13int)=0
.ic v(o14int)=0
.ic v(o15int)=0
.ic v(o16int)=0
.control
set numdgt=15
alter Vin1 DC 0.158819511467957
alter Vin2 DC -0.372773806932782
alter Vin3 DC 0.67193713669852
alter Vin4 DC -0.902048143479307
alter Vin5 DC 0.924933276197322
alter Vin6 DC 0.048863391278005
alter Vin7 DC 0.129424922748179
alter Vin8 DC -0.907355179044633
alter Vin9 DC -0.259300690216605
alter Vin10 DC 0.403487498648932
alter Vin11 DC -0.44173807302037
alter Vin12 DC 0.0459791136363257
alter Vin13 DC 0.0876065715983807
alter Vin14 DC -0.577471098792849
alter Vin15 DC -0.358236586736178
alter Vin16 DC 0.414892769727053
op
print v(o1lin)
print v(o2lin)
print v(o3lin)
print v(o4lin)
print v(o5lin)
print v(o6lin)
print v(o7lin)
print v(o8lin)
print v(o9lin)
print v(o10lin)
print v(o11lin)
print v(o12lin)
print v(o13lin)
print v(o14lin)
print v(o15lin)
print v(o16lin)
alter Vin1 DC 0.429198084108182
alter Vin2 DC -0.322292593357881
alter Vin3 DC 0.601373940679518
alter Vin4 DC 0.557665627661168
alter Vin5 DC 0.302900201780787
alter Vin6 DC -0.734665643564448
alter Vin7 DC -0.601552471435159
alter Vin8 DC 0.905963097550707
alter Vin9 DC -0.694223363136906
alter Vin10 DC 0.524974497277861
alter Vin11 DC 0.926743978567858
alter Vin12 DC -0.529028026248905
alter Vin13 DC -0.342609433389713
alter Vin14 DC -0.86134614966593
alter Vin15 DC -0.773944656535855
alter Vin16 DC -0.151558717300171
op
print v(o1lin)
print v(o2lin)
print v(o3lin)
print v(o4lin)
print v(o5lin)
print v(o6lin)
print v(o7lin)
print v(o8lin)
print v(o9lin)
print v(o10lin)
print v(o11lin)
print v(o12lin)
print v(o13lin)
print v(o14lin)
print v(o15lin)
print v(o16lin)
alter Vin1 DC -0.816100313874169
alter Vin2 DC -0.914309113497003
alter Vin3 DC -0.818699813157977
alter Vin4 DC 0.687833936175371
alter Vin5 DC 0.547214385274628
alter Vin6 DC -0.929019818164162
alter Vin7 DC -0.164825358416194
alter Vin8 DC -0.183223394921166
alter Vin9 DC -0.906562282955664
alter Vin10 DC -0.11000285847072
alter Vin11 DC 0.564211382353377
alter Vin12 DC -0.387501377612333
alter Vin13 DC 0.953426628777747
alter Vin14 DC -0.384686613978901
alter Vin15 DC 0.358711357001829
alter Vin16 DC -0.0772898618241011
op
print v(o1lin)
print v(o2lin)
print v(o3lin)
print v(o4lin)
print v(o5lin)
print v(o6lin)
print v(o7lin)
print v(o8lin)
print v(o9lin)
print v(o10lin)
print v(o11lin)
print v(o12lin)
print v(o13lin)
print v(o14lin)
print v(o15lin)
print v(o16lin)
alter Vin1 DC -0.64418361397032
alter Vin2 DC 0.136934738455547
alter Vin3 DC 0.0825277818161751
alter Vin4 DC -0.782165736568954
alter Vin5 DC 0.688799988195986
alter Vin6 DC 0.00733461008359448
alter Vin7 DC 0.444730935291246
alter Vin8 DC -0.437289758309442
alter Vin9 DC -0.347791506183127
alter Vin10 DC -0.452315907874939
alter Vin11 DC 0.680445310612405
alter Vin12 DC -0.789913519338894
alter Vin13 DC -0.876129771528158
alter Vin14 DC 0.841916571573514
alter Vin15 DC -0.333500188262223
alter Vin16 DC -0.641467924965349
op
print v(o1lin)
print v(o2lin)
print v(o3lin)
print v(o4lin)
print v(o5lin)
print v(o6lin)
print v(o7lin)
print v(o8lin)
print v(o9lin)
print v(o10lin)
print v(o11lin)
print v(o12lin)
print v(o13lin)
print v(o14lin)
print v(o15lin)
print v(o16lin)
alter Vin1 DC -0.494679827997077
alter Vin2 DC -0.994526886023643
alter Vin3 DC -0.687648511166907
alter Vin4 DC 0.17646783469565
alter Vin5 DC 0.741670491149326
alter Vin6 DC 8.07090713470515e-05
alter Vin7 DC -0.0884379176954257
alter Vin8 DC 0.51739353285581
alter Vin9 DC 0.589459436783349
alter Vin10 DC 0.693548538665344
alter Vin11 DC 0.725108096094006
alter Vin12 DC 0.225004043040163
alter Vin13 DC 0.786620030463082
alter Vin14 DC 0.494978105795817
alter Vin15 DC -0.450003319902546
alter Vin16 DC 0.596139359020319
op
print v(o1lin)
print v(o2lin)
print v(o3lin)
print v(o4lin)
print v(o5lin)
print v(o6lin)
print v(o7lin)
print v(o8lin)
print v(o9lin)
print v(o10lin)
print v(o11lin)
print v(o12lin)
print v(o13lin)
print v(o14lin)
print v(o15lin)
print v(o16lin)
alter Vin1 DC 0.300603025848169
alter Vin2 DC 0.249605151459263
alter Vin3 DC 0.655014961206512
alter Vin4 DC -0.389814251549452
alter Vin5 DC 0.740876509745775
alter Vin6 DC 0.270885462063803
alter Vin7 DC -0.508073455273313
alter Vin8 DC 0.485117431263507
alter Vin9 DC 0.149815488976244
alter Vin10 DC -0.856576893953521
alter Vin11 DC 0.241577597609805
alter Vin12 DC -0.061523083915755
alter Vin13 DC 0.0866091873749062
alter Vin14 DC 0.760512208008562
alter Vin15 DC 0.0915918459066685
alter Vin16 DC 0.70053836467865
op
print v(o1lin)
print v(o2lin)
print v(o3lin)
print v(o4lin)
print v(o5lin)
print v(o6lin)
print v(o7lin)
print v(o8lin)
print v(o9lin)
print v(o10lin)
print v(o11lin)
print v(o12lin)
print v(o13lin)
print v(o14lin)
print v(o15lin)
print v(o16lin)
alter Vin1 DC 0.652196823029885
alter Vin2 DC -0.899091698574001
alter Vin3 DC 0.492649892227331
alter Vin4 DC -0.764240305424007
alter Vin5 DC 0.736392900020158
alter Vin6 DC -0.367180195986347
alter Vin7 DC -0.73692147676105
alter Vin8 DC -0.668843990091804
alter Vin9 DC -0.827113048862026
alter Vin10 DC 0.29369376692573
alter Vin11 DC 0.920459786953056
alter Vin12 DC 0.526367792629551
alter Vin13 DC 0.0662771816701806
alter Vin14 DC 0.715284178957727
alter Vin15 DC -0.111381257852424
alter Vin16 DC -0.454010551810974
op
print v(o1lin)
print v(o2lin)
print v(o3lin)
print v(o4lin)
print v(o5lin)
print v(o6lin)
print v(o7lin)
print v(o8lin)
print v(o9lin)
print v(o10lin)
print v(o11lin)
print v(o12lin)
print v(o13lin)
print v(o14lin)
print v(o15lin)
print v(o16lin)
alter Vin1 DC 0.593581659193039
alter Vin2 DC -0.338258833056389
alter Vin3 DC -0.952119605320532
alter Vin4 DC 0.808141471113841
alter Vin5 DC -0.941128417512634
alter Vin6 DC 0.389177430717246
alter Vin7 DC -0.593804653986153
alter Vin8 DC -0.294729113475947
alter Vin9 DC 0.620390491576086
alter Vin10 DC 0.500058280808731
alter Vin11 DC 0.607705112174689
alter Vin12 DC -0.900318599838089
alter Vin13 DC 0.887683604385245
alter Vin14 DC -0.644366416387734
alter Vin15 DC -0.0240078272652291
alter Vin16 DC 0.705369344041731
op
print v(o1lin)
print v(o2lin)
print v(o3lin)
print v(o4lin)
print v(o5lin)
print v(o6lin)
print v(o7lin)
print v(o8lin)
print v(o9lin)
print v(o10lin)
print v(o11lin)
print v(o12lin)
print v(o13lin)
print v(o14lin)
print v(o15lin)
print v(o16lin)
alter Vin1 DC 0.752399115443002
alter Vin2 DC -0.612850478648861
alter Vin3 DC -0.260530187876918
alter Vin4 DC -0.7290750040015
alter Vin5 DC -0.0697187851458576
alter Vin6 DC 0.367274029959735
alter Vin7 DC -0.932492769072846
alter Vin8 DC -0.0997694712428119
alter Vin9 DC -0.923051926948957
alter Vin10 DC 0.127105111024819
alter Vin11 DC -0.234121230709573
alter Vin12 DC 0.693620297508014
alter Vin13 DC -0.238353543056141
alter Vin14 DC -0.941317392831783
alter Vin15 DC -0.399745431134931
alter Vin16 DC -0.943931036097272
op
print v(o1lin)
print v(o2lin)
print v(o3lin)
print v(o4lin)
print v(o5lin)
print v(o6lin)
print v(o7lin)
print v(o8lin)
print v(o9lin)
print v(o10lin)
print v(o11lin)
print v(o12lin)
print v(o13lin)
print v(o14lin)
print v(o15lin)
print v(o16lin)
alter Vin1 DC -0.0320198813336972
alter Vin2 DC 0.279087772669159
alter Vin3 DC 0.798634414590909
alter Vin4 DC -0.139623851399936
alter Vin5 DC -0.552071334562718
alter Vin6 DC -0.718453947093923
alter Vin7 DC -0.354218966285669
alter Vin8 DC -0.376038682583914
alter Vin9 DC 0.434080283890319
alter Vin10 DC 0.833717757772451
alter Vin11 DC -0.753606400909652
alter Vin12 DC 0.63833559671365
alter Vin13 DC -0.635078908950261
alter Vin14 DC -0.567258840295937
alter Vin15 DC -0.43040391447293
alter Vin16 DC -0.776085529648956
op
print v(o1lin)
print v(o2lin)
print v(o3lin)
print v(o4lin)
print v(o5lin)
print v(o6lin)
print v(o7lin)
print v(o8lin)
print v(o9lin)
print v(o10lin)
print v(o11lin)
print v(o12lin)
print v(o13lin)
print v(o14lin)
print v(o15lin)
print v(o16lin)
alter Vin1 DC 0.9957234340325
alter Vin2 DC 0.976768607632254
alter Vin3 DC -0.821697562148621
alter Vin4 DC 0.441584877960288
alter Vin5 DC -0.909797596280518
alter Vin6 DC -0.552176912366082
alter Vin7 DC 0.13716341039642
alter Vin8 DC 0.688790762636875
alter Vin9 DC -0.425207566972672
alter Vin10 DC -0.511852705880083
alter Vin11 DC 0.939721771422718
alter Vin12 DC -0.800934199812161
alter Vin13 DC 0.713472172885293
alter Vin14 DC 0.0729621363821233
alter Vin15 DC 0.844955495147085
alter Vin16 DC -0.141299720705324
op
print v(o1lin)
print v(o2lin)
print v(o3lin)
print v(o4lin)
print v(o5lin)
print v(o6lin)
print v(o7lin)
print v(o8lin)
print v(o9lin)
print v(o10lin)
print v(o11lin)
print v(o12lin)
print v(o13lin)
print v(o14lin)
print v(o15lin)
print v(o16lin)
alter Vin1 DC -0.268467976280975
alter Vin2 DC 0.808699008077704
alter Vin3 DC -0.755158753197875
alter Vin4 DC -0.0559120975870255
alter Vin5 DC 0.526660512293102
alter Vin6 DC -0.351198269097045
alter Vin7 DC -0.251402622186679
alter Vin8 DC 0.0823688465316199
alter Vin9 DC 0.850290624464772
alter Vin10 DC 0.781034649571819
alter Vin11 DC -0.798046607220268
alter Vin12 DC -0.58535957978864
alter Vin13 DC 0.388794250943708
alter Vin14 DC -0.390541584214551
alter Vin15 DC -0.671151962306852
alter Vin16 DC 0.0391434452594681
op
print v(o1lin)
print v(o2lin)
print v(o3lin)
print v(o4lin)
print v(o5lin)
print v(o6lin)
print v(o7lin)
print v(o8lin)
print v(o9lin)
print v(o10lin)
print v(o11lin)
print v(o12lin)
print v(o13lin)
print v(o14lin)
print v(o15lin)
print v(o16lin)
alter Vin1 DC -0.600563382660491
alter Vin2 DC 0.929666641971139
alter Vin3 DC -0.146703568806925
alter Vin4 DC -0.735077298728116
alter Vin5 DC -0.639023961618841
alter Vin6 DC -0.979787882769006
alter Vin7 DC -0.125223062256097
alter Vin8 DC 0.86444565494536
alter Vin9 DC 0.20882499194479
alter Vin10 DC -0.237393729498831
alter Vin11 DC 0.837408890242429
alter Vin12 DC 0.143909629263795
alter Vin13 DC 0.422199812265348
alter Vin14 DC -0.185149866019755
alter Vin15 DC 0.093592060582909
alter Vin16 DC -0.414930623845559
op
print v(o1lin)
print v(o2lin)
print v(o3lin)
print v(o4lin)
print v(o5lin)
print v(o6lin)
print v(o7lin)
print v(o8lin)
print v(o9lin)
print v(o10lin)
print v(o11lin)
print v(o12lin)
print v(o13lin)
print v(o14lin)
print v(o15lin)
print v(o16lin)
alter Vin1 DC 0.634671331791516
alter Vin2 DC 0.976471549424023
alter Vin3 DC -0.391487868042194
alter Vin4 DC -0.615708624847604
alter Vin5 DC 0.853804585982116
alter Vin6 DC 0.968406859268546
alter Vin7 DC -0.45828823030528
alter Vin8 DC -0.377490795913684
alter Vin9 DC -0.886593969136309
alter Vin10 DC 0.366098377369694
alter Vin11 DC -0.122021684630121
alter Vin12 DC 0.613923559598249
alter Vin13 DC -0.478212196304814
alter Vin14 DC -0.738861993735866
alter Vin15 DC 0.540588251169763
alter Vin16 DC -0.436132132292748
op
print v(o1lin)
print v(o2lin)
print v(o3lin)
print v(o4lin)
print v(o5lin)
print v(o6lin)
print v(o7lin)
print v(o8lin)
print v(o9lin)
print v(o10lin)
print v(o11lin)
print v(o12lin)
print v(o13lin)
print v(o14lin)
print v(o15lin)
print v(o16lin)
alter Vin1 DC -0.957011296620827
alter Vin2 DC -0.180036320796048
alter Vin3 DC -0.490329922468375
alter Vin4 DC 0.256404535875224
alter Vin5 DC -0.779463163723338
alter Vin6 DC -0.93943371622231
alter Vin7 DC -0.788685763510147
alter Vin8 DC 0.471731695743663
alter Vin9 DC 0.866578919969293
alter Vin10 DC -0.346455909623532
alter Vin11 DC -0.385827518692149
alter Vin12 DC -0.0543757039556638
alter Vin13 DC 0.566737784994894
alter Vin14 DC -0.0132181377327927
alter Vin15 DC -0.40174586838029
alter Vin16 DC 0.0706471256338457
op
print v(o1lin)
print v(o2lin)
print v(o3lin)
print v(o4lin)
print v(o5lin)
print v(o6lin)
print v(o7lin)
print v(o8lin)
print v(o9lin)
print v(o10lin)
print v(o11lin)
print v(o12lin)
print v(o13lin)
print v(o14lin)
print v(o15lin)
print v(o16lin)
alter Vin1 DC -0.916600105466317
alter Vin2 DC -0.700071864821656
alter Vin3 DC 0.256331637171541
alter Vin4 DC 0.533700674894373
alter Vin5 DC -0.366716971180327
alter Vin6 DC 0.383361723604698
alter Vin7 DC -0.641517887035151
alter Vin8 DC -0.0377921178347453
alter Vin9 DC -0.428625518467714
alter Vin10 DC 0.346446239068274
alter Vin11 DC -0.179938294892382
alter Vin12 DC -0.547221954783504
alter Vin13 DC 0.517366892368981
alter Vin14 DC 0.891889522463648
alter Vin15 DC 0.452496623526322
alter Vin16 DC -0.39952883272811
op
print v(o1lin)
print v(o2lin)
print v(o3lin)
print v(o4lin)
print v(o5lin)
print v(o6lin)
print v(o7lin)
print v(o8lin)
print v(o9lin)
print v(o10lin)
print v(o11lin)
print v(o12lin)
print v(o13lin)
print v(o14lin)
print v(o15lin)
print v(o16lin)
alter Vin1 DC 0.885746667045957
alter Vin2 DC 0.465475986316248
alter Vin3 DC -0.188245946972479
alter Vin4 DC 0.53084185607535
alter Vin5 DC -0.522971784503353
alter Vin6 DC 0.746318694186094
alter Vin7 DC 0.552320540298113
alter Vin8 DC 0.399886865405705
alter Vin9 DC -0.945990708595804
alter Vin10 DC 0.919042038202397
alter Vin11 DC 0.702928380252219
alter Vin12 DC 0.175622681487935
alter Vin13 DC 0.306563106866363
alter Vin14 DC 0.862281042265569
alter Vin15 DC -0.511516790787658
alter Vin16 DC -0.364799843602582
op
print v(o1lin)
print v(o2lin)
print v(o3lin)
print v(o4lin)
print v(o5lin)
print v(o6lin)
print v(o7lin)
print v(o8lin)
print v(o9lin)
print v(o10lin)
print v(o11lin)
print v(o12lin)
print v(o13lin)
print v(o14lin)
print v(o15lin)
print v(o16lin)
alter Vin1 DC -0.275985096696864
alter Vin2 DC 0.804897727345157
alter Vin3 DC -0.813594922460734
alter Vin4 DC 0.283047049151609
alter Vin5 DC 0.986451441562687
alter Vin6 DC 0.152288728122332
alter Vin7 DC -0.667577057016596
alter Vin8 DC 0.400527738931974
alter Vin9 DC 0.1163353584733
alter Vin10 DC 0.508732045815445
alter Vin11 DC 0.991016513262815
alter Vin12 DC -0.859488070655649
alter Vin13 DC -0.163592307097767
alter Vin14 DC -0.410970477767166
alter Vin15 DC 0.456066793257808
alter Vin16 DC 0.882569368398532
op
print v(o1lin)
print v(o2lin)
print v(o3lin)
print v(o4lin)
print v(o5lin)
print v(o6lin)
print v(o7lin)
print v(o8lin)
print v(o9lin)
print v(o10lin)
print v(o11lin)
print v(o12lin)
print v(o13lin)
print v(o14lin)
print v(o15lin)
print v(o16lin)
alter Vin1 DC -0.957235841573219
alter Vin2 DC -0.583352477689581
alter Vin3 DC -0.518333312600381
alter Vin4 DC 0.721767585924766
alter Vin5 DC -0.647121258151345
alter Vin6 DC -0.980663478719929
alter Vin7 DC 0.15699405577676
alter Vin8 DC 0.825570713157576
alter Vin9 DC 0.24936639132647
alter Vin10 DC -0.180451693992818
alter Vin11 DC 0.799487706888593
alter Vin12 DC 0.322202216910603
alter Vin13 DC -0.568731020787757
alter Vin14 DC 0.197774220131837
alter Vin15 DC 0.512069660932079
alter Vin16 DC 0.277797027926094
op
print v(o1lin)
print v(o2lin)
print v(o3lin)
print v(o4lin)
print v(o5lin)
print v(o6lin)
print v(o7lin)
print v(o8lin)
print v(o9lin)
print v(o10lin)
print v(o11lin)
print v(o12lin)
print v(o13lin)
print v(o14lin)
print v(o15lin)
print v(o16lin)
alter Vin1 DC -0.182695219373797
alter Vin2 DC 0.539500970699393
alter Vin3 DC -0.539382604238998
alter Vin4 DC 0.872895916290768
alter Vin5 DC -0.407889941317214
alter Vin6 DC -0.0859880770344472
alter Vin7 DC 0.763768635319106
alter Vin8 DC 0.870942359956876
alter Vin9 DC -0.877525973775396
alter Vin10 DC 0.588501531962838
alter Vin11 DC -0.384023722053046
alter Vin12 DC 0.677995396322368
alter Vin13 DC 0.524388915576248
alter Vin14 DC -0.200880044391957
alter Vin15 DC 0.198555424552027
alter Vin16 DC -0.277615641692143
op
print v(o1lin)
print v(o2lin)
print v(o3lin)
print v(o4lin)
print v(o5lin)
print v(o6lin)
print v(o7lin)
print v(o8lin)
print v(o9lin)
print v(o10lin)
print v(o11lin)
print v(o12lin)
print v(o13lin)
print v(o14lin)
print v(o15lin)
print v(o16lin)
alter Vin1 DC -0.616392615765275
alter Vin2 DC -0.847249588474782
alter Vin3 DC -0.594289111410193
alter Vin4 DC -0.106354931768763
alter Vin5 DC 0.824116987242362
alter Vin6 DC 0.315572378969197
alter Vin7 DC -0.78106626392503
alter Vin8 DC -0.614574585564037
alter Vin9 DC 0.825094706384598
alter Vin10 DC -0.554787114868678
alter Vin11 DC 0.49412798347459
alter Vin12 DC 0.232507587021284
alter Vin13 DC -0.775274465582391
alter Vin14 DC -0.764645894345453
alter Vin15 DC 0.882936298893414
alter Vin16 DC 0.853904389101653
op
print v(o1lin)
print v(o2lin)
print v(o3lin)
print v(o4lin)
print v(o5lin)
print v(o6lin)
print v(o7lin)
print v(o8lin)
print v(o9lin)
print v(o10lin)
print v(o11lin)
print v(o12lin)
print v(o13lin)
print v(o14lin)
print v(o15lin)
print v(o16lin)
alter Vin1 DC -0.109021030034409
alter Vin2 DC -0.350999584823292
alter Vin3 DC -0.164144217353911
alter Vin4 DC 0.700094383635451
alter Vin5 DC -0.706162842356856
alter Vin6 DC -0.312974215546731
alter Vin7 DC -0.112437019288063
alter Vin8 DC 0.160259139508942
alter Vin9 DC -0.591269775589757
alter Vin10 DC 0.655377947428395
alter Vin11 DC -0.0234384636584672
alter Vin12 DC -0.698774077548427
alter Vin13 DC -0.1716661182942
alter Vin14 DC -0.649147029060728
alter Vin15 DC 0.714163722063317
alter Vin16 DC 0.0794396138638493
op
print v(o1lin)
print v(o2lin)
print v(o3lin)
print v(o4lin)
print v(o5lin)
print v(o6lin)
print v(o7lin)
print v(o8lin)
print v(o9lin)
print v(o10lin)
print v(o11lin)
print v(o12lin)
print v(o13lin)
print v(o14lin)
print v(o15lin)
print v(o16lin)
alter Vin1 DC -0.390617946507397
alter Vin2 DC -0.763999306647624
alter Vin3 DC -0.886832971536692
alter Vin4 DC 0.885864920391574
alter Vin5 DC -0.32694542822934
alter Vin6 DC 0.378039452214939
alter Vin7 DC -0.070365735817872
alter Vin8 DC 0.941192505428546
alter Vin9 DC -0.388083488151495
alter Vin10 DC -0.29329980911751
alter Vin11 DC -0.616531449639574
alter Vin12 DC -0.301437580695714
alter Vin13 DC 0.875938998903931
alter Vin14 DC 0.815022713588944
alter Vin15 DC 0.184634929182306
alter Vin16 DC -0.629827789098946
op
print v(o1lin)
print v(o2lin)
print v(o3lin)
print v(o4lin)
print v(o5lin)
print v(o6lin)
print v(o7lin)
print v(o8lin)
print v(o9lin)
print v(o10lin)
print v(o11lin)
print v(o12lin)
print v(o13lin)
print v(o14lin)
print v(o15lin)
print v(o16lin)
alter Vin1 DC -0.686565589033304
alter Vin2 DC 0.723947892539892
alter Vin3 DC 0.059230598168349
alter Vin4 DC -0.466113950099345
alter Vin5 DC 0.727231394967519
alter Vin6 DC 0.855069873092205
alter Vin7 DC 0.253851010056853
alter Vin8 DC -0.634124422921238
alter Vin9 DC -0.951212783957498
alter Vin10 DC -0.993669002301079
alter Vin11 DC -0.998826787139439
alter Vin12 DC -0.810725787516228
alter Vin13 DC 0.487051875007392
alter Vin14 DC -0.851590521100548
alter Vin15 DC 0.51273321720091
alter Vin16 DC 0.958255343432988
op
print v(o1lin)
print v(o2lin)
print v(o3lin)
print v(o4lin)
print v(o5lin)
print v(o6lin)
print v(o7lin)
print v(o8lin)
print v(o9lin)
print v(o10lin)
print v(o11lin)
print v(o12lin)
print v(o13lin)
print v(o14lin)
print v(o15lin)
print v(o16lin)
alter Vin1 DC -0.288667717907495
alter Vin2 DC -0.0272497870788686
alter Vin3 DC 0.554715776148762
alter Vin4 DC 0.784486435240961
alter Vin5 DC -0.207890495839907
alter Vin6 DC -0.705291018441563
alter Vin7 DC 0.00628853717140254
alter Vin8 DC -0.401316223333674
alter Vin9 DC -0.607366331504001
alter Vin10 DC -0.211039460476188
alter Vin11 DC -0.0223750671848824
alter Vin12 DC -0.479183535236777
alter Vin13 DC -0.932261497819964
alter Vin14 DC 0.387476648538021
alter Vin15 DC 0.0951674766605322
alter Vin16 DC 0.774416600162158
op
print v(o1lin)
print v(o2lin)
print v(o3lin)
print v(o4lin)
print v(o5lin)
print v(o6lin)
print v(o7lin)
print v(o8lin)
print v(o9lin)
print v(o10lin)
print v(o11lin)
print v(o12lin)
print v(o13lin)
print v(o14lin)
print v(o15lin)
print v(o16lin)
alter Vin1 DC 0.889984642096064
alter Vin2 DC -0.19852978197463
alter Vin3 DC -0.754038560078359
alter Vin4 DC 0.147118300356341
alter Vin5 DC -0.428919494886414
alter Vin6 DC 0.569899233387268
alter Vin7 DC -0.799077070199383
alter Vin8 DC -0.0050040262758928
alter Vin9 DC 0.814690795737031
alter Vin10 DC -0.553672944383239
alter Vin11 DC 0.485964487281605
alter Vin12 DC 0.633077811252671
alter Vin13 DC 0.69850960566011
alter Vin14 DC 0.350214048048369
alter Vin15 DC -0.456351493633908
alter Vin16 DC 0.891555758410393
op
print v(o1lin)
print v(o2lin)
print v(o3lin)
print v(o4lin)
print v(o5lin)
print v(o6lin)
print v(o7lin)
print v(o8lin)
print v(o9lin)
print v(o10lin)
print v(o11lin)
print v(o12lin)
print v(o13lin)
print v(o14lin)
print v(o15lin)
print v(o16lin)
alter Vin1 DC -0.115083028588165
alter Vin2 DC 0.123630821562508
alter Vin3 DC 0.559888191851869
alter Vin4 DC -0.572080603682658
alter Vin5 DC 0.0225607454029486
alter Vin6 DC -0.789337878954859
alter Vin7 DC -0.856926919212196
alter Vin8 DC 0.41053834931713
alter Vin9 DC -0.108914993619159
alter Vin10 DC 0.759824430727428
alter Vin11 DC 0.824042040836292
alter Vin12 DC -0.383446802578123
alter Vin13 DC -0.290737985000155
alter Vin14 DC 0.0358298348382962
alter Vin15 DC 0.618098386368676
alter Vin16 DC 0.0928159277617004
op
print v(o1lin)
print v(o2lin)
print v(o3lin)
print v(o4lin)
print v(o5lin)
print v(o6lin)
print v(o7lin)
print v(o8lin)
print v(o9lin)
print v(o10lin)
print v(o11lin)
print v(o12lin)
print v(o13lin)
print v(o14lin)
print v(o15lin)
print v(o16lin)
alter Vin1 DC -0.206718151402969
alter Vin2 DC -0.572061567220486
alter Vin3 DC -0.486470673529791
alter Vin4 DC -0.358816994696857
alter Vin5 DC 0.665847364454382
alter Vin6 DC 0.0713481132046145
alter Vin7 DC -0.945345153493795
alter Vin8 DC -0.973522301130553
alter Vin9 DC 0.470421912886614
alter Vin10 DC 0.419263669244865
alter Vin11 DC 0.558715927792292
alter Vin12 DC 0.941926702084367
alter Vin13 DC 0.120337976643699
alter Vin14 DC 0.151744952157683
alter Vin15 DC 0.294715161820971
alter Vin16 DC 0.960993030512827
op
print v(o1lin)
print v(o2lin)
print v(o3lin)
print v(o4lin)
print v(o5lin)
print v(o6lin)
print v(o7lin)
print v(o8lin)
print v(o9lin)
print v(o10lin)
print v(o11lin)
print v(o12lin)
print v(o13lin)
print v(o14lin)
print v(o15lin)
print v(o16lin)
alter Vin1 DC -0.0834869399356983
alter Vin2 DC 0.895206415812229
alter Vin3 DC -0.357832334051346
alter Vin4 DC -0.773855798250571
alter Vin5 DC -0.412954212944365
alter Vin6 DC -0.0988414405475262
alter Vin7 DC 0.0639925434860953
alter Vin8 DC 0.981410865155795
alter Vin9 DC -0.918412914599877
alter Vin10 DC -0.0231209381073847
alter Vin11 DC 0.471771003668606
alter Vin12 DC 0.905361484707143
alter Vin13 DC 0.0488880567190677
alter Vin14 DC -0.547379917336428
alter Vin15 DC -0.4812352847023
alter Vin16 DC -0.776120373784416
op
print v(o1lin)
print v(o2lin)
print v(o3lin)
print v(o4lin)
print v(o5lin)
print v(o6lin)
print v(o7lin)
print v(o8lin)
print v(o9lin)
print v(o10lin)
print v(o11lin)
print v(o12lin)
print v(o13lin)
print v(o14lin)
print v(o15lin)
print v(o16lin)
alter Vin1 DC 0.949437364538229
alter Vin2 DC 0.29544547085245
alter Vin3 DC -0.680337157093564
alter Vin4 DC -0.179423512813786
alter Vin5 DC 0.163395307608621
alter Vin6 DC 0.257898719200798
alter Vin7 DC 0.111754442688021
alter Vin8 DC -0.972423350564747
alter Vin9 DC -0.509229697318037
alter Vin10 DC -0.165955450542179
alter Vin11 DC -0.202890478509549
alter Vin12 DC 0.352728053057074
alter Vin13 DC 0.754218686646297
alter Vin14 DC 0.372708849513793
alter Vin15 DC 0.551872779230266
alter Vin16 DC -0.508509687308747
op
print v(o1lin)
print v(o2lin)
print v(o3lin)
print v(o4lin)
print v(o5lin)
print v(o6lin)
print v(o7lin)
print v(o8lin)
print v(o9lin)
print v(o10lin)
print v(o11lin)
print v(o12lin)
print v(o13lin)
print v(o14lin)
print v(o15lin)
print v(o16lin)
alter Vin1 DC -0.288328207454178
alter Vin2 DC -0.0728027422746225
alter Vin3 DC 0.889480450971633
alter Vin4 DC 0.640274161328948
alter Vin5 DC 0.838324154335599
alter Vin6 DC -0.701853812699984
alter Vin7 DC 0.825004287776111
alter Vin8 DC 0.541320326613053
alter Vin9 DC 0.542302744086439
alter Vin10 DC 0.27854268170963
alter Vin11 DC -0.847824200857663
alter Vin12 DC 0.883233366173862
alter Vin13 DC 0.791388644693341
alter Vin14 DC 0.275231964628792
alter Vin15 DC 0.137321774282514
alter Vin16 DC -0.643292474904798
op
print v(o1lin)
print v(o2lin)
print v(o3lin)
print v(o4lin)
print v(o5lin)
print v(o6lin)
print v(o7lin)
print v(o8lin)
print v(o9lin)
print v(o10lin)
print v(o11lin)
print v(o12lin)
print v(o13lin)
print v(o14lin)
print v(o15lin)
print v(o16lin)
alter Vin1 DC 0.502784629360051
alter Vin2 DC -0.554507319691521
alter Vin3 DC 0.5115224333667
alter Vin4 DC 0.591190383821995
alter Vin5 DC -0.803834242114719
alter Vin6 DC 0.350310819180748
alter Vin7 DC -0.0407596174684226
alter Vin8 DC -0.975252720617087
alter Vin9 DC -0.453145794055706
alter Vin10 DC -0.390962641340032
alter Vin11 DC 0.873781235131511
alter Vin12 DC 0.824474435319712
alter Vin13 DC 0.59517293279349
alter Vin14 DC 0.988526756062699
alter Vin15 DC -0.0982909637343363
alter Vin16 DC -0.608931161339204
op
print v(o1lin)
print v(o2lin)
print v(o3lin)
print v(o4lin)
print v(o5lin)
print v(o6lin)
print v(o7lin)
print v(o8lin)
print v(o9lin)
print v(o10lin)
print v(o11lin)
print v(o12lin)
print v(o13lin)
print v(o14lin)
print v(o15lin)
print v(o16lin)
alter Vin1 DC 0.0105271563669316
alter Vin2 DC 0.373291108922671
alter Vin3 DC 0.969409562854094
alter Vin4 DC -0.920186859823864
alter Vin5 DC -0.664726186861978
alter Vin6 DC -0.249470315543284
alter Vin7 DC 0.626872129091023
alter Vin8 DC -0.617761464616063
alter Vin9 DC -0.157912071571937
alter Vin10 DC -0.641069906181229
alter Vin11 DC 0.566272945838899
alter Vin12 DC -0.410652456703555
alter Vin13 DC -0.0381127205947975
alter Vin14 DC -0.583666729716892
alter Vin15 DC -0.693157997511838
alter Vin16 DC 0.627019587764797
op
print v(o1lin)
print v(o2lin)
print v(o3lin)
print v(o4lin)
print v(o5lin)
print v(o6lin)
print v(o7lin)
print v(o8lin)
print v(o9lin)
print v(o10lin)
print v(o11lin)
print v(o12lin)
print v(o13lin)
print v(o14lin)
print v(o15lin)
print v(o16lin)
alter Vin1 DC -0.909785762386532
alter Vin2 DC 0.311957108211316
alter Vin3 DC 0.176444915218925
alter Vin4 DC 0.354211667308528
alter Vin5 DC 0.583494588618451
alter Vin6 DC -0.531280021954514
alter Vin7 DC -0.455658988212773
alter Vin8 DC 0.357598965616448
alter Vin9 DC -0.471474032447811
alter Vin10 DC 0.452518332711433
alter Vin11 DC 0.833322367183866
alter Vin12 DC -0.422589254092316
alter Vin13 DC 0.254153684881251
alter Vin14 DC -0.774248377939795
alter Vin15 DC -0.212701821931954
alter Vin16 DC 0.512779922239431
op
print v(o1lin)
print v(o2lin)
print v(o3lin)
print v(o4lin)
print v(o5lin)
print v(o6lin)
print v(o7lin)
print v(o8lin)
print v(o9lin)
print v(o10lin)
print v(o11lin)
print v(o12lin)
print v(o13lin)
print v(o14lin)
print v(o15lin)
print v(o16lin)
alter Vin1 DC 0.577342931673083
alter Vin2 DC -0.522795660574967
alter Vin3 DC -0.963214264525345
alter Vin4 DC -0.375765314992966
alter Vin5 DC 0.0479896215664628
alter Vin6 DC 0.117949019665436
alter Vin7 DC 0.135309464948171
alter Vin8 DC 0.396270965976296
alter Vin9 DC 0.350699405257872
alter Vin10 DC -0.887380000304803
alter Vin11 DC 0.220281481549666
alter Vin12 DC -0.394709312118067
alter Vin13 DC 0.608440255066441
alter Vin14 DC -0.403323559736162
alter Vin15 DC 0.854779822874445
alter Vin16 DC 0.0704628726041701
op
print v(o1lin)
print v(o2lin)
print v(o3lin)
print v(o4lin)
print v(o5lin)
print v(o6lin)
print v(o7lin)
print v(o8lin)
print v(o9lin)
print v(o10lin)
print v(o11lin)
print v(o12lin)
print v(o13lin)
print v(o14lin)
print v(o15lin)
print v(o16lin)
alter Vin1 DC 0.488211522922371
alter Vin2 DC -0.542310007976089
alter Vin3 DC -0.656122986592274
alter Vin4 DC -0.113796392098619
alter Vin5 DC -0.190420061148831
alter Vin6 DC 0.796211855744374
alter Vin7 DC -0.273380306176671
alter Vin8 DC -0.0450191651084035
alter Vin9 DC 0.209309632041922
alter Vin10 DC -0.238383048342175
alter Vin11 DC -0.865363105440408
alter Vin12 DC 0.334403767123752
alter Vin13 DC -0.488088339839084
alter Vin14 DC -0.477809319050512
alter Vin15 DC -0.0299951537281546
alter Vin16 DC 0.317098676704569
op
print v(o1lin)
print v(o2lin)
print v(o3lin)
print v(o4lin)
print v(o5lin)
print v(o6lin)
print v(o7lin)
print v(o8lin)
print v(o9lin)
print v(o10lin)
print v(o11lin)
print v(o12lin)
print v(o13lin)
print v(o14lin)
print v(o15lin)
print v(o16lin)
alter Vin1 DC 0.0832192563851988
alter Vin2 DC -0.0726469696614171
alter Vin3 DC -0.0950988278654301
alter Vin4 DC 0.158286653806075
alter Vin5 DC 0.766854720818519
alter Vin6 DC 0.923221592449784
alter Vin7 DC -0.590631887992517
alter Vin8 DC -0.296835262204094
alter Vin9 DC 0.847357774656645
alter Vin10 DC 0.937343398064052
alter Vin11 DC -0.451387279215739
alter Vin12 DC 0.164712348924595
alter Vin13 DC 0.679000858265756
alter Vin14 DC 0.393825072778183
alter Vin15 DC -0.0831664169061184
alter Vin16 DC -0.964860320468118
op
print v(o1lin)
print v(o2lin)
print v(o3lin)
print v(o4lin)
print v(o5lin)
print v(o6lin)
print v(o7lin)
print v(o8lin)
print v(o9lin)
print v(o10lin)
print v(o11lin)
print v(o12lin)
print v(o13lin)
print v(o14lin)
print v(o15lin)
print v(o16lin)
alter Vin1 DC 0.226829929567815
alter Vin2 DC -0.36909505983259
alter Vin3 DC 0.833854904628067
alter Vin4 DC -0.837829959805514
alter Vin5 DC 0.825296445381237
alter Vin6 DC -0.563054396880911
alter Vin7 DC 0.980208697206205
alter Vin8 DC -0.291329525982629
alter Vin9 DC -0.881688318581131
alter Vin10 DC -0.168616488244297
alter Vin11 DC -0.860651320640804
alter Vin12 DC -0.596816775031961
alter Vin13 DC -0.862792436121235
alter Vin14 DC 0.220996190260223
alter Vin15 DC 0.864718657642928
alter Vin16 DC 0.967782209219007
op
print v(o1lin)
print v(o2lin)
print v(o3lin)
print v(o4lin)
print v(o5lin)
print v(o6lin)
print v(o7lin)
print v(o8lin)
print v(o9lin)
print v(o10lin)
print v(o11lin)
print v(o12lin)
print v(o13lin)
print v(o14lin)
print v(o15lin)
print v(o16lin)
alter Vin1 DC 0.306769573369591
alter Vin2 DC 0.248104910758736
alter Vin3 DC -0.155391292095296
alter Vin4 DC -0.980704814950464
alter Vin5 DC -0.323861880065559
alter Vin6 DC -0.885107362101324
alter Vin7 DC 0.491734051853614
alter Vin8 DC 0.440592491808986
alter Vin9 DC 0.462499136053481
alter Vin10 DC 0.178030930151408
alter Vin11 DC 0.143511133939754
alter Vin12 DC 0.216367786407474
alter Vin13 DC 0.391559764421133
alter Vin14 DC -0.0662116411906462
alter Vin15 DC -0.651575362939526
alter Vin16 DC -0.0186954056066124
op
print v(o1lin)
print v(o2lin)
print v(o3lin)
print v(o4lin)
print v(o5lin)
print v(o6lin)
print v(o7lin)
print v(o8lin)
print v(o9lin)
print v(o10lin)
print v(o11lin)
print v(o12lin)
print v(o13lin)
print v(o14lin)
print v(o15lin)
print v(o16lin)
alter Vin1 DC 0.191423108114523
alter Vin2 DC -0.263043738303528
alter Vin3 DC -0.274387757656815
alter Vin4 DC 0.183635371060421
alter Vin5 DC -0.542173499620608
alter Vin6 DC 0.634963638240261
alter Vin7 DC -0.947124728628402
alter Vin8 DC -0.217877795455242
alter Vin9 DC 0.807267531049694
alter Vin10 DC -0.0942061783064505
alter Vin11 DC -0.101633779194258
alter Vin12 DC -0.713205950281187
alter Vin13 DC 0.17543676482962
alter Vin14 DC -0.719898498760424
alter Vin15 DC 0.586882575262605
alter Vin16 DC -0.130276112311178
op
print v(o1lin)
print v(o2lin)
print v(o3lin)
print v(o4lin)
print v(o5lin)
print v(o6lin)
print v(o7lin)
print v(o8lin)
print v(o9lin)
print v(o10lin)
print v(o11lin)
print v(o12lin)
print v(o13lin)
print v(o14lin)
print v(o15lin)
print v(o16lin)
.endc

.end
