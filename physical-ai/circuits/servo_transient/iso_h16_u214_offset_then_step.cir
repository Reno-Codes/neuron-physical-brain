* Experiment 22 isolated TIA neuron n1
* frozen n=16 L1=4.9158066 b=0.0857431075924666
* A=100000 vos=0.000214023 Ileak=0 Rout=0 fp=0 invertA=1e+07
* Behavioral TIA. Not transistor-level. Weights were not edited.
* shape: 16 -> 1 (linear Vlin vs z unless ReLU requested)

* Experiment 24 candidate L
* XSPICE limit TIA (programmable Vos)
* source: ngspice built-in analog code model `limit`
* Behavioral. Used as AZ/servo/chopper carrier and feasibility map.
* Weights were not edited. SPICE is not Python-corrected.
* Exp 25 OTA-C servo (LEVEL 2). Finite C. Not an algebraic integrator.
* gm=0.001 C=1e-06 Rleak=1000000000
* tau=C/gm=0.001 s  DC_gain=gm*R=1000000

.model limtia limit(gain=100000 in_offset=0.0 out_lower_limit=-15 out_upper_limit=15 fraction=false limit_range=0.05)

Vin1 in1 0 PULSE(0 1 0.004 10n 10n 1 2)
Vin2 in2 0 PULSE(0 0 0.004 10n 10n 1 2)
Vin3 in3 0 PULSE(0 0 0.004 10n 10n 1 2)
Vin4 in4 0 PULSE(0 0 0.004 10n 10n 1 2)
Vin5 in5 0 PULSE(0 0 0.004 10n 10n 1 2)
* passive invert in5 -> in5n: R2/R1=1.0000002 closed-loop -1 at A=1e+07
Rinv5ia in5 inv5m 10000
Rinv5ib in5n inv5m 10000.0020000002
Einv5amp in5n 0 0 inv5m 10000000
Vin6 in6 0 PULSE(0 0 0.004 10n 10n 1 2)
Vin7 in7 0 PULSE(0 0 0.004 10n 10n 1 2)
Vin8 in8 0 PULSE(0 0 0.004 10n 10n 1 2)
Vin9 in9 0 PULSE(0 0 0.004 10n 10n 1 2)
* passive invert in9 -> in9n: R2/R1=1.0000002 closed-loop -1 at A=1e+07
Rinv9ia in9 inv9m 10000
Rinv9ib in9n inv9m 10000.0020000002
Einv9amp in9n 0 0 inv9m 10000000
Vin10 in10 0 PULSE(0 0 0.004 10n 10n 1 2)
* passive invert in10 -> in10n: R2/R1=1.0000002 closed-loop -1 at A=1e+07
Rinv10ia in10 inv10m 10000
Rinv10ib in10n inv10m 10000.0020000002
Einv10amp in10n 0 0 inv10m 10000000
Vin11 in11 0 PULSE(0 0 0.004 10n 10n 1 2)
Vin12 in12 0 PULSE(0 0 0.004 10n 10n 1 2)
Vin13 in13 0 PULSE(0 0 0.004 10n 10n 1 2)
Vin14 in14 0 PULSE(0 0 0.004 10n 10n 1 2)
Vin15 in15 0 PULSE(0 0 0.004 10n 10n 1 2)
Vin16 in16 0 PULSE(0 0 0.004 10n 10n 1 2)
Vref vref 0 DC 1
* passive invert vref -> vrefn: R2/R1=1.0000002 closed-loop -1 at A=1e+07
Rinvrefia vref invrefm 10000
Rinvrefib vrefn invrefm 10000.0020000002
Einvrefamp vrefn 0 0 invrefm 10000000

* n1 input 1 w=-0.211528252190937 w-  bank=n alpha=1 R=157583.362922343 G_phys=6.3458475657281e-06 G_eff=6.3458475657281e-06
Rn1n1n1 in1 n1p 157583.362922343
* n1 input 2 w=-0.194947045242045 w-  bank=n alpha=1 R=170986.604551748 G_phys=5.84841135726135e-06 G_eff=5.84841135726135e-06
Rn1n2n1 in2 n1p 170986.604551748
* n1 input 3 w=-0.281660896127353 w-  bank=n alpha=1 R=118345.619827403 G_phys=8.44982688382059e-06 G_eff=8.44982688382059e-06
Rn1n3n1 in3 n1p 118345.619827403
* n1 input 4 w=-0.246854224570453 w-  bank=n alpha=1 R=135032.460519305 G_phys=7.4056267371136e-06 G_eff=7.4056267371136e-06
Rn1n4n1 in4 n1p 135032.460519305
* n1 input 5 w=+0.785179968580328 w+  bank=n alpha=1 R=42453.112238208 G_phys=2.35553990574098e-05 G_eff=2.35553990574098e-05
Rn1p5n1 in5n n1p 42453.112238208
* n1 input 6 w=-0.342055263707418 w-  bank=n alpha=1 R=97450.1399921314 G_phys=1.02616579112226e-05 G_eff=1.02616579112226e-05
Rn1n6n1 in6 n1p 97450.1399921314
* n1 input 7 w=-0.213390213186068 w-  bank=n alpha=1 R=156208.351056231 G_phys=6.40170639558203e-06 G_eff=6.40170639558203e-06
Rn1n7n1 in7 n1p 156208.351056231
* n1 input 8 w=-0.06183287092446 w-  bank=n alpha=1 R=539087.589415927 G_phys=1.8549861277338e-06 G_eff=1.8549861277338e-06
Rn1n8n1 in8 n1p 539087.589415927
* n1 input 9 w=+0.114369297885863 w+  bank=n alpha=1 R=291453.510247121 G_phys=3.43107893657588e-06 G_eff=3.43107893657588e-06
Rn1p9n1 in9n n1p 291453.510247121
* n1 input 10 w=+0.418702574206734 w+  bank=n alpha=1 R=79611.0064440994 G_phys=1.2561077226202e-05 G_eff=1.2561077226202e-05
Rn1p10n1 in10n n1p 79611.0064440994
* n1 input 11 w=-0.38263995973155 w-  bank=n alpha=1 R=87114.0937729534 G_phys=1.14791987919465e-05 G_eff=1.14791987919465e-05
Rn1n11n1 in11 n1p 87114.0937729534
* n1 input 12 w=-0.447982918675276 w-  bank=n alpha=1 R=74407.5989144918 G_phys=1.34394875602583e-05 G_eff=1.34394875602583e-05
Rn1n12n1 in12 n1p 74407.5989144918
* n1 input 13 w=-0.354860709093241 w-  bank=n alpha=1 R=93933.5702126856 G_phys=1.06458212727972e-05 G_eff=1.06458212727972e-05
Rn1n13n1 in13 n1p 93933.5702126856
* n1 input 14 w=-0.245379266072843 w-  bank=n alpha=1 R=135844.131685674 G_phys=7.36137798218528e-06 G_eff=7.36137798218528e-06
Rn1n14n1 in14 n1p 135844.131685674
* n1 input 15 w=-0.0999148922371372 w-  bank=n alpha=1 R=333617.267526249 G_phys=2.99744676711412e-06 G_eff=2.99744676711412e-06
Rn1n15n1 in15 n1p 333617.267526249
* n1 input 16 w=-0.428765175056332 w-  bank=n alpha=1 R=77742.632267077 G_phys=1.286295525169e-05 G_eff=1.286295525169e-05
Rn1n16n1 in16 n1p 77742.632267077
* n1 bias w+  bank=n alpha=1 R=388758.166916054 G_phys=2.572293227774e-06 G_eff=2.572293227774e-06
Rn1bpn1 vrefn n1p 388758.166916054
* feedback TIA n1: Rf=33333.3333333333 A=100000 V(n1lin) = -I(n1p)*Rf*A/(A+1)  (uncompensated)
* Exp 24 L TIA n1 -> n1lin, vg=n1p
Vn1os n1osref 0 DC 0.000214023
* servo n1: Vsum>0 discharges C so IN+ falls
Gn1srv n1int 0 n1p 0 0.001
Cn1int n1int 0 1e-06
Rn1int n1int 0 1000000000
Bn1plus n1osp 0 V = v(n1osref) + v(n1int)
An1tia %vd(n1osp n1p) n1lin limtia
Rn1f n1lin n1p 33333.3333333333
.ic v(n1int)=0
.control
set numdgt=15
set wr_singlescale
tran 4e-05 0.016
wrdata iso_h16_u214_offset_then_step.dat v(n1lin) v(n1p) v(n1int)
print v(n1lin)
print v(n1p)
print v(n1int)
.endc

.end
