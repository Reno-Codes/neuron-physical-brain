* Experiment 39 SKY130 smoke: one xhigh_po resistor + one 5V NFET
* Official ciel open_pdks sky130A 1689ac3f2dc763876eaf967227c7dfe831b031ae
* Not a teaching card. Weights not used.

.lib "C:/dev/pdk/sky130A/libs.tech/ngspice/sky130.lib.spice" tt

.temp 27

Vtest n1 0 DC 1
Xres n1 n2 0 sky130_fd_pr__res_xhigh_po w=1.0 l=16.67
Vamm n2 0 DC 0

Vdd vdd 0 DC 2.5
Vg vg 0 DC 1.5
Xmn vd vg 0 0 sky130_fd_pr__nfet_g5v0d10v5 W=5 L=1 nf=1 mult=1
Vds vd 0 DC 2.5

.control
set numdgt=10
op
let rmeas = 1.0 / i(Vamm)
print rmeas
print i(Vds)
print v(vd)
print v(n1)
.endc

.end
