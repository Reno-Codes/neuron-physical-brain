* SKY130 xhigh_po characterization
.lib "C:/dev/pdk/sky130A/libs.tech/ngspice/sky130.lib.spice" tt
.temp 27
Vtest n1 0 DC 1
Xres n1 n2 0 sky130_fd_pr__res_xhigh_po w=1.0 l=16.67
Vamm n2 0 DC 0
.control
set numdgt=12
op
let rmeas = 1.0 / i(Vamm)
print rmeas
print i(Vamm)
.endc
.end
