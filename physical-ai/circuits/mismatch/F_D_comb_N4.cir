* Physical AI - Experiment 14 architecture D: ratiometric fabric (physical R_IV, weight ~ R_IV/R_w)
* Frozen Experiment 9 weights. No Python output correction.
* Behavioral variation study. Not transistor-level or PCB power.
* divider Ra=999000 Rb=1001 beta=0.001000999 Ileak=1e-08 rail=15 linear=False k1=1 k2=1 physical_iv=True
* shape: 16 -> 32 -> 16

Vin1 in1 0 DC 0
* tiled Rdiv1a series x4  each=249750
Rdiv1at1 in1 Rdiv1an1 250111.135977403
Rdiv1at2 Rdiv1an1 Rdiv1an2 249228.801346003
Rdiv1at3 Rdiv1an2 Rdiv1an3 248722.098399116
Rdiv1at4 Rdiv1an3 tap1 250359.0371809
* tiled Rdiv1b parallel x4  each=4004
Rdiv1bt1 tap1 0 4003.46902784018
Rdiv1bt2 tap1 0 3991.63468699116
Rdiv1bt3 tap1 0 3991.01806536092
Rdiv1bt4 tap1 0 4021.98577555394
Ediv1 inf1 0 tap1 0 1
Vin2 in2 0 DC 0
* tiled Rdiv2a series x4  each=249750
Rdiv2at1 in2 Rdiv2an1 249822.170514873
Rdiv2at2 Rdiv2an1 Rdiv2an2 250672.384210622
Rdiv2at3 Rdiv2an2 Rdiv2an3 248509.772483871
Rdiv2at4 Rdiv2an3 tap2 249462.505739409
* tiled Rdiv2b parallel x4  each=4004
Rdiv2bt1 tap2 0 4021.67939670282
Rdiv2bt2 tap2 0 4009.648466283
Rdiv2bt3 tap2 0 3990.68376453763
Rdiv2bt4 tap2 0 4023.98113124444
Ediv2 inf2 0 tap2 0 1
Vin3 in3 0 DC 0
* tiled Rdiv3a series x4  each=249750
Rdiv3at1 in3 Rdiv3an1 249197.040893221
Rdiv3at2 Rdiv3an1 Rdiv3an2 250749.974582415
Rdiv3at3 Rdiv3an2 Rdiv3an3 250488.335866929
Rdiv3at4 Rdiv3an3 tap3 250185.993324278
* tiled Rdiv3b parallel x4  each=4004
Rdiv3bt1 tap3 0 4004.24557950392
Rdiv3bt2 tap3 0 4005.94927990279
Rdiv3bt3 tap3 0 3992.85207312492
Rdiv3bt4 tap3 0 4010.14847308867
Ediv3 inf3 0 tap3 0 1
Vin4 in4 0 DC 0
* tiled Rdiv4a series x4  each=249750
Rdiv4at1 in4 Rdiv4an1 249298.35824774
Rdiv4at2 Rdiv4an1 Rdiv4an2 249433.90222469
Rdiv4at3 Rdiv4an2 Rdiv4an3 248610.439511607
Rdiv4at4 Rdiv4an3 tap4 249755.676204326
* tiled Rdiv4b parallel x4  each=4004
Rdiv4bt1 tap4 0 4003.14724333851
Rdiv4bt2 tap4 0 4015.24085395255
Rdiv4bt3 tap4 0 4021.24337233878
Rdiv4bt4 tap4 0 4013.27120862108
Ediv4 inf4 0 tap4 0 1
Vin5 in5 0 DC 0
* tiled Rdiv5a series x4  each=249750
Rdiv5at1 in5 Rdiv5an1 248748.092247958
Rdiv5at2 Rdiv5an1 Rdiv5an2 249558.213208467
Rdiv5at3 Rdiv5an2 Rdiv5an3 248829.940452978
Rdiv5at4 Rdiv5an3 tap5 249966.795331624
* tiled Rdiv5b parallel x4  each=4004
Rdiv5bt1 tap5 0 4001.07731487916
Rdiv5bt2 tap5 0 4018.63841874618
Rdiv5bt3 tap5 0 3998.93313611349
Rdiv5bt4 tap5 0 4019.57177437761
Ediv5 inf5 0 tap5 0 1
Vin6 in6 0 DC 0
* tiled Rdiv6a series x4  each=249750
Rdiv6at1 in6 Rdiv6an1 249389.916148448
Rdiv6at2 Rdiv6an1 Rdiv6an2 249247.714881085
Rdiv6at3 Rdiv6an2 Rdiv6an3 249479.779705127
Rdiv6at4 Rdiv6an3 tap6 249452.534089691
* tiled Rdiv6b parallel x4  each=4004
Rdiv6bt1 tap6 0 4007.93726828901
Rdiv6bt2 tap6 0 4016.71596411206
Rdiv6bt3 tap6 0 4016.35751222388
Rdiv6bt4 tap6 0 4013.29275095606
Ediv6 inf6 0 tap6 0 1
Vin7 in7 0 DC 0
* tiled Rdiv7a series x4  each=249750
Rdiv7at1 in7 Rdiv7an1 249507.942193944
Rdiv7at2 Rdiv7an1 Rdiv7an2 249939.520886668
Rdiv7at3 Rdiv7an2 Rdiv7an3 248568.853685818
Rdiv7at4 Rdiv7an3 tap7 249054.360929714
* tiled Rdiv7b parallel x4  each=4004
Rdiv7bt1 tap7 0 4008.9557874208
Rdiv7bt2 tap7 0 4023.32744458752
Rdiv7bt3 tap7 0 4014.15367018341
Rdiv7bt4 tap7 0 4014.20705861345
Ediv7 inf7 0 tap7 0 1
Vin8 in8 0 DC 0
* tiled Rdiv8a series x4  each=249750
Rdiv8at1 in8 Rdiv8an1 250539.188104825
Rdiv8at2 Rdiv8an1 Rdiv8an2 249023.667842027
Rdiv8at3 Rdiv8an2 Rdiv8an3 250355.583135868
Rdiv8at4 Rdiv8an3 tap8 250327.461157532
* tiled Rdiv8b parallel x4  each=4004
Rdiv8bt1 tap8 0 3995.4394646049
Rdiv8bt2 tap8 0 3994.56515897595
Rdiv8bt3 tap8 0 3993.55873302087
Rdiv8bt4 tap8 0 4002.03405712198
Ediv8 inf8 0 tap8 0 1
Vin9 in9 0 DC 0
* tiled Rdiv9a series x4  each=249750
Rdiv9at1 in9 Rdiv9an1 249099.823302933
Rdiv9at2 Rdiv9an1 Rdiv9an2 249241.225566379
Rdiv9at3 Rdiv9an2 Rdiv9an3 250764.965191959
Rdiv9at4 Rdiv9an3 tap9 250615.128657727
* tiled Rdiv9b parallel x4  each=4004
Rdiv9bt1 tap9 0 3994.48313526129
Rdiv9bt2 tap9 0 4022.75800842788
Rdiv9bt3 tap9 0 3987.58475625794
Rdiv9bt4 tap9 0 3991.75950099629
Ediv9 inf9 0 tap9 0 1
Vin10 in10 0 DC 0
* tiled Rdiv10a series x4  each=249750
Rdiv10at1 in10 Rdiv10an1 248664.826842289
Rdiv10at2 Rdiv10an1 Rdiv10an2 249841.526514197
Rdiv10at3 Rdiv10an2 Rdiv10an3 250732.100660215
Rdiv10at4 Rdiv10an3 tap10 250695.369009257
* tiled Rdiv10b parallel x4  each=4004
Rdiv10bt1 tap10 0 4002.78525758061
Rdiv10bt2 tap10 0 3993.46218715726
Rdiv10bt3 tap10 0 4014.01344453038
Rdiv10bt4 tap10 0 4023.43446217204
Ediv10 inf10 0 tap10 0 1
Vin11 in11 0 DC 0
* tiled Rdiv11a series x4  each=249750
Rdiv11at1 in11 Rdiv11an1 249481.036041649
Rdiv11at2 Rdiv11an1 Rdiv11an2 249169.347571315
Rdiv11at3 Rdiv11an2 Rdiv11an3 250667.082166166
Rdiv11at4 Rdiv11an3 tap11 250043.523907026
* tiled Rdiv11b parallel x4  each=4004
Rdiv11bt1 tap11 0 3997.54195754769
Rdiv11bt2 tap11 0 3997.08814036269
Rdiv11bt3 tap11 0 4013.2233502659
Rdiv11bt4 tap11 0 3992.71222914003
Ediv11 inf11 0 tap11 0 1
Vin12 in12 0 DC 0
* tiled Rdiv12a series x4  each=249750
Rdiv12at1 in12 Rdiv12an1 249937.902790001
Rdiv12at2 Rdiv12an1 Rdiv12an2 250248.779630345
Rdiv12at3 Rdiv12an2 Rdiv12an3 250624.714334233
Rdiv12at4 Rdiv12an3 tap12 249742.43793595
* tiled Rdiv12b parallel x4  each=4004
Rdiv12bt1 tap12 0 4003.89744252662
Rdiv12bt2 tap12 0 4009.34584168734
Rdiv12bt3 tap12 0 4018.97640946309
Rdiv12bt4 tap12 0 3985.70749269842
Ediv12 inf12 0 tap12 0 1
Vin13 in13 0 DC 0
* tiled Rdiv13a series x4  each=249750
Rdiv13at1 in13 Rdiv13an1 248890.009480324
Rdiv13at2 Rdiv13an1 Rdiv13an2 248769.094476685
Rdiv13at3 Rdiv13an2 Rdiv13an3 250589.440581974
Rdiv13at4 Rdiv13an3 tap13 250779.440586336
* tiled Rdiv13b parallel x4  each=4004
Rdiv13bt1 tap13 0 4016.04104482227
Rdiv13bt2 tap13 0 3997.75979810546
Rdiv13bt3 tap13 0 4012.0210712795
Rdiv13bt4 tap13 0 4003.10367488779
Ediv13 inf13 0 tap13 0 1
Vin14 in14 0 DC 0
* tiled Rdiv14a series x4  each=249750
Rdiv14at1 in14 Rdiv14an1 249874.334587931
Rdiv14at2 Rdiv14an1 Rdiv14an2 249516.247980108
Rdiv14at3 Rdiv14an2 Rdiv14an3 249841.40811933
Rdiv14at4 Rdiv14an3 tap14 250762.169171463
* tiled Rdiv14b parallel x4  each=4004
Rdiv14bt1 tap14 0 4022.32754142891
Rdiv14bt2 tap14 0 3989.23064937319
Rdiv14bt3 tap14 0 4007.56353323436
Rdiv14bt4 tap14 0 4018.20258408867
Ediv14 inf14 0 tap14 0 1
Vin15 in15 0 DC 0
* tiled Rdiv15a series x4  each=249750
Rdiv15at1 in15 Rdiv15an1 250537.820128124
Rdiv15at2 Rdiv15an1 Rdiv15an2 248825.030501744
Rdiv15at3 Rdiv15an2 Rdiv15an3 248772.922205395
Rdiv15at4 Rdiv15an3 tap15 249282.90025218
* tiled Rdiv15b parallel x4  each=4004
Rdiv15bt1 tap15 0 3985.45121460775
Rdiv15bt2 tap15 0 4019.64564469031
Rdiv15bt3 tap15 0 4016.31499721215
Rdiv15bt4 tap15 0 4019.00129615976
Ediv15 inf15 0 tap15 0 1
Vin16 in16 0 DC 0
* tiled Rdiv16a series x4  each=249750
Rdiv16at1 in16 Rdiv16an1 248996.739323454
Rdiv16at2 Rdiv16an1 Rdiv16an2 249830.87981512
Rdiv16at3 Rdiv16an2 Rdiv16an3 250884.227494759
Rdiv16at4 Rdiv16an3 tap16 249347.956924759
* tiled Rdiv16b parallel x4  each=4004
Rdiv16bt1 tap16 0 3994.43627707737
Rdiv16bt2 tap16 0 3989.12809798253
Rdiv16bt3 tap16 0 4014.05126314969
Rdiv16bt4 tap16 0 3989.74190998813
Ediv16 inf16 0 tap16 0 1
Vref vref 0 DC 1
* tiled Rdivrefa series x4  each=249750
Rdivrefat1 vref Rdivrefan1 250273.390974631
Rdivrefat2 Rdivrefan1 Rdivrefan2 248919.004249146
Rdivrefat3 Rdivrefan2 Rdivrefan3 249999.578588253
Rdivrefat4 Rdivrefan3 tapref 249959.630271678
* tiled Rdivrefb parallel x4  each=4004
Rdivrefbt1 tapref 0 4007.17407871671
Rdivrefbt2 tapref 0 4022.68179041845
Rdivrefbt3 tapref 0 4022.22453070262
Rdivrefbt4 tapref 0 3999.1569764929
Edivref vreff 0 tapref 0 1

* h1 input 1 w=-0.0168555731920106 w-  bank=f alpha=0.001 R=1977.58527423636 G_phys=0.000505667195760317 G_eff=5.05667195760317e-07
* tiled Rh1n1f1 parallel x4  each=7910.34109694546
Rh1n1f1t1 inf1 h1n 7916.97422810149
Rh1n1f1t2 inf1 h1n 7944.84761392558
Rh1n1f1t3 inf1 h1n 7916.45111662117
Rh1n1f1t4 inf1 h1n 7919.80167264961
* h1 input 2 w=+0.167421682129858 w+  bank=n alpha=1 R=199098.067283059 G_phys=5.02265046389574e-06 G_eff=5.02265046389574e-06
* tiled Rh1p2n1 series x4  each=49774.5168207646
Rh1p2n1t1 in2 Rh1p2n1n1 49861.0692524198
Rh1p2n1t2 Rh1p2n1n1 Rh1p2n1n2 49854.4268062532
Rh1p2n1t3 Rh1p2n1n2 Rh1p2n1n3 49553.4987215238
Rh1p2n1t4 Rh1p2n1n3 h1p 49677.4919630383
* h1 input 3 w=-0.175338604042315 w-  bank=n alpha=1 R=190108.353579049 G_phys=5.26015812126946e-06 G_eff=5.26015812126946e-06
* tiled Rh1n3n1 series x4  each=47527.0883947622
Rh1n3n1t1 in3 Rh1n3n1n1 47408.0387675913
Rh1n3n1t2 Rh1n3n1n1 Rh1n3n1n2 47496.9143679752
Rh1n3n1t3 Rh1n3n1n2 Rh1n3n1n3 47734.4323108441
Rh1n3n1t4 Rh1n3n1n3 h1n 47433.8632849476
* h1 input 4 w=-0.3026243730549 w-  bank=n alpha=1 R=110147.55023478 G_phys=9.078731191647e-06 G_eff=9.078731191647e-06
* tiled Rh1n4n1 series x4  each=27536.8875586949
Rh1n4n1t1 in4 Rh1n4n1n1 27631.3853245694
Rh1n4n1t2 Rh1n4n1n1 Rh1n4n1n2 27623.7058201678
Rh1n4n1t3 Rh1n4n1n2 Rh1n4n1n3 27443.0304347323
Rh1n4n1t4 Rh1n4n1n3 h1n 27430.0274617164
* h1 input 5 w=-0.0731653551060092 w-  bank=n alpha=1 R=455589.032336913 G_phys=2.19496065318027e-06 G_eff=2.19496065318027e-06
* tiled Rh1n5n1 series x4  each=113897.258084228
Rh1n5n1t1 in5 Rh1n5n1n1 114381.972383332
Rh1n5n1t2 Rh1n5n1n1 Rh1n5n1n2 114227.670327149
Rh1n5n1t3 Rh1n5n1n2 Rh1n5n1n3 113553.53565014
Rh1n5n1t4 Rh1n5n1n3 h1n 113551.037440385
* h1 input 6 w=+0.135452999280782 w+  bank=n alpha=1 R=246087.820205711 G_phys=4.06358997842346e-06 G_eff=4.06358997842346e-06
* tiled Rh1p6n1 series x4  each=61521.9550514277
Rh1p6n1t1 in6 Rh1p6n1n1 61307.7879116703
Rh1p6n1t2 Rh1p6n1n1 Rh1p6n1n2 61749.83804943
Rh1p6n1t3 Rh1p6n1n2 Rh1p6n1n3 61735.4109498563
Rh1p6n1t4 Rh1p6n1n3 h1p 61390.5034073077
* h1 input 7 w=+0.21541693193391 w+  bank=n alpha=1 R=154738.687595643 G_phys=6.46250795801731e-06 G_eff=6.46250795801731e-06
* tiled Rh1p7n1 series x4  each=38684.6718989108
Rh1p7n1t1 in7 Rh1p7n1n1 38845.2796777862
Rh1p7n1t2 Rh1p7n1n1 Rh1p7n1n2 38688.2878790137
Rh1p7n1t3 Rh1p7n1n2 Rh1p7n1n3 38515.4412838169
Rh1p7n1t4 Rh1p7n1n3 h1p 38592.4049290873
* h1 input 8 w=-0.0225117532106789 w-  bank=f alpha=0.001 R=1480.70801156087 G_phys=0.000675352596320366 G_eff=6.75352596320366e-07
* tiled Rh1n8f1 parallel x4  each=5922.83204624348
Rh1n8f1t1 inf8 h1n 5939.64783084159
Rh1n8f1t2 inf8 h1n 5896.25450925245
Rh1n8f1t3 inf8 h1n 5921.64991560885
Rh1n8f1t4 inf8 h1n 5895.34545440629
* h1 input 9 w=-0.120865686071453 w-  bank=n alpha=1 R=275788.227550601 G_phys=3.62597058214359e-06 G_eff=3.62597058214359e-06
* tiled Rh1n9n1 series x4  each=68947.0568876502
Rh1n9n1t1 in9 Rh1n9n1n1 68964.8298023586
Rh1n9n1t2 Rh1n9n1n1 Rh1n9n1n2 68673.5944987297
Rh1n9n1t3 Rh1n9n1n2 Rh1n9n1n3 68670.3090709208
Rh1n9n1t4 Rh1n9n1n3 h1n 68647.4012284424
* h1 input 10 w=+0.732018397911567 w+  bank=n alpha=1 R=45536.19612353 G_phys=2.1960551937347e-05 G_eff=2.1960551937347e-05
* tiled Rh1p10n1 series x4  each=11384.0490308825
Rh1p10n1t1 in10 Rh1p10n1n1 11362.4281416623
Rh1p10n1t2 Rh1p10n1n1 Rh1p10n1n2 11401.6048192944
Rh1p10n1t3 Rh1p10n1n2 Rh1p10n1n3 11435.4597262934
Rh1p10n1t4 Rh1p10n1n3 h1p 11404.2329708588
* h1 input 11 w=+0.435334885703784 w+  bank=n alpha=1 R=76569.405365814 G_phys=1.30600465711135e-05 G_eff=1.30600465711135e-05
* tiled Rh1p11n1 series x4  each=19142.3513414535
Rh1p11n1t1 in11 Rh1p11n1n1 19224.9915461271
Rh1p11n1t2 Rh1p11n1n1 Rh1p11n1n2 19161.0836980295
Rh1p11n1t3 Rh1p11n1n2 Rh1p11n1n3 19212.3511474508
Rh1p11n1t4 Rh1p11n1n3 h1p 19160.2611298876
* h1 input 12 w=+0.385479984810207 w+  bank=n alpha=1 R=86472.2803954274 G_phys=1.15643995443062e-05 G_eff=1.15643995443062e-05
* tiled Rh1p12n1 series x4  each=21618.0700988569
Rh1p12n1t1 in12 Rh1p12n1n1 21633.8416202931
Rh1p12n1t2 Rh1p12n1n1 Rh1p12n1n2 21584.8313364442
Rh1p12n1t3 Rh1p12n1n2 Rh1p12n1n3 21524.2347109488
Rh1p12n1t4 Rh1p12n1n3 h1p 21708.8266777602
* h1 input 13 w=-0.42800728852471 w-  bank=n alpha=1 R=77880.2936936643 G_phys=1.28402186557413e-05 G_eff=1.28402186557413e-05
* tiled Rh1n13n1 series x4  each=19470.0734234161
Rh1n13n1t1 in13 Rh1n13n1n1 19521.2234120777
Rh1n13n1t2 Rh1n13n1n1 Rh1n13n1n2 19438.2616180692
Rh1n13n1t3 Rh1n13n1n2 Rh1n13n1n3 19377.9007594262
Rh1n13n1t4 Rh1n13n1n3 h1n 19554.9786553436
* h1 input 14 w=+0.104452911276431 w+  bank=n alpha=1 R=319123.066327159 G_phys=3.13358733829293e-06 G_eff=3.13358733829293e-06
* tiled Rh1p14n1 series x4  each=79780.7665817897
Rh1p14n1t1 in14 Rh1p14n1n1 79814.7699471853
Rh1p14n1t2 Rh1p14n1n1 Rh1p14n1n2 79798.3252927833
Rh1p14n1t3 Rh1p14n1n2 Rh1p14n1n3 79887.9868017672
Rh1p14n1t4 Rh1p14n1n3 h1p 80115.5675806817
* h1 input 15 w=-0.361295245628978 w-  bank=n alpha=1 R=92260.6475911506 G_phys=1.08388573688693e-05 G_eff=1.08388573688693e-05
* tiled Rh1n15n1 series x4  each=23065.1618977876
Rh1n15n1t1 in15 Rh1n15n1n1 23156.3526164222
Rh1n15n1t2 Rh1n15n1n1 Rh1n15n1n2 23097.05082119
Rh1n15n1t3 Rh1n15n1n2 Rh1n15n1n3 23132.3526855787
Rh1n15n1t4 Rh1n15n1n3 h1n 23067.5794885635
* h1 input 16 w=+0.0759383856082483 w+  bank=n alpha=1 R=438952.356786904 G_phys=2.27815156824745e-06 G_eff=2.27815156824745e-06
* tiled Rh1p16n1 series x4  each=109738.089196726
Rh1p16n1t1 in16 Rh1p16n1n1 110150.640863326
Rh1p16n1t2 Rh1p16n1n1 Rh1p16n1n2 109405.510522296
Rh1p16n1t3 Rh1p16n1n2 Rh1p16n1n3 109532.977544757
Rh1p16n1t4 Rh1p16n1n3 h1p 109598.921613417
* h1 bias=-0.0910888061470142 b-  bank=n alpha=1 R=365943.245315286 G_phys=2.73266418441043e-06 G_eff=2.73266418441043e-06
* tiled Rh1bnn1 series x4  each=91485.8113288215
Rh1bnn1t1 vref Rh1bnn1n1 91128.4610861216
Rh1bnn1t2 Rh1bnn1n1 Rh1bnn1n2 91248.5292045533
Rh1bnn1t3 Rh1bnn1n2 Rh1bnn1n3 91451.9374323599
Rh1bnn1t4 Rh1bnn1n3 h1n 91206.2687630337
Vh1p h1p 0 DC 0
Vh1n h1n 0 DC 0
Fh1p 0 h1d Vh1p 1.001
Fh1n h1d 0 Vh1n 1.001
* ratiometric I-to-V: V = I * R_IV,  R_IV=33333.3333333333 (weight ~ R_IV / R_w)
* tiled Rh1iv series x4  each=8333.33333333333
Rh1ivt1 h1d Rh1ivn1 8364.76099374244
Rh1ivt2 Rh1ivn1 Rh1ivn2 8365.94396970158
Rh1ivt3 Rh1ivn2 Rh1ivn3 8305.40699261934
Rh1ivt4 Rh1ivn3 0 8334.48478802179
Bh1leak 0 h1d I = 1e-08
Eh1sc h1raw 0 h1d 0 1
Eh1lin h1lin 0 h1raw 0 1
* direct bounded ReLU: y=max(0, min(15, v(h1lin))) no high-gain op-amp loop
Bh1relu h1y 0 V = max(0, min(15, (0.001) + v(h1lin)))
Eh1 h1buf 0 h1y 0 1

* h2 input 1 w=+0.0248542194622879 w+  bank=f alpha=0.001 R=1341.15389879417 G_phys=0.000745626583868636 G_eff=7.45626583868636e-07
* tiled Rh2p1f1 parallel x4  each=5364.61559517668
Rh2p1f1t1 inf1 h2p 5340.19023884835
Rh2p1f1t2 inf1 h2p 5371.01608423896
Rh2p1f1t3 inf1 h2p 5389.00235998548
Rh2p1f1t4 inf1 h2p 5342.27851388593
* h2 input 2 w=+0.400223191665755 w+  bank=n alpha=1 R=83286.8610002279 G_phys=1.20066957499727e-05 G_eff=1.20066957499727e-05
* tiled Rh2p2n1 series x4  each=20821.715250057
Rh2p2n1t1 in2 Rh2p2n1n1 20777.032244506
Rh2p2n1t2 Rh2p2n1n1 Rh2p2n1n2 20870.835406947
Rh2p2n1t3 Rh2p2n1n2 Rh2p2n1n3 20835.5904624034
Rh2p2n1t4 Rh2p2n1n3 h2p 20867.7429628674
* h2 input 3 w=+0.358260577298724 w+  bank=n alpha=1 R=93042.1471004872 G_phys=1.07478173189617e-05 G_eff=1.07478173189617e-05
* tiled Rh2p3n1 series x4  each=23260.5367751218
Rh2p3n1t1 in3 Rh2p3n1n1 23260.8753149447
Rh2p3n1t2 Rh2p3n1n1 Rh2p3n1n2 23151.0628390906
Rh2p3n1t3 Rh2p3n1n2 Rh2p3n1n3 23230.2081585657
Rh2p3n1t4 Rh2p3n1n3 h2p 23312.4935289672
* h2 input 4 w=+0.348073132477087 w+  bank=n alpha=1 R=95765.315455733 G_phys=1.04421939743126e-05 G_eff=1.04421939743126e-05
* tiled Rh2p4n1 series x4  each=23941.3288639332
Rh2p4n1t1 in4 Rh2p4n1n1 24005.083131394
Rh2p4n1t2 Rh2p4n1n1 Rh2p4n1n2 23925.9235617535
Rh2p4n1t3 Rh2p4n1n2 Rh2p4n1n3 24005.9602976509
Rh2p4n1t4 Rh2p4n1n3 h2p 23879.7929412638
* h2 input 5 w=-0.489776715185261 w-  bank=n alpha=1 R=68058.2238800895 G_phys=1.46933014555578e-05 G_eff=1.46933014555578e-05
* tiled Rh2n5n1 series x4  each=17014.5559700224
Rh2n5n1t1 in5 Rh2n5n1n1 16997.2472600648
Rh2n5n1t2 Rh2n5n1n1 Rh2n5n1n2 16942.5058978371
Rh2n5n1t3 Rh2n5n1n2 Rh2n5n1n3 16952.5667567516
Rh2n5n1t4 Rh2n5n1n3 h2n 16958.3025267158
* h2 input 6 w=-0.262585224656684 w-  bank=n alpha=1 R=126942.913017726 G_phys=7.87755673970051e-06 G_eff=7.87755673970051e-06
* tiled Rh2n6n1 series x4  each=31735.7282544314
Rh2n6n1t1 in6 Rh2n6n1n1 31861.5315159098
Rh2n6n1t2 Rh2n6n1n1 Rh2n6n1n2 31749.5681636688
Rh2n6n1t3 Rh2n6n1n2 Rh2n6n1n3 31629.4448816291
Rh2n6n1t4 Rh2n6n1n3 h2n 31711.9055362081
* h2 input 7 w=+0.634452480443638 w+  bank=n alpha=1 R=52538.7390873232 G_phys=1.90335744133091e-05 G_eff=1.90335744133091e-05
* tiled Rh2p7n1 series x4  each=13134.6847718308
Rh2p7n1t1 in7 Rh2p7n1n1 13196.3262608816
Rh2p7n1t2 Rh2p7n1n1 Rh2p7n1n2 13071.5852056933
Rh2p7n1t3 Rh2p7n1n2 Rh2p7n1n3 13194.1096896575
Rh2p7n1t4 Rh2p7n1n3 h2p 13145.674483254
* h2 input 8 w=-0.0150494358056585 w-  bank=f alpha=0.001 R=2214.92245714621 G_phys=0.000451483074169756 G_eff=4.51483074169756e-07
* tiled Rh2n8f1 parallel x4  each=8859.68982858484
Rh2n8f1t1 inf8 h2n 8844.40502595048
Rh2n8f1t2 inf8 h2n 8860.58676373907
Rh2n8f1t3 inf8 h2n 8897.83056746199
Rh2n8f1t4 inf8 h2n 8824.89637372391
* h2 input 9 w=+0.317089980091076 w+  bank=n alpha=1 R=105122.632142962 G_phys=9.51269940273229e-06 G_eff=9.51269940273229e-06
* tiled Rh2p9n1 series x4  each=26280.6580357405
Rh2p9n1t1 in9 Rh2p9n1n1 26377.9453483833
Rh2p9n1t2 Rh2p9n1n1 Rh2p9n1n2 26236.2828298004
Rh2p9n1t3 Rh2p9n1n2 Rh2p9n1n3 26374.2172675427
Rh2p9n1t4 Rh2p9n1n3 h2p 26268.9201624222
* h2 input 10 w=-0.171694565495531 w-  bank=n alpha=1 R=194143.2056229 G_phys=5.15083696486594e-06 G_eff=5.15083696486594e-06
* tiled Rh2n10n1 series x4  each=48535.8014057249
Rh2n10n1t1 in10 Rh2n10n1n1 48477.6278408425
Rh2n10n1t2 Rh2n10n1n1 Rh2n10n1n2 48461.5164701831
Rh2n10n1t3 Rh2n10n1n2 Rh2n10n1n3 48697.6314792628
Rh2n10n1t4 Rh2n10n1n3 h2n 48492.5751186618
* h2 input 11 w=+0.113535277026032 w+  bank=n alpha=1 R=293594.503897589 G_phys=3.40605831078097e-06 G_eff=3.40605831078097e-06
* tiled Rh2p11n1 series x4  each=73398.6259743972
Rh2p11n1t1 in11 Rh2p11n1n1 73162.7800330519
Rh2p11n1t2 Rh2p11n1n1 Rh2p11n1n2 73631.0492938226
Rh2p11n1t3 Rh2p11n1n2 Rh2p11n1n3 73248.8872984311
Rh2p11n1t4 Rh2p11n1n3 h2p 73349.4085031805
* h2 input 12 w=+0.342235951147447 w+  bank=n alpha=1 R=97398.6900603912 G_phys=1.02670785344234e-05 G_eff=1.02670785344234e-05
* tiled Rh2p12n1 series x4  each=24349.6725150978
Rh2p12n1t1 in12 Rh2p12n1n1 24245.8190514585
Rh2p12n1t2 Rh2p12n1n1 Rh2p12n1n2 24364.1512821818
Rh2p12n1t3 Rh2p12n1n2 Rh2p12n1n3 24342.9353648397
Rh2p12n1t4 Rh2p12n1n3 h2p 24258.0998552465
* h2 input 13 w=-0.268945400148547 w-  bank=n alpha=1 R=123940.89400645 G_phys=8.0683620044564e-06 G_eff=8.0683620044564e-06
* tiled Rh2n13n1 series x4  each=30985.2235016125
Rh2n13n1t1 in13 Rh2n13n1n1 30948.7184962805
Rh2n13n1t2 Rh2n13n1n1 Rh2n13n1n2 31078.7832019247
Rh2n13n1t3 Rh2n13n1n2 Rh2n13n1n3 31066.2393463043
Rh2n13n1t4 Rh2n13n1n3 h2n 30844.9953750741
* h2 input 14 w=+0.239258603190851 w+  bank=n alpha=1 R=139319.267473714 G_phys=7.17775809572554e-06 G_eff=7.17775809572554e-06
* tiled Rh2p14n1 series x4  each=34829.8168684284
Rh2p14n1t1 in14 Rh2p14n1n1 34820.8520695143
Rh2p14n1t2 Rh2p14n1n1 Rh2p14n1n2 34698.0509410444
Rh2p14n1t3 Rh2p14n1n2 Rh2p14n1n3 34767.0770304351
Rh2p14n1t4 Rh2p14n1n3 h2p 34723.1724197719
* h2 input 15 w=+0.347826837541335 w+  bank=n alpha=1 R=95833.1265320264 G_phys=1.043480512624e-05 G_eff=1.043480512624e-05
* tiled Rh2p15n1 series x4  each=23958.2816330066
Rh2p15n1t1 in15 Rh2p15n1n1 23893.0501097655
Rh2p15n1t2 Rh2p15n1n1 Rh2p15n1n2 23986.3969848683
Rh2p15n1t3 Rh2p15n1n2 Rh2p15n1n3 23969.8029866473
Rh2p15n1t4 Rh2p15n1n3 h2p 23844.7875683205
* h2 input 16 w=+0.00438097035906581 w+  bank=f alpha=0.001 R=7608.66442849918 G_phys=0.000131429110771974 G_eff=1.31429110771974e-07
* tiled Rh2p16f1 series x4  each=1902.1661071248
Rh2p16f1t1 inf16 Rh2p16f1n1 1899.37366181744
Rh2p16f1t2 Rh2p16f1n1 Rh2p16f1n2 1894.10686825401
Rh2p16f1t3 Rh2p16f1n2 Rh2p16f1n3 1898.49876147975
Rh2p16f1t4 Rh2p16f1n3 h2p 1909.89890187628
* h2 bias=-0.0501304580317642 b-  bank=n alpha=1 R=664931.752911819 G_phys=1.50391374095293e-06 G_eff=1.50391374095293e-06
* tiled Rh2bnn1 series x4  each=166232.938227955
Rh2bnn1t1 vref Rh2bnn1n1 165751.981168773
Rh2bnn1t2 Rh2bnn1n1 Rh2bnn1n2 165682.047719215
Rh2bnn1t3 Rh2bnn1n2 Rh2bnn1n3 166330.385042067
Rh2bnn1t4 Rh2bnn1n3 h2n 165993.135024997
Vh2p h2p 0 DC 0
Vh2n h2n 0 DC 0
Fh2p 0 h2d Vh2p 1.001
Fh2n h2d 0 Vh2n 1.001
* ratiometric I-to-V: V = I * R_IV,  R_IV=33333.3333333333 (weight ~ R_IV / R_w)
* tiled Rh2iv series x4  each=8333.33333333333
Rh2ivt1 h2d Rh2ivn1 8329.84460589084
Rh2ivt2 Rh2ivn1 Rh2ivn2 8334.9870069166
Rh2ivt3 Rh2ivn2 Rh2ivn3 8372.09115660662
Rh2ivt4 Rh2ivn3 0 8344.06820892342
Bh2leak 0 h2d I = 1e-08
Eh2sc h2raw 0 h2d 0 1
Eh2lin h2lin 0 h2raw 0 1
* direct bounded ReLU: y=max(0, min(15, v(h2lin))) no high-gain op-amp loop
Bh2relu h2y 0 V = max(0, min(15, (0.001) + v(h2lin)))
Eh2 h2buf 0 h2y 0 1

* h3 input 1 w=-0.916033562434709 w-  bank=n alpha=1 R=36388.7686000689 G_phys=2.74810068730413e-05 G_eff=2.74810068730413e-05
* tiled Rh3n1n1 series x4  each=9097.19215001721
Rh3n1n1t1 in1 Rh3n1n1n1 9115.57991127663
Rh3n1n1t2 Rh3n1n1n1 Rh3n1n1n2 9088.62777543576
Rh3n1n1t3 Rh3n1n1n2 Rh3n1n1n3 9114.62804252299
Rh3n1n1t4 Rh3n1n1n3 h3n 9112.16286117248
* h3 input 2 w=+0.507521982744407 w+  bank=n alpha=1 R=65678.6000738028 G_phys=1.52256594823322e-05 G_eff=1.52256594823322e-05
* tiled Rh3p2n1 series x4  each=16419.6500184507
Rh3p2n1t1 in2 Rh3p2n1n1 16398.8308979848
Rh3p2n1t2 Rh3p2n1n1 Rh3p2n1n2 16401.9816228038
Rh3p2n1t3 Rh3p2n1n2 Rh3p2n1n3 16354.5731393643
Rh3p2n1t4 Rh3p2n1n3 h3p 16420.3062193525
* h3 input 3 w=+0.0871477019742823 w+  bank=n alpha=1 R=382492.395991924 G_phys=2.61443105922847e-06 G_eff=2.61443105922847e-06
* tiled Rh3p3n1 series x4  each=95623.098997981
Rh3p3n1t1 in3 Rh3p3n1n1 95965.3384147712
Rh3p3n1t2 Rh3p3n1n1 Rh3p3n1n2 95589.3759931596
Rh3p3n1t3 Rh3p3n1n2 Rh3p3n1n3 95380.1882178335
Rh3p3n1t4 Rh3p3n1n3 h3p 95833.4284987566
* h3 input 4 w=-0.0658557100969535 w-  bank=n alpha=1 R=506157.071030889 G_phys=1.97567130290861e-06 G_eff=1.97567130290861e-06
* tiled Rh3n4n1 series x4  each=126539.267757722
Rh3n4n1t1 in4 Rh3n4n1n1 126876.661449143
Rh3n4n1t2 Rh3n4n1n1 Rh3n4n1n2 126716.636462494
Rh3n4n1t3 Rh3n4n1n2 Rh3n4n1n3 126820.498898828
Rh3n4n1t4 Rh3n4n1n3 h3n 126985.468216389
* h3 input 5 w=-0.179053685151098 w-  bank=n alpha=1 R=186163.905563878 G_phys=5.37161055453294e-06 G_eff=5.37161055453294e-06
* tiled Rh3n5n1 series x4  each=46540.9763909695
Rh3n5n1t1 in5 Rh3n5n1n1 46638.6398336257
Rh3n5n1t2 Rh3n5n1n1 Rh3n5n1n2 46497.1373882162
Rh3n5n1t3 Rh3n5n1n2 Rh3n5n1n3 46524.9638458783
Rh3n5n1t4 Rh3n5n1n3 h3n 46546.4028979164
* h3 input 6 w=+0.315007728496672 w+  bank=n alpha=1 R=105817.509597024 G_phys=9.45023185490017e-06 G_eff=9.45023185490017e-06
* tiled Rh3p6n1 series x4  each=26454.377399256
Rh3p6n1t1 in6 Rh3p6n1n1 26465.1256481644
Rh3p6n1t2 Rh3p6n1n1 Rh3p6n1n2 26578.3863449148
Rh3p6n1t3 Rh3p6n1n2 Rh3p6n1n3 26564.6119341726
Rh3p6n1t4 Rh3p6n1n3 h3p 26491.7111981587
* h3 input 7 w=+0.677608935484657 w+  bank=n alpha=1 R=49192.5823107569 G_phys=2.03282680645397e-05 G_eff=2.03282680645397e-05
* tiled Rh3p7n1 series x4  each=12298.1455776892
Rh3p7n1t1 in7 Rh3p7n1n1 12339.6297408605
Rh3p7n1t2 Rh3p7n1n1 Rh3p7n1n2 12259.325709271
Rh3p7n1t3 Rh3p7n1n2 Rh3p7n1n3 12251.2678111381
Rh3p7n1t4 Rh3p7n1n3 h3p 12294.3979970285
* h3 input 8 w=+0.295351776524173 w+  bank=n alpha=1 R=112859.769206789 G_phys=8.8605532957252e-06 G_eff=8.8605532957252e-06
* tiled Rh3p8n1 series x4  each=28214.9423016972
Rh3p8n1t1 in8 Rh3p8n1n1 28076.825445862
Rh3p8n1t2 Rh3p8n1n1 Rh3p8n1n2 28327.6013970789
Rh3p8n1t3 Rh3p8n1n2 Rh3p8n1n3 28078.4125566386
Rh3p8n1t4 Rh3p8n1n3 h3p 28277.5681436451
* h3 input 9 w=+0.00172302579693755 w+  bank=f alpha=0.001 R=19345.8121129578 G_phys=5.16907739081266e-05 G_eff=5.16907739081266e-08
* tiled Rh3p9f1 series x4  each=4836.45302823946
Rh3p9f1t1 inf9 Rh3p9f1n1 4844.71535472351
Rh3p9f1t2 Rh3p9f1n1 Rh3p9f1n2 4852.76440456128
Rh3p9f1t3 Rh3p9f1n2 Rh3p9f1n3 4816.27541628989
Rh3p9f1t4 Rh3p9f1n3 h3p 4841.0719015594
* h3 input 10 w=+0.317835264102281 w+  bank=n alpha=1 R=104876.132695604 G_phys=9.53505792306844e-06 G_eff=9.53505792306844e-06
* tiled Rh3p10n1 series x4  each=26219.0331739011
Rh3p10n1t1 in10 Rh3p10n1n1 26227.4192496386
Rh3p10n1t2 Rh3p10n1n1 Rh3p10n1n2 26259.6622143968
Rh3p10n1t3 Rh3p10n1n2 Rh3p10n1n3 26271.7130113624
Rh3p10n1t4 Rh3p10n1n3 h3p 26125.9693513721
* h3 input 11 w=-0.530129158700576 w-  bank=n alpha=1 R=62877.7587240027 G_phys=1.59038747610173e-05 G_eff=1.59038747610173e-05
* tiled Rh3n11n1 series x4  each=15719.4396810007
Rh3n11n1t1 in11 Rh3n11n1n1 15721.1465161985
Rh3n11n1t2 Rh3n11n1n1 Rh3n11n1n2 15747.5133573257
Rh3n11n1t3 Rh3n11n1n2 Rh3n11n1n3 15759.7873735354
Rh3n11n1t4 Rh3n11n1n3 h3n 15790.8236020835
* h3 input 12 w=-0.291249394999097 w-  bank=n alpha=1 R=114449.450902505 G_phys=8.7374818499729e-06 G_eff=8.7374818499729e-06
* tiled Rh3n12n1 series x4  each=28612.3627256262
Rh3n12n1t1 in12 Rh3n12n1n1 28522.7325455079
Rh3n12n1t2 Rh3n12n1n1 Rh3n12n1n2 28607.2738370196
Rh3n12n1t3 Rh3n12n1n2 Rh3n12n1n3 28581.1383893679
Rh3n12n1t4 Rh3n12n1n3 h3n 28552.9974085845
* h3 input 13 w=-0.395820894073244 w-  bank=n alpha=1 R=84213.1727567804 G_phys=1.18746268221973e-05 G_eff=1.18746268221973e-05
* tiled Rh3n13n1 series x4  each=21053.2931891951
Rh3n13n1t1 in13 Rh3n13n1n1 20968.0185245567
Rh3n13n1t2 Rh3n13n1n1 Rh3n13n1n2 21053.271077919
Rh3n13n1t3 Rh3n13n1n2 Rh3n13n1n3 21122.7999809788
Rh3n13n1t4 Rh3n13n1n3 h3n 21013.2121010982
* h3 input 14 w=-0.0451489915790311 w-  bank=n alpha=1 R=738296.297825057 G_phys=1.35446974737093e-06 G_eff=1.35446974737093e-06
* tiled Rh3n14n1 series x4  each=184574.074456264
Rh3n14n1t1 in14 Rh3n14n1n1 184479.898987075
Rh3n14n1t2 Rh3n14n1n1 Rh3n14n1n2 184719.209446453
Rh3n14n1t3 Rh3n14n1n2 Rh3n14n1n3 184701.422569913
Rh3n14n1t4 Rh3n14n1n3 h3n 184484.863198377
* h3 input 15 w=+0.0633187763010491 w+  bank=n alpha=1 R=526436.789852823 G_phys=1.89956328903147e-06 G_eff=1.89956328903147e-06
* tiled Rh3p15n1 series x4  each=131609.197463206
Rh3p15n1t1 in15 Rh3p15n1n1 132129.098546273
Rh3p15n1t2 Rh3p15n1n1 Rh3p15n1n2 131414.207498016
Rh3p15n1t3 Rh3p15n1n2 Rh3p15n1n3 131529.629330478
Rh3p15n1t4 Rh3p15n1n3 h3p 131788.696570433
* h3 input 16 w=-0.149745176344707 w-  bank=n alpha=1 R=222600.381174225 G_phys=4.49235529034122e-06 G_eff=4.49235529034122e-06
* tiled Rh3n16n1 series x4  each=55650.0952935562
Rh3n16n1t1 in16 Rh3n16n1n1 55820.0481726677
Rh3n16n1t2 Rh3n16n1n1 Rh3n16n1n2 55711.2757241942
Rh3n16n1t3 Rh3n16n1n2 Rh3n16n1n3 55926.2221063721
Rh3n16n1t4 Rh3n16n1n3 h3n 55631.9769314502
* h3 bias=-0.0553554658432052 b-  bank=n alpha=1 R=602168.780003591 G_phys=1.66066397529616e-06 G_eff=1.66066397529616e-06
* tiled Rh3bnn1 series x4  each=150542.195000898
Rh3bnn1t1 vref Rh3bnn1n1 150752.242658723
Rh3bnn1t2 Rh3bnn1n1 Rh3bnn1n2 149871.335117619
Rh3bnn1t3 Rh3bnn1n2 Rh3bnn1n3 150220.576523929
Rh3bnn1t4 Rh3bnn1n3 h3n 150037.763476821
Vh3p h3p 0 DC 0
Vh3n h3n 0 DC 0
Fh3p 0 h3d Vh3p 1.001
Fh3n h3d 0 Vh3n 1.001
* ratiometric I-to-V: V = I * R_IV,  R_IV=33333.3333333333 (weight ~ R_IV / R_w)
* tiled Rh3iv series x4  each=8333.33333333333
Rh3ivt1 h3d Rh3ivn1 8309.30658466636
Rh3ivt2 Rh3ivn1 Rh3ivn2 8342.10085831757
Rh3ivt3 Rh3ivn2 Rh3ivn3 8322.17064383342
Rh3ivt4 Rh3ivn3 0 8325.56474444186
Bh3leak 0 h3d I = 1e-08
Eh3sc h3raw 0 h3d 0 1
Eh3lin h3lin 0 h3raw 0 1
* direct bounded ReLU: y=max(0, min(15, v(h3lin))) no high-gain op-amp loop
Bh3relu h3y 0 V = max(0, min(15, (0.001) + v(h3lin)))
Eh3 h3buf 0 h3y 0 1

* h4 input 1 w=+0.0673940677866904 w+  bank=n alpha=1 R=494603.374273786 G_phys=2.02182203360071e-06 G_eff=2.02182203360071e-06
* tiled Rh4p1n1 series x4  each=123650.843568446
Rh4p1n1t1 in1 Rh4p1n1n1 123390.230810627
Rh4p1n1t2 Rh4p1n1n1 Rh4p1n1n2 124259.698008177
Rh4p1n1t3 Rh4p1n1n2 Rh4p1n1n3 123636.22198784
Rh4p1n1t4 Rh4p1n1n3 h4p 123217.299167688
* h4 input 2 w=-0.087995350925692 w-  bank=n alpha=1 R=378807.891356463 G_phys=2.63986052777076e-06 G_eff=2.63986052777076e-06
* tiled Rh4n2n1 series x4  each=94701.9728391157
Rh4n2n1t1 in2 Rh4n2n1n1 94748.6280031984
Rh4n2n1t2 Rh4n2n1n1 Rh4n2n1n2 95087.8779311979
Rh4n2n1t3 Rh4n2n1n2 Rh4n2n1n3 94617.4649586033
Rh4n2n1t4 Rh4n2n1n3 h4n 94372.8955463598
* h4 input 3 w=-0.354237391786533 w-  bank=n alpha=1 R=94098.8560389478 G_phys=1.0627121753596e-05 G_eff=1.0627121753596e-05
* tiled Rh4n3n1 series x4  each=23524.714009737
Rh4n3n1t1 in3 Rh4n3n1n1 23495.8430618877
Rh4n3n1t2 Rh4n3n1n1 Rh4n3n1n2 23638.8465986411
Rh4n3n1t3 Rh4n3n1n2 Rh4n3n1n3 23473.9134107224
Rh4n3n1t4 Rh4n3n1n3 h4n 23626.0254220685
* h4 input 4 w=-0.0201421700797575 w-  bank=f alpha=0.001 R=1654.90278362969 G_phys=0.000604265102392725 G_eff=6.04265102392725e-07
* tiled Rh4n4f1 parallel x4  each=6619.61113451876
Rh4n4f1t1 inf4 h4n 6634.53075297885
Rh4n4f1t2 inf4 h4n 6591.97908922435
Rh4n4f1t3 inf4 h4n 6601.59332178502
Rh4n4f1t4 inf4 h4n 6609.06311072858
* h4 input 5 w=-0.808084436849872 w-  bank=n alpha=1 R=41249.814763511 G_phys=2.42425331054962e-05 G_eff=2.42425331054962e-05
* tiled Rh4n5n1 series x4  each=10312.4536908777
Rh4n5n1t1 in5 Rh4n5n1n1 10271.5938384738
Rh4n5n1t2 Rh4n5n1n1 Rh4n5n1n2 10348.7234015256
Rh4n5n1t3 Rh4n5n1n2 Rh4n5n1n3 10330.4380182512
Rh4n5n1t4 Rh4n5n1n3 h4n 10301.866855804
* h4 input 6 w=-0.290030636557288 w-  bank=n alpha=1 R=114930.387110153 G_phys=8.70091909671864e-06 G_eff=8.70091909671864e-06
* tiled Rh4n6n1 series x4  each=28732.5967775384
Rh4n6n1t1 in6 Rh4n6n1n1 28592.2811228455
Rh4n6n1t2 Rh4n6n1n1 Rh4n6n1n2 28592.4443974172
Rh4n6n1t3 Rh4n6n1n2 Rh4n6n1n3 28806.3167091173
Rh4n6n1t4 Rh4n6n1n3 h4n 28814.5453697828
* h4 input 7 w=+0.344262354214072 w+  bank=n alpha=1 R=96825.3801942158 G_phys=1.03278706264222e-05 G_eff=1.03278706264222e-05
* tiled Rh4p7n1 series x4  each=24206.345048554
Rh4p7n1t1 in7 Rh4p7n1n1 24302.735198376
Rh4p7n1t2 Rh4p7n1n1 Rh4p7n1n2 24289.8064182498
Rh4p7n1t3 Rh4p7n1n2 Rh4p7n1n3 24213.9893343105
Rh4p7n1t4 Rh4p7n1n3 h4p 24201.5055272064
* h4 input 8 w=-0.872472737770673 w-  bank=n alpha=1 R=38205.5872811637 G_phys=2.61741821331202e-05 G_eff=2.61741821331202e-05
* tiled Rh4n8n1 series x4  each=9551.39682029094
Rh4n8n1t1 in8 Rh4n8n1n1 9560.86024025323
Rh4n8n1t2 Rh4n8n1n1 Rh4n8n1n2 9556.52201723754
Rh4n8n1t3 Rh4n8n1n2 Rh4n8n1n3 9543.50903155455
Rh4n8n1t4 Rh4n8n1n3 h4n 9579.82641470466
* h4 input 9 w=+0.163024654235771 w+  bank=n alpha=1 R=204468.051103029 G_phys=4.89073962707314e-06 G_eff=4.89073962707314e-06
* tiled Rh4p9n1 series x4  each=51117.0127757573
Rh4p9n1t1 in9 Rh4p9n1n1 51188.7412387057
Rh4p9n1t2 Rh4p9n1n1 Rh4p9n1n2 51098.5153958412
Rh4p9n1t3 Rh4p9n1n2 Rh4p9n1n3 50962.4122159145
Rh4p9n1t4 Rh4p9n1n3 h4p 50979.3696748519
* h4 input 10 w=-0.143734302026109 w-  bank=n alpha=1 R=231909.383240185 G_phys=4.31202906078326e-06 G_eff=4.31202906078326e-06
* tiled Rh4n10n1 series x4  each=57977.3458100462
Rh4n10n1t1 in10 Rh4n10n1n1 58062.4268682985
Rh4n10n1t2 Rh4n10n1n1 Rh4n10n1n2 58096.2376397005
Rh4n10n1t3 Rh4n10n1n2 Rh4n10n1n3 58021.965505573
Rh4n10n1t4 Rh4n10n1n3 h4n 58016.1256376249
* h4 input 11 w=-0.110414936368951 w-  bank=n alpha=1 R=301891.523280421 G_phys=3.31244809106853e-06 G_eff=3.31244809106853e-06
* tiled Rh4n11n1 series x4  each=75472.8808201051
Rh4n11n1t1 in11 Rh4n11n1n1 75107.2540133336
Rh4n11n1t2 Rh4n11n1n1 Rh4n11n1n2 75782.5033077785
Rh4n11n1t3 Rh4n11n1n2 Rh4n11n1n3 75269.3675290233
Rh4n11n1t4 Rh4n11n1n3 h4n 75412.9504411014
* h4 input 12 w=+0.321561566587255 w+  bank=n alpha=1 R=103660.812724298 G_phys=9.64684699761765e-06 G_eff=9.64684699761765e-06
* tiled Rh4p12n1 series x4  each=25915.2031810745
Rh4p12n1t1 in12 Rh4p12n1n1 25883.9675127068
Rh4p12n1t2 Rh4p12n1n1 Rh4p12n1n2 25930.8363732064
Rh4p12n1t3 Rh4p12n1n2 Rh4p12n1n3 25822.1794462094
Rh4p12n1t4 Rh4p12n1n3 h4p 25798.8459109094
* h4 input 13 w=-0.501486514423905 w-  bank=n alpha=1 R=66469.0522568205 G_phys=1.50445954327172e-05 G_eff=1.50445954327172e-05
* tiled Rh4n13n1 series x4  each=16617.2630642051
Rh4n13n1t1 in13 Rh4n13n1n1 16622.087260317
Rh4n13n1t2 Rh4n13n1n1 Rh4n13n1n2 16549.8599531906
Rh4n13n1t3 Rh4n13n1n2 Rh4n13n1n3 16633.6212771131
Rh4n13n1t4 Rh4n13n1n3 h4n 16572.3233103655
* h4 input 14 w=-0.0233644803539605 w-  bank=f alpha=0.001 R=1426.66701028012 G_phys=0.000700934410618815 G_eff=7.00934410618815e-07
* tiled Rh4n14f1 parallel x4  each=5706.66804112047
Rh4n14f1t1 inf14 h4n 5718.19026218129
Rh4n14f1t2 inf14 h4n 5717.32788460032
Rh4n14f1t3 inf14 h4n 5683.34686289032
Rh4n14f1t4 inf14 h4n 5727.22954626168
* h4 input 15 w=-0.211065663454959 w-  bank=n alpha=1 R=157928.735483053 G_phys=6.33196990364878e-06 G_eff=6.33196990364878e-06
* tiled Rh4n15n1 series x4  each=39482.1838707632
Rh4n15n1t1 in15 Rh4n15n1n1 39305.4926605725
Rh4n15n1t2 Rh4n15n1n1 Rh4n15n1n2 39606.5227969276
Rh4n15n1t3 Rh4n15n1n2 Rh4n15n1n3 39410.8983243754
Rh4n15n1t4 Rh4n15n1n3 h4n 39416.183521025
* h4 input 16 w=+0.18002446765288 w+  bank=n alpha=1 R=185160.016124064 G_phys=5.40073402958641e-06 G_eff=5.40073402958641e-06
* tiled Rh4p16n1 series x4  each=46290.004031016
Rh4p16n1t1 in16 Rh4p16n1n1 46338.2482685715
Rh4p16n1t2 Rh4p16n1n1 Rh4p16n1n2 46362.5738409673
Rh4p16n1t3 Rh4p16n1n2 Rh4p16n1n3 46418.7455381589
Rh4p16n1t4 Rh4p16n1n3 h4p 46481.7667621275
* h4 bias=+0.0472838049870426 b+  bank=n alpha=1 R=704963.006730694 G_phys=1.41851414961128e-06 G_eff=1.41851414961128e-06
* tiled Rh4bpn1 series x4  each=176240.751682673
Rh4bpn1t1 vref Rh4bpn1n1 175886.303673744
Rh4bpn1t2 Rh4bpn1n1 Rh4bpn1n2 175616.746369663
Rh4bpn1t3 Rh4bpn1n2 Rh4bpn1n3 175841.867412422
Rh4bpn1t4 Rh4bpn1n3 h4p 175851.920289164
Vh4p h4p 0 DC 0
Vh4n h4n 0 DC 0
Fh4p 0 h4d Vh4p 1.001
Fh4n h4d 0 Vh4n 1.001
* ratiometric I-to-V: V = I * R_IV,  R_IV=33333.3333333333 (weight ~ R_IV / R_w)
* tiled Rh4iv series x4  each=8333.33333333333
Rh4ivt1 h4d Rh4ivn1 8357.58675031016
Rh4ivt2 Rh4ivn1 Rh4ivn2 8294.18105424373
Rh4ivt3 Rh4ivn2 Rh4ivn3 8365.238168577
Rh4ivt4 Rh4ivn3 0 8362.49500958028
Bh4leak 0 h4d I = 1e-08
Eh4sc h4raw 0 h4d 0 1
Eh4lin h4lin 0 h4raw 0 1
* direct bounded ReLU: y=max(0, min(15, v(h4lin))) no high-gain op-amp loop
Bh4relu h4y 0 V = max(0, min(15, (0.001) + v(h4lin)))
Eh4 h4buf 0 h4y 0 1

* h5 input 1 w=-0.122756848133934 w-  bank=n alpha=1 R=271539.501380525 G_phys=3.68270544401802e-06 G_eff=3.68270544401802e-06
* tiled Rh5n1n1 series x4  each=67884.8753451313
Rh5n1n1t1 in1 Rh5n1n1n1 67789.5410642843
Rh5n1n1t2 Rh5n1n1n1 Rh5n1n1n2 67770.181552841
Rh5n1n1t3 Rh5n1n1n2 Rh5n1n1n3 67990.7885666956
Rh5n1n1t4 Rh5n1n1n3 h5n 68135.2598080775
* h5 input 2 w=+0.794704720471975 w+  bank=n alpha=1 R=41944.300159104 G_phys=2.38411416141592e-05 G_eff=2.38411416141592e-05
* tiled Rh5p2n1 series x4  each=10486.075039776
Rh5p2n1t1 in2 Rh5p2n1n1 10522.0128907059
Rh5p2n1t2 Rh5p2n1n1 Rh5p2n1n2 10521.5324130567
Rh5p2n1t3 Rh5p2n1n2 Rh5p2n1n3 10447.354885235
Rh5p2n1t4 Rh5p2n1n3 h5p 10470.5982867108
* h5 input 3 w=-0.26372184795707 w-  bank=n alpha=1 R=126395.797661631 G_phys=7.91165543871211e-06 G_eff=7.91165543871211e-06
* tiled Rh5n3n1 series x4  each=31598.9494154078
Rh5n3n1t1 in3 Rh5n3n1n1 31657.9719497642
Rh5n3n1t2 Rh5n3n1n1 Rh5n3n1n2 31592.8073724038
Rh5n3n1t3 Rh5n3n1n2 Rh5n3n1n3 31701.1800576888
Rh5n3n1t4 Rh5n3n1n3 h5n 31596.1064779142
* h5 input 4 w=+0.65217090039031 w+  bank=n alpha=1 R=51111.3472149464 G_phys=1.95651270117093e-05 G_eff=1.95651270117093e-05
* tiled Rh5p4n1 series x4  each=12777.8368037366
Rh5p4n1t1 in4 Rh5p4n1n1 12796.6728668624
Rh5p4n1t2 Rh5p4n1n1 Rh5p4n1n2 12818.8196657613
Rh5p4n1t3 Rh5p4n1n2 Rh5p4n1n3 12830.0570067139
Rh5p4n1t4 Rh5p4n1n3 h5p 12821.2044542539
* h5 input 5 w=-0.272670344884174 w-  bank=n alpha=1 R=122247.739656077 G_phys=8.18011034652521e-06 G_eff=8.18011034652521e-06
* tiled Rh5n5n1 series x4  each=30561.9349140194
Rh5n5n1t1 in5 Rh5n5n1n1 30706.2306320278
Rh5n5n1t2 Rh5n5n1n1 Rh5n5n1n2 30476.9169443898
Rh5n5n1t3 Rh5n5n1n2 Rh5n5n1n3 30586.9581390868
Rh5n5n1t4 Rh5n5n1n3 h5n 30509.431210572
* h5 input 6 w=+0.0607101548077554 w+  bank=n alpha=1 R=549056.964833751 G_phys=1.82130464423266e-06 G_eff=1.82130464423266e-06
* tiled Rh5p6n1 series x4  each=137264.241208438
Rh5p6n1t1 in6 Rh5p6n1n1 136750.250061912
Rh5p6n1t2 Rh5p6n1n1 Rh5p6n1n2 137331.824780022
Rh5p6n1t3 Rh5p6n1n2 Rh5p6n1n3 137387.318118035
Rh5p6n1t4 Rh5p6n1n3 h5p 137302.565229163
* h5 input 7 w=+0.629980287413506 w+  bank=n alpha=1 R=52911.7085078791 G_phys=1.88994086224052e-05 G_eff=1.88994086224052e-05
* tiled Rh5p7n1 series x4  each=13227.9271269698
Rh5p7n1t1 in7 Rh5p7n1n1 13170.7780068947
Rh5p7n1t2 Rh5p7n1n1 Rh5p7n1n2 13268.6634081581
Rh5p7n1t3 Rh5p7n1n2 Rh5p7n1n3 13218.1318605884
Rh5p7n1t4 Rh5p7n1n3 h5p 13255.040363281
* h5 input 8 w=-0.369402487956774 w-  bank=n alpha=1 R=90235.8116690157 G_phys=1.10820746387032e-05 G_eff=1.10820746387032e-05
* tiled Rh5n8n1 series x4  each=22558.9529172539
Rh5n8n1t1 in8 Rh5n8n1n1 22518.853306663
Rh5n8n1t2 Rh5n8n1n1 Rh5n8n1n2 22523.4583453698
Rh5n8n1t3 Rh5n8n1n2 Rh5n8n1n3 22539.8367012719
Rh5n8n1t4 Rh5n8n1n3 h5n 22470.1214354262
* h5 input 9 w=-0.0924511829208223 w-  bank=n alpha=1 R=360550.641757401 G_phys=2.77353548762467e-06 G_eff=2.77353548762467e-06
* tiled Rh5n9n1 series x4  each=90137.6604393502
Rh5n9n1t1 in9 Rh5n9n1n1 89815.9181020008
Rh5n9n1t2 Rh5n9n1n1 Rh5n9n1n2 90012.4984954843
Rh5n9n1t3 Rh5n9n1n2 Rh5n9n1n3 89967.345751079
Rh5n9n1t4 Rh5n9n1n3 h5n 90013.3087541763
* h5 input 10 w=-0.00426485730080124 w-  bank=f alpha=0.001 R=7815.81445340996 G_phys=0.000127945719024037 G_eff=1.27945719024037e-07
* tiled Rh5n10f1 series x4  each=1953.95361335249
Rh5n10f1t1 inf10 Rh5n10f1n1 1955.57007979421
Rh5n10f1t2 Rh5n10f1n1 Rh5n10f1n2 1956.38309617013
Rh5n10f1t3 Rh5n10f1n2 Rh5n10f1n3 1953.14047212203
Rh5n10f1t4 Rh5n10f1n3 h5n 1949.84272383908
* h5 input 11 w=+0.540478898079688 w+  bank=n alpha=1 R=61673.6998461292 G_phys=1.62143669423906e-05 G_eff=1.62143669423906e-05
* tiled Rh5p11n1 series x4  each=15418.4249615323
Rh5p11n1t1 in11 Rh5p11n1n1 15420.9970100525
Rh5p11n1t2 Rh5p11n1n1 Rh5p11n1n2 15385.2297635566
Rh5p11n1t3 Rh5p11n1n2 Rh5p11n1n3 15358.5508240522
Rh5p11n1t4 Rh5p11n1n3 h5p 15384.4813804789
* h5 input 12 w=+0.161688921548601 w+  bank=n alpha=1 R=206157.187604928 G_phys=4.85066764645802e-06 G_eff=4.85066764645802e-06
* tiled Rh5p12n1 series x4  each=51539.2969012319
Rh5p12n1t1 in12 Rh5p12n1n1 51531.7687880841
Rh5p12n1t2 Rh5p12n1n1 Rh5p12n1n2 51774.5408604663
Rh5p12n1t3 Rh5p12n1n2 Rh5p12n1n3 51488.1548835606
Rh5p12n1t4 Rh5p12n1n3 h5p 51329.1239150081
* h5 input 13 w=+0.0259557799028364 w+  bank=f alpha=0.001 R=1284.23547503154 G_phys=0.000778673397085092 G_eff=7.78673397085092e-07
* tiled Rh5p13f1 parallel x4  each=5136.94190012618
Rh5p13f1t1 inf13 h5p 5134.17467839791
Rh5p13f1t2 inf13 h5p 5160.05658180409
Rh5p13f1t3 inf13 h5p 5139.04287251944
Rh5p13f1t4 inf13 h5p 5131.94315831905
* h5 input 14 w=+0.470073429319239 w+  bank=n alpha=1 R=70910.907220616 G_phys=1.41022028795772e-05 G_eff=1.41022028795772e-05
* tiled Rh5p14n1 series x4  each=17727.726805154
Rh5p14n1t1 in14 Rh5p14n1n1 17677.4470929764
Rh5p14n1t2 Rh5p14n1n1 Rh5p14n1n2 17693.2158600482
Rh5p14n1t3 Rh5p14n1n2 Rh5p14n1n3 17663.3699103524
Rh5p14n1t4 Rh5p14n1n3 h5p 17805.0663071107
* h5 input 15 w=+0.188749264833093 w+  bank=n alpha=1 R=176601.129349083 G_phys=5.66247794499279e-06 G_eff=5.66247794499279e-06
* tiled Rh5p15n1 series x4  each=44150.2823372707
Rh5p15n1t1 in15 Rh5p15n1n1 43966.1264050001
Rh5p15n1t2 Rh5p15n1n1 Rh5p15n1n2 44016.0199468475
Rh5p15n1t3 Rh5p15n1n2 Rh5p15n1n3 44307.4674747076
Rh5p15n1t4 Rh5p15n1n3 h5p 44280.0105336803
* h5 input 16 w=+0.031866913791992 w+  bank=f alpha=0.001 R=1046.01699276288 G_phys=0.000956007413759761 G_eff=9.56007413759761e-07
* tiled Rh5p16f1 parallel x4  each=4184.06797105151
Rh5p16f1t1 inf16 h5p 4171.01681051976
Rh5p16f1t2 inf16 h5p 4164.58695592961
Rh5p16f1t3 inf16 h5p 4189.36671509399
Rh5p16f1t4 inf16 h5p 4173.24132546448
* h5 bias=+0.0181393489298792 b+  bank=f alpha=0.001 R=1837.62567566174 G_phys=0.000544180467896375 G_eff=5.44180467896375e-07
* tiled Rh5bpf1 parallel x4  each=7350.50270264697
Rh5bpf1t1 vreff h5p 7369.3555311619
Rh5bpf1t2 vreff h5p 7360.22813699259
Rh5bpf1t3 vreff h5p 7355.98223993529
Rh5bpf1t4 vreff h5p 7353.14173081347
Vh5p h5p 0 DC 0
Vh5n h5n 0 DC 0
Fh5p 0 h5d Vh5p 1.001
Fh5n h5d 0 Vh5n 1.001
* ratiometric I-to-V: V = I * R_IV,  R_IV=33333.3333333333 (weight ~ R_IV / R_w)
* tiled Rh5iv series x4  each=8333.33333333333
Rh5ivt1 h5d Rh5ivn1 8302.9132315282
Rh5ivt2 Rh5ivn1 Rh5ivn2 8299.57276587965
Rh5ivt3 Rh5ivn2 Rh5ivn3 8352.66948629935
Rh5ivt4 Rh5ivn3 0 8364.96721821777
Bh5leak 0 h5d I = 1e-08
Eh5sc h5raw 0 h5d 0 1
Eh5lin h5lin 0 h5raw 0 1
* direct bounded ReLU: y=max(0, min(15, v(h5lin))) no high-gain op-amp loop
Bh5relu h5y 0 V = max(0, min(15, (0.001) + v(h5lin)))
Eh5 h5buf 0 h5y 0 1

* h6 input 1 w=-0.340583473625464 w-  bank=n alpha=1 R=97871.2589266431 G_phys=1.02175042087639e-05 G_eff=1.02175042087639e-05
* tiled Rh6n1n1 series x4  each=24467.8147316608
Rh6n1n1t1 in1 Rh6n1n1n1 24466.6556952293
Rh6n1n1t2 Rh6n1n1n1 Rh6n1n1n2 24561.9917711541
Rh6n1n1t3 Rh6n1n1n2 Rh6n1n1n3 24383.3579365268
Rh6n1n1t4 Rh6n1n1n3 h6n 24506.1735578551
* h6 input 2 w=-0.593797589144587 w-  bank=n alpha=1 R=56135.8515809279 G_phys=1.78139276743376e-05 G_eff=1.78139276743376e-05
* tiled Rh6n2n1 series x4  each=14033.962895232
Rh6n2n1t1 in2 Rh6n2n1n1 14017.66391538
Rh6n2n1t2 Rh6n2n1n1 Rh6n2n1n2 13978.3826415045
Rh6n2n1t3 Rh6n2n1n2 Rh6n2n1n3 14049.586447616
Rh6n2n1t4 Rh6n2n1n3 h6n 14084.4442196516
* h6 input 3 w=-0.388639564922933 w-  bank=n alpha=1 R=85769.2740057059 G_phys=1.1659186947688e-05 G_eff=1.1659186947688e-05
* tiled Rh6n3n1 series x4  each=21442.3185014265
Rh6n3n1t1 in3 Rh6n3n1n1 21436.2214713666
Rh6n3n1t2 Rh6n3n1n1 Rh6n3n1n2 21486.5520273084
Rh6n3n1t3 Rh6n3n1n2 Rh6n3n1n3 21535.9340180409
Rh6n3n1t4 Rh6n3n1n3 h6n 21342.3226776846
* h6 input 4 w=+0.284617429170421 w+  bank=n alpha=1 R=117116.275803947 G_phys=8.53852287511263e-06 G_eff=8.53852287511263e-06
* tiled Rh6p4n1 series x4  each=29279.0689509867
Rh6p4n1t1 in4 Rh6p4n1n1 29351.1608939031
Rh6p4n1t2 Rh6p4n1n1 Rh6p4n1n2 29269.4153661358
Rh6p4n1t3 Rh6p4n1n2 Rh6p4n1n3 29244.2652097021
Rh6p4n1t4 Rh6p4n1n3 h6p 29376.7520357927
* h6 input 5 w=-0.270576674342045 w-  bank=n alpha=1 R=123193.669278364 G_phys=8.11730023026134e-06 G_eff=8.11730023026134e-06
* tiled Rh6n5n1 series x4  each=30798.4173195909
Rh6n5n1t1 in5 Rh6n5n1n1 30738.9535159422
Rh6n5n1t2 Rh6n5n1n1 Rh6n5n1n2 30757.3608613491
Rh6n5n1t3 Rh6n5n1n2 Rh6n5n1n3 30897.2473695564
Rh6n5n1t4 Rh6n5n1n3 h6n 30754.7864044627
* h6 input 6 w=+0.0593082278184784 w+  bank=n alpha=1 R=562035.565037534 G_phys=1.77924683455435e-06 G_eff=1.77924683455435e-06
* tiled Rh6p6n1 series x4  each=140508.891259384
Rh6p6n1t1 in6 Rh6p6n1n1 140989.393736173
Rh6p6n1t2 Rh6p6n1n1 Rh6p6n1n2 139970.48305841
Rh6p6n1t3 Rh6p6n1n2 Rh6p6n1n3 140837.00619516
Rh6p6n1t4 Rh6p6n1n3 h6p 140681.264695784
* h6 input 7 w=+0.460681196235491 w+  bank=n alpha=1 R=72356.6179946576 G_phys=1.38204358870647e-05 G_eff=1.38204358870647e-05
* tiled Rh6p7n1 series x4  each=18089.1544986644
Rh6p7n1t1 in7 Rh6p7n1n1 18051.8392800539
Rh6p7n1t2 Rh6p7n1n1 Rh6p7n1n2 18038.083162819
Rh6p7n1t3 Rh6p7n1n2 Rh6p7n1n3 18032.4838548528
Rh6p7n1t4 Rh6p7n1n3 h6p 18029.8395917467
* h6 input 8 w=+0.530418434730864 w+  bank=n alpha=1 R=62843.46687582 G_phys=1.59125530419259e-05 G_eff=1.59125530419259e-05
* tiled Rh6p8n1 series x4  each=15710.866718955
Rh6p8n1t1 in8 Rh6p8n1n1 15768.4559086598
Rh6p8n1t2 Rh6p8n1n1 Rh6p8n1n2 15652.5716359738
Rh6p8n1t3 Rh6p8n1n2 Rh6p8n1n3 15739.947566862
Rh6p8n1t4 Rh6p8n1n3 h6p 15661.9660340006
* h6 input 9 w=+0.069052799324409 w+  bank=n alpha=1 R=482722.40458687 G_phys=2.07158397973227e-06 G_eff=2.07158397973227e-06
* tiled Rh6p9n1 series x4  each=120680.601146718
Rh6p9n1t1 in9 Rh6p9n1n1 121254.848316068
Rh6p9n1t2 Rh6p9n1n1 Rh6p9n1n2 120202.946621999
Rh6p9n1t3 Rh6p9n1n2 Rh6p9n1n3 120566.004757369
Rh6p9n1t4 Rh6p9n1n3 h6p 120858.635090839
* h6 input 10 w=+0.150678240315211 w+  bank=n alpha=1 R=221221.944612585 G_phys=4.52034720945633e-06 G_eff=4.52034720945633e-06
* tiled Rh6p10n1 series x4  each=55305.4861531462
Rh6p10n1t1 in10 Rh6p10n1n1 55492.3477197728
Rh6p10n1t2 Rh6p10n1n1 Rh6p10n1n2 55181.1622518934
Rh6p10n1t3 Rh6p10n1n2 Rh6p10n1n3 55501.5345324165
Rh6p10n1t4 Rh6p10n1n3 h6p 55541.4825699323
* h6 input 11 w=+0.0896190095447204 w+  bank=n alpha=1 R=371944.897658123 G_phys=2.68857028634161e-06 G_eff=2.68857028634161e-06
* tiled Rh6p11n1 series x4  each=92986.2244145307
Rh6p11n1t1 in11 Rh6p11n1n1 93042.3381122368
Rh6p11n1t2 Rh6p11n1n1 Rh6p11n1n2 93262.9933206554
Rh6p11n1t3 Rh6p11n1n2 Rh6p11n1n3 92542.408127346
Rh6p11n1t4 Rh6p11n1n3 h6p 92761.9120571215
* h6 input 12 w=-0.177342454994274 w-  bank=n alpha=1 R=187960.256524077 G_phys=5.32027364982823e-06 G_eff=5.32027364982823e-06
* tiled Rh6n12n1 series x4  each=46990.0641310192
Rh6n12n1t1 in12 Rh6n12n1n1 46819.2153879078
Rh6n12n1t2 Rh6n12n1n1 Rh6n12n1n2 47022.5134408933
Rh6n12n1t3 Rh6n12n1n2 Rh6n12n1n3 47084.7641633746
Rh6n12n1t4 Rh6n12n1n3 h6n 46913.6121256496
* h6 input 13 w=+0.643544080066549 w+  bank=n alpha=1 R=51796.5037140678 G_phys=1.93063224019965e-05 G_eff=1.93063224019965e-05
* tiled Rh6p13n1 series x4  each=12949.1259285169
Rh6p13n1t1 in13 Rh6p13n1n1 13004.7024292611
Rh6p13n1t2 Rh6p13n1n1 Rh6p13n1n2 12912.1818792053
Rh6p13n1t3 Rh6p13n1n2 Rh6p13n1n3 12964.3608271669
Rh6p13n1t4 Rh6p13n1n3 h6p 12898.8256281976
* h6 input 14 w=+0.0993069474158396 w+  bank=n alpha=1 R=335659.63108052 G_phys=2.97920842247519e-06 G_eff=2.97920842247519e-06
* tiled Rh6p14n1 series x4  each=83914.9077701301
Rh6p14n1t1 in14 Rh6p14n1n1 83864.7183250799
Rh6p14n1t2 Rh6p14n1n1 Rh6p14n1n2 83525.8968545427
Rh6p14n1t3 Rh6p14n1n2 Rh6p14n1n3 83998.1783597382
Rh6p14n1t4 Rh6p14n1n3 h6p 84082.4942537683
* h6 input 15 w=-0.324176483950696 w-  bank=n alpha=1 R=102824.649484455 G_phys=9.72529451852089e-06 G_eff=9.72529451852089e-06
* tiled Rh6n15n1 series x4  each=25706.1623711137
Rh6n15n1t1 in15 Rh6n15n1n1 25795.8110249874
Rh6n15n1t2 Rh6n15n1n1 Rh6n15n1n2 25828.0238897312
Rh6n15n1t3 Rh6n15n1n2 Rh6n15n1n3 25657.4672252989
Rh6n15n1t4 Rh6n15n1n3 h6n 25638.6745149939
* h6 input 16 w=+0.0932186969347454 w+  bank=n alpha=1 R=357582.056276406 G_phys=2.79656090804236e-06 G_eff=2.79656090804236e-06
* tiled Rh6p16n1 series x4  each=89395.5140691014
Rh6p16n1t1 in16 Rh6p16n1n1 89363.4717534387
Rh6p16n1t2 Rh6p16n1n1 Rh6p16n1n2 88979.5258090489
Rh6p16n1t3 Rh6p16n1n2 Rh6p16n1n3 89605.9616539283
Rh6p16n1t4 Rh6p16n1n3 h6p 89394.6103442702
* h6 bias=-0.0198556852101353 b-  bank=f alpha=0.001 R=1678.78030803583 G_phys=0.000595670556304058 G_eff=5.95670556304058e-07
* tiled Rh6bnf1 parallel x4  each=6715.12123214332
Rh6bnf1t1 vreff h6n 6714.11863030617
Rh6bnf1t2 vreff h6n 6723.19305621279
Rh6bnf1t3 vreff h6n 6725.00848158709
Rh6bnf1t4 vreff h6n 6707.73353890179
Vh6p h6p 0 DC 0
Vh6n h6n 0 DC 0
Fh6p 0 h6d Vh6p 1.001
Fh6n h6d 0 Vh6n 1.001
* ratiometric I-to-V: V = I * R_IV,  R_IV=33333.3333333333 (weight ~ R_IV / R_w)
* tiled Rh6iv series x4  each=8333.33333333333
Rh6ivt1 h6d Rh6ivn1 8333.67262007446
Rh6ivt2 Rh6ivn1 Rh6ivn2 8363.72117523143
Rh6ivt3 Rh6ivn2 Rh6ivn3 8355.51220509025
Rh6ivt4 Rh6ivn3 0 8357.11028040694
Bh6leak 0 h6d I = 1e-08
Eh6sc h6raw 0 h6d 0 1
Eh6lin h6lin 0 h6raw 0 1
* direct bounded ReLU: y=max(0, min(15, v(h6lin))) no high-gain op-amp loop
Bh6relu h6y 0 V = max(0, min(15, (0.001) + v(h6lin)))
Eh6 h6buf 0 h6y 0 1

* h7 input 1 w=+0.32217720874051 w+  bank=n alpha=1 R=103462.729296227 G_phys=9.6653162622153e-06 G_eff=9.6653162622153e-06
* tiled Rh7p1n1 series x4  each=25865.6823240567
Rh7p1n1t1 in1 Rh7p1n1n1 25914.9358650768
Rh7p1n1t2 Rh7p1n1n1 Rh7p1n1n2 25774.2492905639
Rh7p1n1t3 Rh7p1n1n2 Rh7p1n1n3 25738.3807873867
Rh7p1n1t4 Rh7p1n1n3 h7p 25806.3103502098
* h7 input 2 w=-0.146738476402048 w-  bank=n alpha=1 R=227161.50631143 G_phys=4.40215429206143e-06 G_eff=4.40215429206143e-06
* tiled Rh7n2n1 series x4  each=56790.3765778574
Rh7n2n1t1 in2 Rh7n2n1n1 56841.6013208453
Rh7n2n1t2 Rh7n2n1n1 Rh7n2n1n2 56662.3483251909
Rh7n2n1t3 Rh7n2n1n2 Rh7n2n1n3 56629.8731276195
Rh7n2n1t4 Rh7n2n1n3 h7n 56849.3520116053
* h7 input 3 w=+0.524171111363509 w+  bank=n alpha=1 R=63592.4655340589 G_phys=1.57251333409053e-05 G_eff=1.57251333409053e-05
* tiled Rh7p3n1 series x4  each=15898.1163835147
Rh7p3n1t1 in3 Rh7p3n1n1 15842.8271233401
Rh7p3n1t2 Rh7p3n1n1 Rh7p3n1n2 15868.5486956157
Rh7p3n1t3 Rh7p3n1n2 Rh7p3n1n3 15854.6263255882
Rh7p3n1t4 Rh7p3n1n3 h7p 15868.0724719312
* h7 input 4 w=-0.439531494343149 w-  bank=n alpha=1 R=75838.3273151968 G_phys=1.31859448302945e-05 G_eff=1.31859448302945e-05
* tiled Rh7n4n1 series x4  each=18959.5818287992
Rh7n4n1t1 in4 Rh7n4n1n1 19033.2433542812
Rh7n4n1t2 Rh7n4n1n1 Rh7n4n1n2 18983.954040964
Rh7n4n1t3 Rh7n4n1n2 Rh7n4n1n3 18913.484636285
Rh7n4n1t4 Rh7n4n1n3 h7n 18927.7022619411
* h7 input 5 w=+0.367500929015048 w+  bank=n alpha=1 R=90702.718555491 G_phys=1.10250278704514e-05 G_eff=1.10250278704514e-05
* tiled Rh7p5n1 series x4  each=22675.6796388727
Rh7p5n1t1 in5 Rh7p5n1n1 22755.9287593111
Rh7p5n1t2 Rh7p5n1n1 Rh7p5n1n2 22785.2501018355
Rh7p5n1t3 Rh7p5n1n2 Rh7p5n1n3 22762.5652668326
Rh7p5n1t4 Rh7p5n1n3 h7p 22712.4567685948
* h7 input 6 w=-1.05409273633464 w-  bank=n alpha=1 R=31622.7711133294 G_phys=3.16227820900391e-05 G_eff=3.16227820900391e-05
* tiled Rh7n6n1 series x4  each=7905.69277833236
Rh7n6n1t1 in6 Rh7n6n1n1 7914.4000035775
Rh7n6n1t2 Rh7n6n1n1 Rh7n6n1n2 7867.15445275545
Rh7n6n1t3 Rh7n6n1n2 Rh7n6n1n3 7943.74467726744
Rh7n6n1t4 Rh7n6n1n3 h7n 7943.44534615642
* h7 input 7 w=-0.045065971974084 w-  bank=n alpha=1 R=739656.372051673 G_phys=1.35197915922252e-06 G_eff=1.35197915922252e-06
* tiled Rh7n7n1 series x4  each=184914.093012918
Rh7n7n1t1 in7 Rh7n7n1n1 185041.404586926
Rh7n7n1t2 Rh7n7n1n1 Rh7n7n1n2 185826.362669418
Rh7n7n1t3 Rh7n7n1n2 Rh7n7n1n3 184962.829793864
Rh7n7n1t4 Rh7n7n1n3 h7n 184682.542746796
* h7 input 8 w=-0.167915862386558 w-  bank=n alpha=1 R=198512.117077998 G_phys=5.03747587159673e-06 G_eff=5.03747587159673e-06
* tiled Rh7n8n1 series x4  each=49628.0292694995
Rh7n8n1t1 in8 Rh7n8n1n1 49717.9995373135
Rh7n8n1t2 Rh7n8n1n1 Rh7n8n1n2 49711.2062694832
Rh7n8n1t3 Rh7n8n1n2 Rh7n8n1n3 49765.5986542588
Rh7n8n1t4 Rh7n8n1n3 h7n 49439.9923655747
* h7 input 9 w=+0.0197430594045346 w+  bank=f alpha=0.001 R=1688.35703982521 G_phys=0.000592291782136037 G_eff=5.92291782136037e-07
* tiled Rh7p9f1 parallel x4  each=6753.42815930086
Rh7p9f1t1 inf9 h7p 6724.90657396993
Rh7p9f1t2 inf9 h7p 6725.89215559943
Rh7p9f1t3 inf9 h7p 6776.39808376899
Rh7p9f1t4 inf9 h7p 6761.85261966158
* h7 input 10 w=-0.287534460104587 w-  bank=n alpha=1 R=115928.133696423 G_phys=8.6260338031376e-06 G_eff=8.6260338031376e-06
* tiled Rh7n10n1 series x4  each=28982.0334241058
Rh7n10n1t1 in10 Rh7n10n1n1 28925.9588251541
Rh7n10n1t2 Rh7n10n1n1 Rh7n10n1n2 29054.5870992506
Rh7n10n1t3 Rh7n10n1n2 Rh7n10n1n3 28982.6063769442
Rh7n10n1t4 Rh7n10n1n3 h7n 29003.7971597051
* h7 input 11 w=-0.517871662481308 w-  bank=n alpha=1 R=64366.0114044885 G_phys=1.55361498744393e-05 G_eff=1.55361498744393e-05
* tiled Rh7n11n1 series x4  each=16091.5028511221
Rh7n11n1t1 in11 Rh7n11n1n1 16134.4603356852
Rh7n11n1t2 Rh7n11n1n1 Rh7n11n1n2 16049.3145412895
Rh7n11n1t3 Rh7n11n1n2 Rh7n11n1n3 16092.4549957784
Rh7n11n1t4 Rh7n11n1n3 h7n 16057.6213513932
* h7 input 12 w=+0.348150035983652 w+  bank=n alpha=1 R=95744.1616777503 G_phys=1.04445010795096e-05 G_eff=1.04445010795096e-05
* tiled Rh7p12n1 series x4  each=23936.0404194376
Rh7p12n1t1 in12 Rh7p12n1n1 24026.0054586126
Rh7p12n1t2 Rh7p12n1n1 Rh7p12n1n2 23914.8759641026
Rh7p12n1t3 Rh7p12n1n2 Rh7p12n1n3 23841.2952261074
Rh7p12n1t4 Rh7p12n1n3 h7p 24019.1298040795
* h7 input 13 w=-0.408247593362815 w-  bank=n alpha=1 R=81649.7975132203 G_phys=1.22474278008844e-05 G_eff=1.22474278008844e-05
* tiled Rh7n13n1 series x4  each=20412.4493783051
Rh7n13n1t1 in13 Rh7n13n1n1 20374.8944938323
Rh7n13n1t2 Rh7n13n1n1 Rh7n13n1n2 20336.3102113033
Rh7n13n1t3 Rh7n13n1n2 Rh7n13n1n3 20313.8317506207
Rh7n13n1t4 Rh7n13n1n3 h7n 20435.1592752702
* h7 input 14 w=-0.41711419269885 w-  bank=n alpha=1 R=79914.1671916195 G_phys=1.25134257809655e-05 G_eff=1.25134257809655e-05
* tiled Rh7n14n1 series x4  each=19978.5417979049
Rh7n14n1t1 in14 Rh7n14n1n1 19937.9039312646
Rh7n14n1t2 Rh7n14n1n1 Rh7n14n1n2 19976.1133955604
Rh7n14n1t3 Rh7n14n1n2 Rh7n14n1n3 19970.1485794704
Rh7n14n1t4 Rh7n14n1n3 h7n 19899.0229303697
* h7 input 15 w=-0.341449872918214 w-  bank=n alpha=1 R=97622.9191372918 G_phys=1.02434961875464e-05 G_eff=1.02434961875464e-05
* tiled Rh7n15n1 series x4  each=24405.7297843229
Rh7n15n1t1 in15 Rh7n15n1n1 24475.2517801469
Rh7n15n1t2 Rh7n15n1n1 Rh7n15n1n2 24300.8288927113
Rh7n15n1t3 Rh7n15n1n2 Rh7n15n1n3 24368.2906866471
Rh7n15n1t4 Rh7n15n1n3 h7n 24310.1656856916
* h7 input 16 w=-0.0335582003371702 w-  bank=n alpha=1 R=993299.193592697 G_phys=1.00674601011511e-06 G_eff=1.00674601011511e-06
* tiled Rh7n16n1 series x4  each=248324.798398174
Rh7n16n1t1 in16 Rh7n16n1n1 248849.137573232
Rh7n16n1t2 Rh7n16n1n1 Rh7n16n1n2 249383.955826166
Rh7n16n1t3 Rh7n16n1n2 Rh7n16n1n3 248384.919004915
Rh7n16n1t4 Rh7n16n1n3 h7n 247770.920802644
* h7 bias=-0.0212324287895191 b-  bank=f alpha=0.001 R=1569.92559182808 G_phys=0.000636972863685573 G_eff=6.36972863685573e-07
* tiled Rh7bnf1 parallel x4  each=6279.70236731232
Rh7bnf1t1 vreff h7n 6294.6441845776
Rh7bnf1t2 vreff h7n 6300.86528430852
Rh7bnf1t3 vreff h7n 6262.52274247445
Rh7bnf1t4 vreff h7n 6268.52133914364
Vh7p h7p 0 DC 0
Vh7n h7n 0 DC 0
Fh7p 0 h7d Vh7p 1.001
Fh7n h7d 0 Vh7n 1.001
* ratiometric I-to-V: V = I * R_IV,  R_IV=33333.3333333333 (weight ~ R_IV / R_w)
* tiled Rh7iv series x4  each=8333.33333333333
Rh7ivt1 h7d Rh7ivn1 8330.59924438338
Rh7ivt2 Rh7ivn1 Rh7ivn2 8351.74856507168
Rh7ivt3 Rh7ivn2 Rh7ivn3 8315.77358978392
Rh7ivt4 Rh7ivn3 0 8323.409670779
Bh7leak 0 h7d I = 1e-08
Eh7sc h7raw 0 h7d 0 1
Eh7lin h7lin 0 h7raw 0 1
* direct bounded ReLU: y=max(0, min(15, v(h7lin))) no high-gain op-amp loop
Bh7relu h7y 0 V = max(0, min(15, (0.001) + v(h7lin)))
Eh7 h7buf 0 h7y 0 1

* h8 input 1 w=+0.185544590700454 w+  bank=n alpha=1 R=179651.334525549 G_phys=5.56633772101363e-06 G_eff=5.56633772101363e-06
* tiled Rh8p1n1 series x4  each=44912.8336313871
Rh8p1n1t1 in1 Rh8p1n1n1 44963.5689740591
Rh8p1n1t2 Rh8p1n1n1 Rh8p1n1n2 44933.0521541869
Rh8p1n1t3 Rh8p1n1n2 Rh8p1n1n3 44966.6334409594
Rh8p1n1t4 Rh8p1n1n3 h8p 44929.8434714727
* h8 input 2 w=-0.385658106289114 w-  bank=n alpha=1 R=86432.3419882805 G_phys=1.15697431886734e-05 G_eff=1.15697431886734e-05
* tiled Rh8n2n1 series x4  each=21608.0854970701
Rh8n2n1t1 in2 Rh8n2n1n1 21672.4347436302
Rh8n2n1t2 Rh8n2n1n1 Rh8n2n1n2 21700.2914889955
Rh8n2n1t3 Rh8n2n1n2 Rh8n2n1n3 21567.9824602719
Rh8n2n1t4 Rh8n2n1n3 h8n 21691.3856378294
* h8 input 3 w=+0.230915543832556 w+  bank=n alpha=1 R=144352.92133259 G_phys=6.92746631497669e-06 G_eff=6.92746631497669e-06
* tiled Rh8p3n1 series x4  each=36088.2303331476
Rh8p3n1t1 in3 Rh8p3n1n1 35920.8752571994
Rh8p3n1t2 Rh8p3n1n1 Rh8p3n1n2 36248.7145167702
Rh8p3n1t3 Rh8p3n1n2 Rh8p3n1n3 36107.2661612739
Rh8p3n1t4 Rh8p3n1n3 h8p 36020.8462684324
* h8 input 4 w=+0.205353187615931 w+  bank=n alpha=1 R=162321.966950307 G_phys=6.16059562847793e-06 G_eff=6.16059562847793e-06
* tiled Rh8p4n1 series x4  each=40580.4917375768
Rh8p4n1t1 in4 Rh8p4n1n1 40728.2675425903
Rh8p4n1t2 Rh8p4n1n1 Rh8p4n1n2 40632.8829846714
Rh8p4n1t3 Rh8p4n1n2 Rh8p4n1n3 40430.4735306157
Rh8p4n1t4 Rh8p4n1n3 h8p 40609.4811159378
* h8 input 5 w=+0.00415238713767869 w+  bank=f alpha=0.001 R=8027.51097817138 G_phys=0.000124571614130361 G_eff=1.24571614130361e-07
* tiled Rh8p5f1 series x4  each=2006.87774454285
Rh8p5f1t1 inf5 Rh8p5f1n1 2009.51838739888
Rh8p5f1t2 Rh8p5f1n1 Rh8p5f1n2 2014.04361075967
Rh8p5f1t3 Rh8p5f1n2 Rh8p5f1n3 1998.01238811538
Rh8p5f1t4 Rh8p5f1n3 h8p 2009.52098646166
* h8 input 6 w=-0.514726379917983 w-  bank=n alpha=1 R=64759.3257968335 G_phys=1.54417913975395e-05 G_eff=1.54417913975395e-05
* tiled Rh8n6n1 series x4  each=16189.8314492084
Rh8n6n1t1 in6 Rh8n6n1n1 16156.0226349706
Rh8n6n1t2 Rh8n6n1n1 Rh8n6n1n2 16203.8272446907
Rh8n6n1t3 Rh8n6n1n2 Rh8n6n1n3 16240.3378300234
Rh8n6n1t4 Rh8n6n1n3 h8n 16200.3055687196
* h8 input 7 w=+0.210716479044664 w+  bank=n alpha=1 R=158190.443787113 G_phys=6.32149437133992e-06 G_eff=6.32149437133992e-06
* tiled Rh8p7n1 series x4  each=39547.6109467783
Rh8p7n1t1 in7 Rh8p7n1n1 39719.4235214819
Rh8p7n1t2 Rh8p7n1n1 Rh8p7n1n2 39484.0409492291
Rh8p7n1t3 Rh8p7n1n2 Rh8p7n1n3 39690.1939827393
Rh8p7n1t4 Rh8p7n1n3 h8p 39440.3732920086
* h8 input 8 w=+0.375574589425665 w+  bank=n alpha=1 R=88752.8982839526 G_phys=1.126723768277e-05 G_eff=1.126723768277e-05
* tiled Rh8p8n1 series x4  each=22188.2245709882
Rh8p8n1t1 in8 Rh8p8n1n1 22288.3746414727
Rh8p8n1t2 Rh8p8n1n1 Rh8p8n1n2 22084.8697817707
Rh8p8n1t3 Rh8p8n1n2 Rh8p8n1n3 22168.0055982037
Rh8p8n1t4 Rh8p8n1n3 h8p 22111.3084718781
* h8 input 9 w=+0.00572491873576676 w+  bank=f alpha=0.001 R=5822.49895096002 G_phys=0.000171747562073003 G_eff=1.71747562073003e-07
* tiled Rh8p9f1 series x4  each=1455.62473774
Rh8p9f1t1 inf9 Rh8p9f1n1 1448.52183741439
Rh8p9f1t2 Rh8p9f1n1 Rh8p9f1n2 1450.97604080427
Rh8p9f1t3 Rh8p9f1n2 Rh8p9f1n3 1453.53280731517
Rh8p9f1t4 Rh8p9f1n3 h8p 1461.95415129627
* h8 input 10 w=-0.367556769900021 w-  bank=n alpha=1 R=90688.9385887256 G_phys=1.10267030970006e-05 G_eff=1.10267030970006e-05
* tiled Rh8n10n1 series x4  each=22672.2346471814
Rh8n10n1t1 in10 Rh8n10n1n1 22757.3653351117
Rh8n10n1t2 Rh8n10n1n1 Rh8n10n1n2 22566.7880476923
Rh8n10n1t3 Rh8n10n1n2 Rh8n10n1n3 22567.3860072043
Rh8n10n1t4 Rh8n10n1n3 h8n 22698.1440155069
* h8 input 11 w=+0.41225604099869 w+  bank=n alpha=1 R=80855.9002618455 G_phys=1.23676812299607e-05 G_eff=1.23676812299607e-05
* tiled Rh8p11n1 series x4  each=20213.9750654614
Rh8p11n1t1 in11 Rh8p11n1n1 20239.4638389949
Rh8p11n1t2 Rh8p11n1n1 Rh8p11n1n2 20282.3124216887
Rh8p11n1t3 Rh8p11n1n2 Rh8p11n1n3 20207.4479658501
Rh8p11n1t4 Rh8p11n1n3 h8p 20304.2437558293
* h8 input 12 w=+0.21126612483399 w+  bank=n alpha=1 R=157778.883668767 G_phys=6.33798374501969e-06 G_eff=6.33798374501969e-06
* tiled Rh8p12n1 series x4  each=39444.7209171919
Rh8p12n1t1 in12 Rh8p12n1n1 39377.966524068
Rh8p12n1t2 Rh8p12n1n1 Rh8p12n1n2 39622.6316969145
Rh8p12n1t3 Rh8p12n1n2 Rh8p12n1n3 39305.6944240726
Rh8p12n1t4 Rh8p12n1n3 h8p 39298.6162243171
* h8 input 13 w=+0.318427374873886 w+  bank=n alpha=1 R=104681.117151235 G_phys=9.55282124621658e-06 G_eff=9.55282124621658e-06
* tiled Rh8p13n1 series x4  each=26170.2792878086
Rh8p13n1t1 in13 Rh8p13n1n1 26131.5401580122
Rh8p13n1t2 Rh8p13n1n1 Rh8p13n1n2 26170.6619151202
Rh8p13n1t3 Rh8p13n1n2 Rh8p13n1n3 26066.9981196364
Rh8p13n1t4 Rh8p13n1n3 h8p 26132.393963345
* h8 input 14 w=-0.262828471961964 w-  bank=n alpha=1 R=126825.427566909 G_phys=7.88485415885892e-06 G_eff=7.88485415885892e-06
* tiled Rh8n14n1 series x4  each=31706.3568917271
Rh8n14n1t1 in14 Rh8n14n1n1 31652.893285718
Rh8n14n1t2 Rh8n14n1n1 Rh8n14n1n2 31846.2800713027
Rh8n14n1t3 Rh8n14n1n2 Rh8n14n1n3 31859.0527389127
Rh8n14n1t4 Rh8n14n1n3 h8n 31641.2575902595
* h8 input 15 w=+0.319620775512722 w+  bank=n alpha=1 R=104290.258603689 G_phys=9.58862326538165e-06 G_eff=9.58862326538165e-06
* tiled Rh8p15n1 series x4  each=26072.5646509222
Rh8p15n1t1 in15 Rh8p15n1n1 26134.0614131811
Rh8p15n1t2 Rh8p15n1n1 Rh8p15n1n2 26025.5932879116
Rh8p15n1t3 Rh8p15n1n2 Rh8p15n1n3 26022.4541594865
Rh8p15n1t4 Rh8p15n1n3 h8p 26162.7560226493
* h8 input 16 w=+0.15331491024055 w+  bank=n alpha=1 R=217417.427183263 G_phys=4.59944730721651e-06 G_eff=4.59944730721651e-06
* tiled Rh8p16n1 series x4  each=54354.3567958157
Rh8p16n1t1 in16 Rh8p16n1n1 54618.4751290909
Rh8p16n1t2 Rh8p16n1n1 Rh8p16n1n2 54229.6182541246
Rh8p16n1t3 Rh8p16n1n2 Rh8p16n1n3 54200.0690092788
Rh8p16n1t4 Rh8p16n1n3 h8p 54199.2926312242
* h8 bias=-0.030517345445392 b-  bank=f alpha=0.001 R=1092.27499465772 G_phys=0.00091552036336176 G_eff=9.1552036336176e-07
* tiled Rh8bnf1 parallel x4  each=4369.09997863088
Rh8bnf1t1 vreff h8n 4358.82117121572
Rh8bnf1t2 vreff h8n 4369.05949424479
Rh8bnf1t3 vreff h8n 4354.3624575556
Rh8bnf1t4 vreff h8n 4357.89192305593
Vh8p h8p 0 DC 0
Vh8n h8n 0 DC 0
Fh8p 0 h8d Vh8p 1.001
Fh8n h8d 0 Vh8n 1.001
* ratiometric I-to-V: V = I * R_IV,  R_IV=33333.3333333333 (weight ~ R_IV / R_w)
* tiled Rh8iv series x4  each=8333.33333333333
Rh8ivt1 h8d Rh8ivn1 8340.21595629521
Rh8ivt2 Rh8ivn1 Rh8ivn2 8306.7773425875
Rh8ivt3 Rh8ivn2 Rh8ivn3 8321.95800698823
Rh8ivt4 Rh8ivn3 0 8323.09976254294
Bh8leak 0 h8d I = 1e-08
Eh8sc h8raw 0 h8d 0 1
Eh8lin h8lin 0 h8raw 0 1
* direct bounded ReLU: y=max(0, min(15, v(h8lin))) no high-gain op-amp loop
Bh8relu h8y 0 V = max(0, min(15, (0.001) + v(h8lin)))
Eh8 h8buf 0 h8y 0 1

* h9 input 1 w=-0.192368051906404 w-  bank=n alpha=1 R=173278.946285486 G_phys=5.77104155719211e-06 G_eff=5.77104155719211e-06
* tiled Rh9n1n1 series x4  each=43319.7365713716
Rh9n1n1t1 in1 Rh9n1n1n1 43254.258227002
Rh9n1n1t2 Rh9n1n1n1 Rh9n1n1n2 43498.2251534816
Rh9n1n1t3 Rh9n1n1n2 Rh9n1n1n3 43462.6468258275
Rh9n1n1t4 Rh9n1n1n3 h9n 43155.2833315028
* h9 input 2 w=-0.0188071151742732 w-  bank=f alpha=0.001 R=1772.37885898263 G_phys=0.000564213455228197 G_eff=5.64213455228197e-07
* tiled Rh9n2f1 parallel x4  each=7089.51543593052
Rh9n2f1t1 inf2 h9n 7118.49304169133
Rh9n2f1t2 inf2 h9n 7095.96258649501
Rh9n2f1t3 inf2 h9n 7099.82022181025
Rh9n2f1t4 inf2 h9n 7113.44137703763
* h9 input 3 w=+0.675590388456855 w+  bank=n alpha=1 R=49339.5612235861 G_phys=2.02677116537057e-05 G_eff=2.02677116537057e-05
* tiled Rh9p3n1 series x4  each=12334.8903058965
Rh9p3n1t1 in3 Rh9p3n1n1 12367.101093162
Rh9p3n1t2 Rh9p3n1n1 Rh9p3n1n2 12378.5550901795
Rh9p3n1t3 Rh9p3n1n2 Rh9p3n1n3 12350.913085089
Rh9p3n1t4 Rh9p3n1n3 h9p 12282.4178853719
* h9 input 4 w=-0.777819910920126 w-  bank=n alpha=1 R=42854.8213607717 G_phys=2.33345973276038e-05 G_eff=2.33345973276038e-05
* tiled Rh9n4n1 series x4  each=10713.7053401929
Rh9n4n1t1 in4 Rh9n4n1n1 10692.3638263116
Rh9n4n1t2 Rh9n4n1n1 Rh9n4n1n2 10738.0427361903
Rh9n4n1t3 Rh9n4n1n2 Rh9n4n1n3 10663.3040377604
Rh9n4n1t4 Rh9n4n1n3 h9n 10717.6100406096
* h9 input 5 w=-0.0591658911038067 w-  bank=n alpha=1 R=563387.666634648 G_phys=1.7749767331142e-06 G_eff=1.7749767331142e-06
* tiled Rh9n5n1 series x4  each=140846.916658662
Rh9n5n1t1 in5 Rh9n5n1n1 140936.860906826
Rh9n5n1t2 Rh9n5n1n1 Rh9n5n1n2 141077.561146703
Rh9n5n1t3 Rh9n5n1n2 Rh9n5n1n3 140319.266019707
Rh9n5n1t4 Rh9n5n1n3 h9n 140677.154388168
* h9 input 6 w=-0.373077376819092 w-  bank=n alpha=1 R=89346.9703725748 G_phys=1.11923213045728e-05 G_eff=1.11923213045728e-05
* tiled Rh9n6n1 series x4  each=22336.7425931437
Rh9n6n1t1 in6 Rh9n6n1n1 22279.1117545658
Rh9n6n1t2 Rh9n6n1n1 Rh9n6n1n2 22378.5127075943
Rh9n6n1t3 Rh9n6n1n2 Rh9n6n1n3 22345.7162057931
Rh9n6n1t4 Rh9n6n1n3 h9n 22365.1316251008
* h9 input 7 w=+0.173600484730372 w+  bank=n alpha=1 R=192011.752646342 G_phys=5.20801454191117e-06 G_eff=5.20801454191117e-06
* tiled Rh9p7n1 series x4  each=48002.9381615855
Rh9p7n1t1 in7 Rh9p7n1n1 48216.8356857433
Rh9p7n1t2 Rh9p7n1n1 Rh9p7n1n2 48054.7957789355
Rh9p7n1t3 Rh9p7n1n2 Rh9p7n1n3 47995.5207647625
Rh9p7n1t4 Rh9p7n1n3 h9p 48045.4032793027
* h9 input 8 w=+0.21285190098274 w+  bank=n alpha=1 R=156603.409128286 G_phys=6.38555702948219e-06 G_eff=6.38555702948219e-06
* tiled Rh9p8n1 series x4  each=39150.8522820714
Rh9p8n1t1 in8 Rh9p8n1n1 39088.5222789621
Rh9p8n1t2 Rh9p8n1n1 Rh9p8n1n2 39180.123271569
Rh9p8n1t3 Rh9p8n1n2 Rh9p8n1n3 39168.6766657924
Rh9p8n1t4 Rh9p8n1n3 h9p 39187.2154881935
* h9 input 9 w=+0.47939396555815 w+  bank=n alpha=1 R=69532.2338789223 G_phys=1.43818189667445e-05 G_eff=1.43818189667445e-05
* tiled Rh9p9n1 series x4  each=17383.0584697306
Rh9p9n1t1 in9 Rh9p9n1n1 17403.3896460851
Rh9p9n1t2 Rh9p9n1n1 Rh9p9n1n2 17376.0233658008
Rh9p9n1t3 Rh9p9n1n2 Rh9p9n1n3 17299.5628982183
Rh9p9n1t4 Rh9p9n1n3 h9p 17365.2644099149
* h9 input 10 w=-0.695860852133009 w-  bank=n alpha=1 R=47902.2971778874 G_phys=2.08758255639903e-05 G_eff=2.08758255639903e-05
* tiled Rh9n10n1 series x4  each=11975.5742944718
Rh9n10n1t1 in10 Rh9n10n1n1 12017.687510889
Rh9n10n1t2 Rh9n10n1n1 Rh9n10n1n2 11916.6470005329
Rh9n10n1t3 Rh9n10n1n2 Rh9n10n1n3 11971.2660324616
Rh9n10n1t4 Rh9n10n1n3 h9n 11960.9406782232
* h9 input 11 w=+0.426719797848979 w+  bank=n alpha=1 R=78115.2726012736 G_phys=1.28015939354694e-05 G_eff=1.28015939354694e-05
* tiled Rh9p11n1 series x4  each=19528.8181503184
Rh9p11n1t1 in11 Rh9p11n1n1 19516.3366104486
Rh9p11n1t2 Rh9p11n1n1 Rh9p11n1n2 19619.325212244
Rh9p11n1t3 Rh9p11n1n2 Rh9p11n1n3 19535.3459138298
Rh9p11n1t4 Rh9p11n1n3 h9p 19549.7220829154
* h9 input 12 w=+0.190883817865507 w+  bank=n alpha=1 R=174626.292087365 G_phys=5.7265145359652e-06 G_eff=5.7265145359652e-06
* tiled Rh9p12n1 series x4  each=43656.5730218412
Rh9p12n1t1 in12 Rh9p12n1n1 43604.6974270903
Rh9p12n1t2 Rh9p12n1n1 Rh9p12n1n2 43827.4948912585
Rh9p12n1t3 Rh9p12n1n2 Rh9p12n1n3 43738.1996538666
Rh9p12n1t4 Rh9p12n1n3 h9p 43702.3664581536
* h9 input 13 w=-0.203891646942192 w-  bank=n alpha=1 R=163485.526912165 G_phys=6.11674940826577e-06 G_eff=6.11674940826577e-06
* tiled Rh9n13n1 series x4  each=40871.3817280411
Rh9n13n1t1 in13 Rh9n13n1n1 40922.6022313215
Rh9n13n1t2 Rh9n13n1n1 Rh9n13n1n2 40908.0049119603
Rh9n13n1t3 Rh9n13n1n2 Rh9n13n1n3 40802.669299637
Rh9n13n1t4 Rh9n13n1n3 h9n 40750.1716097364
* h9 input 14 w=-0.0564974778722501 w-  bank=n alpha=1 R=589996.838597032 G_phys=1.6949243361675e-06 G_eff=1.6949243361675e-06
* tiled Rh9n14n1 series x4  each=147499.209649258
Rh9n14n1t1 in14 Rh9n14n1n1 147218.019647589
Rh9n14n1t2 Rh9n14n1n1 Rh9n14n1n2 148215.712123699
Rh9n14n1t3 Rh9n14n1n2 Rh9n14n1n3 148101.728684339
Rh9n14n1t4 Rh9n14n1n3 h9n 147933.047903608
* h9 input 15 w=-0.251891815788561 w-  bank=n alpha=1 R=132331.942699216 G_phys=7.55675447365683e-06 G_eff=7.55675447365683e-06
* tiled Rh9n15n1 series x4  each=33082.985674804
Rh9n15n1t1 in15 Rh9n15n1n1 33012.3103459759
Rh9n15n1t2 Rh9n15n1n1 Rh9n15n1n2 33246.3619083062
Rh9n15n1t3 Rh9n15n1n2 Rh9n15n1n3 33085.1765669135
Rh9n15n1t4 Rh9n15n1n3 h9n 32949.2465367587
* h9 input 16 w=-0.340248378281639 w-  bank=n alpha=1 R=97967.6479331866 G_phys=1.02074513484492e-05 G_eff=1.02074513484492e-05
* tiled Rh9n16n1 series x4  each=24491.9119832967
Rh9n16n1t1 in16 Rh9n16n1n1 24568.9829508642
Rh9n16n1t2 Rh9n16n1n1 Rh9n16n1n2 24556.788967682
Rh9n16n1t3 Rh9n16n1n2 Rh9n16n1n3 24487.8274937282
Rh9n16n1t4 Rh9n16n1n3 h9n 24391.2044340435
* h9 bias=-0.0264599072666679 b-  bank=f alpha=0.001 R=1259.76757958347 G_phys=0.000793797218000037 G_eff=7.93797218000037e-07
* tiled Rh9bnf1 parallel x4  each=5039.07031833389
Rh9bnf1t1 vreff h9n 5049.59427605837
Rh9bnf1t2 vreff h9n 5063.35088641711
Rh9bnf1t3 vreff h9n 5025.71588434998
Rh9bnf1t4 vreff h9n 5049.2402407421
Vh9p h9p 0 DC 0
Vh9n h9n 0 DC 0
Fh9p 0 h9d Vh9p 1.001
Fh9n h9d 0 Vh9n 1.001
* ratiometric I-to-V: V = I * R_IV,  R_IV=33333.3333333333 (weight ~ R_IV / R_w)
* tiled Rh9iv series x4  each=8333.33333333333
Rh9ivt1 h9d Rh9ivn1 8337.59875406666
Rh9ivt2 Rh9ivn1 Rh9ivn2 8352.80312965543
Rh9ivt3 Rh9ivn2 Rh9ivn3 8346.30329422383
Rh9ivt4 Rh9ivn3 0 8304.30103023986
Bh9leak 0 h9d I = 1e-08
Eh9sc h9raw 0 h9d 0 1
Eh9lin h9lin 0 h9raw 0 1
* direct bounded ReLU: y=max(0, min(15, v(h9lin))) no high-gain op-amp loop
Bh9relu h9y 0 V = max(0, min(15, (0.001) + v(h9lin)))
Eh9 h9buf 0 h9y 0 1

* h10 input 1 w=+0.0856004623316453 w+  bank=n alpha=1 R=389405.996479186 G_phys=2.56801386994936e-06 G_eff=2.56801386994936e-06
* tiled Rh10p1n1 series x4  each=97351.4991197965
Rh10p1n1t1 in1 Rh10p1n1n1 97570.8459735827
Rh10p1n1t2 Rh10p1n1n1 Rh10p1n1n2 97062.3280698529
Rh10p1n1t3 Rh10p1n1n2 Rh10p1n1n3 96866.1791329286
Rh10p1n1t4 Rh10p1n1n3 h10p 96927.304200012
* h10 input 2 w=+0.717707405140542 w+  bank=n alpha=1 R=46444.1819808254 G_phys=2.15312221542163e-05 G_eff=2.15312221542163e-05
* tiled Rh10p2n1 series x4  each=11611.0454952064
Rh10p2n1t1 in2 Rh10p2n1n1 11627.8040667539
Rh10p2n1t2 Rh10p2n1n1 Rh10p2n1n2 11571.6325173453
Rh10p2n1t3 Rh10p2n1n2 Rh10p2n1n3 11604.7898698694
Rh10p2n1t4 Rh10p2n1n3 h10p 11617.5120328054
* h10 input 3 w=+0.367326370670395 w+  bank=n alpha=1 R=90745.8216857607 G_phys=1.10197911201119e-05 G_eff=1.10197911201119e-05
* tiled Rh10p3n1 series x4  each=22686.4554214402
Rh10p3n1t1 in3 Rh10p3n1n1 22706.5573835289
Rh10p3n1t2 Rh10p3n1n1 Rh10p3n1n2 22604.0397031209
Rh10p3n1t3 Rh10p3n1n2 Rh10p3n1n3 22783.2754407721
Rh10p3n1t4 Rh10p3n1n3 h10p 22637.7245590577
* h10 input 4 w=+0.5220921972442 w+  bank=n alpha=1 R=63845.6837878046 G_phys=1.5662765917326e-05 G_eff=1.5662765917326e-05
* tiled Rh10p4n1 series x4  each=15961.4209469512
Rh10p4n1t1 in4 Rh10p4n1n1 15890.4975461587
Rh10p4n1t2 Rh10p4n1n1 Rh10p4n1n2 16031.7441197143
Rh10p4n1t3 Rh10p4n1n2 Rh10p4n1n3 15946.1477640993
Rh10p4n1t4 Rh10p4n1n3 h10p 15905.1278415403
* h10 input 5 w=+0.0909071116243784 w+  bank=n alpha=1 R=366674.649955487 G_phys=2.72721334873135e-06 G_eff=2.72721334873135e-06
* tiled Rh10p5n1 series x4  each=91668.6624888717
Rh10p5n1t1 in5 Rh10p5n1n1 91357.8524276225
Rh10p5n1t2 Rh10p5n1n1 Rh10p5n1n2 92043.8698385165
Rh10p5n1t3 Rh10p5n1n2 Rh10p5n1n3 92066.2933456396
Rh10p5n1t4 Rh10p5n1n3 h10p 91295.8111314936
* h10 input 6 w=-0.0568053629833511 w-  bank=n alpha=1 R=586799.055277631 G_phys=1.70416088950053e-06 G_eff=1.70416088950053e-06
* tiled Rh10n6n1 series x4  each=146699.763819408
Rh10n6n1t1 in6 Rh10n6n1n1 147230.293373095
Rh10n6n1t2 Rh10n6n1n1 Rh10n6n1n2 146390.879838175
Rh10n6n1t3 Rh10n6n1n2 Rh10n6n1n3 147146.388570383
Rh10n6n1t4 Rh10n6n1n3 h10n 147104.80549785
* h10 input 7 w=+0.372078007523385 w+  bank=n alpha=1 R=89586.9485950155 G_phys=1.11623402257016e-05 G_eff=1.11623402257016e-05
* tiled Rh10p7n1 series x4  each=22396.7371487539
Rh10p7n1t1 in7 Rh10p7n1n1 22431.1111671437
Rh10p7n1t2 Rh10p7n1n1 Rh10p7n1n2 22489.8943241008
Rh10p7n1t3 Rh10p7n1n2 Rh10p7n1n3 22303.6315661456
Rh10p7n1t4 Rh10p7n1n3 h10p 22446.0077487906
* h10 input 8 w=+0.384900055079612 w+  bank=n alpha=1 R=86602.568363984 G_phys=1.15470016523884e-05 G_eff=1.15470016523884e-05
* tiled Rh10p8n1 series x4  each=21650.642090996
Rh10p8n1t1 in8 Rh10p8n1n1 21644.0854127593
Rh10p8n1t2 Rh10p8n1n1 Rh10p8n1n2 21641.7420787865
Rh10p8n1t3 Rh10p8n1n2 Rh10p8n1n3 21554.0519621486
Rh10p8n1t4 Rh10p8n1n3 h10p 21720.492815741
* h10 input 9 w=+0.617655459577812 w+  bank=n alpha=1 R=53967.5199440765 G_phys=1.85296637873344e-05 G_eff=1.85296637873344e-05
* tiled Rh10p9n1 series x4  each=13491.8799860191
Rh10p9n1t1 in9 Rh10p9n1n1 13440.1411672882
Rh10p9n1t2 Rh10p9n1n1 Rh10p9n1n2 13436.1019847722
Rh10p9n1t3 Rh10p9n1n2 Rh10p9n1n3 13550.4153340494
Rh10p9n1t4 Rh10p9n1n3 h10p 13533.9847351868
* h10 input 10 w=+0.306521845436409 w+  bank=n alpha=1 R=108747.007202293 G_phys=9.19565536309227e-06 G_eff=9.19565536309227e-06
* tiled Rh10p10n1 series x4  each=27186.7518005733
Rh10p10n1t1 in10 Rh10p10n1n1 27153.7903647018
Rh10p10n1t2 Rh10p10n1n1 Rh10p10n1n2 27298.3130237311
Rh10p10n1t3 Rh10p10n1n2 Rh10p10n1n3 27094.3120705231
Rh10p10n1t4 Rh10p10n1n3 h10p 27264.832835987
* h10 input 11 w=-0.0307901580575706 w-  bank=f alpha=0.001 R=1082.5970191841 G_phys=0.000923704741727117 G_eff=9.23704741727117e-07
* tiled Rh10n11f1 parallel x4  each=4330.38807673642
Rh10n11f1t1 inf11 h10n 4343.82746079206
Rh10n11f1t2 inf11 h10n 4337.8554752607
Rh10n11f1t3 inf11 h10n 4324.02937368539
Rh10n11f1t4 inf11 h10n 4346.58407503485
* h10 input 12 w=+0.163538031424557 w+  bank=n alpha=1 R=203826.186746724 G_phys=4.9061409427367e-06 G_eff=4.9061409427367e-06
* tiled Rh10p12n1 series x4  each=50956.5466866811
Rh10p12n1t1 in12 Rh10p12n1n1 51092.7251315977
Rh10p12n1t2 Rh10p12n1n1 Rh10p12n1n2 51158.4115340421
Rh10p12n1t3 Rh10p12n1n2 Rh10p12n1n3 51058.1633840559
Rh10p12n1t4 Rh10p12n1n3 h10p 51195.2991093334
* h10 input 13 w=-0.0170713095619708 w-  bank=f alpha=0.001 R=1952.59380730749 G_phys=0.000512139286859123 G_eff=5.12139286859123e-07
* tiled Rh10n13f1 parallel x4  each=7810.37522922998
Rh10n13f1t1 inf13 h10n 7829.900427871
Rh10n13f1t2 inf13 h10n 7837.43686016825
Rh10n13f1t3 inf13 h10n 7824.63275964049
Rh10n13f1t4 inf13 h10n 7821.34510803635
* h10 input 14 w=-0.123347220224403 w-  bank=n alpha=1 R=270239.842233093 G_phys=3.7004166067321e-06 G_eff=3.7004166067321e-06
* tiled Rh10n14n1 series x4  each=67559.9605582733
Rh10n14n1t1 in14 Rh10n14n1n1 67591.9471353072
Rh10n14n1t2 Rh10n14n1n1 Rh10n14n1n2 67825.226423209
Rh10n14n1t3 Rh10n14n1n2 Rh10n14n1n3 67833.1884430204
Rh10n14n1t4 Rh10n14n1n3 h10n 67788.6999342322
* h10 input 15 w=-0.136765368652097 w-  bank=n alpha=1 R=243726.417453869 G_phys=4.10296105956291e-06 G_eff=4.10296105956291e-06
* tiled Rh10n15n1 series x4  each=60931.6043634674
Rh10n15n1t1 in15 Rh10n15n1n1 61004.3471217536
Rh10n15n1t2 Rh10n15n1n1 Rh10n15n1n2 61089.0257289366
Rh10n15n1t3 Rh10n15n1n2 Rh10n15n1n3 60996.8260976109
Rh10n15n1t4 Rh10n15n1n3 h10n 60946.9124727809
* h10 input 16 w=+0.269183781267177 w+  bank=n alpha=1 R=123831.1356517 G_phys=8.07551343801532e-06 G_eff=8.07551343801532e-06
* tiled Rh10p16n1 series x4  each=30957.783912925
Rh10p16n1t1 in16 Rh10p16n1n1 31002.15093377
Rh10p16n1t2 Rh10p16n1n1 Rh10p16n1n2 30953.6408200898
Rh10p16n1t3 Rh10p16n1n2 Rh10p16n1n3 30920.9257388062
Rh10p16n1t4 Rh10p16n1n3 h10p 30861.5442568825
* h10 bias=-0.0641449868406755 b-  bank=n alpha=1 R=519656.094343386 G_phys=1.92434960522027e-06 G_eff=1.92434960522027e-06
* tiled Rh10bnn1 series x4  each=129914.023585847
Rh10bnn1t1 vref Rh10bnn1n1 129666.375266559
Rh10bnn1t2 Rh10bnn1n1 Rh10bnn1n2 129708.755871558
Rh10bnn1t3 Rh10bnn1n2 Rh10bnn1n3 129950.689133661
Rh10bnn1t4 Rh10bnn1n3 h10n 130012.221890145
Vh10p h10p 0 DC 0
Vh10n h10n 0 DC 0
Fh10p 0 h10d Vh10p 1.001
Fh10n h10d 0 Vh10n 1.001
* ratiometric I-to-V: V = I * R_IV,  R_IV=33333.3333333333 (weight ~ R_IV / R_w)
* tiled Rh10iv series x4  each=8333.33333333333
Rh10ivt1 h10d Rh10ivn1 8373.89478663276
Rh10ivt2 Rh10ivn1 Rh10ivn2 8320.99008396899
Rh10ivt3 Rh10ivn2 Rh10ivn3 8363.02261091891
Rh10ivt4 Rh10ivn3 0 8356.73645142557
Bh10leak 0 h10d I = 1e-08
Eh10sc h10raw 0 h10d 0 1
Eh10lin h10lin 0 h10raw 0 1
* direct bounded ReLU: y=max(0, min(15, v(h10lin))) no high-gain op-amp loop
Bh10relu h10y 0 V = max(0, min(15, (0.001) + v(h10lin)))
Eh10 h10buf 0 h10y 0 1

* h11 input 1 w=+0.100174494534941 w+  bank=n alpha=1 R=332752.69806035 G_phys=3.00523483604823e-06 G_eff=3.00523483604823e-06
* tiled Rh11p1n1 series x4  each=83188.1745150875
Rh11p1n1t1 in1 Rh11p1n1n1 83406.5855973462
Rh11p1n1t2 Rh11p1n1n1 Rh11p1n1n2 83323.5444173608
Rh11p1n1t3 Rh11p1n1n2 Rh11p1n1n3 82811.72001659
Rh11p1n1t4 Rh11p1n1n3 h11p 83542.0840704132
* h11 input 2 w=-0.350357054027393 w-  bank=n alpha=1 R=95141.0366943178 G_phys=1.05107116208218e-05 G_eff=1.05107116208218e-05
* tiled Rh11n2n1 series x4  each=23785.2591735795
Rh11n2n1t1 in2 Rh11n2n1n1 23855.2181119486
Rh11n2n1t2 Rh11n2n1n1 Rh11n2n1n2 23686.3963847765
Rh11n2n1t3 Rh11n2n1n2 Rh11n2n1n3 23896.7453197768
Rh11n2n1t4 Rh11n2n1n3 h11n 23678.1305788566
* h11 input 3 w=-0.364058373495884 w-  bank=n alpha=1 R=91560.4083302596 G_phys=1.09217512048765e-05 G_eff=1.09217512048765e-05
* tiled Rh11n3n1 series x4  each=22890.1020825649
Rh11n3n1t1 in3 Rh11n3n1n1 22856.5627114817
Rh11n3n1t2 Rh11n3n1n1 Rh11n3n1n2 22977.0913646819
Rh11n3n1t3 Rh11n3n1n2 Rh11n3n1n3 22829.9405654358
Rh11n3n1t4 Rh11n3n1n3 h11n 22803.5231996334
* h11 input 4 w=+0.201551043415431 w+  bank=n alpha=1 R=165384.077246515 G_phys=6.04653130246294e-06 G_eff=6.04653130246294e-06
* tiled Rh11p4n1 series x4  each=41346.0193116287
Rh11p4n1t1 in4 Rh11p4n1n1 41371.7992176426
Rh11p4n1t2 Rh11p4n1n1 Rh11p4n1n2 41303.6460091012
Rh11p4n1t3 Rh11p4n1n2 Rh11p4n1n3 41378.2702292241
Rh11p4n1t4 Rh11p4n1n3 h11p 41196.1349887795
* h11 input 5 w=+0.30370864041576 w+  bank=n alpha=1 R=109754.313501591 G_phys=9.1112592124728e-06 G_eff=9.1112592124728e-06
* tiled Rh11p5n1 series x4  each=27438.5783753978
Rh11p5n1t1 in5 Rh11p5n1n1 27371.8021483894
Rh11p5n1t2 Rh11p5n1n1 Rh11p5n1n2 27362.4665695337
Rh11p5n1t3 Rh11p5n1n2 Rh11p5n1n3 27465.1173010164
Rh11p5n1t4 Rh11p5n1n3 h11p 27323.0371196895
* h11 input 6 w=+0.221531530750713 w+  bank=n alpha=1 R=150467.670314809 G_phys=6.64594592252139e-06 G_eff=6.64594592252139e-06
* tiled Rh11p6n1 series x4  each=37616.9175787024
Rh11p6n1t1 in6 Rh11p6n1n1 37611.8516983869
Rh11p6n1t2 Rh11p6n1n1 Rh11p6n1n2 37781.8451352592
Rh11p6n1t3 Rh11p6n1n2 Rh11p6n1n3 37692.4628285328
Rh11p6n1t4 Rh11p6n1n3 h11p 37589.1011742049
* h11 input 7 w=-0.554388667333083 w-  bank=n alpha=1 R=60126.2891856812 G_phys=1.66316600199925e-05 G_eff=1.66316600199925e-05
* tiled Rh11n7n1 series x4  each=15031.5722964203
Rh11n7n1t1 in7 Rh11n7n1n1 15098.8849572984
Rh11n7n1t2 Rh11n7n1n1 Rh11n7n1n2 15063.3200816656
Rh11n7n1t3 Rh11n7n1n2 Rh11n7n1n3 14967.7655316798
Rh11n7n1t4 Rh11n7n1n3 h11n 15079.9317759546
* h11 input 8 w=+0.382929077760783 w+  bank=n alpha=1 R=87048.3211362621 G_phys=1.14878723328235e-05 G_eff=1.14878723328235e-05
* tiled Rh11p8n1 series x4  each=21762.0802840655
Rh11p8n1t1 in8 Rh11p8n1n1 21688.0021874144
Rh11p8n1t2 Rh11p8n1n1 Rh11p8n1n2 21665.7323324096
Rh11p8n1t3 Rh11p8n1n2 Rh11p8n1n3 21825.6920153532
Rh11p8n1t4 Rh11p8n1n3 h11p 21815.3809216895
* h11 input 9 w=-0.415059943002996 w-  bank=n alpha=1 R=80309.6851316552 G_phys=1.24517982900899e-05 G_eff=1.24517982900899e-05
* tiled Rh11n9n1 series x4  each=20077.4212829138
Rh11n9n1t1 in9 Rh11n9n1n1 20012.1207035656
Rh11n9n1t2 Rh11n9n1n1 Rh11n9n1n2 20111.3262768876
Rh11n9n1t3 Rh11n9n1n2 Rh11n9n1n3 20073.9753610289
Rh11n9n1t4 Rh11n9n1n3 h11n 20168.8668438444
* h11 input 10 w=-0.579957638432045 w-  bank=n alpha=1 R=57475.4622138477 G_phys=1.73987291529614e-05 G_eff=1.73987291529614e-05
* tiled Rh11n10n1 series x4  each=14368.8655534619
Rh11n10n1t1 in10 Rh11n10n1n1 14308.8494236028
Rh11n10n1t2 Rh11n10n1n1 Rh11n10n1n2 14307.5437599501
Rh11n10n1t3 Rh11n10n1n2 Rh11n10n1n3 14418.5316155982
Rh11n10n1t4 Rh11n10n1n3 h11n 14356.2018781405
* h11 input 11 w=+0.208304459025755 w+  bank=n alpha=1 R=160022.178542092 G_phys=6.24913377077265e-06 G_eff=6.24913377077265e-06
* tiled Rh11p11n1 series x4  each=40005.5446355231
Rh11p11n1t1 in11 Rh11p11n1n1 39870.1272360543
Rh11p11n1t2 Rh11p11n1n1 Rh11p11n1n2 39844.6013210087
Rh11p11n1t3 Rh11p11n1n2 Rh11p11n1n3 39917.3078290845
Rh11p11n1t4 Rh11p11n1n3 h11p 40100.8936316574
* h11 input 12 w=+0.150185585205542 w+  bank=n alpha=1 R=221947.620923232 G_phys=4.50556755616625e-06 G_eff=4.50556755616625e-06
* tiled Rh11p12n1 series x4  each=55486.905230808
Rh11p12n1t1 in12 Rh11p12n1n1 55647.3247970608
Rh11p12n1t2 Rh11p12n1n1 Rh11p12n1n2 55445.6326435294
Rh11p12n1t3 Rh11p12n1n2 Rh11p12n1n3 55693.4099955703
Rh11p12n1t4 Rh11p12n1n3 h11p 55419.7653981423
* h11 input 13 w=-0.130595100347527 w-  bank=n alpha=1 R=255241.837133476 G_phys=3.9178530104258e-06 G_eff=3.9178530104258e-06
* tiled Rh11n13n1 series x4  each=63810.459283369
Rh11n13n1t1 in13 Rh11n13n1n1 63640.9876808153
Rh11n13n1t2 Rh11n13n1n1 Rh11n13n1n2 63713.3855290139
Rh11n13n1t3 Rh11n13n1n2 Rh11n13n1n3 63849.1451029635
Rh11n13n1t4 Rh11n13n1n3 h11n 63941.6266495693
* h11 input 14 w=+0.223944918125423 w+  bank=n alpha=1 R=148846.125254178 G_phys=6.71834754376269e-06 G_eff=6.71834754376269e-06
* tiled Rh11p14n1 series x4  each=37211.5313135445
Rh11p14n1t1 in14 Rh11p14n1n1 37046.3018792394
Rh11p14n1t2 Rh11p14n1n1 Rh11p14n1n2 37192.4016666014
Rh11p14n1t3 Rh11p14n1n2 Rh11p14n1n3 37290.6388351378
Rh11p14n1t4 Rh11p14n1n3 h11p 37067.5083684444
* h11 input 15 w=+0.219816736012751 w+  bank=n alpha=1 R=151641.471609331 G_phys=6.59450208038254e-06 G_eff=6.59450208038254e-06
* tiled Rh11p15n1 series x4  each=37910.3679023327
Rh11p15n1t1 in15 Rh11p15n1n1 37808.0427868991
Rh11p15n1t2 Rh11p15n1n1 Rh11p15n1n2 37738.9697837215
Rh11p15n1t3 Rh11p15n1n2 Rh11p15n1n3 37825.3112921373
Rh11p15n1t4 Rh11p15n1n3 h11p 37833.963050524
* h11 input 16 w=-0.0825561420887272 w-  bank=n alpha=1 R=403765.637419301 G_phys=2.47668426266182e-06 G_eff=2.47668426266182e-06
* tiled Rh11n16n1 series x4  each=100941.409354825
Rh11n16n1t1 in16 Rh11n16n1n1 100683.875993048
Rh11n16n1t2 Rh11n16n1n1 Rh11n16n1n2 100807.507385811
Rh11n16n1t3 Rh11n16n1n2 Rh11n16n1n3 101334.529499447
Rh11n16n1t4 Rh11n16n1n3 h11n 101235.720700038
* h11 bias=-0.0111908465565794 b-  bank=f alpha=0.001 R=2978.62482206369 G_phys=0.000335725396697381 G_eff=3.35725396697381e-07
* tiled Rh11bnf1 parallel x4  each=11914.4992882548
Rh11bnf1t1 vreff h11n 11916.9343030025
Rh11bnf1t2 vreff h11n 11909.6024936552
Rh11bnf1t3 vreff h11n 11875.0621668874
Rh11bnf1t4 vreff h11n 11861.6195725323
Vh11p h11p 0 DC 0
Vh11n h11n 0 DC 0
Fh11p 0 h11d Vh11p 1.001
Fh11n h11d 0 Vh11n 1.001
* ratiometric I-to-V: V = I * R_IV,  R_IV=33333.3333333333 (weight ~ R_IV / R_w)
* tiled Rh11iv series x4  each=8333.33333333333
Rh11ivt1 h11d Rh11ivn1 8357.85143566683
Rh11ivt2 Rh11ivn1 Rh11ivn2 8348.18652741465
Rh11ivt3 Rh11ivn2 Rh11ivn3 8338.45060764983
Rh11ivt4 Rh11ivn3 0 8322.2713492148
Bh11leak 0 h11d I = 1e-08
Eh11sc h11raw 0 h11d 0 1
Eh11lin h11lin 0 h11raw 0 1
* direct bounded ReLU: y=max(0, min(15, v(h11lin))) no high-gain op-amp loop
Bh11relu h11y 0 V = max(0, min(15, (0.001) + v(h11lin)))
Eh11 h11buf 0 h11y 0 1

* h12 input 1 w=-0.0647804813106503 w-  bank=n alpha=1 R=514558.284516066 G_phys=1.94341443931951e-06 G_eff=1.94341443931951e-06
* tiled Rh12n1n1 series x4  each=128639.571129017
Rh12n1n1t1 in1 Rh12n1n1n1 128806.322083647
Rh12n1n1t2 Rh12n1n1n1 Rh12n1n1n2 129198.044504834
Rh12n1n1t3 Rh12n1n1n2 Rh12n1n1n3 128950.970760899
Rh12n1n1t4 Rh12n1n1n3 h12n 128492.927783569
* h12 input 2 w=-0.668825239918342 w-  bank=n alpha=1 R=49838.6295011879 G_phys=2.00647571975503e-05 G_eff=2.00647571975503e-05
* tiled Rh12n2n1 series x4  each=12459.657375297
Rh12n2n1t1 in2 Rh12n2n1n1 12450.26163497
Rh12n2n1t2 Rh12n2n1n1 Rh12n2n1n2 12508.0918929515
Rh12n2n1t3 Rh12n2n1n2 Rh12n2n1n3 12415.350192664
Rh12n2n1t4 Rh12n2n1n3 h12n 12517.0145632174
* h12 input 3 w=+0.43152134817872 w+  bank=n alpha=1 R=77246.0817385283 G_phys=1.29456404453616e-05 G_eff=1.29456404453616e-05
* tiled Rh12p3n1 series x4  each=19311.5204346321
Rh12p3n1t1 in3 Rh12p3n1n1 19293.2502070213
Rh12p3n1t2 Rh12p3n1n1 Rh12p3n1n2 19346.8251376563
Rh12p3n1t3 Rh12p3n1n2 Rh12p3n1n3 19364.0321978497
Rh12p3n1t4 Rh12p3n1n3 h12p 19315.215037365
* h12 input 4 w=+0.0766102486579458 w+  bank=n alpha=1 R=435102.795216892 G_phys=2.29830745973837e-06 G_eff=2.29830745973837e-06
* tiled Rh12p4n1 series x4  each=108775.698804223
Rh12p4n1t1 in4 Rh12p4n1n1 108794.211472349
Rh12p4n1t2 Rh12p4n1n1 Rh12p4n1n2 108899.028040777
Rh12p4n1t3 Rh12p4n1n2 Rh12p4n1n3 108386.807217439
Rh12p4n1t4 Rh12p4n1n3 h12p 108875.494625772
* h12 input 5 w=+0.112143595115044 w+  bank=n alpha=1 R=297237.959057206 G_phys=3.36430785345132e-06 G_eff=3.36430785345132e-06
* tiled Rh12p5n1 series x4  each=74309.4897643016
Rh12p5n1t1 in5 Rh12p5n1n1 74168.1921834917
Rh12p5n1t2 Rh12p5n1n1 Rh12p5n1n2 74238.7853395827
Rh12p5n1t3 Rh12p5n1n2 Rh12p5n1n3 74635.7543128166
Rh12p5n1t4 Rh12p5n1n3 h12p 74204.6031111796
* h12 input 6 w=-0.214387519256146 w-  bank=n alpha=1 R=155481.687781961 G_phys=6.43162557768439e-06 G_eff=6.43162557768439e-06
* tiled Rh12n6n1 series x4  each=38870.4219454903
Rh12n6n1t1 in6 Rh12n6n1n1 38728.9844327954
Rh12n6n1t2 Rh12n6n1n1 Rh12n6n1n2 38789.5752172867
Rh12n6n1t3 Rh12n6n1n2 Rh12n6n1n3 39050.9345053577
Rh12n6n1t4 Rh12n6n1n3 h12n 38905.9456433878
* h12 input 7 w=+0.0362945018752433 w+  bank=n alpha=1 R=918412.751548746 G_phys=1.0888350562573e-06 G_eff=1.0888350562573e-06
* tiled Rh12p7n1 series x4  each=229603.187887187
Rh12p7n1t1 in7 Rh12p7n1n1 230512.054434962
Rh12p7n1t2 Rh12p7n1n1 Rh12p7n1n2 228559.664489348
Rh12p7n1t3 Rh12p7n1n2 Rh12p7n1n3 229933.756711204
Rh12p7n1t4 Rh12p7n1n3 h12p 228833.996112061
* h12 input 8 w=-0.654320698371061 w-  bank=n alpha=1 R=50943.4187491196 G_phys=1.96296209511318e-05 G_eff=1.96296209511318e-05
* tiled Rh12n8n1 series x4  each=12735.8546872799
Rh12n8n1t1 in8 Rh12n8n1n1 12715.7283646421
Rh12n8n1t2 Rh12n8n1n1 Rh12n8n1n2 12773.4055560259
Rh12n8n1t3 Rh12n8n1n2 Rh12n8n1n3 12681.5434158864
Rh12n8n1t4 Rh12n8n1n3 h12n 12746.4324350756
* h12 input 9 w=-0.424313635659581 w-  bank=n alpha=1 R=78558.2421397273 G_phys=1.27294090697874e-05 G_eff=1.27294090697874e-05
* tiled Rh12n9n1 series x4  each=19639.5605349318
Rh12n9n1t1 in9 Rh12n9n1n1 19603.825250153
Rh12n9n1t2 Rh12n9n1n1 Rh12n9n1n2 19580.9638406778
Rh12n9n1t3 Rh12n9n1n2 Rh12n9n1n3 19592.3966947196
Rh12n9n1t4 Rh12n9n1n3 h12n 19641.7152369038
* h12 input 10 w=-0.147731830075345 w-  bank=n alpha=1 R=225634.064888609 G_phys=4.43195490226035e-06 G_eff=4.43195490226035e-06
* tiled Rh12n10n1 series x4  each=56408.5162221522
Rh12n10n1t1 in10 Rh12n10n1n1 56352.461283131
Rh12n10n1t2 Rh12n10n1n1 Rh12n10n1n2 56422.5838868561
Rh12n10n1t3 Rh12n10n1n2 Rh12n10n1n3 56641.4347711757
Rh12n10n1t4 Rh12n10n1n3 h12n 56342.8962268184
* h12 input 11 w=+0.422841356490785 w+  bank=n alpha=1 R=78831.7718256581 G_phys=1.26852406947236e-05 G_eff=1.26852406947236e-05
* tiled Rh12p11n1 series x4  each=19707.9429564145
Rh12p11n1t1 in11 Rh12p11n1n1 19687.8486747486
Rh12p11n1t2 Rh12p11n1n1 Rh12p11n1n2 19797.1984442903
Rh12p11n1t3 Rh12p11n1n2 Rh12p11n1n3 19772.2532630205
Rh12p11n1t4 Rh12p11n1n3 h12p 19683.9471010647
* h12 input 12 w=+0.250573650346706 w+  bank=n alpha=1 R=133028.086900644 G_phys=7.51720951040119e-06 G_eff=7.51720951040119e-06
* tiled Rh12p12n1 series x4  each=33257.0217251611
Rh12p12n1t1 in12 Rh12p12n1n1 33251.0662323749
Rh12p12n1t2 Rh12p12n1n1 Rh12p12n1n2 33344.1709408028
Rh12p12n1t3 Rh12p12n1n2 Rh12p12n1n3 33263.0898093186
Rh12p12n1t4 Rh12p12n1n3 h12p 33091.1664798845
* h12 input 13 w=+0.0601122436783251 w+  bank=n alpha=1 R=554518.202842467 G_phys=1.80336731034975e-06 G_eff=1.80336731034975e-06
* tiled Rh12p13n1 series x4  each=138629.550710617
Rh12p13n1t1 in13 Rh12p13n1n1 139240.833207108
Rh12p13n1t2 Rh12p13n1n1 Rh12p13n1n2 138811.747858409
Rh12p13n1t3 Rh12p13n1n2 Rh12p13n1n3 138020.753730636
Rh12p13n1t4 Rh12p13n1n3 h12p 139152.914193429
* h12 input 14 w=-0.651755086554606 w-  bank=n alpha=1 R=51143.9557910386 G_phys=1.95526525966382e-05 G_eff=1.95526525966382e-05
* tiled Rh12n14n1 series x4  each=12785.9889477596
Rh12n14n1t1 in14 Rh12n14n1n1 12837.3933148418
Rh12n14n1t2 Rh12n14n1n1 Rh12n14n1n2 12750.5089639718
Rh12n14n1t3 Rh12n14n1n2 Rh12n14n1n3 12823.8071287366
Rh12n14n1t4 Rh12n14n1n3 h12n 12793.1678160941
* h12 input 15 w=+0.130109285988943 w+  bank=n alpha=1 R=256194.88324735 G_phys=3.90327857966829e-06 G_eff=3.90327857966829e-06
* tiled Rh12p15n1 series x4  each=64048.7208118375
Rh12p15n1t1 in15 Rh12p15n1n1 64093.7966657667
Rh12p15n1t2 Rh12p15n1n1 Rh12p15n1n2 64310.400392425
Rh12p15n1t3 Rh12p15n1n2 Rh12p15n1n3 64337.5813487318
Rh12p15n1t4 Rh12p15n1n3 h12p 63738.9486102584
* h12 input 16 w=-0.0778767908450736 w-  bank=n alpha=1 R=428026.54002071 G_phys=2.33630372535221e-06 G_eff=2.33630372535221e-06
* tiled Rh12n16n1 series x4  each=107006.635005177
Rh12n16n1t1 in16 Rh12n16n1n1 106982.639949477
Rh12n16n1t2 Rh12n16n1n1 Rh12n16n1n2 106673.60071613
Rh12n16n1t3 Rh12n16n1n2 Rh12n16n1n3 106504.608188371
Rh12n16n1t4 Rh12n16n1n3 h12n 107231.208808613
* h12 bias=+0.0176157808963936 b+  bank=f alpha=0.001 R=1892.24272993526 G_phys=0.000528473426891809 G_eff=5.28473426891809e-07
* tiled Rh12bpf1 parallel x4  each=7568.97091974105
Rh12bpf1t1 vreff h12p 7599.740873608
Rh12bpf1t2 vreff h12p 7535.35126552311
Rh12bpf1t3 vreff h12p 7584.50787810976
Rh12bpf1t4 vreff h12p 7588.71110049314
Vh12p h12p 0 DC 0
Vh12n h12n 0 DC 0
Fh12p 0 h12d Vh12p 1.001
Fh12n h12d 0 Vh12n 1.001
* ratiometric I-to-V: V = I * R_IV,  R_IV=33333.3333333333 (weight ~ R_IV / R_w)
* tiled Rh12iv series x4  each=8333.33333333333
Rh12ivt1 h12d Rh12ivn1 8317.5318716127
Rh12ivt2 Rh12ivn1 Rh12ivn2 8312.68973391718
Rh12ivt3 Rh12ivn2 Rh12ivn3 8295.12043605101
Rh12ivt4 Rh12ivn3 0 8333.28805081666
Bh12leak 0 h12d I = 1e-08
Eh12sc h12raw 0 h12d 0 1
Eh12lin h12lin 0 h12raw 0 1
* direct bounded ReLU: y=max(0, min(15, v(h12lin))) no high-gain op-amp loop
Bh12relu h12y 0 V = max(0, min(15, (0.001) + v(h12lin)))
Eh12 h12buf 0 h12y 0 1

* h13 input 1 w=+0.034343742118514 w+  bank=n alpha=1 R=970579.537264929 G_phys=1.03031226355542e-06 G_eff=1.03031226355542e-06
* tiled Rh13p1n1 series x4  each=242644.884316232
Rh13p1n1t1 in1 Rh13p1n1n1 241909.980206979
Rh13p1n1t2 Rh13p1n1n1 Rh13p1n1n2 243711.787605858
Rh13p1n1t3 Rh13p1n1n2 Rh13p1n1n3 242824.754098768
Rh13p1n1t4 Rh13p1n1n3 h13p 242918.753254796
* h13 input 2 w=-0.102232912320493 w-  bank=n alpha=1 R=326052.858876169 G_phys=3.06698736961478e-06 G_eff=3.06698736961478e-06
* tiled Rh13n2n1 series x4  each=81513.2147190422
Rh13n2n1t1 in2 Rh13n2n1n1 81306.2860550466
Rh13n2n1t2 Rh13n2n1n1 Rh13n2n1n2 81885.4988552509
Rh13n2n1t3 Rh13n2n1n2 Rh13n2n1n3 81684.0537034908
Rh13n2n1t4 Rh13n2n1n3 h13n 81303.6821490999
* h13 input 3 w=+1.31993068300228 w+  bank=n alpha=1 R=25253.8514049194 G_phys=3.95979204900683e-05 G_eff=3.95979204900683e-05
* tiled Rh13p3n1 series x4  each=6313.46285122986
Rh13p3n1t1 in3 Rh13p3n1n1 6341.43185624134
Rh13p3n1t2 Rh13p3n1n1 Rh13p3n1n2 6326.21143290149
Rh13p3n1t3 Rh13p3n1n2 Rh13p3n1n3 6317.71479928184
Rh13p3n1t4 Rh13p3n1n3 h13p 6310.40032709749
* h13 input 4 w=-0.233319639483811 w-  bank=n alpha=1 R=142865.527338714 G_phys=6.99958918451433e-06 G_eff=6.99958918451433e-06
* tiled Rh13n4n1 series x4  each=35716.3818346785
Rh13n4n1t1 in4 Rh13n4n1n1 35641.9532389704
Rh13n4n1t2 Rh13n4n1n1 Rh13n4n1n2 35758.7701536743
Rh13n4n1t3 Rh13n4n1n2 Rh13n4n1n3 35732.0739000553
Rh13n4n1t4 Rh13n4n1n3 h13n 35754.1914586243
* h13 input 5 w=-0.375430599339701 w-  bank=n alpha=1 R=88786.9379639253 G_phys=1.1262917980191e-05 G_eff=1.1262917980191e-05
* tiled Rh13n5n1 series x4  each=22196.7344909813
Rh13n5n1t1 in5 Rh13n5n1n1 22307.6612643144
Rh13n5n1t2 Rh13n5n1n1 Rh13n5n1n2 22283.1251688854
Rh13n5n1t3 Rh13n5n1n2 Rh13n5n1n3 22230.366401531
Rh13n5n1t4 Rh13n5n1n3 h13n 22169.3467590241
* h13 input 6 w=+0.442115486842334 w+  bank=n alpha=1 R=75395.0818855177 G_phys=1.326346460527e-05 G_eff=1.326346460527e-05
* tiled Rh13p6n1 series x4  each=18848.7704713794
Rh13p6n1t1 in6 Rh13p6n1n1 18807.919862821
Rh13p6n1t2 Rh13p6n1n1 Rh13p6n1n2 18834.5585793027
Rh13p6n1t3 Rh13p6n1n2 Rh13p6n1n3 18816.1063698655
Rh13p6n1t4 Rh13p6n1n3 h13p 18833.704343347
* h13 input 7 w=-0.102130412545238 w-  bank=n alpha=1 R=326380.090930979 G_phys=3.06391237635715e-06 G_eff=3.06391237635715e-06
* tiled Rh13n7n1 series x4  each=81595.0227327448
Rh13n7n1t1 in7 Rh13n7n1n1 81320.9007844133
Rh13n7n1t2 Rh13n7n1n1 Rh13n7n1n2 81846.8440969926
Rh13n7n1t3 Rh13n7n1n2 Rh13n7n1n3 81458.5332155539
Rh13n7n1t4 Rh13n7n1n3 h13n 81608.3830109416
* h13 input 8 w=-0.136235661297007 w-  bank=n alpha=1 R=244674.067098066 G_phys=4.08706983891021e-06 G_eff=4.08706983891021e-06
* tiled Rh13n8n1 series x4  each=61168.5167745166
Rh13n8n1t1 in8 Rh13n8n1n1 60946.6418160793
Rh13n8n1t2 Rh13n8n1n1 Rh13n8n1n2 61056.3727912834
Rh13n8n1t3 Rh13n8n1n2 Rh13n8n1n3 61205.8275728427
Rh13n8n1t4 Rh13n8n1n3 h13n 61334.4744993296
* h13 input 9 w=+0.0915800560074952 w+  bank=n alpha=1 R=363980.268046628 G_phys=2.74740168022485e-06 G_eff=2.74740168022485e-06
* tiled Rh13p9n1 series x4  each=90995.0670116571
Rh13p9n1t1 in9 Rh13p9n1n1 90732.2159597139
Rh13p9n1t2 Rh13p9n1n1 Rh13p9n1n2 90758.531809651
Rh13p9n1t3 Rh13p9n1n2 Rh13p9n1n3 91119.550535114
Rh13p9n1t4 Rh13p9n1n3 h13p 91056.0449167259
* h13 input 10 w=-0.194905587913072 w-  bank=n alpha=1 R=171022.974201232 G_phys=5.84716763739217e-06 G_eff=5.84716763739217e-06
* tiled Rh13n10n1 series x4  each=42755.743550308
Rh13n10n1t1 in10 Rh13n10n1n1 42857.7738482531
Rh13n10n1t2 Rh13n10n1n1 Rh13n10n1n2 42741.0958047679
Rh13n10n1t3 Rh13n10n1n2 Rh13n10n1n3 42881.0377605387
Rh13n10n1t4 Rh13n10n1n3 h13n 42713.8422249263
* h13 input 11 w=-0.611958537828416 w-  bank=n alpha=1 R=54469.9212002489 G_phys=1.83587561348525e-05 G_eff=1.83587561348525e-05
* tiled Rh13n11n1 series x4  each=13617.4803000622
Rh13n11n1t1 in11 Rh13n11n1n1 13609.0535407577
Rh13n11n1t2 Rh13n11n1n1 Rh13n11n1n2 13563.8546951837
Rh13n11n1t3 Rh13n11n1n2 Rh13n11n1n3 13623.3735630226
Rh13n11n1t4 Rh13n11n1n3 h13n 13654.8730456641
* h13 input 12 w=+0.19411196838682 w+  bank=n alpha=1 R=171722.195237894 G_phys=5.8233590516046e-06 G_eff=5.8233590516046e-06
* tiled Rh13p12n1 series x4  each=42930.5488094734
Rh13p12n1t1 in12 Rh13p12n1n1 42843.4162617853
Rh13p12n1t2 Rh13p12n1n1 Rh13p12n1n2 42932.8536568858
Rh13p12n1t3 Rh13p12n1n2 Rh13p12n1n3 42984.8961007124
Rh13p12n1t4 Rh13p12n1n3 h13p 42942.2654629277
* h13 input 13 w=+0.146421986160596 w+  bank=n alpha=1 R=227652.514539539 G_phys=4.39265958481789e-06 G_eff=4.39265958481789e-06
* tiled Rh13p13n1 series x4  each=56913.1286348848
Rh13p13n1t1 in13 Rh13p13n1n1 56774.8795480748
Rh13p13n1t2 Rh13p13n1n1 Rh13p13n1n2 56843.3124027947
Rh13p13n1t3 Rh13p13n1n2 Rh13p13n1n3 56754.7779262598
Rh13p13n1t4 Rh13p13n1n3 h13p 57064.7793210631
* h13 input 14 w=+0.246088955287688 w+  bank=n alpha=1 R=135452.374505655 G_phys=7.38266865863065e-06 G_eff=7.38266865863065e-06
* tiled Rh13p14n1 series x4  each=33863.0936264137
Rh13p14n1t1 in14 Rh13p14n1n1 33765.8127060002
Rh13p14n1t2 Rh13p14n1n1 Rh13p14n1n2 33874.453239779
Rh13p14n1t3 Rh13p14n1n2 Rh13p14n1n3 33821.1294526132
Rh13p14n1t4 Rh13p14n1n3 h13p 33763.8035679449
* h13 input 15 w=-0.101801651380703 w-  bank=n alpha=1 R=327434.112131228 G_phys=3.05404954142109e-06 G_eff=3.05404954142109e-06
* tiled Rh13n15n1 series x4  each=81858.528032807
Rh13n15n1t1 in15 Rh13n15n1n1 82266.1656511843
Rh13n15n1t2 Rh13n15n1n1 Rh13n15n1n2 81964.5727197433
Rh13n15n1t3 Rh13n15n1n2 Rh13n15n1n3 81877.7995434332
Rh13n15n1t4 Rh13n15n1n3 h13n 81684.7347566198
* h13 input 16 w=-0.212672591801914 w-  bank=n alpha=1 R=156735.445084435 G_phys=6.38017775405741e-06 G_eff=6.38017775405741e-06
* tiled Rh13n16n1 series x4  each=39183.8612711088
Rh13n16n1t1 in16 Rh13n16n1n1 39121.2730011526
Rh13n16n1t2 Rh13n16n1n1 Rh13n16n1n2 39091.8648917409
Rh13n16n1t3 Rh13n16n1n2 Rh13n16n1n3 39077.9210097622
Rh13n16n1t4 Rh13n16n1n3 h13n 39172.4306141921
* h13 bias=+0.0212362032828689 b+  bank=f alpha=0.001 R=1569.64655542844 G_phys=0.000637086098486067 G_eff=6.37086098486067e-07
* tiled Rh13bpf1 parallel x4  each=6278.58622171376
Rh13bpf1t1 vreff h13p 6257.19411824934
Rh13bpf1t2 vreff h13p 6255.20590417891
Rh13bpf1t3 vreff h13p 6290.51728932157
Rh13bpf1t4 vreff h13p 6294.83656137779
Vh13p h13p 0 DC 0
Vh13n h13n 0 DC 0
Fh13p 0 h13d Vh13p 1.001
Fh13n h13d 0 Vh13n 1.001
* ratiometric I-to-V: V = I * R_IV,  R_IV=33333.3333333333 (weight ~ R_IV / R_w)
* tiled Rh13iv series x4  each=8333.33333333333
Rh13ivt1 h13d Rh13ivn1 8362.08086430299
Rh13ivt2 Rh13ivn1 Rh13ivn2 8353.2112414265
Rh13ivt3 Rh13ivn2 Rh13ivn3 8317.55253084257
Rh13ivt4 Rh13ivn3 0 8352.75875820905
Bh13leak 0 h13d I = 1e-08
Eh13sc h13raw 0 h13d 0 1
Eh13lin h13lin 0 h13raw 0 1
* direct bounded ReLU: y=max(0, min(15, v(h13lin))) no high-gain op-amp loop
Bh13relu h13y 0 V = max(0, min(15, (0.001) + v(h13lin)))
Eh13 h13buf 0 h13y 0 1

* h14 input 1 w=-0.089975491938664 w-  bank=n alpha=1 R=370471.254061679 G_phys=2.69926475815992e-06 G_eff=2.69926475815992e-06
* tiled Rh14n1n1 series x4  each=92617.8135154197
Rh14n1n1t1 in1 Rh14n1n1n1 92219.733090521
Rh14n1n1t2 Rh14n1n1n1 Rh14n1n1n2 92224.9184376835
Rh14n1n1t3 Rh14n1n1n2 Rh14n1n1n3 92947.9562260133
Rh14n1n1t4 Rh14n1n1n3 h14n 92954.0023042579
* h14 input 2 w=-0.0792638889786837 w-  bank=n alpha=1 R=420536.183157725 G_phys=2.37791666936051e-06 G_eff=2.37791666936051e-06
* tiled Rh14n2n1 series x4  each=105134.045789431
Rh14n2n1t1 in2 Rh14n2n1n1 104866.523632083
Rh14n2n1t2 Rh14n2n1n1 Rh14n2n1n2 104711.548606519
Rh14n2n1t3 Rh14n2n1n2 Rh14n2n1n3 105215.845224926
Rh14n2n1t4 Rh14n2n1n3 h14n 104627.587046316
* h14 input 3 w=-0.392380373690676 w-  bank=n alpha=1 R=84951.5815987547 G_phys=1.17714112107203e-05 G_eff=1.17714112107203e-05
* tiled Rh14n3n1 series x4  each=21237.8953996887
Rh14n3n1t1 in3 Rh14n3n1n1 21308.2464534133
Rh14n3n1t2 Rh14n3n1n1 Rh14n3n1n2 21168.7066036511
Rh14n3n1t3 Rh14n3n1n2 Rh14n3n1n3 21221.0836702438
Rh14n3n1t4 Rh14n3n1n3 h14n 21182.1185982104
* h14 input 4 w=+0.471386854681532 w+  bank=n alpha=1 R=70713.3281343902 G_phys=1.4141605640446e-05 G_eff=1.4141605640446e-05
* tiled Rh14p4n1 series x4  each=17678.3320335976
Rh14p4n1t1 in4 Rh14p4n1n1 17665.3612563358
Rh14p4n1t2 Rh14p4n1n1 Rh14p4n1n2 17741.7205730316
Rh14p4n1t3 Rh14p4n1n2 Rh14p4n1n3 17705.2603503321
Rh14p4n1t4 Rh14p4n1n3 h14p 17686.307174621
* h14 input 5 w=-0.118903138220599 w-  bank=n alpha=1 R=280340.231823744 G_phys=3.56709414661796e-06 G_eff=3.56709414661796e-06
* tiled Rh14n5n1 series x4  each=70085.0579559361
Rh14n5n1t1 in5 Rh14n5n1n1 70158.0973129143
Rh14n5n1t2 Rh14n5n1n1 Rh14n5n1n2 70401.0147158405
Rh14n5n1t3 Rh14n5n1n2 Rh14n5n1n3 69951.0292907973
Rh14n5n1t4 Rh14n5n1n3 h14n 69896.4337005038
* h14 input 6 w=+0.618408634475196 w+  bank=n alpha=1 R=53901.7915906385 G_phys=1.85522590342559e-05 G_eff=1.85522590342559e-05
* tiled Rh14p6n1 series x4  each=13475.4478976596
Rh14p6n1t1 in6 Rh14p6n1n1 13408.911482428
Rh14p6n1t2 Rh14p6n1n1 Rh14p6n1n2 13410.5696287006
Rh14p6n1t3 Rh14p6n1n2 Rh14p6n1n3 13417.5924324287
Rh14p6n1t4 Rh14p6n1n3 h14p 13419.9666174427
* h14 input 7 w=-0.0462466843022721 w-  bank=n alpha=1 R=720772.393442608 G_phys=1.38740052906816e-06 G_eff=1.38740052906816e-06
* tiled Rh14n7n1 series x4  each=180193.098360652
Rh14n7n1t1 in7 Rh14n7n1n1 179896.951148679
Rh14n7n1t2 Rh14n7n1n1 Rh14n7n1n2 180254.81842693
Rh14n7n1t3 Rh14n7n1n2 Rh14n7n1n3 179331.902614657
Rh14n7n1t4 Rh14n7n1n3 h14n 179513.911796004
* h14 input 8 w=-0.0297824475583231 w-  bank=f alpha=0.001 R=1119.22746671698 G_phys=0.000893473426749692 G_eff=8.93473426749692e-07
* tiled Rh14n8f1 parallel x4  each=4476.90986686793
Rh14n8f1t1 inf8 h14n 4485.2374208733
Rh14n8f1t2 inf8 h14n 4463.41140302507
Rh14n8f1t3 inf8 h14n 4473.76571566723
Rh14n8f1t4 inf8 h14n 4471.21003740664
* h14 input 9 w=+0.0766531636417715 w+  bank=n alpha=1 R=434859.198885937 G_phys=2.29959490925314e-06 G_eff=2.29959490925314e-06
* tiled Rh14p9n1 series x4  each=108714.799721484
Rh14p9n1t1 in9 Rh14p9n1n1 108210.118213237
Rh14p9n1t2 Rh14p9n1n1 Rh14p9n1n2 108822.130849619
Rh14p9n1t3 Rh14p9n1n2 Rh14p9n1n3 108561.041436802
Rh14p9n1t4 Rh14p9n1n3 h14p 109142.361581975
* h14 input 10 w=-0.0192124865162136 w-  bank=f alpha=0.001 R=1734.98278347277 G_phys=0.000576374595486407 G_eff=5.76374595486407e-07
* tiled Rh14n10f1 parallel x4  each=6939.93113389109
Rh14n10f1t1 inf10 h14n 6948.57004045451
Rh14n10f1t2 inf10 h14n 6944.47792794743
Rh14n10f1t3 inf10 h14n 6969.06751590291
Rh14n10f1t4 inf10 h14n 6912.14852640356
* h14 input 11 w=-0.118584174544602 w-  bank=n alpha=1 R=281094.281436313 G_phys=3.55752523633807e-06 G_eff=3.55752523633807e-06
* tiled Rh14n11n1 series x4  each=70273.5703590783
Rh14n11n1t1 in11 Rh14n11n1n1 69945.5979181519
Rh14n11n1t2 Rh14n11n1n1 Rh14n11n1n2 70557.7209445946
Rh14n11n1t3 Rh14n11n1n2 Rh14n11n1n3 70489.1210509934
Rh14n11n1t4 Rh14n11n1n3 h14n 70296.8882965229
* h14 input 12 w=+0.498792575097448 w+  bank=n alpha=1 R=66828.0463613979 G_phys=1.49637772529234e-05 G_eff=1.49637772529234e-05
* tiled Rh14p12n1 series x4  each=16707.0115903495
Rh14p12n1t1 in12 Rh14p12n1n1 16689.2485131999
Rh14p12n1t2 Rh14p12n1n1 Rh14p12n1n2 16669.0106535016
Rh14p12n1t3 Rh14p12n1n2 Rh14p12n1n3 16643.8628510921
Rh14p12n1t4 Rh14p12n1n3 h14p 16770.7570582067
* h14 input 13 w=+0.131240430694277 w+  bank=n alpha=1 R=253986.771888785 G_phys=3.93721292082832e-06 G_eff=3.93721292082832e-06
* tiled Rh14p13n1 series x4  each=63496.6929721963
Rh14p13n1t1 in13 Rh14p13n1n1 63315.3596831745
Rh14p13n1t2 Rh14p13n1n1 Rh14p13n1n2 63660.0559466386
Rh14p13n1t3 Rh14p13n1n2 Rh14p13n1n3 63550.7299574797
Rh14p13n1t4 Rh14p13n1n3 h14p 63423.8171136138
* h14 input 14 w=-0.699789872634837 w-  bank=n alpha=1 R=47633.346289833 G_phys=2.09936961790451e-05 G_eff=2.09936961790451e-05
* tiled Rh14n14n1 series x4  each=11908.3365724583
Rh14n14n1t1 in14 Rh14n14n1n1 11861.0216336825
Rh14n14n1t2 Rh14n14n1n1 Rh14n14n1n2 11923.8559650293
Rh14n14n1t3 Rh14n14n1n2 Rh14n14n1n3 11875.1811544432
Rh14n14n1t4 Rh14n14n1n3 h14n 11923.773264852
* h14 input 15 w=+0.0882030102342884 w+  bank=n alpha=1 R=377916.051218569 G_phys=2.64609030702865e-06 G_eff=2.64609030702865e-06
* tiled Rh14p15n1 series x4  each=94479.0128046423
Rh14p15n1t1 in15 Rh14p15n1n1 94557.6194835792
Rh14p15n1t2 Rh14p15n1n1 Rh14p15n1n2 94639.9272537907
Rh14p15n1t3 Rh14p15n1n2 Rh14p15n1n3 94939.0213800681
Rh14p15n1t4 Rh14p15n1n3 h14p 94928.8558554231
* h14 input 16 w=-0.409062788225599 w-  bank=n alpha=1 R=81487.082894839 G_phys=1.2271883646768e-05 G_eff=1.2271883646768e-05
* tiled Rh14n16n1 series x4  each=20371.7707237098
Rh14n16n1t1 in16 Rh14n16n1n1 20337.9910168352
Rh14n16n1t2 Rh14n16n1n1 Rh14n16n1n2 20390.2150567517
Rh14n16n1t3 Rh14n16n1n2 Rh14n16n1n3 20472.0860257602
Rh14n16n1t4 Rh14n16n1n3 h14n 20389.6205937538
* h14 bias=+0.0824693880781811 b+  bank=n alpha=1 R=404190.380335226 G_phys=2.47408164234543e-06 G_eff=2.47408164234543e-06
* tiled Rh14bpn1 series x4  each=101047.595083806
Rh14bpn1t1 vref Rh14bpn1n1 100644.758644168
Rh14bpn1t2 Rh14bpn1n1 Rh14bpn1n2 101380.064313647
Rh14bpn1t3 Rh14bpn1n2 Rh14bpn1n3 101194.304889305
Rh14bpn1t4 Rh14bpn1n3 h14p 100839.423132575
Vh14p h14p 0 DC 0
Vh14n h14n 0 DC 0
Fh14p 0 h14d Vh14p 1.001
Fh14n h14d 0 Vh14n 1.001
* ratiometric I-to-V: V = I * R_IV,  R_IV=33333.3333333333 (weight ~ R_IV / R_w)
* tiled Rh14iv series x4  each=8333.33333333333
Rh14ivt1 h14d Rh14ivn1 8369.85190035984
Rh14ivt2 Rh14ivn1 Rh14ivn2 8349.25593780444
Rh14ivt3 Rh14ivn2 Rh14ivn3 8304.73472704941
Rh14ivt4 Rh14ivn3 0 8301.02188637117
Bh14leak 0 h14d I = 1e-08
Eh14sc h14raw 0 h14d 0 1
Eh14lin h14lin 0 h14raw 0 1
* direct bounded ReLU: y=max(0, min(15, v(h14lin))) no high-gain op-amp loop
Bh14relu h14y 0 V = max(0, min(15, (0.001) + v(h14lin)))
Eh14 h14buf 0 h14y 0 1

* h15 input 1 w=-0.104362920527351 w-  bank=n alpha=1 R=319398.241874589 G_phys=3.13088761582053e-06 G_eff=3.13088761582053e-06
* tiled Rh15n1n1 series x4  each=79849.5604686471
Rh15n1n1t1 in1 Rh15n1n1n1 79871.8000635749
Rh15n1n1t2 Rh15n1n1n1 Rh15n1n1n2 80105.3926840205
Rh15n1n1t3 Rh15n1n1n2 Rh15n1n1n3 79960.0558335368
Rh15n1n1t4 Rh15n1n1n3 h15n 80003.1283591835
* h15 input 2 w=+0.0920701784982539 w+  bank=n alpha=1 R=362042.670895501 G_phys=2.76210535494762e-06 G_eff=2.76210535494762e-06
* tiled Rh15p2n1 series x4  each=90510.6677238752
Rh15p2n1t1 in2 Rh15p2n1n1 90081.1346358239
Rh15p2n1t2 Rh15p2n1n1 Rh15p2n1n2 90768.1091785922
Rh15p2n1t3 Rh15p2n1n2 Rh15p2n1n3 90557.8125721796
Rh15p2n1t4 Rh15p2n1n3 h15p 90717.6769318146
* h15 input 3 w=+0.710914651543076 w+  bank=n alpha=1 R=46887.9537944276 G_phys=2.13274395462923e-05 G_eff=2.13274395462923e-05
* tiled Rh15p3n1 series x4  each=11721.9884486069
Rh15p3n1t1 in3 Rh15p3n1n1 11696.4731286587
Rh15p3n1t2 Rh15p3n1n1 Rh15p3n1n2 11676.7615841206
Rh15p3n1t3 Rh15p3n1n2 Rh15p3n1n3 11696.8449003259
Rh15p3n1t4 Rh15p3n1n3 h15p 11722.6612094328
* h15 input 4 w=+0.0431405504557543 w+  bank=n alpha=1 R=772668.243246468 G_phys=1.29421651367263e-06 G_eff=1.29421651367263e-06
* tiled Rh15p4n1 series x4  each=193167.060811617
Rh15p4n1t1 in4 Rh15p4n1n1 194048.357819899
Rh15p4n1t2 Rh15p4n1n1 Rh15p4n1n2 192695.969235942
Rh15p4n1t3 Rh15p4n1n2 Rh15p4n1n3 193761.028393488
Rh15p4n1t4 Rh15p4n1n3 h15p 193366.774520318
* h15 input 5 w=-0.544653793286569 w-  bank=n alpha=1 R=61200.9569091444 G_phys=1.63396137985971e-05 G_eff=1.63396137985971e-05
* tiled Rh15n5n1 series x4  each=15300.2392272861
Rh15n5n1t1 in5 Rh15n5n1n1 15289.8043723113
Rh15n5n1t2 Rh15n5n1n1 Rh15n5n1n2 15273.894349253
Rh15n5n1t3 Rh15n5n1n2 Rh15n5n1n3 15348.929197401
Rh15n5n1t4 Rh15n5n1n3 h15n 15289.4076416731
* h15 input 6 w=+0.236607896967987 w+  bank=n alpha=1 R=140880.054133795 G_phys=7.0982369090396e-06 G_eff=7.0982369090396e-06
* tiled Rh15p6n1 series x4  each=35220.0135334487
Rh15p6n1t1 in6 Rh15p6n1n1 35372.7707044644
Rh15p6n1t2 Rh15p6n1n1 Rh15p6n1n2 35361.7349683511
Rh15p6n1t3 Rh15p6n1n2 Rh15p6n1n3 35127.2022165835
Rh15p6n1t4 Rh15p6n1n3 h15p 35294.9322138049
* h15 input 7 w=+0.205722108048513 w+  bank=n alpha=1 R=162030.875774774 G_phys=6.17166324145539e-06 G_eff=6.17166324145539e-06
* tiled Rh15p7n1 series x4  each=40507.7189436936
Rh15p7n1t1 in7 Rh15p7n1n1 40557.6691835164
Rh15p7n1t2 Rh15p7n1n1 Rh15p7n1n2 40628.1004376661
Rh15p7n1t3 Rh15p7n1n2 Rh15p7n1n3 40538.8535935218
Rh15p7n1t4 Rh15p7n1n3 h15p 40387.1841171616
* h15 input 8 w=+0.119910326826568 w+  bank=n alpha=1 R=277985.509801377 G_phys=3.59730980479705e-06 G_eff=3.59730980479705e-06
* tiled Rh15p8n1 series x4  each=69496.3774503442
Rh15p8n1t1 in8 Rh15p8n1n1 69803.3491782918
Rh15p8n1t2 Rh15p8n1n1 Rh15p8n1n2 69826.4391777206
Rh15p8n1t3 Rh15p8n1n2 Rh15p8n1n3 69579.2611428711
Rh15p8n1t4 Rh15p8n1n3 h15p 69470.5498797359
* h15 input 9 w=-0.0351999996705356 w-  bank=n alpha=1 R=946969.705833129 G_phys=1.05599999011607e-06 G_eff=1.05599999011607e-06
* tiled Rh15n9n1 series x4  each=236742.426458282
Rh15n9n1t1 in9 Rh15n9n1n1 236492.168516867
Rh15n9n1t2 Rh15n9n1n1 Rh15n9n1n2 237751.152417279
Rh15n9n1t3 Rh15n9n1n2 Rh15n9n1n3 236666.442912141
Rh15n9n1t4 Rh15n9n1n3 h15n 236806.989303652
* h15 input 10 w=-0.0279846802936883 w-  bank=f alpha=0.001 R=1191.12789510236 G_phys=0.000839540408810648 G_eff=8.39540408810648e-07
* tiled Rh15n10f1 parallel x4  each=4764.51158040943
Rh15n10f1t1 inf10 h15n 4759.16780305495
Rh15n10f1t2 inf10 h15n 4785.63238751713
Rh15n10f1t3 inf10 h15n 4741.0139357734
Rh15n10f1t4 inf10 h15n 4787.53874425591
* h15 input 11 w=-0.155672537202176 w-  bank=n alpha=1 R=214124.68719542 G_phys=4.67017611606528e-06 G_eff=4.67017611606528e-06
* tiled Rh15n11n1 series x4  each=53531.171798855
Rh15n11n1t1 in11 Rh15n11n1n1 53294.7838310274
Rh15n11n1t2 Rh15n11n1n1 Rh15n11n1n2 53497.4431958442
Rh15n11n1t3 Rh15n11n1n2 Rh15n11n1n3 53704.486757225
Rh15n11n1t4 Rh15n11n1n3 h15n 53311.4040470912
* h15 input 12 w=-0.248740189524738 w-  bank=n alpha=1 R=134008.635263254 G_phys=7.46220568574215e-06 G_eff=7.46220568574215e-06
* tiled Rh15n12n1 series x4  each=33502.1588158135
Rh15n12n1t1 in12 Rh15n12n1n1 33503.6503975823
Rh15n12n1t2 Rh15n12n1n1 Rh15n12n1n2 33538.7362323644
Rh15n12n1t3 Rh15n12n1n2 Rh15n12n1n3 33550.6623911918
Rh15n12n1t4 Rh15n12n1n3 h15n 33455.6983962669
* h15 input 13 w=+0.142944744841187 w+  bank=n alpha=1 R=233190.337779587 G_phys=4.28834234523561e-06 G_eff=4.28834234523561e-06
* tiled Rh15p13n1 series x4  each=58297.5844448968
Rh15p13n1t1 in13 Rh15p13n1n1 58451.9110474691
Rh15p13n1t2 Rh15p13n1n1 Rh15p13n1n2 58241.1651536755
Rh15p13n1t3 Rh15p13n1n2 Rh15p13n1n3 58516.2085242805
Rh15p13n1t4 Rh15p13n1n3 h15p 58450.7076248859
* h15 input 14 w=-0.364164748984914 w-  bank=n alpha=1 R=91533.6627892949 G_phys=1.09249424695474e-05 G_eff=1.09249424695474e-05
* tiled Rh15n14n1 series x4  each=22883.4156973237
Rh15n14n1t1 in14 Rh15n14n1n1 22961.8039271795
Rh15n14n1t2 Rh15n14n1n1 Rh15n14n1n2 22842.3506360031
Rh15n14n1t3 Rh15n14n1n2 Rh15n14n1n3 22869.1214722979
Rh15n14n1t4 Rh15n14n1n3 h15n 22938.134550423
* h15 input 15 w=-0.240848341925517 w-  bank=n alpha=1 R=138399.679511357 G_phys=7.22545025776552e-06 G_eff=7.22545025776552e-06
* tiled Rh15n15n1 series x4  each=34599.9198778393
Rh15n15n1t1 in15 Rh15n15n1n1 34682.522900333
Rh15n15n1t2 Rh15n15n1n1 Rh15n15n1n2 34675.6598599591
Rh15n15n1t3 Rh15n15n1n2 Rh15n15n1n3 34619.2834144736
Rh15n15n1t4 Rh15n15n1n3 h15n 34643.9761871386
* h15 input 16 w=-0.736896288827917 w-  bank=n alpha=1 R=45234.7689066968 G_phys=2.21068886648375e-05 G_eff=2.21068886648375e-05
* tiled Rh15n16n1 series x4  each=11308.6922266742
Rh15n16n1t1 in16 Rh15n16n1n1 11256.5168015388
Rh15n16n1t2 Rh15n16n1n1 Rh15n16n1n2 11312.2400263742
Rh15n16n1t3 Rh15n16n1n2 Rh15n16n1n3 11287.0027443691
Rh15n16n1t4 Rh15n16n1n3 h15n 11286.2852870949
* h15 bias=+0.00140769830063221 b+  bank=f alpha=0.001 R=23679.3163125671 G_phys=4.22309490189663e-05 G_eff=4.22309490189663e-08
* tiled Rh15bpf1 series x4  each=5919.82907814178
Rh15bpf1t1 vreff Rh15bpf1n1 5927.76241764532
Rh15bpf1t2 Rh15bpf1n1 Rh15bpf1n2 5906.50383208118
Rh15bpf1t3 Rh15bpf1n2 Rh15bpf1n3 5919.54553749634
Rh15bpf1t4 Rh15bpf1n3 h15p 5891.96536423897
Vh15p h15p 0 DC 0
Vh15n h15n 0 DC 0
Fh15p 0 h15d Vh15p 1.001
Fh15n h15d 0 Vh15n 1.001
* ratiometric I-to-V: V = I * R_IV,  R_IV=33333.3333333333 (weight ~ R_IV / R_w)
* tiled Rh15iv series x4  each=8333.33333333333
Rh15ivt1 h15d Rh15ivn1 8328.34668931347
Rh15ivt2 Rh15ivn1 Rh15ivn2 8326.43878202084
Rh15ivt3 Rh15ivn2 Rh15ivn3 8342.49606523299
Rh15ivt4 Rh15ivn3 0 8310.42220117307
Bh15leak 0 h15d I = 1e-08
Eh15sc h15raw 0 h15d 0 1
Eh15lin h15lin 0 h15raw 0 1
* direct bounded ReLU: y=max(0, min(15, v(h15lin))) no high-gain op-amp loop
Bh15relu h15y 0 V = max(0, min(15, (0.001) + v(h15lin)))
Eh15 h15buf 0 h15y 0 1

* h16 input 1 w=-0.211528252190937 w-  bank=n alpha=1 R=157583.362922343 G_phys=6.3458475657281e-06 G_eff=6.3458475657281e-06
* tiled Rh16n1n1 series x4  each=39395.8407305858
Rh16n1n1t1 in1 Rh16n1n1n1 39474.4417874973
Rh16n1n1t2 Rh16n1n1n1 Rh16n1n1n2 39475.8335420142
Rh16n1n1t3 Rh16n1n1n2 Rh16n1n1n3 39394.5865801224
Rh16n1n1t4 Rh16n1n1n3 h16n 39569.6066056777
* h16 input 2 w=-0.194947045242045 w-  bank=n alpha=1 R=170986.604551748 G_phys=5.84841135726135e-06 G_eff=5.84841135726135e-06
* tiled Rh16n2n1 series x4  each=42746.6511379371
Rh16n2n1t1 in2 Rh16n2n1n1 42770.691200829
Rh16n2n1t2 Rh16n2n1n1 Rh16n2n1n2 42943.492786647
Rh16n2n1t3 Rh16n2n1n2 Rh16n2n1n3 42616.4568393707
Rh16n2n1t4 Rh16n2n1n3 h16n 42861.70314854
* h16 input 3 w=-0.281660896127353 w-  bank=n alpha=1 R=118345.619827403 G_phys=8.44982688382059e-06 G_eff=8.44982688382059e-06
* tiled Rh16n3n1 series x4  each=29586.4049568507
Rh16n3n1t1 in3 Rh16n3n1n1 29481.4051397342
Rh16n3n1t2 Rh16n3n1n1 Rh16n3n1n2 29451.9054920661
Rh16n3n1t3 Rh16n3n1n2 Rh16n3n1n3 29641.0659480068
Rh16n3n1t4 Rh16n3n1n3 h16n 29668.0527479147
* h16 input 4 w=-0.246854224570453 w-  bank=n alpha=1 R=135032.460519305 G_phys=7.4056267371136e-06 G_eff=7.4056267371136e-06
* tiled Rh16n4n1 series x4  each=33758.1151298262
Rh16n4n1t1 in4 Rh16n4n1n1 33744.0288166483
Rh16n4n1t2 Rh16n4n1n1 Rh16n4n1n2 33861.067151562
Rh16n4n1t3 Rh16n4n1n2 Rh16n4n1n3 33768.6874385646
Rh16n4n1t4 Rh16n4n1n3 h16n 33665.7631422479
* h16 input 5 w=+0.785179968580328 w+  bank=n alpha=1 R=42453.112238208 G_phys=2.35553990574098e-05 G_eff=2.35553990574098e-05
* tiled Rh16p5n1 series x4  each=10613.278059552
Rh16p5n1t1 in5 Rh16p5n1n1 10652.1468083683
Rh16p5n1t2 Rh16p5n1n1 Rh16p5n1n2 10628.0613512227
Rh16p5n1t3 Rh16p5n1n2 Rh16p5n1n3 10633.5349498951
Rh16p5n1t4 Rh16p5n1n3 h16p 10599.886577644
* h16 input 6 w=-0.342055263707418 w-  bank=n alpha=1 R=97450.1399921314 G_phys=1.02616579112226e-05 G_eff=1.02616579112226e-05
* tiled Rh16n6n1 series x4  each=24362.5349980328
Rh16n6n1t1 in6 Rh16n6n1n1 24458.423549622
Rh16n6n1t2 Rh16n6n1n1 Rh16n6n1n2 24449.8233512318
Rh16n6n1t3 Rh16n6n1n2 Rh16n6n1n3 24342.0631932042
Rh16n6n1t4 Rh16n6n1n3 h16n 24306.515107789
* h16 input 7 w=-0.213390213186068 w-  bank=n alpha=1 R=156208.351056231 G_phys=6.40170639558203e-06 G_eff=6.40170639558203e-06
* tiled Rh16n7n1 series x4  each=39052.0877640578
Rh16n7n1t1 in7 Rh16n7n1n1 38957.0508631149
Rh16n7n1t2 Rh16n7n1n1 Rh16n7n1n2 38984.2564979615
Rh16n7n1t3 Rh16n7n1n2 Rh16n7n1n3 39044.5831368325
Rh16n7n1t4 Rh16n7n1n3 h16n 39133.1940229654
* h16 input 8 w=-0.06183287092446 w-  bank=n alpha=1 R=539087.589415927 G_phys=1.8549861277338e-06 G_eff=1.8549861277338e-06
* tiled Rh16n8n1 series x4  each=134771.897353982
Rh16n8n1t1 in8 Rh16n8n1n1 134238.168343998
Rh16n8n1t2 Rh16n8n1n1 Rh16n8n1n2 134865.937708621
Rh16n8n1t3 Rh16n8n1n2 Rh16n8n1n3 134238.714078693
Rh16n8n1t4 Rh16n8n1n3 h16n 135374.549867625
* h16 input 9 w=+0.114369297885863 w+  bank=n alpha=1 R=291453.510247121 G_phys=3.43107893657588e-06 G_eff=3.43107893657588e-06
* tiled Rh16p9n1 series x4  each=72863.3775617803
Rh16p9n1t1 in9 Rh16p9n1n1 73002.9063017651
Rh16p9n1t2 Rh16p9n1n1 Rh16p9n1n2 73060.0746213072
Rh16p9n1t3 Rh16p9n1n2 Rh16p9n1n3 72570.1025667442
Rh16p9n1t4 Rh16p9n1n3 h16p 72727.6481672955
* h16 input 10 w=+0.418702574206734 w+  bank=n alpha=1 R=79611.0064440994 G_phys=1.2561077226202e-05 G_eff=1.2561077226202e-05
* tiled Rh16p10n1 series x4  each=19902.7516110249
Rh16p10n1t1 in10 Rh16p10n1n1 19823.9065731488
Rh16p10n1t2 Rh16p10n1n1 Rh16p10n1n2 19930.5133218867
Rh16p10n1t3 Rh16p10n1n2 Rh16p10n1n3 19813.6038865042
Rh16p10n1t4 Rh16p10n1n3 h16p 19945.8835253838
* h16 input 11 w=-0.38263995973155 w-  bank=n alpha=1 R=87114.0937729534 G_phys=1.14791987919465e-05 G_eff=1.14791987919465e-05
* tiled Rh16n11n1 series x4  each=21778.5234432383
Rh16n11n1t1 in11 Rh16n11n1n1 21817.8182277906
Rh16n11n1t2 Rh16n11n1n1 Rh16n11n1n2 21707.6472349043
Rh16n11n1t3 Rh16n11n1n2 Rh16n11n1n3 21756.6460042184
Rh16n11n1t4 Rh16n11n1n3 h16n 21829.3832025358
* h16 input 12 w=-0.447982918675276 w-  bank=n alpha=1 R=74407.5989144918 G_phys=1.34394875602583e-05 G_eff=1.34394875602583e-05
* tiled Rh16n12n1 series x4  each=18601.8997286229
Rh16n12n1t1 in12 Rh16n12n1n1 18606.0337121593
Rh16n12n1t2 Rh16n12n1n1 Rh16n12n1n2 18607.4243353101
Rh16n12n1t3 Rh16n12n1n2 Rh16n12n1n3 18515.3257010369
Rh16n12n1t4 Rh16n12n1n3 h16n 18687.0165971631
* h16 input 13 w=-0.354860709093241 w-  bank=n alpha=1 R=93933.5702126856 G_phys=1.06458212727972e-05 G_eff=1.06458212727972e-05
* tiled Rh16n13n1 series x4  each=23483.3925531714
Rh16n13n1t1 in13 Rh16n13n1n1 23397.1539530413
Rh16n13n1t2 Rh16n13n1n1 Rh16n13n1n2 23474.0080673908
Rh16n13n1t3 Rh16n13n1n2 Rh16n13n1n3 23451.6030973544
Rh16n13n1t4 Rh16n13n1n3 h16n 23551.5685859065
* h16 input 14 w=-0.245379266072843 w-  bank=n alpha=1 R=135844.131685674 G_phys=7.36137798218528e-06 G_eff=7.36137798218528e-06
* tiled Rh16n14n1 series x4  each=33961.0329214186
Rh16n14n1t1 in14 Rh16n14n1n1 33915.2171119887
Rh16n14n1t2 Rh16n14n1n1 Rh16n14n1n2 33932.6916694319
Rh16n14n1t3 Rh16n14n1n2 Rh16n14n1n3 34016.1239377712
Rh16n14n1t4 Rh16n14n1n3 h16n 34096.3611114418
* h16 input 15 w=-0.0999148922371372 w-  bank=n alpha=1 R=333617.267526249 G_phys=2.99744676711412e-06 G_eff=2.99744676711412e-06
* tiled Rh16n15n1 series x4  each=83404.3168815622
Rh16n15n1t1 in15 Rh16n15n1n1 83234.99855101
Rh16n15n1t2 Rh16n15n1n1 Rh16n15n1n2 83428.5484420702
Rh16n15n1t3 Rh16n15n1n2 Rh16n15n1n3 83814.6120104401
Rh16n15n1t4 Rh16n15n1n3 h16n 83184.7082551816
* h16 input 16 w=-0.428765175056332 w-  bank=n alpha=1 R=77742.632267077 G_phys=1.286295525169e-05 G_eff=1.286295525169e-05
* tiled Rh16n16n1 series x4  each=19435.6580667693
Rh16n16n1t1 in16 Rh16n16n1n1 19501.1193960179
Rh16n16n1t2 Rh16n16n1n1 Rh16n16n1n2 19491.0869560712
Rh16n16n1t3 Rh16n16n1n2 Rh16n16n1n3 19350.8221066751
Rh16n16n1t4 Rh16n16n1n3 h16n 19354.2064977238
* h16 bias=+0.0857431075924666 b+  bank=n alpha=1 R=388758.166916054 G_phys=2.572293227774e-06 G_eff=2.572293227774e-06
* tiled Rh16bpn1 series x4  each=97189.5417290136
Rh16bpn1t1 vref Rh16bpn1n1 97555.6404682509
Rh16bpn1t2 Rh16bpn1n1 Rh16bpn1n2 97308.0867561495
Rh16bpn1t3 Rh16bpn1n2 Rh16bpn1n3 97551.9224780415
Rh16bpn1t4 Rh16bpn1n3 h16p 97621.6635632619
Vh16p h16p 0 DC 0
Vh16n h16n 0 DC 0
Fh16p 0 h16d Vh16p 1.001
Fh16n h16d 0 Vh16n 1.001
* ratiometric I-to-V: V = I * R_IV,  R_IV=33333.3333333333 (weight ~ R_IV / R_w)
* tiled Rh16iv series x4  each=8333.33333333333
Rh16ivt1 h16d Rh16ivn1 8346.09051666497
Rh16ivt2 Rh16ivn1 Rh16ivn2 8363.37089308683
Rh16ivt3 Rh16ivn2 Rh16ivn3 8355.53467381864
Rh16ivt4 Rh16ivn3 0 8351.68335870598
Bh16leak 0 h16d I = 1e-08
Eh16sc h16raw 0 h16d 0 1
Eh16lin h16lin 0 h16raw 0 1
* direct bounded ReLU: y=max(0, min(15, v(h16lin))) no high-gain op-amp loop
Bh16relu h16y 0 V = max(0, min(15, (0.001) + v(h16lin)))
Eh16 h16buf 0 h16y 0 1

* h17 input 1 w=+0.690050155404084 w+  bank=n alpha=1 R=48305.667453714 G_phys=2.07015046621225e-05 G_eff=2.07015046621225e-05
* tiled Rh17p1n1 series x4  each=12076.4168634285
Rh17p1n1t1 in1 Rh17p1n1n1 12044.45228556
Rh17p1n1t2 Rh17p1n1n1 Rh17p1n1n2 12030.6079416885
Rh17p1n1t3 Rh17p1n1n2 Rh17p1n1n3 12067.7857826242
Rh17p1n1t4 Rh17p1n1n3 h17p 12124.0258657433
* h17 input 2 w=-0.128803090681736 w-  bank=n alpha=1 R=258792.961852894 G_phys=3.86409272045207e-06 G_eff=3.86409272045207e-06
* tiled Rh17n2n1 series x4  each=64698.2404632236
Rh17n2n1t1 in2 Rh17n2n1n1 64581.5480310277
Rh17n2n1t2 Rh17n2n1n1 Rh17n2n1n2 64782.335736844
Rh17n2n1t3 Rh17n2n1n2 Rh17n2n1n3 64533.8679449742
Rh17n2n1t4 Rh17n2n1n3 h17n 64782.3174411361
* h17 input 3 w=-0.49836012605351 w-  bank=n alpha=1 R=66886.036002315 G_phys=1.49508037816053e-05 G_eff=1.49508037816053e-05
* tiled Rh17n3n1 series x4  each=16721.5090005787
Rh17n3n1t1 in3 Rh17n3n1n1 16748.2050431025
Rh17n3n1t2 Rh17n3n1n1 Rh17n3n1n2 16722.5124860657
Rh17n3n1t3 Rh17n3n1n2 Rh17n3n1n3 16794.4601930397
Rh17n3n1t4 Rh17n3n1n3 h17n 16654.4725255417
* h17 input 4 w=-0.0597081457071854 w-  bank=n alpha=1 R=558271.119267432 G_phys=1.79124437121556e-06 G_eff=1.79124437121556e-06
* tiled Rh17n4n1 series x4  each=139567.779816858
Rh17n4n1t1 in4 Rh17n4n1n1 139920.048794815
Rh17n4n1t2 Rh17n4n1n1 Rh17n4n1n2 140251.0525625
Rh17n4n1t3 Rh17n4n1n2 Rh17n4n1n3 138923.926416983
Rh17n4n1t4 Rh17n4n1n3 h17n 139957.379439145
* h17 input 5 w=+0.0531710366485299 w+  bank=n alpha=1 R=626907.71958562 G_phys=1.5951310994559e-06 G_eff=1.5951310994559e-06
* tiled Rh17p5n1 series x4  each=156726.929896405
Rh17p5n1t1 in5 Rh17p5n1n1 156045.971197051
Rh17p5n1t2 Rh17p5n1n1 Rh17p5n1n2 157455.085394126
Rh17p5n1t3 Rh17p5n1n2 Rh17p5n1n3 157507.698798532
Rh17p5n1t4 Rh17p5n1n3 h17p 156495.478652259
* h17 input 6 w=+0.325686197829899 w+  bank=n alpha=1 R=102348.007239603 G_phys=9.77058593489698e-06 G_eff=9.77058593489698e-06
* tiled Rh17p6n1 series x4  each=25587.0018099008
Rh17p6n1t1 in6 Rh17p6n1n1 25701.8787525429
Rh17p6n1t2 Rh17p6n1n1 Rh17p6n1n2 25603.6059496164
Rh17p6n1t3 Rh17p6n1n2 Rh17p6n1n3 25576.9237219272
Rh17p6n1t4 Rh17p6n1n3 h17p 25573.1433790277
* h17 input 7 w=-0.138446110206034 w-  bank=n alpha=1 R=240767.568577601 G_phys=4.15338330618101e-06 G_eff=4.15338330618101e-06
* tiled Rh17n7n1 series x4  each=60191.8921444003
Rh17n7n1t1 in7 Rh17n7n1n1 60340.2232905849
Rh17n7n1t2 Rh17n7n1n1 Rh17n7n1n2 60387.6147639687
Rh17n7n1t3 Rh17n7n1n2 Rh17n7n1n3 60061.9495038623
Rh17n7n1t4 Rh17n7n1n3 h17n 60376.0681326136
* h17 input 8 w=-0.354640771144099 w-  bank=n alpha=1 R=93991.8250961316 G_phys=1.0639223134323e-05 G_eff=1.0639223134323e-05
* tiled Rh17n8n1 series x4  each=23497.9562740329
Rh17n8n1t1 in8 Rh17n8n1n1 23385.5740531502
Rh17n8n1t2 Rh17n8n1n1 Rh17n8n1n2 23457.7999571545
Rh17n8n1t3 Rh17n8n1n2 Rh17n8n1n3 23543.6211819681
Rh17n8n1t4 Rh17n8n1n3 h17n 23529.3982915059
* h17 input 9 w=+0.283153126675736 w+  bank=n alpha=1 R=117721.932738911 G_phys=8.49459380027208e-06 G_eff=8.49459380027208e-06
* tiled Rh17p9n1 series x4  each=29430.4831847277
Rh17p9n1t1 in9 Rh17p9n1n1 29330.9457872828
Rh17p9n1t2 Rh17p9n1n1 Rh17p9n1n2 29459.0216086195
Rh17p9n1t3 Rh17p9n1n2 Rh17p9n1n3 29376.2842785472
Rh17p9n1t4 Rh17p9n1n3 h17p 29486.8855544306
* h17 input 10 w=+0.187509087652136 w+  bank=n alpha=1 R=177769.161754831 G_phys=5.62527262956408e-06 G_eff=5.62527262956408e-06
* tiled Rh17p10n1 series x4  each=44442.2904387077
Rh17p10n1t1 in10 Rh17p10n1n1 44293.0142687881
Rh17p10n1t2 Rh17p10n1n1 Rh17p10n1n2 44256.4534008483
Rh17p10n1t3 Rh17p10n1n2 Rh17p10n1n3 44366.5814470752
Rh17p10n1t4 Rh17p10n1n3 h17p 44508.9718375389
* h17 input 11 w=+0.286891884918939 w+  bank=n alpha=1 R=116187.78740553 G_phys=8.60675654756817e-06 G_eff=8.60675654756817e-06
* tiled Rh17p11n1 series x4  each=29046.9468513824
Rh17p11n1t1 in11 Rh17p11n1n1 28984.5968960057
Rh17p11n1t2 Rh17p11n1n1 Rh17p11n1n2 29189.9700679931
Rh17p11n1t3 Rh17p11n1n2 Rh17p11n1n3 29171.0213549967
Rh17p11n1t4 Rh17p11n1n3 h17p 28963.0131563684
* h17 input 12 w=-0.663420236101193 w-  bank=n alpha=1 R=50244.6737670041 G_phys=1.99026070830358e-05 G_eff=1.99026070830358e-05
* tiled Rh17n12n1 series x4  each=12561.168441751
Rh17n12n1t1 in12 Rh17n12n1n1 12561.8792125216
Rh17n12n1t2 Rh17n12n1n1 Rh17n12n1n2 12574.8256975881
Rh17n12n1t3 Rh17n12n1n2 Rh17n12n1n3 12538.9616469921
Rh17n12n1t4 Rh17n12n1n3 h17n 12600.535862908
* h17 input 13 w=-0.00672050178940724 w-  bank=f alpha=0.001 R=4959.94709589586 G_phys=0.000201615053682217 G_eff=2.01615053682217e-07
* tiled Rh17n13f1 series x4  each=1239.98677397396
Rh17n13f1t1 inf13 Rh17n13f1n1 1234.22375452667
Rh17n13f1t2 Rh17n13f1n1 Rh17n13f1n2 1234.01216138887
Rh17n13f1t3 Rh17n13f1n2 Rh17n13f1n3 1242.14915402834
Rh17n13f1t4 Rh17n13f1n3 h17n 1242.95938279965
* h17 input 14 w=+0.213870810385993 w+  bank=n alpha=1 R=155857.32935305 G_phys=6.41612431157979e-06 G_eff=6.41612431157979e-06
* tiled Rh17p14n1 series x4  each=38964.3323382624
Rh17p14n1t1 in14 Rh17p14n1n1 38997.6049985842
Rh17p14n1t2 Rh17p14n1n1 Rh17p14n1n2 39141.1445303079
Rh17p14n1t3 Rh17p14n1n2 Rh17p14n1n3 38833.1198976293
Rh17p14n1t4 Rh17p14n1n3 h17p 38932.4331618352
* h17 input 15 w=+0.856655380645102 w+  bank=n alpha=1 R=38911.0184637278 G_phys=2.56996614193531e-05 G_eff=2.56996614193531e-05
* tiled Rh17p15n1 series x4  each=9727.75461593195
Rh17p15n1t1 in15 Rh17p15n1n1 9752.75296869085
Rh17p15n1t2 Rh17p15n1n1 Rh17p15n1n2 9726.8958436166
Rh17p15n1t3 Rh17p15n1n2 Rh17p15n1n3 9771.49856764278
Rh17p15n1t4 Rh17p15n1n3 h17p 9733.97795536563
* h17 input 16 w=-0.153994690926048 w-  bank=n alpha=1 R=216457.6787218 G_phys=4.61984072778143e-06 G_eff=4.61984072778143e-06
* tiled Rh17n16n1 series x4  each=54114.41968045
Rh17n16n1t1 in16 Rh17n16n1n1 54143.8969730026
Rh17n16n1t2 Rh17n16n1n1 Rh17n16n1n2 54292.7027198552
Rh17n16n1t3 Rh17n16n1n2 Rh17n16n1n3 54287.340393792
Rh17n16n1t4 Rh17n16n1n3 h17n 54096.2801650378
* h17 bias=+0.0931053836114148 b+  bank=n alpha=1 R=358017.249275869 G_phys=2.79316150834244e-06 G_eff=2.79316150834244e-06
* tiled Rh17bpn1 series x4  each=89504.3123189674
Rh17bpn1t1 vref Rh17bpn1n1 89297.8781306708
Rh17bpn1t2 Rh17bpn1n1 Rh17bpn1n2 89877.600712866
Rh17bpn1t3 Rh17bpn1n2 Rh17bpn1n3 89081.0204069596
Rh17bpn1t4 Rh17bpn1n3 h17p 89398.7642368369
Vh17p h17p 0 DC 0
Vh17n h17n 0 DC 0
Fh17p 0 h17d Vh17p 1.001
Fh17n h17d 0 Vh17n 1.001
* ratiometric I-to-V: V = I * R_IV,  R_IV=33333.3333333333 (weight ~ R_IV / R_w)
* tiled Rh17iv series x4  each=8333.33333333333
Rh17ivt1 h17d Rh17ivn1 8326.23577559302
Rh17ivt2 Rh17ivn1 Rh17ivn2 8344.4949975965
Rh17ivt3 Rh17ivn2 Rh17ivn3 8322.95821076708
Rh17ivt4 Rh17ivn3 0 8372.99273612957
Bh17leak 0 h17d I = 1e-08
Eh17sc h17raw 0 h17d 0 1
Eh17lin h17lin 0 h17raw 0 1
* direct bounded ReLU: y=max(0, min(15, v(h17lin))) no high-gain op-amp loop
Bh17relu h17y 0 V = max(0, min(15, (0.001) + v(h17lin)))
Eh17 h17buf 0 h17y 0 1

* h18 input 1 w=+0.00309692999044255 w+  bank=f alpha=0.001 R=10763.3473911917 G_phys=9.29078997132766e-05 G_eff=9.29078997132766e-08
* tiled Rh18p1f1 series x4  each=2690.83684779794
Rh18p1f1t1 inf1 Rh18p1f1n1 2695.91377881416
Rh18p1f1t2 Rh18p1f1n1 Rh18p1f1n2 2692.13162675763
Rh18p1f1t3 Rh18p1f1n2 Rh18p1f1n3 2696.082878033
Rh18p1f1t4 Rh18p1f1n3 h18p 2679.71429709749
* h18 input 2 w=-0.290006429631547 w-  bank=n alpha=1 R=114939.98038486 G_phys=8.70019288894641e-06 G_eff=8.70019288894641e-06
* tiled Rh18n2n1 series x4  each=28734.995096215
Rh18n2n1t1 in2 Rh18n2n1n1 28760.6660876231
Rh18n2n1t2 Rh18n2n1n1 Rh18n2n1n2 28755.4556588504
Rh18n2n1t3 Rh18n2n1n2 Rh18n2n1n3 28769.779721137
Rh18n2n1t4 Rh18n2n1n3 h18n 28808.5227290949
* h18 input 3 w=+0.161902441115013 w+  bank=n alpha=1 R=205885.304160755 G_phys=4.8570732334504e-06 G_eff=4.8570732334504e-06
* tiled Rh18p3n1 series x4  each=51471.3260401888
Rh18p3n1t1 in3 Rh18p3n1n1 51456.9461633749
Rh18p3n1t2 Rh18p3n1n1 Rh18p3n1n2 51262.8634031742
Rh18p3n1t3 Rh18p3n1n2 Rh18p3n1n3 51720.003623954
Rh18p3n1t4 Rh18p3n1n3 h18p 51408.0175233845
* h18 input 4 w=-0.201165440039706 w-  bank=n alpha=1 R=165701.093223339 G_phys=6.03496320119118e-06 G_eff=6.03496320119118e-06
* tiled Rh18n4n1 series x4  each=41425.2733058348
Rh18n4n1t1 in4 Rh18n4n1n1 41372.4624522534
Rh18n4n1t2 Rh18n4n1n1 Rh18n4n1n2 41238.3353471241
Rh18n4n1t3 Rh18n4n1n2 Rh18n4n1n3 41619.5053682189
Rh18n4n1t4 Rh18n4n1n3 h18n 41396.5799744508
* h18 input 5 w=+0.167521926893116 w+  bank=n alpha=1 R=198978.927424831 G_phys=5.02565780679349e-06 G_eff=5.02565780679349e-06
* tiled Rh18p5n1 series x4  each=49744.7318562079
Rh18p5n1t1 in5 Rh18p5n1n1 49749.8346810269
Rh18p5n1t2 Rh18p5n1n1 Rh18p5n1n2 49823.3457936947
Rh18p5n1t3 Rh18p5n1n2 Rh18p5n1n3 49831.4495308596
Rh18p5n1t4 Rh18p5n1n3 h18p 49631.1569399228
* h18 input 6 w=+0.306365656745506 w+  bank=n alpha=1 R=108802.447661498 G_phys=9.19096970236517e-06 G_eff=9.19096970236517e-06
* tiled Rh18p6n1 series x4  each=27200.6119153745
Rh18p6n1t1 in6 Rh18p6n1n1 27187.3889880154
Rh18p6n1t2 Rh18p6n1n1 Rh18p6n1n2 27215.7970449302
Rh18p6n1t3 Rh18p6n1n2 Rh18p6n1n3 27087.7477447927
Rh18p6n1t4 Rh18p6n1n3 h18p 27277.7108048449
* h18 input 7 w=+0.567135277617062 w+  bank=n alpha=1 R=58774.9248704654 G_phys=1.70140583285119e-05 G_eff=1.70140583285119e-05
* tiled Rh18p7n1 series x4  each=14693.7312176163
Rh18p7n1t1 in7 Rh18p7n1n1 14752.0961374903
Rh18p7n1t2 Rh18p7n1n1 Rh18p7n1n2 14758.7062394639
Rh18p7n1t3 Rh18p7n1n2 Rh18p7n1n3 14722.9393168945
Rh18p7n1t4 Rh18p7n1n3 h18p 14701.7165358853
* h18 input 8 w=+0.27754647202065 w+  bank=n alpha=1 R=120100.007363283 G_phys=8.3263941606195e-06 G_eff=8.3263941606195e-06
* tiled Rh18p8n1 series x4  each=30025.0018408208
Rh18p8n1t1 in8 Rh18p8n1n1 30137.6191018181
Rh18p8n1t2 Rh18p8n1n1 Rh18p8n1n2 30123.017976579
Rh18p8n1t3 Rh18p8n1n2 Rh18p8n1n3 29996.7917210141
Rh18p8n1t4 Rh18p8n1n3 h18p 29922.7163823531
* h18 input 9 w=-0.295299170614896 w-  bank=n alpha=1 R=112879.874548662 G_phys=8.85897511844687e-06 G_eff=8.85897511844687e-06
* tiled Rh18n9n1 series x4  each=28219.9686371655
Rh18n9n1t1 in9 Rh18n9n1n1 28094.8216148093
Rh18n9n1t2 Rh18n9n1n1 Rh18n9n1n2 28135.5707239853
Rh18n9n1t3 Rh18n9n1n2 Rh18n9n1n3 28185.3555707096
Rh18n9n1t4 Rh18n9n1n3 h18n 28338.4376557888
* h18 input 10 w=+0.627786354607437 w+  bank=n alpha=1 R=53096.6197157584 G_phys=1.88335906382231e-05 G_eff=1.88335906382231e-05
* tiled Rh18p10n1 series x4  each=13274.1549289396
Rh18p10n1t1 in10 Rh18p10n1n1 13220.7490230533
Rh18p10n1t2 Rh18p10n1n1 Rh18p10n1n2 13285.1494281469
Rh18p10n1t3 Rh18p10n1n2 Rh18p10n1n3 13252.4435619562
Rh18p10n1t4 Rh18p10n1n3 h18p 13279.7820634228
* h18 input 11 w=+0.158870042328046 w+  bank=n alpha=1 R=209815.09694889 G_phys=4.76610126984139e-06 G_eff=4.76610126984139e-06
* tiled Rh18p11n1 series x4  each=52453.7742372226
Rh18p11n1t1 in11 Rh18p11n1n1 52439.6131854788
Rh18p11n1t2 Rh18p11n1n1 Rh18p11n1n2 52657.3838152545
Rh18p11n1t3 Rh18p11n1n2 Rh18p11n1n3 52419.0933597069
Rh18p11n1t4 Rh18p11n1n3 h18p 52630.5174849671
* h18 input 12 w=+0.503831351799562 w+  bank=n alpha=1 R=66159.704461175 G_phys=1.51149405539869e-05 G_eff=1.51149405539869e-05
* tiled Rh18p12n1 series x4  each=16539.9261152938
Rh18p12n1t1 in12 Rh18p12n1n1 16606.7328693937
Rh18p12n1t2 Rh18p12n1n1 Rh18p12n1n2 16470.8225923358
Rh18p12n1t3 Rh18p12n1n2 Rh18p12n1n3 16536.7056732819
Rh18p12n1t4 Rh18p12n1n3 h18p 16482.3152071566
* h18 input 13 w=+0.0259448474340262 w+  bank=f alpha=0.001 R=1284.77661771166 G_phys=0.000778345423020786 G_eff=7.78345423020786e-07
* tiled Rh18p13f1 parallel x4  each=5139.10647084666
Rh18p13f1t1 inf13 h18p 5124.22738271327
Rh18p13f1t2 inf13 h18p 5152.59517389244
Rh18p13f1t3 inf13 h18p 5132.61044157431
Rh18p13f1t4 inf13 h18p 5122.55538384507
* h18 input 14 w=-0.0445667146819355 w-  bank=n alpha=1 R=747942.350501428 G_phys=1.33700144045806e-06 G_eff=1.33700144045806e-06
* tiled Rh18n14n1 series x4  each=186985.587625357
Rh18n14n1t1 in14 Rh18n14n1n1 186501.895567546
Rh18n14n1t2 Rh18n14n1n1 Rh18n14n1n2 186638.808110905
Rh18n14n1t3 Rh18n14n1n2 Rh18n14n1n3 186173.735736314
Rh18n14n1t4 Rh18n14n1n3 h18n 187821.110468061
* h18 input 15 w=-0.425048584977393 w-  bank=n alpha=1 R=78422.4074880905 G_phys=1.27514575493218e-05 G_eff=1.27514575493218e-05
* tiled Rh18n15n1 series x4  each=19605.6018720226
Rh18n15n1t1 in15 Rh18n15n1n1 19662.4372735187
Rh18n15n1t2 Rh18n15n1n1 Rh18n15n1n2 19514.9414451241
Rh18n15n1t3 Rh18n15n1n2 Rh18n15n1n3 19574.2160798485
Rh18n15n1t4 Rh18n15n1n3 h18n 19549.3620751708
* h18 input 16 w=-0.290071708244206 w-  bank=n alpha=1 R=114914.113944786 G_phys=8.70215124732617e-06 G_eff=8.70215124732617e-06
* tiled Rh18n16n1 series x4  each=28728.5284861965
Rh18n16n1t1 in16 Rh18n16n1n1 28637.2796637684
Rh18n16n1t2 Rh18n16n1n1 Rh18n16n1n2 28656.7176422439
Rh18n16n1t3 Rh18n16n1n2 Rh18n16n1n3 28687.1793453528
Rh18n16n1t4 Rh18n16n1n3 h18n 28846.1086249692
* h18 bias=+0.103219643590821 b+  bank=n alpha=1 R=322935.946819115 G_phys=3.09658930772463e-06 G_eff=3.09658930772463e-06
* tiled Rh18bpn1 series x4  each=80733.9867047787
Rh18bpn1t1 vref Rh18bpn1n1 80568.4311489459
Rh18bpn1t2 Rh18bpn1n1 Rh18bpn1n2 80747.0510422841
Rh18bpn1t3 Rh18bpn1n2 Rh18bpn1n3 81109.3395591595
Rh18bpn1t4 Rh18bpn1n3 h18p 80548.8740727766
Vh18p h18p 0 DC 0
Vh18n h18n 0 DC 0
Fh18p 0 h18d Vh18p 1.001
Fh18n h18d 0 Vh18n 1.001
* ratiometric I-to-V: V = I * R_IV,  R_IV=33333.3333333333 (weight ~ R_IV / R_w)
* tiled Rh18iv series x4  each=8333.33333333333
Rh18ivt1 h18d Rh18ivn1 8339.08632375983
Rh18ivt2 Rh18ivn1 Rh18ivn2 8296.19767988712
Rh18ivt3 Rh18ivn2 Rh18ivn3 8336.6240362844
Rh18ivt4 Rh18ivn3 0 8320.2237307158
Bh18leak 0 h18d I = 1e-08
Eh18sc h18raw 0 h18d 0 1
Eh18lin h18lin 0 h18raw 0 1
* direct bounded ReLU: y=max(0, min(15, v(h18lin))) no high-gain op-amp loop
Bh18relu h18y 0 V = max(0, min(15, (0.001) + v(h18lin)))
Eh18 h18buf 0 h18y 0 1

* h19 input 1 w=+0.361917529899694 w+  bank=n alpha=1 R=92102.0138001377 G_phys=1.08575258969908e-05 G_eff=1.08575258969908e-05
* tiled Rh19p1n1 series x4  each=23025.5034500344
Rh19p1n1t1 in1 Rh19p1n1n1 22980.0731806549
Rh19p1n1t2 Rh19p1n1n1 Rh19p1n1n2 23047.9679596469
Rh19p1n1t3 Rh19p1n1n2 Rh19p1n1n3 23104.1600894605
Rh19p1n1t4 Rh19p1n1n3 h19p 22990.7933052702
* h19 input 2 w=+0.460196491117441 w+  bank=n alpha=1 R=72432.8281000013 G_phys=1.38058947335232e-05 G_eff=1.38058947335232e-05
* tiled Rh19p2n1 series x4  each=18108.2070250003
Rh19p2n1t1 in2 Rh19p2n1n1 18100.9206099871
Rh19p2n1t2 Rh19p2n1n1 Rh19p2n1n2 18148.8258597866
Rh19p2n1t3 Rh19p2n1n2 Rh19p2n1n3 18019.182968074
Rh19p2n1t4 Rh19p2n1n3 h19p 18076.8499207414
* h19 input 3 w=+0.284766719035728 w+  bank=n alpha=1 R=117054.877220927 G_phys=8.54300157107185e-06 G_eff=8.54300157107185e-06
* tiled Rh19p3n1 series x4  each=29263.7193052317
Rh19p3n1t1 in3 Rh19p3n1n1 29170.0468995004
Rh19p3n1t2 Rh19p3n1n1 Rh19p3n1n2 29177.5081425138
Rh19p3n1t3 Rh19p3n1n2 Rh19p3n1n3 29230.3065829022
Rh19p3n1t4 Rh19p3n1n3 h19p 29330.5123493297
* h19 input 4 w=-0.664899666016021 w-  bank=n alpha=1 R=50132.8772400529 G_phys=1.99469899804806e-05 G_eff=1.99469899804806e-05
* tiled Rh19n4n1 series x4  each=12533.2193100132
Rh19n4n1t1 in4 Rh19n4n1n1 12560.8526613993
Rh19n4n1t2 Rh19n4n1n1 Rh19n4n1n2 12485.4141909178
Rh19n4n1t3 Rh19n4n1n2 Rh19n4n1n3 12521.4398447591
Rh19n4n1t4 Rh19n4n1n3 h19n 12558.0550459167
* h19 input 5 w=+0.507213486118456 w+  bank=n alpha=1 R=65718.5470134534 G_phys=1.52164045835537e-05 G_eff=1.52164045835537e-05
* tiled Rh19p5n1 series x4  each=16429.6367533633
Rh19p5n1t1 in5 Rh19p5n1n1 16351.0186578846
Rh19p5n1t2 Rh19p5n1n1 Rh19p5n1n2 16443.3800056801
Rh19p5n1t3 Rh19p5n1n2 Rh19p5n1n3 16430.4844666278
Rh19p5n1t4 Rh19p5n1n3 h19p 16438.5555460512
* h19 input 6 w=+0.130688397719858 w+  bank=n alpha=1 R=255059.622085094 G_phys=3.92065193159573e-06 G_eff=3.92065193159573e-06
* tiled Rh19p6n1 series x4  each=63764.9055212735
Rh19p6n1t1 in6 Rh19p6n1n1 63906.3534965292
Rh19p6n1t2 Rh19p6n1n1 Rh19p6n1n2 63498.5527709018
Rh19p6n1t3 Rh19p6n1n2 Rh19p6n1n3 63953.2786873708
Rh19p6n1t4 Rh19p6n1n3 h19p 63916.6683115089
* h19 input 7 w=+0.0897047942241856 w+  bank=n alpha=1 R=371589.206815729 G_phys=2.69114382672557e-06 G_eff=2.69114382672557e-06
* tiled Rh19p7n1 series x4  each=92897.3017039323
Rh19p7n1t1 in7 Rh19p7n1n1 93124.5795400545
Rh19p7n1t2 Rh19p7n1n1 Rh19p7n1n2 92779.2914895932
Rh19p7n1t3 Rh19p7n1n2 Rh19p7n1n3 92560.9990256687
Rh19p7n1t4 Rh19p7n1n3 h19p 93314.2701209616
* h19 input 8 w=+0.0897866911799249 w+  bank=n alpha=1 R=371250.269892853 G_phys=2.69360073539775e-06 G_eff=2.69360073539775e-06
* tiled Rh19p8n1 series x4  each=92812.5674732132
Rh19p8n1t1 in8 Rh19p8n1n1 92774.8971546221
Rh19p8n1t2 Rh19p8n1n1 Rh19p8n1n2 92915.3623213647
Rh19p8n1t3 Rh19p8n1n2 Rh19p8n1n3 92894.8494012112
Rh19p8n1t4 Rh19p8n1n3 h19p 92831.909441839
* h19 input 9 w=-0.272382660879323 w-  bank=n alpha=1 R=122376.854773812 G_phys=8.17147982637969e-06 G_eff=8.17147982637969e-06
* tiled Rh19n9n1 series x4  each=30594.2136934529
Rh19n9n1t1 in9 Rh19n9n1n1 30687.488114117
Rh19n9n1t2 Rh19n9n1n1 Rh19n9n1n2 30587.5556243069
Rh19n9n1t3 Rh19n9n1n2 Rh19n9n1n3 30496.2641541033
Rh19n9n1t4 Rh19n9n1n3 h19n 30589.6697906602
* h19 input 10 w=+0.0908546616405757 w+  bank=n alpha=1 R=366886.329566679 G_phys=2.72563984921727e-06 G_eff=2.72563984921727e-06
* tiled Rh19p10n1 series x4  each=91721.5823916697
Rh19p10n1t1 in10 Rh19p10n1n1 91633.5950444331
Rh19p10n1t2 Rh19p10n1n1 Rh19p10n1n2 91678.5931400808
Rh19p10n1t3 Rh19p10n1n2 Rh19p10n1n3 91849.8723941758
Rh19p10n1t4 Rh19p10n1n3 h19p 92092.820904186
* h19 input 11 w=-0.0411180740799587 w-  bank=n alpha=1 R=810673.507434053 G_phys=1.23354222239876e-06 G_eff=1.23354222239876e-06
* tiled Rh19n11n1 series x4  each=202668.376858513
Rh19n11n1t1 in11 Rh19n11n1n1 203604.99657497
Rh19n11n1t2 Rh19n11n1n1 Rh19n11n1n2 203607.994149008
Rh19n11n1t3 Rh19n11n1n2 Rh19n11n1n3 201710.342423528
Rh19n11n1t4 Rh19n11n1n3 h19n 202335.172313489
* h19 input 12 w=-0.14910928160707 w-  bank=n alpha=1 R=223549.687679219 G_phys=4.47327844821211e-06 G_eff=4.47327844821211e-06
* tiled Rh19n12n1 series x4  each=55887.4219198048
Rh19n12n1t1 in12 Rh19n12n1n1 56127.7868294376
Rh19n12n1t2 Rh19n12n1n1 Rh19n12n1n2 56027.0998305867
Rh19n12n1t3 Rh19n12n1n2 Rh19n12n1n3 56161.4660444833
Rh19n12n1t4 Rh19n12n1n3 h19n 55939.7924072966
* h19 input 13 w=-0.0351824330179761 w-  bank=n alpha=1 R=947442.529523243 G_phys=1.05547299053928e-06 G_eff=1.05547299053928e-06
* tiled Rh19n13n1 series x4  each=236860.632380811
Rh19n13n1t1 in13 Rh19n13n1n1 236408.81865075
Rh19n13n1t2 Rh19n13n1n1 Rh19n13n1n2 237834.149246658
Rh19n13n1t3 Rh19n13n1n2 Rh19n13n1n3 236019.576209774
Rh19n13n1t4 Rh19n13n1n3 h19n 236809.144908428
* h19 input 14 w=+0.491588757414346 w+  bank=n alpha=1 R=67807.3548887889 G_phys=1.47476627224304e-05 G_eff=1.47476627224304e-05
* tiled Rh19p14n1 series x4  each=16951.8387221972
Rh19p14n1t1 in14 Rh19p14n1n1 16903.9664050637
Rh19p14n1t2 Rh19p14n1n1 Rh19p14n1n2 16931.0035395908
Rh19p14n1t3 Rh19p14n1n2 Rh19p14n1n3 16948.3840845534
Rh19p14n1t4 Rh19p14n1n3 h19p 17020.969473977
* h19 input 15 w=-0.0385925197286318 w-  bank=n alpha=1 R=863725.239184197 G_phys=1.15777559185895e-06 G_eff=1.15777559185895e-06
* tiled Rh19n15n1 series x4  each=215931.309796049
Rh19n15n1t1 in15 Rh19n15n1n1 216720.359650875
Rh19n15n1t2 Rh19n15n1n1 Rh19n15n1n2 216161.457206448
Rh19n15n1t3 Rh19n15n1n2 Rh19n15n1n3 216319.366879522
Rh19n15n1t4 Rh19n15n1n3 h19n 216789.688792185
* h19 input 16 w=-0.690622583753164 w-  bank=n alpha=1 R=48265.628894127 G_phys=2.07186775125949e-05 G_eff=2.07186775125949e-05
* tiled Rh19n16n1 series x4  each=12066.4072235317
Rh19n16n1t1 in16 Rh19n16n1n1 12072.8501051625
Rh19n16n1t2 Rh19n16n1n1 Rh19n16n1n2 12013.971442271
Rh19n16n1t3 Rh19n16n1n2 Rh19n16n1n3 12069.5571649955
Rh19n16n1t4 Rh19n16n1n3 h19n 12097.55694159
* h19 bias=+0.0200863362195416 b+  bank=f alpha=0.001 R=1659.50290630424 G_phys=0.000602590086586248 G_eff=6.02590086586248e-07
* tiled Rh19bpf1 parallel x4  each=6638.01162521694
Rh19bpf1t1 vreff h19p 6639.01245376325
Rh19bpf1t2 vreff h19p 6628.07170267077
Rh19bpf1t3 vreff h19p 6609.00580706552
Rh19bpf1t4 vreff h19p 6610.48580546964
Vh19p h19p 0 DC 0
Vh19n h19n 0 DC 0
Fh19p 0 h19d Vh19p 1.001
Fh19n h19d 0 Vh19n 1.001
* ratiometric I-to-V: V = I * R_IV,  R_IV=33333.3333333333 (weight ~ R_IV / R_w)
* tiled Rh19iv series x4  each=8333.33333333333
Rh19ivt1 h19d Rh19ivn1 8339.46992263405
Rh19ivt2 Rh19ivn1 Rh19ivn2 8349.60536716232
Rh19ivt3 Rh19ivn2 Rh19ivn3 8336.19559371287
Rh19ivt4 Rh19ivn3 0 8314.46906681695
Bh19leak 0 h19d I = 1e-08
Eh19sc h19raw 0 h19d 0 1
Eh19lin h19lin 0 h19raw 0 1
* direct bounded ReLU: y=max(0, min(15, v(h19lin))) no high-gain op-amp loop
Bh19relu h19y 0 V = max(0, min(15, (0.001) + v(h19lin)))
Eh19 h19buf 0 h19y 0 1

* h20 input 1 w=-0.0810043123301717 w-  bank=n alpha=1 R=411500.72600416 G_phys=2.43012936990515e-06 G_eff=2.43012936990515e-06
* tiled Rh20n1n1 series x4  each=102875.18150104
Rh20n1n1t1 in1 Rh20n1n1n1 103086.689179575
Rh20n1n1t2 Rh20n1n1n1 Rh20n1n1n2 102740.357258184
Rh20n1n1t3 Rh20n1n1n2 Rh20n1n1n3 102380.419416988
Rh20n1n1t4 Rh20n1n1n3 h20n 102695.266291625
* h20 input 2 w=+0.646296718361532 w+  bank=n alpha=1 R=51575.8975503369 G_phys=1.9388901550846e-05 G_eff=1.9388901550846e-05
* tiled Rh20p2n1 series x4  each=12893.9743875842
Rh20p2n1t1 in2 Rh20p2n1n1 12915.0423337542
Rh20p2n1t2 Rh20p2n1n1 Rh20p2n1n2 12913.178147056
Rh20p2n1t3 Rh20p2n1n2 Rh20p2n1n3 12916.0469020086
Rh20p2n1t4 Rh20p2n1n3 h20p 12835.4804330806
* h20 input 3 w=-0.000929252010170944 w-  bank=f alpha=0.001 R=35871.1447147705 G_phys=2.78775603051283e-05 G_eff=2.78775603051283e-08
* tiled Rh20n3f1 series x4  each=8967.78617869263
Rh20n3f1t1 inf3 Rh20n3f1n1 9006.82869904882
Rh20n3f1t2 Rh20n3f1n1 Rh20n3f1n2 8974.00831243028
Rh20n3f1t3 Rh20n3f1n2 Rh20n3f1n3 8930.48112733928
Rh20n3f1t4 Rh20n3f1n3 h20n 8989.55022980328
* h20 input 4 w=+0.269987692172837 w+  bank=n alpha=1 R=123462.418101617 G_phys=8.09963076518511e-06 G_eff=8.09963076518511e-06
* tiled Rh20p4n1 series x4  each=30865.6045254041
Rh20p4n1t1 in4 Rh20p4n1n1 30803.2428559763
Rh20p4n1t2 Rh20p4n1n1 Rh20p4n1n2 30743.4710619489
Rh20p4n1t3 Rh20p4n1n2 Rh20p4n1n3 30973.3491358353
Rh20p4n1t4 Rh20p4n1n3 h20p 30723.8110204743
* h20 input 5 w=+0.140155013181344 w+  bank=n alpha=1 R=237831.901811489 G_phys=4.20465039544031e-06 G_eff=4.20465039544031e-06
* tiled Rh20p5n1 series x4  each=59457.9754528723
Rh20p5n1t1 in5 Rh20p5n1n1 59573.9414660899
Rh20p5n1t2 Rh20p5n1n1 Rh20p5n1n2 59747.7523163882
Rh20p5n1t3 Rh20p5n1n2 Rh20p5n1n3 59569.9612793075
Rh20p5n1t4 Rh20p5n1n3 h20p 59249.34129084
* h20 input 6 w=+0.15481044132605 w+  bank=n alpha=1 R=215317.087451028 G_phys=4.6443132397815e-06 G_eff=4.6443132397815e-06
* tiled Rh20p6n1 series x4  each=53829.271862757
Rh20p6n1t1 in6 Rh20p6n1n1 53621.640519186
Rh20p6n1t2 Rh20p6n1n1 Rh20p6n1n2 53629.0552923581
Rh20p6n1t3 Rh20p6n1n2 Rh20p6n1n3 53593.3573795164
Rh20p6n1t4 Rh20p6n1n3 h20p 53883.1538202095
* h20 input 7 w=-0.803119096824844 w-  bank=n alpha=1 R=41504.8446302892 G_phys=2.40935729047453e-05 G_eff=2.40935729047453e-05
* tiled Rh20n7n1 series x4  each=10376.2111575723
Rh20n7n1t1 in7 Rh20n7n1n1 10405.5741995987
Rh20n7n1t2 Rh20n7n1n1 Rh20n7n1n2 10343.6520276359
Rh20n7n1t3 Rh20n7n1n2 Rh20n7n1n3 10356.4011458229
Rh20n7n1t4 Rh20n7n1n3 h20n 10372.2511561458
* h20 input 8 w=+0.12095822380885 w+  bank=n alpha=1 R=275577.238849092 G_phys=3.62874671426549e-06 G_eff=3.62874671426549e-06
* tiled Rh20p8n1 series x4  each=68894.3097122731
Rh20p8n1t1 in8 Rh20p8n1n1 68584.3111453611
Rh20p8n1t2 Rh20p8n1n1 Rh20p8n1n2 68754.0272480955
Rh20p8n1t3 Rh20p8n1n2 Rh20p8n1n3 69170.9764426932
Rh20p8n1t4 Rh20p8n1n3 h20p 69044.1093350342
* h20 input 9 w=+0.307944073046154 w+  bank=n alpha=1 R=108244.763419549 G_phys=9.23832219138461e-06 G_eff=9.23832219138461e-06
* tiled Rh20p9n1 series x4  each=27061.1908548873
Rh20p9n1t1 in9 Rh20p9n1n1 27185.5063221823
Rh20p9n1t2 Rh20p9n1n1 Rh20p9n1n2 27094.7007042419
Rh20p9n1t3 Rh20p9n1n2 Rh20p9n1n3 26927.7918799828
Rh20p9n1t4 Rh20p9n1n3 h20p 26927.8102306008
* h20 input 10 w=+0.100067069291622 w+  bank=n alpha=1 R=333109.918870425 G_phys=3.00201207874865e-06 G_eff=3.00201207874865e-06
* tiled Rh20p10n1 series x4  each=83277.4797176063
Rh20p10n1t1 in10 Rh20p10n1n1 83627.8096743085
Rh20p10n1t2 Rh20p10n1n1 Rh20p10n1n2 82970.4781066613
Rh20p10n1t3 Rh20p10n1n2 Rh20p10n1n3 83210.2747778913
Rh20p10n1t4 Rh20p10n1n3 h20p 83172.6415097455
* h20 input 11 w=+0.376050768766317 w+  bank=n alpha=1 R=88640.513733525 G_phys=1.12815230629895e-05 G_eff=1.12815230629895e-05
* tiled Rh20p11n1 series x4  each=22160.1284333812
Rh20p11n1t1 in11 Rh20p11n1n1 22259.0235389715
Rh20p11n1t2 Rh20p11n1n1 Rh20p11n1n2 22257.2089530298
Rh20p11n1t3 Rh20p11n1n2 Rh20p11n1n3 22131.940392377
Rh20p11n1t4 Rh20p11n1n3 h20p 22156.9784994567
* h20 input 12 w=-0.859853426992325 w-  bank=n alpha=1 R=38766.2970070722 G_phys=2.57956028097698e-05 G_eff=2.57956028097698e-05
* tiled Rh20n12n1 series x4  each=9691.57425176804
Rh20n12n1t1 in12 Rh20n12n1n1 9736.35897900356
Rh20n12n1t2 Rh20n12n1n1 Rh20n12n1n2 9673.56345050702
Rh20n12n1t3 Rh20n12n1n2 Rh20n12n1n3 9713.32028004845
Rh20n12n1t4 Rh20n12n1n3 h20n 9654.70815630262
* h20 input 13 w=+0.0677970111280841 w+  bank=n alpha=1 R=491663.758898737 G_phys=2.03391033384252e-06 G_eff=2.03391033384252e-06
* tiled Rh20p13n1 series x4  each=122915.939724684
Rh20p13n1t1 in13 Rh20p13n1n1 122476.136330826
Rh20p13n1t2 Rh20p13n1n1 Rh20p13n1n2 123327.088383343
Rh20p13n1t3 Rh20p13n1n2 Rh20p13n1n3 122941.11313932
Rh20p13n1t4 Rh20p13n1n3 h20p 122941.102976963
* h20 input 14 w=-0.43012675419833 w-  bank=n alpha=1 R=77496.5356327578 G_phys=1.29038026259499e-05 G_eff=1.29038026259499e-05
* tiled Rh20n14n1 series x4  each=19374.1339081895
Rh20n14n1t1 in14 Rh20n14n1n1 19398.9044744908
Rh20n14n1t2 Rh20n14n1n1 Rh20n14n1n2 19442.8009497646
Rh20n14n1t3 Rh20n14n1n2 Rh20n14n1n3 19330.8010667117
Rh20n14n1t4 Rh20n14n1n3 h20n 19430.7321977026
* h20 input 15 w=-0.0800571778528839 w-  bank=n alpha=1 R=416369.078043045 G_phys=2.40171533558652e-06 G_eff=2.40171533558652e-06
* tiled Rh20n15n1 series x4  each=104092.269510761
Rh20n15n1t1 in15 Rh20n15n1n1 104558.936962377
Rh20n15n1t2 Rh20n15n1n1 Rh20n15n1n2 104328.536045243
Rh20n15n1t3 Rh20n15n1n2 Rh20n15n1n3 104092.124467003
Rh20n15n1t4 Rh20n15n1n3 h20n 103678.704472968
* h20 input 16 w=-0.127529601563162 w-  bank=n alpha=1 R=261377.224775726 G_phys=3.82588804689485e-06 G_eff=3.82588804689485e-06
* tiled Rh20n16n1 series x4  each=65344.3061939316
Rh20n16n1t1 in16 Rh20n16n1n1 65423.1040760338
Rh20n16n1t2 Rh20n16n1n1 Rh20n16n1n2 65317.0245099854
Rh20n16n1t3 Rh20n16n1n2 Rh20n16n1n3 65192.4744112927
Rh20n16n1t4 Rh20n16n1n3 h20n 65515.9146220129
* h20 bias=+0.0269672795638665 b+  bank=f alpha=0.001 R=1236.06584989005 G_phys=0.000809018386915995 G_eff=8.09018386915995e-07
* tiled Rh20bpf1 parallel x4  each=4944.26339956022
Rh20bpf1t1 vreff h20p 4959.08952751539
Rh20bpf1t2 vreff h20p 4935.10992052456
Rh20bpf1t3 vreff h20p 4961.32051845141
Rh20bpf1t4 vreff h20p 4958.32127131924
Vh20p h20p 0 DC 0
Vh20n h20n 0 DC 0
Fh20p 0 h20d Vh20p 1.001
Fh20n h20d 0 Vh20n 1.001
* ratiometric I-to-V: V = I * R_IV,  R_IV=33333.3333333333 (weight ~ R_IV / R_w)
* tiled Rh20iv series x4  each=8333.33333333333
Rh20ivt1 h20d Rh20ivn1 8364.15096402101
Rh20ivt2 Rh20ivn1 Rh20ivn2 8338.69176269268
Rh20ivt3 Rh20ivn2 Rh20ivn3 8353.8158916794
Rh20ivt4 Rh20ivn3 0 8293.49973507432
Bh20leak 0 h20d I = 1e-08
Eh20sc h20raw 0 h20d 0 1
Eh20lin h20lin 0 h20raw 0 1
* direct bounded ReLU: y=max(0, min(15, v(h20lin))) no high-gain op-amp loop
Bh20relu h20y 0 V = max(0, min(15, (0.001) + v(h20lin)))
Eh20 h20buf 0 h20y 0 1

* h21 input 1 w=-0.00681344895090886 w-  bank=f alpha=0.001 R=4892.28488736045 G_phys=0.000204403468527266 G_eff=2.04403468527266e-07
* tiled Rh21n1f1 series x4  each=1223.07122184011
Rh21n1f1t1 inf1 Rh21n1f1n1 1228.96245589492
Rh21n1f1t2 Rh21n1f1n1 Rh21n1f1n2 1224.96818705616
Rh21n1f1t3 Rh21n1f1n2 Rh21n1f1n3 1226.89527949266
Rh21n1f1t4 Rh21n1f1n3 h21n 1218.72636476401
* h21 input 2 w=+0.17215275761211 w+  bank=n alpha=1 R=193626.484964238 G_phys=5.1645827283633e-06 G_eff=5.1645827283633e-06
* tiled Rh21p2n1 series x4  each=48406.6212410595
Rh21p2n1t1 in2 Rh21p2n1n1 48518.4828601617
Rh21p2n1t2 Rh21p2n1n1 Rh21p2n1n2 48378.5597527456
Rh21p2n1t3 Rh21p2n1n2 Rh21p2n1n3 48515.756089783
Rh21p2n1t4 Rh21p2n1n3 h21p 48419.6441956765
* h21 input 3 w=-0.241244992284912 w-  bank=n alpha=1 R=138172.12542993 G_phys=7.23734976854735e-06 G_eff=7.23734976854735e-06
* tiled Rh21n3n1 series x4  each=34543.0313574825
Rh21n3n1t1 in3 Rh21n3n1n1 34690.3029120471
Rh21n3n1t2 Rh21n3n1n1 Rh21n3n1n2 34499.99855802
Rh21n3n1t3 Rh21n3n1n2 Rh21n3n1n3 34450.6193291687
Rh21n3n1t4 Rh21n3n1n3 h21n 34589.4076195432
* h21 input 4 w=-0.253516997925259 w-  bank=n alpha=1 R=131483.622818698 G_phys=7.60550993775776e-06 G_eff=7.60550993775776e-06
* tiled Rh21n4n1 series x4  each=32870.9057046745
Rh21n4n1t1 in4 Rh21n4n1n1 32899.7111619519
Rh21n4n1t2 Rh21n4n1n1 Rh21n4n1n2 32805.5668723436
Rh21n4n1t3 Rh21n4n1n2 Rh21n4n1n3 32787.454273667
Rh21n4n1t4 Rh21n4n1n3 h21n 32714.2257337516
* h21 input 5 w=+0.732528033504134 w+  bank=n alpha=1 R=45504.515607245 G_phys=2.1975841005124e-05 G_eff=2.1975841005124e-05
* tiled Rh21p5n1 series x4  each=11376.1289018112
Rh21p5n1t1 in5 Rh21p5n1n1 11375.9793011722
Rh21p5n1t2 Rh21p5n1n1 Rh21p5n1n2 11344.4035819778
Rh21p5n1t3 Rh21p5n1n2 Rh21p5n1n3 11353.6154082825
Rh21p5n1t4 Rh21p5n1n3 h21p 11341.0576059637
* h21 input 6 w=-0.335745026911547 w-  bank=n alpha=1 R=99281.6889648676 G_phys=1.00723508073464e-05 G_eff=1.00723508073464e-05
* tiled Rh21n6n1 series x4  each=24820.4222412169
Rh21n6n1t1 in6 Rh21n6n1n1 24708.6582097909
Rh21n6n1t2 Rh21n6n1n1 Rh21n6n1n2 24864.463973221
Rh21n6n1t3 Rh21n6n1n2 Rh21n6n1n3 24796.5881297799
Rh21n6n1t4 Rh21n6n1n3 h21n 24901.2226016043
* h21 input 7 w=-0.133397447206163 w-  bank=n alpha=1 R=249879.844265815 G_phys=4.00192341618489e-06 G_eff=4.00192341618489e-06
* tiled Rh21n7n1 series x4  each=62469.9610664538
Rh21n7n1t1 in7 Rh21n7n1n1 62722.4600205739
Rh21n7n1t2 Rh21n7n1n1 Rh21n7n1n2 62422.5626500545
Rh21n7n1t3 Rh21n7n1n2 Rh21n7n1n3 62230.8781765801
Rh21n7n1t4 Rh21n7n1n3 h21n 62413.7371409726
* h21 input 8 w=-0.602502751086194 w-  bank=n alpha=1 R=55324.7819586548 G_phys=1.80750825325858e-05 G_eff=1.80750825325858e-05
* tiled Rh21n8n1 series x4  each=13831.1954896637
Rh21n8n1t1 in8 Rh21n8n1n1 13846.2588640719
Rh21n8n1t2 Rh21n8n1n1 Rh21n8n1n2 13790.7429557343
Rh21n8n1t3 Rh21n8n1n2 Rh21n8n1n3 13884.0821676131
Rh21n8n1t4 Rh21n8n1n3 h21n 13812.1761502833
* h21 input 9 w=-0.464313715662176 w-  bank=n alpha=1 R=71790.5420601142 G_phys=1.39294114698653e-05 G_eff=1.39294114698653e-05
* tiled Rh21n9n1 series x4  each=17947.6355150286
Rh21n9n1t1 in9 Rh21n9n1n1 17891.5853097558
Rh21n9n1t2 Rh21n9n1n1 Rh21n9n1n2 17988.9640451927
Rh21n9n1t3 Rh21n9n1n2 Rh21n9n1n3 17891.934072378
Rh21n9n1t4 Rh21n9n1n3 h21n 17933.500809728
* h21 input 10 w=+0.0220606443883595 w+  bank=f alpha=0.001 R=1510.98638582479 G_phys=0.000661819331650786 G_eff=6.61819331650786e-07
* tiled Rh21p10f1 parallel x4  each=6043.94554329917
Rh21p10f1t1 inf10 h21p 6048.85387499182
Rh21p10f1t2 inf10 h21p 6014.61360916711
Rh21p10f1t3 inf10 h21p 6031.94125156117
Rh21p10f1t4 inf10 h21p 6053.89941438922
* h21 input 11 w=+0.293613135845564 w+  bank=n alpha=1 R=113528.072364127 G_phys=8.80839407536691e-06 G_eff=8.80839407536691e-06
* tiled Rh21p11n1 series x4  each=28382.0180910317
Rh21p11n1t1 in11 Rh21p11n1n1 28287.6344044593
Rh21p11n1t2 Rh21p11n1n1 Rh21p11n1n2 28456.0262180343
Rh21p11n1t3 Rh21p11n1n2 Rh21p11n1n3 28320.8963351517
Rh21p11n1t4 Rh21p11n1n3 h21p 28455.9493342201
* h21 input 12 w=+0.585788543436 w+  bank=n alpha=1 R=56903.3548143728 G_phys=1.757365630308e-05 G_eff=1.757365630308e-05
* tiled Rh21p12n1 series x4  each=14225.8387035932
Rh21p12n1t1 in12 Rh21p12n1n1 14216.1523878958
Rh21p12n1t2 Rh21p12n1n1 Rh21p12n1n2 14220.418375038
Rh21p12n1t3 Rh21p12n1n2 Rh21p12n1n3 14198.4340798994
Rh21p12n1t4 Rh21p12n1n3 h21p 14243.1215525562
* h21 input 13 w=-0.255400978522459 w-  bank=n alpha=1 R=130513.726009089 G_phys=7.66202935567376e-06 G_eff=7.66202935567376e-06
* tiled Rh21n13n1 series x4  each=32628.4315022722
Rh21n13n1t1 in13 Rh21n13n1n1 32548.9000061106
Rh21n13n1t2 Rh21n13n1n1 Rh21n13n1n2 32542.9874856538
Rh21n13n1t3 Rh21n13n1n2 Rh21n13n1n3 32511.6538171726
Rh21n13n1t4 Rh21n13n1n3 h21n 32770.2497784567
* h21 input 14 w=+0.15251581562556 w+  bank=n alpha=1 R=218556.568685111 G_phys=4.57547446876679e-06 G_eff=4.57547446876679e-06
* tiled Rh21p14n1 series x4  each=54639.1421712777
Rh21p14n1t1 in14 Rh21p14n1n1 54533.85863967
Rh21p14n1t2 Rh21p14n1n1 Rh21p14n1n2 54709.9399847666
Rh21p14n1t3 Rh21p14n1n2 Rh21p14n1n3 54394.322550136
Rh21p14n1t4 Rh21p14n1n3 h21p 54526.6336602228
* h21 input 15 w=-0.610279514665944 w-  bank=n alpha=1 R=54619.7808254787 G_phys=1.83083854399783e-05 G_eff=1.83083854399783e-05
* tiled Rh21n15n1 series x4  each=13654.9452063697
Rh21n15n1t1 in15 Rh21n15n1n1 13675.1167354294
Rh21n15n1t2 Rh21n15n1n1 Rh21n15n1n2 13625.943342659
Rh21n15n1t3 Rh21n15n1n2 Rh21n15n1n3 13720.4340348723
Rh21n15n1t4 Rh21n15n1n3 h21n 13631.3385703089
* h21 input 16 w=+0.0580238118020399 w+  bank=n alpha=1 R=574476.793200985 G_phys=1.7407143540612e-06 G_eff=1.7407143540612e-06
* tiled Rh21p16n1 series x4  each=143619.198300246
Rh21p16n1t1 in16 Rh21p16n1n1 143482.266341728
Rh21p16n1t2 Rh21p16n1n1 Rh21p16n1n2 143943.650628285
Rh21p16n1t3 Rh21p16n1n2 Rh21p16n1n3 143848.257562953
Rh21p16n1t4 Rh21p16n1n3 h21p 142936.894389651
* h21 bias=-0.00602264402556266 b-  bank=f alpha=0.001 R=5534.66769609038 G_phys=0.00018067932076688 G_eff=1.8067932076688e-07
* tiled Rh21bnf1 series x4  each=1383.66692402259
Rh21bnf1t1 vreff Rh21bnf1n1 1389.44010872219
Rh21bnf1t2 Rh21bnf1n1 Rh21bnf1n2 1380.54732165886
Rh21bnf1t3 Rh21bnf1n2 Rh21bnf1n3 1389.21001045273
Rh21bnf1t4 Rh21bnf1n3 h21n 1382.24616959057
Vh21p h21p 0 DC 0
Vh21n h21n 0 DC 0
Fh21p 0 h21d Vh21p 1.001
Fh21n h21d 0 Vh21n 1.001
* ratiometric I-to-V: V = I * R_IV,  R_IV=33333.3333333333 (weight ~ R_IV / R_w)
* tiled Rh21iv series x4  each=8333.33333333333
Rh21ivt1 h21d Rh21ivn1 8305.2404048592
Rh21ivt2 Rh21ivn1 Rh21ivn2 8322.40314926081
Rh21ivt3 Rh21ivn2 Rh21ivn3 8351.78559120717
Rh21ivt4 Rh21ivn3 0 8364.90205605125
Bh21leak 0 h21d I = 1e-08
Eh21sc h21raw 0 h21d 0 1
Eh21lin h21lin 0 h21raw 0 1
* direct bounded ReLU: y=max(0, min(15, v(h21lin))) no high-gain op-amp loop
Bh21relu h21y 0 V = max(0, min(15, (0.001) + v(h21lin)))
Eh21 h21buf 0 h21y 0 1

* h22 input 1 w=+0.733134048211177 w+  bank=n alpha=1 R=45466.901195853 G_phys=2.19940214463353e-05 G_eff=2.19940214463353e-05
* tiled Rh22p1n1 series x4  each=11366.7252989633
Rh22p1n1t1 in1 Rh22p1n1n1 11372.2174221442
Rh22p1n1t2 Rh22p1n1n1 Rh22p1n1n2 11323.8311427715
Rh22p1n1t3 Rh22p1n1n2 Rh22p1n1n3 11394.7974758612
Rh22p1n1t4 Rh22p1n1n3 h22p 11382.0982246471
* h22 input 2 w=-0.468945077984231 w-  bank=n alpha=1 R=71081.5293693183 G_phys=1.40683523395269e-05 G_eff=1.40683523395269e-05
* tiled Rh22n2n1 series x4  each=17770.3823423296
Rh22n2n1t1 in2 Rh22n2n1n1 17784.5721554717
Rh22n2n1t2 Rh22n2n1n1 Rh22n2n1n2 17743.7378471416
Rh22n2n1t3 Rh22n2n1n2 Rh22n2n1n3 17682.6091058184
Rh22n2n1t4 Rh22n2n1n3 h22n 17825.3141361095
* h22 input 3 w=+0.0425168801269381 w+  bank=n alpha=1 R=784002.335867861 G_phys=1.27550640380814e-06 G_eff=1.27550640380814e-06
* tiled Rh22p3n1 series x4  each=196000.583966965
Rh22p3n1t1 in3 Rh22p3n1n1 196597.228778277
Rh22p3n1t2 Rh22p3n1n1 Rh22p3n1n2 196836.470537732
Rh22p3n1t3 Rh22p3n1n2 Rh22p3n1n3 195604.678323444
Rh22p3n1t4 Rh22p3n1n3 h22p 196727.597637196
* h22 input 4 w=-0.440513463519883 w-  bank=n alpha=1 R=75669.2725506874 G_phys=1.32154039055965e-05 G_eff=1.32154039055965e-05
* tiled Rh22n4n1 series x4  each=18917.3181376719
Rh22n4n1t1 in4 Rh22n4n1n1 18855.0240904638
Rh22n4n1t2 Rh22n4n1n1 Rh22n4n1n2 18893.954891642
Rh22n4n1t3 Rh22n4n1n2 Rh22n4n1n3 18917.1444026814
Rh22n4n1t4 Rh22n4n1n3 h22n 18893.3156853225
* h22 input 5 w=+0.139436850403416 w+  bank=n alpha=1 R=239056.843559604 G_phys=4.18310551210248e-06 G_eff=4.18310551210248e-06
* tiled Rh22p5n1 series x4  each=59764.210889901
Rh22p5n1t1 in5 Rh22p5n1n1 59747.7733643479
Rh22p5n1t2 Rh22p5n1n1 Rh22p5n1n2 59992.6795556625
Rh22p5n1t3 Rh22p5n1n2 Rh22p5n1n3 59755.5047819406
Rh22p5n1t4 Rh22p5n1n3 h22p 59859.0820739052
* h22 input 6 w=-0.216633688080034 w-  bank=n alpha=1 R=153869.574158838 G_phys=6.49901064240101e-06 G_eff=6.49901064240101e-06
* tiled Rh22n6n1 series x4  each=38467.3935397095
Rh22n6n1t1 in6 Rh22n6n1n1 38410.6861905168
Rh22n6n1t2 Rh22n6n1n1 Rh22n6n1n2 38303.0910604472
Rh22n6n1t3 Rh22n6n1n2 Rh22n6n1n3 38332.8258657325
Rh22n6n1t4 Rh22n6n1n3 h22n 38407.11013576
* h22 input 7 w=+0.3413541130964 w+  bank=n alpha=1 R=97650.305224006 G_phys=1.0240623392892e-05 G_eff=1.0240623392892e-05
* tiled Rh22p7n1 series x4  each=24412.5763060015
Rh22p7n1t1 in7 Rh22p7n1n1 24483.6562386821
Rh22p7n1t2 Rh22p7n1n1 Rh22p7n1n2 24436.4514462938
Rh22p7n1t3 Rh22p7n1n2 Rh22p7n1n3 24470.9022389843
Rh22p7n1t4 Rh22p7n1n3 h22p 24515.2131406782
* h22 input 8 w=+0.375494249585175 w+  bank=n alpha=1 R=88771.88763918 G_phys=1.12648274875552e-05 G_eff=1.12648274875552e-05
* tiled Rh22p8n1 series x4  each=22192.971909795
Rh22p8n1t1 in8 Rh22p8n1n1 22132.1597132374
Rh22p8n1t2 Rh22p8n1n1 Rh22p8n1n2 22130.7631488986
Rh22p8n1t3 Rh22p8n1n2 Rh22p8n1n3 22090.6173738139
Rh22p8n1t4 Rh22p8n1n3 h22p 22112.1403746446
* h22 input 9 w=-0.0598723775607 w-  bank=n alpha=1 R=556739.763667131 G_phys=1.796171326821e-06 G_eff=1.796171326821e-06
* tiled Rh22n9n1 series x4  each=139184.940916783
Rh22n9n1t1 in9 Rh22n9n1n1 139060.025834622
Rh22n9n1t2 Rh22n9n1n1 Rh22n9n1n2 138997.015989045
Rh22n9n1t3 Rh22n9n1n2 Rh22n9n1n3 139015.824824724
Rh22n9n1t4 Rh22n9n1n3 h22n 138912.201404854
* h22 input 10 w=-0.886177024526985 w-  bank=n alpha=1 R=37614.7568835083 G_phys=2.65853107358095e-05 G_eff=2.65853107358095e-05
* tiled Rh22n10n1 series x4  each=9403.68922087708
Rh22n10n1t1 in10 Rh22n10n1n1 9368.64121809862
Rh22n10n1t2 Rh22n10n1n1 Rh22n10n1n2 9450.53310574665
Rh22n10n1t3 Rh22n10n1n2 Rh22n10n1n3 9357.83111765357
Rh22n10n1t4 Rh22n10n1n3 h22n 9364.95505287977
* h22 input 11 w=-0.158397755226926 w-  bank=n alpha=1 R=210440.692707917 G_phys=4.75193265680777e-06 G_eff=4.75193265680777e-06
* tiled Rh22n11n1 series x4  each=52610.1731769793
Rh22n11n1t1 in11 Rh22n11n1n1 52433.3939207747
Rh22n11n1t2 Rh22n11n1n1 Rh22n11n1n2 52407.9070300171
Rh22n11n1t3 Rh22n11n1n2 Rh22n11n1n3 52624.3759108666
Rh22n11n1t4 Rh22n11n1n3 h22n 52357.5268011433
* h22 input 12 w=+0.00642379373490928 w+  bank=f alpha=0.001 R=5189.04166430307 G_phys=0.000192713812047279 G_eff=1.92713812047279e-07
* tiled Rh22p12f1 series x4  each=1297.26041607577
Rh22p12f1t1 inf12 Rh22p12f1n1 1302.50590875642
Rh22p12f1t2 Rh22p12f1n1 Rh22p12f1n2 1295.02945134518
Rh22p12f1t3 Rh22p12f1n2 Rh22p12f1n3 1300.89076946781
Rh22p12f1t4 Rh22p12f1n3 h22p 1296.1666970798
* h22 input 13 w=+0.483338726494796 w+  bank=n alpha=1 R=68964.7477144421 G_phys=1.45001617948439e-05 G_eff=1.45001617948439e-05
* tiled Rh22p13n1 series x4  each=17241.1869286105
Rh22p13n1t1 in13 Rh22p13n1n1 17289.923966107
Rh22p13n1t2 Rh22p13n1n1 Rh22p13n1n2 17179.2439241051
Rh22p13n1t3 Rh22p13n1n2 Rh22p13n1n3 17180.2659774972
Rh22p13n1t4 Rh22p13n1n3 h22p 17315.9290759138
* h22 input 14 w=+0.995892890290009 w+  bank=n alpha=1 R=33470.8015875347 G_phys=2.98767867087003e-05 G_eff=2.98767867087003e-05
* tiled Rh22p14n1 series x4  each=8367.70039688367
Rh22p14n1t1 in14 Rh22p14n1n1 8343.32917624812
Rh22p14n1t2 Rh22p14n1n1 Rh22p14n1n2 8331.9889179664
Rh22p14n1t3 Rh22p14n1n2 Rh22p14n1n3 8364.34199605353
Rh22p14n1t4 Rh22p14n1n3 h22p 8405.62097077929
* h22 input 15 w=-0.0635579626600016 w-  bank=n alpha=1 R=524455.661230796 G_phys=1.90673887980005e-06 G_eff=1.90673887980005e-06
* tiled Rh22n15n1 series x4  each=131113.915307699
Rh22n15n1t1 in15 Rh22n15n1n1 130609.819026889
Rh22n15n1t2 Rh22n15n1n1 Rh22n15n1n2 131635.602388366
Rh22n15n1t3 Rh22n15n1n2 Rh22n15n1n3 130548.260938831
Rh22n15n1t4 Rh22n15n1n3 h22n 131534.723973256
* h22 input 16 w=+0.143429643183018 w+  bank=n alpha=1 R=232401.981860887 G_phys=4.30288929549054e-06 G_eff=4.30288929549054e-06
* tiled Rh22p16n1 series x4  each=58100.4954652218
Rh22p16n1t1 in16 Rh22p16n1n1 58174.6373398611
Rh22p16n1t2 Rh22p16n1n1 Rh22p16n1n2 57933.1678522951
Rh22p16n1t3 Rh22p16n1n2 Rh22p16n1n3 57936.3087084917
Rh22p16n1t4 Rh22p16n1n3 h22p 57914.6832636764
* h22 bias=+0.00381018335041017 b+  bank=f alpha=0.001 R=8748.48537925215 G_phys=0.000114305500512305 G_eff=1.14305500512305e-07
* tiled Rh22bpf1 series x4  each=2187.12134481304
Rh22bpf1t1 vreff Rh22bpf1n1 2197.95465281845
Rh22bpf1t2 Rh22bpf1n1 Rh22bpf1n2 2182.12807046142
Rh22bpf1t3 Rh22bpf1n2 Rh22bpf1n3 2188.33690948481
Rh22bpf1t4 Rh22bpf1n3 h22p 2181.09214531294
Vh22p h22p 0 DC 0
Vh22n h22n 0 DC 0
Fh22p 0 h22d Vh22p 1.001
Fh22n h22d 0 Vh22n 1.001
* ratiometric I-to-V: V = I * R_IV,  R_IV=33333.3333333333 (weight ~ R_IV / R_w)
* tiled Rh22iv series x4  each=8333.33333333333
Rh22ivt1 h22d Rh22ivn1 8357.20567254862
Rh22ivt2 Rh22ivn1 Rh22ivn2 8331.22934828809
Rh22ivt3 Rh22ivn2 Rh22ivn3 8309.13876847489
Rh22ivt4 Rh22ivn3 0 8333.57105767332
Bh22leak 0 h22d I = 1e-08
Eh22sc h22raw 0 h22d 0 1
Eh22lin h22lin 0 h22raw 0 1
* direct bounded ReLU: y=max(0, min(15, v(h22lin))) no high-gain op-amp loop
Bh22relu h22y 0 V = max(0, min(15, (0.001) + v(h22lin)))
Eh22 h22buf 0 h22y 0 1

* h23 input 1 w=-0.311855168471888 w-  bank=n alpha=1 R=106887.224273592 G_phys=9.35565505415663e-06 G_eff=9.35565505415663e-06
* tiled Rh23n1n1 series x4  each=26721.8060683979
Rh23n1n1t1 in1 Rh23n1n1n1 26590.5691910549
Rh23n1n1t2 Rh23n1n1n1 Rh23n1n1n2 26741.2395748243
Rh23n1n1t3 Rh23n1n1n2 Rh23n1n1n3 26778.5678059204
Rh23n1n1t4 Rh23n1n1n3 h23n 26742.7804930717
* h23 input 2 w=-0.519305850985266 w-  bank=n alpha=1 R=64188.2491215741 G_phys=1.5579175529558e-05 G_eff=1.5579175529558e-05
* tiled Rh23n2n1 series x4  each=16047.0622803935
Rh23n2n1t1 in2 Rh23n2n1n1 15973.1938398561
Rh23n2n1t2 Rh23n2n1n1 Rh23n2n1n2 16049.5928456071
Rh23n2n1t3 Rh23n2n1n2 Rh23n2n1n3 16006.8440187149
Rh23n2n1t4 Rh23n2n1n3 h23n 16100.9757942464
* h23 input 3 w=+0.0590711076347425 w+  bank=n alpha=1 R=564291.659121157 G_phys=1.77213322904228e-06 G_eff=1.77213322904228e-06
* tiled Rh23p3n1 series x4  each=141072.914780289
Rh23p3n1t1 in3 Rh23p3n1n1 140833.691826828
Rh23p3n1t2 Rh23p3n1n1 Rh23p3n1n2 141265.35766215
Rh23p3n1t3 Rh23p3n1n2 Rh23p3n1n3 140739.40037499
Rh23p3n1t4 Rh23p3n1n3 h23p 141709.501272222
* h23 input 4 w=-0.153433475387477 w-  bank=n alpha=1 R=217249.418675776 G_phys=4.60300426162431e-06 G_eff=4.60300426162431e-06
* tiled Rh23n4n1 series x4  each=54312.354668944
Rh23n4n1t1 in4 Rh23n4n1n1 54524.7537580727
Rh23n4n1t2 Rh23n4n1n1 Rh23n4n1n2 54138.5678551429
Rh23n4n1t3 Rh23n4n1n2 Rh23n4n1n3 54510.3792963518
Rh23n4n1t4 Rh23n4n1n3 h23n 54240.4931492801
* h23 input 5 w=+0.565735693190981 w+  bank=n alpha=1 R=58920.3292889647 G_phys=1.69720707957294e-05 G_eff=1.69720707957294e-05
* tiled Rh23p5n1 series x4  each=14730.0823222412
Rh23p5n1t1 in5 Rh23p5n1n1 14758.7958859493
Rh23p5n1t2 Rh23p5n1n1 Rh23p5n1n2 14726.7547153485
Rh23p5n1t3 Rh23p5n1n2 Rh23p5n1n3 14670.525313609
Rh23p5n1t4 Rh23p5n1n3 h23p 14785.3667194246
* h23 input 6 w=-0.371646754353268 w-  bank=n alpha=1 R=89690.90391046 G_phys=1.1149402630598e-05 G_eff=1.1149402630598e-05
* tiled Rh23n6n1 series x4  each=22422.725977615
Rh23n6n1t1 in6 Rh23n6n1n1 22451.6311051356
Rh23n6n1t2 Rh23n6n1n1 Rh23n6n1n2 22435.9749485471
Rh23n6n1t3 Rh23n6n1n2 Rh23n6n1n3 22407.8123361026
Rh23n6n1t4 Rh23n6n1n3 h23n 22419.4781351635
* h23 input 7 w=-0.111660278324499 w-  bank=n alpha=1 R=298524.540987283 G_phys=3.34980834973497e-06 G_eff=3.34980834973497e-06
* tiled Rh23n7n1 series x4  each=74631.1352468207
Rh23n7n1t1 in7 Rh23n7n1n1 74330.3640879214
Rh23n7n1t2 Rh23n7n1n1 Rh23n7n1n2 74319.0681168563
Rh23n7n1t3 Rh23n7n1n2 Rh23n7n1n3 74840.7448081483
Rh23n7n1t4 Rh23n7n1n3 h23n 74546.3484190018
* h23 input 8 w=+0.496809212320021 w+  bank=n alpha=1 R=67094.8374279775 G_phys=1.49042763696006e-05 G_eff=1.49042763696006e-05
* tiled Rh23p8n1 series x4  each=16773.7093569944
Rh23p8n1t1 in8 Rh23p8n1n1 16821.5904444039
Rh23p8n1t2 Rh23p8n1n1 Rh23p8n1n2 16706.0900173713
Rh23p8n1t3 Rh23p8n1n2 Rh23p8n1n3 16830.8198361125
Rh23p8n1t4 Rh23p8n1n3 h23p 16775.0185872665
* h23 input 9 w=-0.177241184436762 w-  bank=n alpha=1 R=188067.65165365 G_phys=5.31723553310286e-06 G_eff=5.31723553310286e-06
* tiled Rh23n9n1 series x4  each=47016.9129134125
Rh23n9n1t1 in9 Rh23n9n1n1 47186.9313122621
Rh23n9n1t2 Rh23n9n1n1 Rh23n9n1n2 47060.5687562091
Rh23n9n1t3 Rh23n9n1n2 Rh23n9n1n3 47040.030163503
Rh23n9n1t4 Rh23n9n1n3 h23n 47008.2875570449
* h23 input 10 w=-0.405292848695184 w-  bank=n alpha=1 R=82245.0567303322 G_phys=1.21587854608555e-05 G_eff=1.21587854608555e-05
* tiled Rh23n10n1 series x4  each=20561.2641825831
Rh23n10n1t1 in10 Rh23n10n1n1 20570.6519889364
Rh23n10n1t2 Rh23n10n1n1 Rh23n10n1n2 20542.4940839147
Rh23n10n1t3 Rh23n10n1n2 Rh23n10n1n3 20493.8757299815
Rh23n10n1t4 Rh23n10n1n3 h23n 20596.9015112398
* h23 input 11 w=-0.16052467280172 w-  bank=n alpha=1 R=207652.398547522 G_phys=4.81574018405159e-06 G_eff=4.81574018405159e-06
* tiled Rh23n11n1 series x4  each=51913.0996368806
Rh23n11n1t1 in11 Rh23n11n1n1 51886.3223328302
Rh23n11n1t2 Rh23n11n1n1 Rh23n11n1n2 51767.6056026331
Rh23n11n1t3 Rh23n11n1n2 Rh23n11n1n3 52149.9321552984
Rh23n11n1t4 Rh23n11n1n3 h23n 52138.4175818614
* h23 input 12 w=+0.846508036935069 w+  bank=n alpha=1 R=39377.4564196963 G_phys=2.53952411080521e-05 G_eff=2.53952411080521e-05
* tiled Rh23p12n1 series x4  each=9844.36410492407
Rh23p12n1t1 in12 Rh23p12n1n1 9817.72914120794
Rh23p12n1t2 Rh23p12n1n1 Rh23p12n1n2 9814.57577780142
Rh23p12n1t3 Rh23p12n1n2 Rh23p12n1n3 9824.15447259014
Rh23p12n1t4 Rh23p12n1n3 h23p 9864.4800874486
* h23 input 13 w=-0.0538311215013525 w-  bank=n alpha=1 R=619220.488142641 G_phys=1.61493364504058e-06 G_eff=1.61493364504058e-06
* tiled Rh23n13n1 series x4  each=154805.12203566
Rh23n13n1t1 in13 Rh23n13n1n1 155032.451940429
Rh23n13n1t2 Rh23n13n1n1 Rh23n13n1n2 154632.974125754
Rh23n13n1t3 Rh23n13n1n2 Rh23n13n1n3 155265.340368434
Rh23n13n1t4 Rh23n13n1n3 h23n 154105.670236274
* h23 input 14 w=+0.31071243911676 w+  bank=n alpha=1 R=107280.331061375 G_phys=9.3213731735028e-06 G_eff=9.3213731735028e-06
* tiled Rh23p14n1 series x4  each=26820.0827653438
Rh23p14n1t1 in14 Rh23p14n1n1 26903.8298921744
Rh23p14n1t2 Rh23p14n1n1 Rh23p14n1n2 26897.671873831
Rh23p14n1t3 Rh23p14n1n2 Rh23p14n1n3 26707.673340781
Rh23p14n1t4 Rh23p14n1n3 h23p 26764.4207210818
* h23 input 15 w=+0.331311012578656 w+  bank=n alpha=1 R=100610.399497118 G_phys=9.93933037735967e-06 G_eff=9.93933037735967e-06
* tiled Rh23p15n1 series x4  each=25152.5998742796
Rh23p15n1t1 in15 Rh23p15n1n1 25101.5525542447
Rh23p15n1t2 Rh23p15n1n1 Rh23p15n1n2 25222.5991187964
Rh23p15n1t3 Rh23p15n1n2 Rh23p15n1n3 25061.8115146331
Rh23p15n1t4 Rh23p15n1n3 h23p 25161.9857221804
* h23 input 16 w=-0.486368816876819 w-  bank=n alpha=1 R=68535.0955420638 G_phys=1.45910645063046e-05 G_eff=1.45910645063046e-05
* tiled Rh23n16n1 series x4  each=17133.773885516
Rh23n16n1t1 in16 Rh23n16n1n1 17055.6176220578
Rh23n16n1t2 Rh23n16n1n1 Rh23n16n1n2 17132.5083530005
Rh23n16n1t3 Rh23n16n1n2 Rh23n16n1n3 17157.0461620406
Rh23n16n1t4 Rh23n16n1n3 h23n 17145.4299916454
* h23 bias=-0.0518579015055903 b-  bank=n alpha=1 R=642782.148246781 G_phys=1.55573704516771e-06 G_eff=1.55573704516771e-06
* tiled Rh23bnn1 series x4  each=160695.537061695
Rh23bnn1t1 vref Rh23bnn1n1 161398.76685707
Rh23bnn1t2 Rh23bnn1n1 Rh23bnn1n2 160777.739804416
Rh23bnn1t3 Rh23bnn1n2 Rh23bnn1n3 161194.473902355
Rh23bnn1t4 Rh23bnn1n3 h23n 160632.770618633
Vh23p h23p 0 DC 0
Vh23n h23n 0 DC 0
Fh23p 0 h23d Vh23p 1.001
Fh23n h23d 0 Vh23n 1.001
* ratiometric I-to-V: V = I * R_IV,  R_IV=33333.3333333333 (weight ~ R_IV / R_w)
* tiled Rh23iv series x4  each=8333.33333333333
Rh23ivt1 h23d Rh23ivn1 8317.28072407443
Rh23ivt2 Rh23ivn1 Rh23ivn2 8334.27092726023
Rh23ivt3 Rh23ivn2 Rh23ivn3 8354.58772642394
Rh23ivt4 Rh23ivn3 0 8294.07444638987
Bh23leak 0 h23d I = 1e-08
Eh23sc h23raw 0 h23d 0 1
Eh23lin h23lin 0 h23raw 0 1
* direct bounded ReLU: y=max(0, min(15, v(h23lin))) no high-gain op-amp loop
Bh23relu h23y 0 V = max(0, min(15, (0.001) + v(h23lin)))
Eh23 h23buf 0 h23y 0 1

* h24 input 1 w=+0.61389120350986 w+  bank=n alpha=1 R=54298.4378058415 G_phys=1.84167361052958e-05 G_eff=1.84167361052958e-05
* tiled Rh24p1n1 series x4  each=13574.6094514604
Rh24p1n1t1 in1 Rh24p1n1n1 13591.8656254151
Rh24p1n1t2 Rh24p1n1n1 Rh24p1n1n2 13539.5515207969
Rh24p1n1t3 Rh24p1n1n2 Rh24p1n1n3 13620.7136074631
Rh24p1n1t4 Rh24p1n1n3 h24p 13588.0173056258
* h24 input 2 w=-0.0429199313830527 w-  bank=n alpha=1 R=776639.949300928 G_phys=1.28759794149158e-06 G_eff=1.28759794149158e-06
* tiled Rh24n2n1 series x4  each=194159.987325232
Rh24n2n1t1 in2 Rh24n2n1n1 195099.888524706
Rh24n2n1t2 Rh24n2n1n1 Rh24n2n1n2 194383.784052959
Rh24n2n1t3 Rh24n2n1n2 Rh24n2n1n3 194727.656773896
Rh24n2n1t4 Rh24n2n1n3 h24n 193702.715332768
* h24 input 3 w=-0.014915873427812 w-  bank=f alpha=0.001 R=2234.75571140073 G_phys=0.000447476202834361 G_eff=4.47476202834361e-07
* tiled Rh24n3f1 parallel x4  each=8939.02284560293
Rh24n3f1t1 inf3 h24n 8896.64259663931
Rh24n3f1t2 inf3 h24n 8912.9443230508
Rh24n3f1t3 inf3 h24n 8970.38576374012
Rh24n3f1t4 inf3 h24n 8902.74922452029
* h24 input 4 w=-0.169036355792668 w-  bank=n alpha=1 R=197196.237324345 G_phys=5.07109067378003e-06 G_eff=5.07109067378003e-06
* tiled Rh24n4n1 series x4  each=49299.0593310862
Rh24n4n1t1 in4 Rh24n4n1n1 49123.1085383914
Rh24n4n1t2 Rh24n4n1n1 Rh24n4n1n2 49065.659816271
Rh24n4n1t3 Rh24n4n1n2 Rh24n4n1n3 49383.2382647793
Rh24n4n1t4 Rh24n4n1n3 h24n 49511.9256504368
* h24 input 5 w=-0.510336523880732 w-  bank=n alpha=1 R=65316.378063357 G_phys=1.5310095716422e-05 G_eff=1.5310095716422e-05
* tiled Rh24n5n1 series x4  each=16329.0945158392
Rh24n5n1t1 in5 Rh24n5n1n1 16303.9242171901
Rh24n5n1t2 Rh24n5n1n1 Rh24n5n1n2 16271.7009494009
Rh24n5n1t3 Rh24n5n1n2 Rh24n5n1n3 16332.8181108889
Rh24n5n1t4 Rh24n5n1n3 h24n 16330.7859205127
* h24 input 6 w=-0.303361656916169 w-  bank=n alpha=1 R=109879.849919678 G_phys=9.10084970748506e-06 G_eff=9.10084970748506e-06
* tiled Rh24n6n1 series x4  each=27469.9624799194
Rh24n6n1t1 in6 Rh24n6n1n1 27378.3206653168
Rh24n6n1t2 Rh24n6n1n1 Rh24n6n1n2 27427.1538030827
Rh24n6n1t3 Rh24n6n1n2 Rh24n6n1n3 27387.9966248746
Rh24n6n1t4 Rh24n6n1n3 h24n 27547.8270353269
* h24 input 7 w=-0.0292327970624363 w-  bank=f alpha=0.001 R=1140.27177290422 G_phys=0.000876983911873088 G_eff=8.76983911873088e-07
* tiled Rh24n7f1 parallel x4  each=4561.08709161686
Rh24n7f1t1 inf7 h24n 4580.64955747839
Rh24n7f1t2 inf7 h24n 4545.61025279292
Rh24n7f1t3 inf7 h24n 4549.35227468578
Rh24n7f1t4 inf7 h24n 4571.63085079354
* h24 input 8 w=-0.329334996951297 w-  bank=n alpha=1 R=101214.063618823 G_phys=9.88004990853891e-06 G_eff=9.88004990853891e-06
* tiled Rh24n8n1 series x4  each=25303.5159047057
Rh24n8n1t1 in8 Rh24n8n1n1 25198.6596077694
Rh24n8n1t2 Rh24n8n1n1 Rh24n8n1n2 25294.2963362729
Rh24n8n1t3 Rh24n8n1n2 Rh24n8n1n3 25246.2892585724
Rh24n8n1t4 Rh24n8n1n3 h24n 25376.304395507
* h24 input 9 w=+0.0109599477370603 w+  bank=f alpha=0.001 R=3041.37703326988 G_phys=0.000328798432111809 G_eff=3.28798432111809e-07
* tiled Rh24p9f1 parallel x4  each=12165.5081330795
Rh24p9f1t1 inf9 h24p 12150.4424494353
Rh24p9f1t2 inf9 h24p 12154.6806315113
Rh24p9f1t3 inf9 h24p 12174.2944857626
Rh24p9f1t4 inf9 h24p 12179.0403899977
* h24 input 10 w=+0.0571459019805778 w+  bank=n alpha=1 R=583302.252271078 G_phys=1.71437705941734e-06 G_eff=1.71437705941734e-06
* tiled Rh24p10n1 series x4  each=145825.56306777
Rh24p10n1t1 in10 Rh24p10n1n1 145145.787174546
Rh24p10n1t2 Rh24p10n1n1 Rh24p10n1n2 145712.60352885
Rh24p10n1t3 Rh24p10n1n2 Rh24p10n1n3 145894.679361354
Rh24p10n1t4 Rh24p10n1n3 h24p 146420.767771969
* h24 input 11 w=+0.243568584743939 w+  bank=n alpha=1 R=136853.992760915 G_phys=7.30705754231816e-06 G_eff=7.30705754231816e-06
* tiled Rh24p11n1 series x4  each=34213.4981902288
Rh24p11n1t1 in11 Rh24p11n1n1 34373.8011969471
Rh24p11n1t2 Rh24p11n1n1 Rh24p11n1n2 34381.6176307816
Rh24p11n1t3 Rh24p11n1n2 Rh24p11n1n3 34367.7068050917
Rh24p11n1t4 Rh24p11n1n3 h24p 34190.1409238281
* h24 input 12 w=-0.323004255102081 w-  bank=n alpha=1 R=103197.814910515 G_phys=9.69012765306243e-06 G_eff=9.69012765306243e-06
* tiled Rh24n12n1 series x4  each=25799.4537276288
Rh24n12n1t1 in12 Rh24n12n1n1 25850.608410989
Rh24n12n1t2 Rh24n12n1n1 Rh24n12n1n2 25798.2488354243
Rh24n12n1t3 Rh24n12n1n2 Rh24n12n1n3 25782.8837956755
Rh24n12n1t4 Rh24n12n1n3 h24n 25745.4347640673
* h24 input 13 w=+0.243938800887145 w+  bank=n alpha=1 R=136646.294939994 G_phys=7.31816402661434e-06 G_eff=7.31816402661434e-06
* tiled Rh24p13n1 series x4  each=34161.5737349986
Rh24p13n1t1 in13 Rh24p13n1n1 33993.5195514657
Rh24p13n1t2 Rh24p13n1n1 Rh24p13n1n2 34051.8513026079
Rh24p13n1t3 Rh24p13n1n2 Rh24p13n1n3 34000.733178329
Rh24p13n1t4 Rh24p13n1n3 h24p 34011.524230906
* h24 input 14 w=+0.0840399613598874 w+  bank=n alpha=1 R=396636.704657547 G_phys=2.52119884079662e-06 G_eff=2.52119884079662e-06
* tiled Rh24p14n1 series x4  each=99159.1761643867
Rh24p14n1t1 in14 Rh24p14n1n1 98875.8501310873
Rh24p14n1t2 Rh24p14n1n1 Rh24p14n1n2 99090.6133348364
Rh24p14n1t3 Rh24p14n1n2 Rh24p14n1n3 99049.9105844183
Rh24p14n1t4 Rh24p14n1n3 h24p 99574.1902941021
* h24 input 15 w=-0.352451854106752 w-  bank=n alpha=1 R=94575.5652720646 G_phys=1.05735556232026e-05 G_eff=1.05735556232026e-05
* tiled Rh24n15n1 series x4  each=23643.8913180162
Rh24n15n1t1 in15 Rh24n15n1n1 23749.4222124897
Rh24n15n1t2 Rh24n15n1n1 Rh24n15n1n2 23597.8837492152
Rh24n15n1t3 Rh24n15n1n2 Rh24n15n1n3 23735.633439954
Rh24n15n1t4 Rh24n15n1n3 h24n 23638.1872444893
* h24 input 16 w=+0.406056698737055 w+  bank=n alpha=1 R=82090.3421542089 G_phys=1.21817009621116e-05 G_eff=1.21817009621116e-05
* tiled Rh24p16n1 series x4  each=20522.5855385522
Rh24p16n1t1 in16 Rh24p16n1n1 20621.2917074665
Rh24p16n1t2 Rh24p16n1n1 Rh24p16n1n2 20463.5393260824
Rh24p16n1t3 Rh24p16n1n2 Rh24p16n1n3 20550.4931060161
Rh24p16n1t4 Rh24p16n1n3 h24p 20455.7688187623
* h24 bias=+0.0185909259510049 b+  bank=f alpha=0.001 R=1792.9894089827 G_phys=0.000557727778530147 G_eff=5.57727778530147e-07
* tiled Rh24bpf1 parallel x4  each=7171.95763593078
Rh24bpf1t1 vreff h24p 7189.77585989999
Rh24bpf1t2 vreff h24p 7187.14704752421
Rh24bpf1t3 vreff h24p 7205.57037359809
Rh24bpf1t4 vreff h24p 7145.23871763383
Vh24p h24p 0 DC 0
Vh24n h24n 0 DC 0
Fh24p 0 h24d Vh24p 1.001
Fh24n h24d 0 Vh24n 1.001
* ratiometric I-to-V: V = I * R_IV,  R_IV=33333.3333333333 (weight ~ R_IV / R_w)
* tiled Rh24iv series x4  each=8333.33333333333
Rh24ivt1 h24d Rh24ivn1 8309.90482824228
Rh24ivt2 Rh24ivn1 Rh24ivn2 8298.01139149891
Rh24ivt3 Rh24ivn2 Rh24ivn3 8346.52377214773
Rh24ivt4 Rh24ivn3 0 8313.36795836936
Bh24leak 0 h24d I = 1e-08
Eh24sc h24raw 0 h24d 0 1
Eh24lin h24lin 0 h24raw 0 1
* direct bounded ReLU: y=max(0, min(15, v(h24lin))) no high-gain op-amp loop
Bh24relu h24y 0 V = max(0, min(15, (0.001) + v(h24lin)))
Eh24 h24buf 0 h24y 0 1

* h25 input 1 w=-0.507226781565224 w-  bank=n alpha=1 R=65716.824396519 G_phys=1.52168034469567e-05 G_eff=1.52168034469567e-05
* tiled Rh25n1n1 series x4  each=16429.2060991298
Rh25n1n1t1 in1 Rh25n1n1n1 16485.5772269617
Rh25n1n1t2 Rh25n1n1n1 Rh25n1n1n2 16454.0719910698
Rh25n1n1t3 Rh25n1n1n2 Rh25n1n1n3 16363.9620200744
Rh25n1n1t4 Rh25n1n1n3 h25n 16493.3565203734
* h25 input 2 w=-0.323616844242374 w-  bank=n alpha=1 R=103002.467042068 G_phys=9.70850532727122e-06 G_eff=9.70850532727122e-06
* tiled Rh25n2n1 series x4  each=25750.6167605171
Rh25n2n1t1 in2 Rh25n2n1n1 25654.4437956854
Rh25n2n1t2 Rh25n2n1n1 Rh25n2n1n2 25677.4214646984
Rh25n2n1t3 Rh25n2n1n2 Rh25n2n1n3 25724.7860399911
Rh25n2n1t4 Rh25n2n1n3 h25n 25675.8489346081
* h25 input 3 w=+0.251581142719107 w+  bank=n alpha=1 R=132495.35705683 G_phys=7.5474342815732e-06 G_eff=7.5474342815732e-06
* tiled Rh25p3n1 series x4  each=33123.8392642075
Rh25p3n1t1 in3 Rh25p3n1n1 33087.9984341089
Rh25p3n1t2 Rh25p3n1n1 Rh25p3n1n2 33160.6302384182
Rh25p3n1t3 Rh25p3n1n2 Rh25p3n1n3 33271.2147806533
Rh25p3n1t4 Rh25p3n1n3 h25p 32962.9287253015
* h25 input 4 w=+0.0279414599016099 w+  bank=f alpha=0.001 R=1192.97035483149 G_phys=0.000838243797048297 G_eff=8.38243797048297e-07
* tiled Rh25p4f1 parallel x4  each=4771.88141932595
Rh25p4f1t1 inf4 h25p 4762.45293676576
Rh25p4f1t2 inf4 h25p 4790.74189816131
Rh25p4f1t3 inf4 h25p 4779.90496160075
Rh25p4f1t4 inf4 h25p 4771.8231160386
* h25 input 5 w=+0.310516223746861 w+  bank=n alpha=1 R=107348.121560654 G_phys=9.31548671240582e-06 G_eff=9.31548671240582e-06
* tiled Rh25p5n1 series x4  each=26837.0303901636
Rh25p5n1t1 in5 Rh25p5n1n1 26872.7958784128
Rh25p5n1t2 Rh25p5n1n1 Rh25p5n1n2 26734.0256441825
Rh25p5n1t3 Rh25p5n1n2 Rh25p5n1n3 26788.0063867705
Rh25p5n1t4 Rh25p5n1n3 h25p 26856.081188896
* h25 input 6 w=-0.583310440311788 w-  bank=n alpha=1 R=57145.0998125736 G_phys=1.74993132093536e-05 G_eff=1.74993132093536e-05
* tiled Rh25n6n1 series x4  each=14286.2749531434
Rh25n6n1t1 in6 Rh25n6n1n1 14351.9892576932
Rh25n6n1t2 Rh25n6n1n1 Rh25n6n1n2 14226.363374598
Rh25n6n1t3 Rh25n6n1n2 Rh25n6n1n3 14353.7800009112
Rh25n6n1t4 Rh25n6n1n3 h25n 14237.249886383
* h25 input 7 w=-0.128366308561082 w-  bank=n alpha=1 R=259673.536670037 G_phys=3.85098925683245e-06 G_eff=3.85098925683245e-06
* tiled Rh25n7n1 series x4  each=64918.3841675092
Rh25n7n1t1 in7 Rh25n7n1n1 64674.9725629553
Rh25n7n1t2 Rh25n7n1n1 Rh25n7n1n2 65144.8101886959
Rh25n7n1t3 Rh25n7n1n2 Rh25n7n1n3 65178.0509085978
Rh25n7n1t4 Rh25n7n1n3 h25n 65033.4203134297
* h25 input 8 w=-0.237966635841971 w-  bank=n alpha=1 R=140075.658990571 G_phys=7.13899907525912e-06 G_eff=7.13899907525912e-06
* tiled Rh25n8n1 series x4  each=35018.9147476428
Rh25n8n1t1 in8 Rh25n8n1n1 34906.060803533
Rh25n8n1t2 Rh25n8n1n1 Rh25n8n1n2 34897.9638309403
Rh25n8n1t3 Rh25n8n1n2 Rh25n8n1n3 35003.111367094
Rh25n8n1t4 Rh25n8n1n3 h25n 35118.0781258898
* h25 input 9 w=+0.869293927250567 w+  bank=n alpha=1 R=38345.2964393311 G_phys=2.6078817817517e-05 G_eff=2.6078817817517e-05
* tiled Rh25p9n1 series x4  each=9586.32410983278
Rh25p9n1t1 in9 Rh25p9n1n1 9571.05895081883
Rh25p9n1t2 Rh25p9n1n1 Rh25p9n1n2 9567.79455354557
Rh25p9n1t3 Rh25p9n1n2 Rh25p9n1n3 9584.68842036194
Rh25p9n1t4 Rh25p9n1n3 h25p 9545.72380361085
* h25 input 10 w=-0.700407093798758 w-  bank=n alpha=1 R=47591.3702594662 G_phys=2.10122128139627e-05 G_eff=2.10122128139627e-05
* tiled Rh25n10n1 series x4  each=11897.8425648665
Rh25n10n1t1 in10 Rh25n10n1n1 11928.9750455244
Rh25n10n1t2 Rh25n10n1n1 Rh25n10n1n2 11902.9143132478
Rh25n10n1t3 Rh25n10n1n2 Rh25n10n1n3 11868.3125534671
Rh25n10n1t4 Rh25n10n1n3 h25n 11845.3688879649
* h25 input 11 w=+0.176416664646434 w+  bank=n alpha=1 R=188946.624742841 G_phys=5.29249993939301e-06 G_eff=5.29249993939301e-06
* tiled Rh25p11n1 series x4  each=47236.6561857102
Rh25p11n1t1 in11 Rh25p11n1n1 47443.1612127554
Rh25p11n1t2 Rh25p11n1n1 Rh25p11n1n2 47444.6041563352
Rh25p11n1t3 Rh25p11n1n2 Rh25p11n1n3 47307.4909279704
Rh25p11n1t4 Rh25p11n1n3 h25p 47316.791291526
* h25 input 12 w=+0.165054591787149 w+  bank=n alpha=1 R=201953.383861743 G_phys=4.95163775361447e-06 G_eff=4.95163775361447e-06
* tiled Rh25p12n1 series x4  each=50488.3459654357
Rh25p12n1t1 in12 Rh25p12n1n1 50422.2155674648
Rh25p12n1t2 Rh25p12n1n1 Rh25p12n1n2 50446.5626164456
Rh25p12n1t3 Rh25p12n1n2 Rh25p12n1n3 50728.8342859227
Rh25p12n1t4 Rh25p12n1n3 h25p 50718.7487905212
* h25 input 13 w=+0.414882742059982 w+  bank=n alpha=1 R=80343.9862738715 G_phys=1.24464822617995e-05 G_eff=1.24464822617995e-05
* tiled Rh25p13n1 series x4  each=20085.9965684679
Rh25p13n1t1 in13 Rh25p13n1n1 20115.7807029787
Rh25p13n1t2 Rh25p13n1n1 Rh25p13n1n2 20106.0510013186
Rh25p13n1t3 Rh25p13n1n2 Rh25p13n1n3 20175.3788964902
Rh25p13n1t4 Rh25p13n1n3 h25p 20085.0958695811
* h25 input 14 w=-0.441614461314228 w-  bank=n alpha=1 R=75480.619982721 G_phys=1.32484338394269e-05 G_eff=1.32484338394269e-05
* tiled Rh25n14n1 series x4  each=18870.1549956803
Rh25n14n1t1 in14 Rh25n14n1n1 18853.3400715054
Rh25n14n1t2 Rh25n14n1n1 Rh25n14n1n2 18941.592285215
Rh25n14n1t3 Rh25n14n1n2 Rh25n14n1n3 18877.9254571724
Rh25n14n1t4 Rh25n14n1n3 h25n 18953.2058936385
* h25 input 15 w=+0.152726206779301 w+  bank=n alpha=1 R=218255.491550983 G_phys=4.58178620337902e-06 G_eff=4.58178620337902e-06
* tiled Rh25p15n1 series x4  each=54563.8728877457
Rh25p15n1t1 in15 Rh25p15n1n1 54648.1052962582
Rh25p15n1t2 Rh25p15n1n1 Rh25p15n1n2 54344.8214641237
Rh25p15n1t3 Rh25p15n1n2 Rh25p15n1n3 54517.0766713972
Rh25p15n1t4 Rh25p15n1n3 h25p 54639.1506448939
* h25 input 16 w=-0.0538945970745783 w-  bank=n alpha=1 R=618491.187292992 G_phys=1.61683791223735e-06 G_eff=1.61683791223735e-06
* tiled Rh25n16n1 series x4  each=154622.796823248
Rh25n16n1t1 in16 Rh25n16n1n1 153923.155498584
Rh25n16n1t2 Rh25n16n1n1 Rh25n16n1n2 154491.655485185
Rh25n16n1t3 Rh25n16n1n2 Rh25n16n1n3 154808.122555848
Rh25n16n1t4 Rh25n16n1n3 h25n 155196.463068353
* h25 bias=+0.0841612656537764 b+  bank=n alpha=1 R=396065.019631007 G_phys=2.52483796961329e-06 G_eff=2.52483796961329e-06
* tiled Rh25bpn1 series x4  each=99016.2549077516
Rh25bpn1t1 vref Rh25bpn1n1 99133.5041117191
Rh25bpn1t2 Rh25bpn1n1 Rh25bpn1n2 99197.3094541639
Rh25bpn1t3 Rh25bpn1n2 Rh25bpn1n3 99275.8398039878
Rh25bpn1t4 Rh25bpn1n3 h25p 99052.5994819667
Vh25p h25p 0 DC 0
Vh25n h25n 0 DC 0
Fh25p 0 h25d Vh25p 1.001
Fh25n h25d 0 Vh25n 1.001
* ratiometric I-to-V: V = I * R_IV,  R_IV=33333.3333333333 (weight ~ R_IV / R_w)
* tiled Rh25iv series x4  each=8333.33333333333
Rh25ivt1 h25d Rh25ivn1 8358.64529174893
Rh25ivt2 Rh25ivn1 Rh25ivn2 8297.59906800846
Rh25ivt3 Rh25ivn2 Rh25ivn3 8335.16520465028
Rh25ivt4 Rh25ivn3 0 8374.79614977108
Bh25leak 0 h25d I = 1e-08
Eh25sc h25raw 0 h25d 0 1
Eh25lin h25lin 0 h25raw 0 1
* direct bounded ReLU: y=max(0, min(15, v(h25lin))) no high-gain op-amp loop
Bh25relu h25y 0 V = max(0, min(15, (0.001) + v(h25lin)))
Eh25 h25buf 0 h25y 0 1

* h26 input 1 w=-0.733410608571861 w-  bank=n alpha=1 R=45449.7561717056 G_phys=2.20023182571558e-05 G_eff=2.20023182571558e-05
* tiled Rh26n1n1 series x4  each=11362.4390429264
Rh26n1n1t1 in1 Rh26n1n1n1 11375.4691725516
Rh26n1n1t2 Rh26n1n1n1 Rh26n1n1n2 11382.5859120512
Rh26n1n1t3 Rh26n1n1n2 Rh26n1n1n3 11411.4349455223
Rh26n1n1t4 Rh26n1n1n3 h26n 11355.8821191119
* h26 input 2 w=+0.207000343516658 w+  bank=n alpha=1 R=161030.328583251 G_phys=6.21001030549975e-06 G_eff=6.21001030549975e-06
* tiled Rh26p2n1 series x4  each=40257.5821458128
Rh26p2n1t1 in2 Rh26p2n1n1 40437.8815664202
Rh26p2n1t2 Rh26p2n1n1 Rh26p2n1n2 40333.5896849187
Rh26p2n1t3 Rh26p2n1n2 Rh26p2n1n3 40266.0000623031
Rh26p2n1t4 Rh26p2n1n3 h26p 40209.779562943
* h26 input 3 w=-0.0671817515718929 w-  bank=n alpha=1 R=496166.482019488 G_phys=2.01545254715679e-06 G_eff=2.01545254715679e-06
* tiled Rh26n3n1 series x4  each=124041.620504872
Rh26n3n1t1 in3 Rh26n3n1n1 124152.942951292
Rh26n3n1t2 Rh26n3n1n1 Rh26n3n1n2 123510.063859645
Rh26n3n1t3 Rh26n3n1n2 Rh26n3n1n3 124127.050958404
Rh26n3n1t4 Rh26n3n1n3 h26n 124427.973858875
* h26 input 4 w=+0.312724326896377 w+  bank=n alpha=1 R=106590.151345592 G_phys=9.38172980689131e-06 G_eff=9.38172980689131e-06
* tiled Rh26p4n1 series x4  each=26647.5378363981
Rh26p4n1t1 in4 Rh26p4n1n1 26526.9288960759
Rh26p4n1t2 Rh26p4n1n1 Rh26p4n1n2 26684.87218499
Rh26p4n1t3 Rh26p4n1n2 Rh26p4n1n3 26659.9057107981
Rh26p4n1t4 Rh26p4n1n3 h26p 26531.7803576547
* h26 input 5 w=+0.0982363551813243 w+  bank=n alpha=1 R=339317.692231219 G_phys=2.94709065543973e-06 G_eff=2.94709065543973e-06
* tiled Rh26p5n1 series x4  each=84829.4230578048
Rh26p5n1t1 in5 Rh26p5n1n1 84820.5952271134
Rh26p5n1t2 Rh26p5n1n1 Rh26p5n1n2 84736.9907170695
Rh26p5n1t3 Rh26p5n1n2 Rh26p5n1n3 84589.7368052017
Rh26p5n1t4 Rh26p5n1n3 h26p 84827.5103899246
* h26 input 6 w=+0.0433697195878843 w+  bank=n alpha=1 R=768585.401291025 G_phys=1.30109158763653e-06 G_eff=1.30109158763653e-06
* tiled Rh26p6n1 series x4  each=192146.350322756
Rh26p6n1t1 in6 Rh26p6n1n1 191208.178965398
Rh26p6n1t2 Rh26p6n1n1 Rh26p6n1n2 191835.401230508
Rh26p6n1t3 Rh26p6n1n2 Rh26p6n1n3 192315.465879022
Rh26p6n1t4 Rh26p6n1n3 h26p 192371.264791304
* h26 input 7 w=-0.253243820471769 w-  bank=n alpha=1 R=131625.45593901 G_phys=7.59731461415306e-06 G_eff=7.59731461415306e-06
* tiled Rh26n7n1 series x4  each=32906.3639847525
Rh26n7n1t1 in7 Rh26n7n1n1 32974.7557578747
Rh26n7n1t2 Rh26n7n1n1 Rh26n7n1n2 33009.9911519068
Rh26n7n1t3 Rh26n7n1n2 Rh26n7n1n3 32966.1653396239
Rh26n7n1t4 Rh26n7n1n3 h26n 32940.3922689726
* h26 input 8 w=+0.388367135047654 w+  bank=n alpha=1 R=85829.4390158508 G_phys=1.16510140514296e-05 G_eff=1.16510140514296e-05
* tiled Rh26p8n1 series x4  each=21457.3597539627
Rh26p8n1t1 in8 Rh26p8n1n1 21546.348675317
Rh26p8n1t2 Rh26p8n1n1 Rh26p8n1n2 21399.3238880587
Rh26p8n1t3 Rh26p8n1n2 Rh26p8n1n3 21562.8033682186
Rh26p8n1t4 Rh26p8n1n3 h26p 21443.0517509126
* h26 input 9 w=+0.190562655499984 w+  bank=n alpha=1 R=174920.596304013 G_phys=5.71687966499952e-06 G_eff=5.71687966499952e-06
* tiled Rh26p9n1 series x4  each=43730.1490760031
Rh26p9n1t1 in9 Rh26p9n1n1 43563.7007323701
Rh26p9n1t2 Rh26p9n1n1 Rh26p9n1n2 43714.7076073298
Rh26p9n1t3 Rh26p9n1n2 Rh26p9n1n3 43764.319477159
Rh26p9n1t4 Rh26p9n1n3 h26p 43765.4825867967
* h26 input 10 w=-0.282938574156096 w-  bank=n alpha=1 R=117811.201363245 G_phys=8.48815722468287e-06 G_eff=8.48815722468287e-06
* tiled Rh26n10n1 series x4  each=29452.8003408113
Rh26n10n1t1 in10 Rh26n10n1n1 29444.7528817959
Rh26n10n1t2 Rh26n10n1n1 Rh26n10n1n2 29309.6721865957
Rh26n10n1t3 Rh26n10n1n2 Rh26n10n1n3 29485.5699590257
Rh26n10n1t4 Rh26n10n1n3 h26n 29456.8408928749
* h26 input 11 w=+0.123317846030254 w+  bank=n alpha=1 R=270304.21310761 G_phys=3.69953538090763e-06 G_eff=3.69953538090763e-06
* tiled Rh26p11n1 series x4  each=67576.0532769026
Rh26p11n1t1 in11 Rh26p11n1n1 67263.1752237642
Rh26p11n1t2 Rh26p11n1n1 Rh26p11n1n2 67574.6467524646
Rh26p11n1t3 Rh26p11n1n2 Rh26p11n1n3 67728.0128301276
Rh26p11n1t4 Rh26p11n1n3 h26p 67903.2993630733
* h26 input 12 w=-0.494646699470857 w-  bank=n alpha=1 R=67388.1648639146 G_phys=1.48394009841257e-05 G_eff=1.48394009841257e-05
* tiled Rh26n12n1 series x4  each=16847.0412159787
Rh26n12n1t1 in12 Rh26n12n1n1 16865.0120489124
Rh26n12n1t2 Rh26n12n1n1 Rh26n12n1n2 16834.5689959903
Rh26n12n1t3 Rh26n12n1n2 Rh26n12n1n3 16839.9540785087
Rh26n12n1t4 Rh26n12n1n3 h26n 16851.9505062028
* h26 input 13 w=-0.136127092468903 w-  bank=n alpha=1 R=244869.208096457 G_phys=4.08381277406708e-06 G_eff=4.08381277406708e-06
* tiled Rh26n13n1 series x4  each=61217.3020241142
Rh26n13n1t1 in13 Rh26n13n1n1 61083.0723947764
Rh26n13n1t2 Rh26n13n1n1 Rh26n13n1n2 61117.4932777558
Rh26n13n1t3 Rh26n13n1n2 Rh26n13n1n3 61242.2712742546
Rh26n13n1t4 Rh26n13n1n3 h26n 61476.3597640107
* h26 input 14 w=+0.481522107274068 w+  bank=n alpha=1 R=69224.928263493 G_phys=1.4445663218222e-05 G_eff=1.4445663218222e-05
* tiled Rh26p14n1 series x4  each=17306.2320658732
Rh26p14n1t1 in14 Rh26p14n1n1 17347.6054548722
Rh26p14n1t2 Rh26p14n1n1 Rh26p14n1n2 17230.0224994621
Rh26p14n1t3 Rh26p14n1n2 Rh26p14n1n3 17383.6537409676
Rh26p14n1t4 Rh26p14n1n3 h26p 17346.4280730987
* h26 input 15 w=+0.0644124429905188 w+  bank=n alpha=1 R=517498.355686336 G_phys=1.93237328971556e-06 G_eff=1.93237328971556e-06
* tiled Rh26p15n1 series x4  each=129374.588921584
Rh26p15n1t1 in15 Rh26p15n1n1 129702.667713528
Rh26p15n1t2 Rh26p15n1n1 Rh26p15n1n2 129660.521993422
Rh26p15n1t3 Rh26p15n1n2 Rh26p15n1n3 129321.194583308
Rh26p15n1t4 Rh26p15n1n3 h26p 128746.775810111
* h26 input 16 w=+0.0297993400818282 w+  bank=f alpha=0.001 R=1118.5930037981 G_phys=0.000893980202454845 G_eff=8.93980202454845e-07
* tiled Rh26p16f1 parallel x4  each=4474.37201519241
Rh26p16f1t1 inf16 h26p 4494.06699334909
Rh26p16f1t2 inf16 h26p 4462.83727783399
Rh26p16f1t3 inf16 h26p 4457.32858070446
Rh26p16f1t4 inf16 h26p 4455.65078225828
* h26 bias=-0.0154994859917217 b-  bank=f alpha=0.001 R=2150.60895252505 G_phys=0.000464984579751652 G_eff=4.64984579751652e-07
* tiled Rh26bnf1 parallel x4  each=8602.43581010018
Rh26bnf1t1 vreff h26n 8566.70771545497
Rh26bnf1t2 vreff h26n 8625.52908556865
Rh26bnf1t3 vreff h26n 8639.01192649284
Rh26bnf1t4 vreff h26n 8627.34377802949
Vh26p h26p 0 DC 0
Vh26n h26n 0 DC 0
Fh26p 0 h26d Vh26p 1.001
Fh26n h26d 0 Vh26n 1.001
* ratiometric I-to-V: V = I * R_IV,  R_IV=33333.3333333333 (weight ~ R_IV / R_w)
* tiled Rh26iv series x4  each=8333.33333333333
Rh26ivt1 h26d Rh26ivn1 8374.87067858018
Rh26ivt2 Rh26ivn1 Rh26ivn2 8327.03829104295
Rh26ivt3 Rh26ivn2 Rh26ivn3 8310.60627905522
Rh26ivt4 Rh26ivn3 0 8347.61991136213
Bh26leak 0 h26d I = 1e-08
Eh26sc h26raw 0 h26d 0 1
Eh26lin h26lin 0 h26raw 0 1
* direct bounded ReLU: y=max(0, min(15, v(h26lin))) no high-gain op-amp loop
Bh26relu h26y 0 V = max(0, min(15, (0.001) + v(h26lin)))
Eh26 h26buf 0 h26y 0 1

* h27 input 1 w=-0.473232380174693 w-  bank=n alpha=1 R=70437.5582267393 G_phys=1.41969714052408e-05 G_eff=1.41969714052408e-05
* tiled Rh27n1n1 series x4  each=17609.3895566848
Rh27n1n1t1 in1 Rh27n1n1n1 17693.1680510644
Rh27n1n1t2 Rh27n1n1n1 Rh27n1n1n2 17602.3214591921
Rh27n1n1t3 Rh27n1n1n2 Rh27n1n1n3 17560.84027793
Rh27n1n1t4 Rh27n1n1n3 h27n 17608.3703671361
* h27 input 2 w=+0.0192680774504759 w+  bank=f alpha=0.001 R=1729.97713025645 G_phys=0.000578042323514278 G_eff=5.78042323514278e-07
* tiled Rh27p2f1 parallel x4  each=6919.90852102579
Rh27p2f1t1 inf2 h27p 6939.72984928122
Rh27p2f1t2 inf2 h27p 6889.83407941961
Rh27p2f1t3 inf2 h27p 6887.49476408948
Rh27p2f1t4 inf2 h27p 6954.03142335558
* h27 input 3 w=-0.33925202928177 w-  bank=n alpha=1 R=98255.3690361212 G_phys=1.01775608784531e-05 G_eff=1.01775608784531e-05
* tiled Rh27n3n1 series x4  each=24563.8422590303
Rh27n3n1t1 in3 Rh27n3n1n1 24566.4502990782
Rh27n3n1t2 Rh27n3n1n1 Rh27n3n1n2 24630.2963800013
Rh27n3n1t3 Rh27n3n1n2 Rh27n3n1n3 24651.7221606732
Rh27n3n1t4 Rh27n3n1n3 h27n 24496.8775639032
* h27 input 4 w=+0.300608725256371 w+  bank=n alpha=1 R=110886.113850838 G_phys=9.01826175769113e-06 G_eff=9.01826175769113e-06
* tiled Rh27p4n1 series x4  each=27721.5284627096
Rh27p4n1t1 in4 Rh27p4n1n1 27627.2907131465
Rh27p4n1t2 Rh27p4n1n1 Rh27p4n1n2 27775.3856442609
Rh27p4n1t3 Rh27p4n1n2 Rh27p4n1n3 27844.1250666067
Rh27p4n1t4 Rh27p4n1n3 h27p 27607.4488479759
* h27 input 5 w=-0.265937781386581 w-  bank=n alpha=1 R=125342.60141427 G_phys=7.97813344159742e-06 G_eff=7.97813344159742e-06
* tiled Rh27n5n1 series x4  each=31335.6503535674
Rh27n5n1t1 in5 Rh27n5n1n1 31366.3993138478
Rh27n5n1t2 Rh27n5n1n1 Rh27n5n1n2 31237.9140046844
Rh27n5n1t3 Rh27n5n1n2 Rh27n5n1n3 31457.4502628642
Rh27n5n1t4 Rh27n5n1n3 h27n 31395.5466378668
* h27 input 6 w=-0.0714924370091341 w-  bank=n alpha=1 R=466249.784282421 G_phys=2.14477311027402e-06 G_eff=2.14477311027402e-06
* tiled Rh27n6n1 series x4  each=116562.446070605
Rh27n6n1t1 in6 Rh27n6n1n1 116820.933524075
Rh27n6n1t2 Rh27n6n1n1 Rh27n6n1n2 116275.647761545
Rh27n6n1t3 Rh27n6n1n2 Rh27n6n1n3 117048.919154176
Rh27n6n1t4 Rh27n6n1n3 h27n 116498.816536986
* h27 input 7 w=+0.32365049129675 w+  bank=n alpha=1 R=102991.758794429 G_phys=9.7095147389025e-06 G_eff=9.7095147389025e-06
* tiled Rh27p7n1 series x4  each=25747.9396986073
Rh27p7n1t1 in7 Rh27p7n1n1 25839.2358108386
Rh27p7n1t2 Rh27p7n1n1 Rh27p7n1n2 25747.7288771675
Rh27p7n1t3 Rh27p7n1n2 Rh27p7n1n3 25634.2135909795
Rh27p7n1t4 Rh27p7n1n3 h27p 25812.7033658322
* h27 input 8 w=+0.264468500812474 w+  bank=n alpha=1 R=126038.954472574 G_phys=7.93405502437422e-06 G_eff=7.93405502437422e-06
* tiled Rh27p8n1 series x4  each=31509.7386181435
Rh27p8n1t1 in8 Rh27p8n1n1 31626.1006066577
Rh27p8n1t2 Rh27p8n1n1 Rh27p8n1n2 31576.6252313237
Rh27p8n1t3 Rh27p8n1n2 Rh27p8n1n3 31658.7471114459
Rh27p8n1t4 Rh27p8n1n3 h27p 31557.2638371453
* h27 input 9 w=-0.251852607935664 w-  bank=n alpha=1 R=132352.543841231 G_phys=7.55557823806993e-06 G_eff=7.55557823806993e-06
* tiled Rh27n9n1 series x4  each=33088.1359603077
Rh27n9n1t1 in9 Rh27n9n1n1 33185.6171751406
Rh27n9n1t2 Rh27n9n1n1 Rh27n9n1n2 33027.6802344175
Rh27n9n1t3 Rh27n9n1n2 Rh27n9n1n3 33228.615872481
Rh27n9n1t4 Rh27n9n1n3 h27n 32986.1022840008
* h27 input 10 w=-0.0922567674902895 w-  bank=n alpha=1 R=361310.440850226 G_phys=2.76770302470868e-06 G_eff=2.76770302470868e-06
* tiled Rh27n10n1 series x4  each=90327.6102125566
Rh27n10n1t1 in10 Rh27n10n1n1 90511.2501204527
Rh27n10n1t2 Rh27n10n1n1 Rh27n10n1n2 89884.6050088319
Rh27n10n1t3 Rh27n10n1n2 Rh27n10n1n3 90132.3876367861
Rh27n10n1t4 Rh27n10n1n3 h27n 90461.9663778755
* h27 input 11 w=-0.519972660308657 w-  bank=n alpha=1 R=64105.9345573026 G_phys=1.55991798092597e-05 G_eff=1.55991798092597e-05
* tiled Rh27n11n1 series x4  each=16026.4836393257
Rh27n11n1t1 in11 Rh27n11n1n1 16061.6166035911
Rh27n11n1t2 Rh27n11n1n1 Rh27n11n1n2 16052.6110987652
Rh27n11n1t3 Rh27n11n1n2 Rh27n11n1n3 16025.129872791
Rh27n11n1t4 Rh27n11n1n3 h27n 16073.8614301572
* h27 input 12 w=+0.109096005067641 w+  bank=n alpha=1 R=305541.282768935 G_phys=3.27288015202924e-06 G_eff=3.27288015202924e-06
* tiled Rh27p12n1 series x4  each=76385.3206922337
Rh27p12n1t1 in12 Rh27p12n1n1 76312.5921988431
Rh27p12n1t2 Rh27p12n1n1 Rh27p12n1n2 76573.3237944979
Rh27p12n1t3 Rh27p12n1n2 Rh27p12n1n3 76468.9561558819
Rh27p12n1t4 Rh27p12n1n3 h27p 76068.9142454483
* h27 input 13 w=+0.0733868764952063 w+  bank=n alpha=1 R=454213.817582367 G_phys=2.20160629485619e-06 G_eff=2.20160629485619e-06
* tiled Rh27p13n1 series x4  each=113553.454395592
Rh27p13n1t1 in13 Rh27p13n1n1 113666.332121529
Rh27p13n1t2 Rh27p13n1n1 Rh27p13n1n2 112986.049423901
Rh27p13n1t3 Rh27p13n1n2 Rh27p13n1n3 113268.406546559
Rh27p13n1t4 Rh27p13n1n3 h27p 113885.892641525
* h27 input 14 w=-0.779894486957924 w-  bank=n alpha=1 R=42740.8244201779 G_phys=2.33968346087377e-05 G_eff=2.33968346087377e-05
* tiled Rh27n14n1 series x4  each=10685.2061050445
Rh27n14n1t1 in14 Rh27n14n1n1 10636.3423320851
Rh27n14n1t2 Rh27n14n1n1 Rh27n14n1n2 10680.8022503451
Rh27n14n1t3 Rh27n14n1n2 Rh27n14n1n3 10653.6282806688
Rh27n14n1t4 Rh27n14n1n3 h27n 10641.3518375001
* h27 input 15 w=+0.520337169546291 w+  bank=n alpha=1 R=64061.0267423301 G_phys=1.56101150863887e-05 G_eff=1.56101150863887e-05
* tiled Rh27p15n1 series x4  each=16015.2566855825
Rh27p15n1t1 in15 Rh27p15n1n1 15966.5610600988
Rh27p15n1t2 Rh27p15n1n1 Rh27p15n1n2 15993.3186385452
Rh27p15n1t3 Rh27p15n1n2 Rh27p15n1n3 16055.3144359075
Rh27p15n1t4 Rh27p15n1n3 h27p 16019.1873877437
* h27 input 16 w=+0.00922691889455085 w+  bank=f alpha=0.001 R=3612.61800545565 G_phys=0.000276807566836526 G_eff=2.76807566836526e-07
* tiled Rh27p16f1 parallel x4  each=14450.4720218226
Rh27p16f1t1 inf16 h27p 14515.6261989328
Rh27p16f1t2 inf16 h27p 14415.2349613847
Rh27p16f1t3 inf16 h27p 14434.6747362968
Rh27p16f1t4 inf16 h27p 14413.7181430685
* h27 bias=+0.0122793649099004 b+  bank=f alpha=0.001 R=2714.58121636714 G_phys=0.000368380947297011 G_eff=3.68380947297011e-07
* tiled Rh27bpf1 parallel x4  each=10858.3248654686
Rh27bpf1t1 vreff h27p 10840.5466397235
Rh27bpf1t2 vreff h27p 10831.2766212648
Rh27bpf1t3 vreff h27p 10870.0174281291
Rh27bpf1t4 vreff h27p 10829.568575917
Vh27p h27p 0 DC 0
Vh27n h27n 0 DC 0
Fh27p 0 h27d Vh27p 1.001
Fh27n h27d 0 Vh27n 1.001
* ratiometric I-to-V: V = I * R_IV,  R_IV=33333.3333333333 (weight ~ R_IV / R_w)
* tiled Rh27iv series x4  each=8333.33333333333
Rh27ivt1 h27d Rh27ivn1 8361.16460641985
Rh27ivt2 Rh27ivn1 Rh27ivn2 8319.28324105589
Rh27ivt3 Rh27ivn2 Rh27ivn3 8335.81700663941
Rh27ivt4 Rh27ivn3 0 8317.35168059822
Bh27leak 0 h27d I = 1e-08
Eh27sc h27raw 0 h27d 0 1
Eh27lin h27lin 0 h27raw 0 1
* direct bounded ReLU: y=max(0, min(15, v(h27lin))) no high-gain op-amp loop
Bh27relu h27y 0 V = max(0, min(15, (0.001) + v(h27lin)))
Eh27 h27buf 0 h27y 0 1

* h28 input 1 w=+0.0928477001370985 w+  bank=n alpha=1 R=359010.86708786 G_phys=2.78543100411296e-06 G_eff=2.78543100411296e-06
* tiled Rh28p1n1 series x4  each=89752.7167719649
Rh28p1n1t1 in1 Rh28p1n1n1 89658.8542763651
Rh28p1n1t2 Rh28p1n1n1 Rh28p1n1n2 89407.2612875283
Rh28p1n1t3 Rh28p1n1n2 Rh28p1n1n3 89594.5861747711
Rh28p1n1t4 Rh28p1n1n3 h28p 89805.4800062371
* h28 input 2 w=+0.628866123797832 w+  bank=n alpha=1 R=53005.4523083984 G_phys=1.8865983713935e-05 G_eff=1.8865983713935e-05
* tiled Rh28p2n1 series x4  each=13251.3630770996
Rh28p2n1t1 in2 Rh28p2n1n1 13217.0005583706
Rh28p2n1t2 Rh28p2n1n1 Rh28p2n1n2 13214.5959749431
Rh28p2n1t3 Rh28p2n1n2 Rh28p2n1n3 13297.2104000864
Rh28p2n1t4 Rh28p2n1n3 h28p 13314.916658271
* h28 input 3 w=-0.429442295580587 w-  bank=n alpha=1 R=77620.0520451022 G_phys=1.28832688674176e-05 G_eff=1.28832688674176e-05
* tiled Rh28n3n1 series x4  each=19405.0130112755
Rh28n3n1t1 in3 Rh28n3n1n1 19438.6183768404
Rh28n3n1t2 Rh28n3n1n1 Rh28n3n1n2 19494.1007210177
Rh28n3n1t3 Rh28n3n1n2 Rh28n3n1n3 19461.9063585897
Rh28n3n1t4 Rh28n3n1n3 h28n 19329.8747632649
* h28 input 4 w=+0.0390774584408687 w+  bank=n alpha=1 R=853006.686291349 G_phys=1.17232375322606e-06 G_eff=1.17232375322606e-06
* tiled Rh28p4n1 series x4  each=213251.671572837
Rh28p4n1t1 in4 Rh28p4n1n1 212886.786917157
Rh28p4n1t2 Rh28p4n1n1 Rh28p4n1n2 212425.690455886
Rh28p4n1t3 Rh28p4n1n2 Rh28p4n1n3 214269.203000569
Rh28p4n1t4 Rh28p4n1n3 h28p 212667.295894481
* h28 input 5 w=-0.500231352741198 w-  bank=n alpha=1 R=66635.8339009967 G_phys=1.50069405822359e-05 G_eff=1.50069405822359e-05
* tiled Rh28n5n1 series x4  each=16658.9584752492
Rh28n5n1t1 in5 Rh28n5n1n1 16705.1932318871
Rh28n5n1t2 Rh28n5n1n1 Rh28n5n1n2 16697.6283831296
Rh28n5n1t3 Rh28n5n1n2 Rh28n5n1n3 16607.4840734118
Rh28n5n1t4 Rh28n5n1n3 h28n 16633.1011646107
* h28 input 6 w=-0.374880121408735 w-  bank=n alpha=1 R=88917.3136416848 G_phys=1.1246403642262e-05 G_eff=1.1246403642262e-05
* tiled Rh28n6n1 series x4  each=22229.3284104212
Rh28n6n1t1 in6 Rh28n6n1n1 22156.0799064962
Rh28n6n1t2 Rh28n6n1n1 Rh28n6n1n2 22137.3065394406
Rh28n6n1t3 Rh28n6n1n2 Rh28n6n1n3 22257.6920489068
Rh28n6n1t4 Rh28n6n1n3 h28n 22154.9852812543
* h28 input 7 w=-0.575469641796179 w-  bank=n alpha=1 R=57923.7042449224 G_phys=1.72640892538854e-05 G_eff=1.72640892538854e-05
* tiled Rh28n7n1 series x4  each=14480.9260612306
Rh28n7n1t1 in7 Rh28n7n1n1 14528.0812639766
Rh28n7n1t2 Rh28n7n1n1 Rh28n7n1n2 14482.9550240598
Rh28n7n1t3 Rh28n7n1n2 Rh28n7n1n3 14495.9821996677
Rh28n7n1t4 Rh28n7n1n3 h28n 14419.5321541319
* h28 input 8 w=+0.475130253886277 w+  bank=n alpha=1 R=70156.2004538479 G_phys=1.42539076165883e-05 G_eff=1.42539076165883e-05
* tiled Rh28p8n1 series x4  each=17539.050113462
Rh28p8n1t1 in8 Rh28p8n1n1 17584.9849815873
Rh28p8n1t2 Rh28p8n1n1 Rh28p8n1n2 17474.9919945579
Rh28p8n1t3 Rh28p8n1n2 Rh28p8n1n3 17488.2930746674
Rh28p8n1t4 Rh28p8n1n3 h28p 17608.1316936367
* h28 input 9 w=-0.381841652824232 w-  bank=n alpha=1 R=87296.221056002 G_phys=1.1455249584727e-05 G_eff=1.1455249584727e-05
* tiled Rh28n9n1 series x4  each=21824.0552640005
Rh28n9n1t1 in9 Rh28n9n1n1 21817.5498864635
Rh28n9n1t2 Rh28n9n1n1 Rh28n9n1n2 21806.1530454253
Rh28n9n1t3 Rh28n9n1n2 Rh28n9n1n3 21767.0236772617
Rh28n9n1t4 Rh28n9n1n3 h28n 21864.5766902049
* h28 input 10 w=+0.758567082707225 w+  bank=n alpha=1 R=43942.4990791469 G_phys=2.27570124812167e-05 G_eff=2.27570124812167e-05
* tiled Rh28p10n1 series x4  each=10985.6247697867
Rh28p10n1t1 in10 Rh28p10n1n1 10970.3392082675
Rh28p10n1t2 Rh28p10n1n1 Rh28p10n1n2 10973.9609558396
Rh28p10n1t3 Rh28p10n1n2 Rh28p10n1n3 10985.8257444765
Rh28p10n1t4 Rh28p10n1n3 h28p 10936.1660083672
* h28 input 11 w=-0.0530277840915393 w-  bank=n alpha=1 R=628601.287125096 G_phys=1.59083352274618e-06 G_eff=1.59083352274618e-06
* tiled Rh28n11n1 series x4  each=157150.321781274
Rh28n11n1t1 in11 Rh28n11n1n1 157730.873566877
Rh28n11n1t2 Rh28n11n1n1 Rh28n11n1n2 157359.456430644
Rh28n11n1t3 Rh28n11n1n2 Rh28n11n1n3 156901.094682244
Rh28n11n1t4 Rh28n11n1n3 h28n 157670.339834862
* h28 input 12 w=+0.0401492881024246 w+  bank=n alpha=1 R=830234.729151284 G_phys=1.20447864307274e-06 G_eff=1.20447864307274e-06
* tiled Rh28p12n1 series x4  each=207558.682287821
Rh28p12n1t1 in12 Rh28p12n1n1 208552.499136748
Rh28p12n1t2 Rh28p12n1n1 Rh28p12n1n2 207624.174809115
Rh28p12n1t3 Rh28p12n1n2 Rh28p12n1n3 207044.462560313
Rh28p12n1t4 Rh28p12n1n3 h28p 208504.276863829
* h28 input 13 w=-0.344979802042177 w-  bank=n alpha=1 R=96624.0143220269 G_phys=1.03493940612653e-05 G_eff=1.03493940612653e-05
* tiled Rh28n13n1 series x4  each=24156.0035805067
Rh28n13n1t1 in13 Rh28n13n1n1 24175.0159551827
Rh28n13n1t2 Rh28n13n1n1 Rh28n13n1n2 24064.5445445439
Rh28n13n1t3 Rh28n13n1n2 Rh28n13n1n3 24210.7885873922
Rh28n13n1t4 Rh28n13n1n3 h28n 24065.4067772829
* h28 input 14 w=+0.139059200435423 w+  bank=n alpha=1 R=239706.062086937 G_phys=4.1717760130627e-06 G_eff=4.1717760130627e-06
* tiled Rh28p14n1 series x4  each=59926.5155217342
Rh28p14n1t1 in14 Rh28p14n1n1 59837.7644300278
Rh28p14n1t2 Rh28p14n1n1 Rh28p14n1n2 60117.5153671935
Rh28p14n1t3 Rh28p14n1n2 Rh28p14n1n3 60051.367267788
Rh28p14n1t4 Rh28p14n1n3 h28p 59967.596950144
* h28 input 15 w=-0.317012120275182 w-  bank=n alpha=1 R=105148.450804967 G_phys=9.51036360825546e-06 G_eff=9.51036360825546e-06
* tiled Rh28n15n1 series x4  each=26287.1127012418
Rh28n15n1t1 in15 Rh28n15n1n1 26418.1963618098
Rh28n15n1t2 Rh28n15n1n1 Rh28n15n1n2 26342.2989418314
Rh28n15n1t3 Rh28n15n1n2 Rh28n15n1n3 26227.0753545417
Rh28n15n1t4 Rh28n15n1n3 h28n 26302.9984550654
* h28 input 16 w=-0.398313118116402 w-  bank=n alpha=1 R=83686.2554037001 G_phys=1.1949393543492e-05 G_eff=1.1949393543492e-05
* tiled Rh28n16n1 series x4  each=20921.563850925
Rh28n16n1t1 in16 Rh28n16n1n1 20925.4871242606
Rh28n16n1t2 Rh28n16n1n1 Rh28n16n1n2 20911.0727458545
Rh28n16n1t3 Rh28n16n1n2 Rh28n16n1n3 21000.4935048594
Rh28n16n1t4 Rh28n16n1n3 h28n 20939.3892902421
* h28 bias=-0.0847668662328426 b-  bank=n alpha=1 R=393235.409243175 G_phys=2.54300598698528e-06 G_eff=2.54300598698528e-06
* tiled Rh28bnn1 series x4  each=98308.8523107937
Rh28bnn1t1 vref Rh28bnn1n1 98685.5437525169
Rh28bnn1t2 Rh28bnn1n1 Rh28bnn1n2 98559.1442374214
Rh28bnn1t3 Rh28bnn1n2 Rh28bnn1n3 98487.4432272493
Rh28bnn1t4 Rh28bnn1n3 h28n 98025.6514043601
Vh28p h28p 0 DC 0
Vh28n h28n 0 DC 0
Fh28p 0 h28d Vh28p 1.001
Fh28n h28d 0 Vh28n 1.001
* ratiometric I-to-V: V = I * R_IV,  R_IV=33333.3333333333 (weight ~ R_IV / R_w)
* tiled Rh28iv series x4  each=8333.33333333333
Rh28ivt1 h28d Rh28ivn1 8322.65462420782
Rh28ivt2 Rh28ivn1 Rh28ivn2 8304.23009046067
Rh28ivt3 Rh28ivn2 Rh28ivn3 8315.22429958472
Rh28ivt4 Rh28ivn3 0 8293.11804766882
Bh28leak 0 h28d I = 1e-08
Eh28sc h28raw 0 h28d 0 1
Eh28lin h28lin 0 h28raw 0 1
* direct bounded ReLU: y=max(0, min(15, v(h28lin))) no high-gain op-amp loop
Bh28relu h28y 0 V = max(0, min(15, (0.001) + v(h28lin)))
Eh28 h28buf 0 h28y 0 1

* h29 input 1 w=+0.125932002984804 w+  bank=n alpha=1 R=264693.108529018 G_phys=3.77796008954411e-06 G_eff=3.77796008954411e-06
* tiled Rh29p1n1 series x4  each=66173.2771322546
Rh29p1n1t1 in1 Rh29p1n1n1 65859.1105696078
Rh29p1n1t2 Rh29p1n1n1 Rh29p1n1n2 65886.2306619619
Rh29p1n1t3 Rh29p1n1n2 Rh29p1n1n3 66341.870657555
Rh29p1n1t4 Rh29p1n1n3 h29p 65957.5003079049
* h29 input 2 w=-0.650061827874195 w-  bank=n alpha=1 R=51277.1738072033 G_phys=1.95018548362258e-05 G_eff=1.95018548362258e-05
* tiled Rh29n2n1 series x4  each=12819.2934518008
Rh29n2n1t1 in2 Rh29n2n1n1 12767.0467065954
Rh29n2n1t2 Rh29n2n1n1 Rh29n2n1n2 12807.1308321647
Rh29n2n1t3 Rh29n2n1n2 Rh29n2n1n3 12867.6204592273
Rh29n2n1t4 Rh29n2n1n3 h29n 12795.1928712387
* h29 input 3 w=-0.0394473233812264 w-  bank=n alpha=1 R=845008.747772155 G_phys=1.18341970143679e-06 G_eff=1.18341970143679e-06
* tiled Rh29n3n1 series x4  each=211252.186943039
Rh29n3n1t1 in3 Rh29n3n1n1 211409.651298176
Rh29n3n1t2 Rh29n3n1n1 Rh29n3n1n2 210393.570879027
Rh29n3n1t3 Rh29n3n1n2 Rh29n3n1n3 210519.855969487
Rh29n3n1t4 Rh29n3n1n3 h29n 210433.229426092
* h29 input 4 w=-0.231823015010513 w-  bank=n alpha=1 R=143787.85183094 G_phys=6.9546904503154e-06 G_eff=6.9546904503154e-06
* tiled Rh29n4n1 series x4  each=35946.9629577349
Rh29n4n1t1 in4 Rh29n4n1n1 35936.2095398076
Rh29n4n1t2 Rh29n4n1n1 Rh29n4n1n2 35973.0358082003
Rh29n4n1t3 Rh29n4n1n2 Rh29n4n1n3 36036.8125269708
Rh29n4n1t4 Rh29n4n1n3 h29n 36001.8501790533
* h29 input 5 w=+0.19053303604273 w+  bank=n alpha=1 R=174947.788717637 G_phys=5.71599108128189e-06 G_eff=5.71599108128189e-06
* tiled Rh29p5n1 series x4  each=43736.9471794092
Rh29p5n1t1 in5 Rh29p5n1n1 43569.7115917971
Rh29p5n1t2 Rh29p5n1n1 Rh29p5n1n2 43679.5751218899
Rh29p5n1t3 Rh29p5n1n2 Rh29p5n1n3 43661.1006139808
Rh29p5n1t4 Rh29p5n1n3 h29p 43907.3729348841
* h29 input 6 w=+0.447719174196915 w+  bank=n alpha=1 R=74451.4312864178 G_phys=1.34315752259074e-05 G_eff=1.34315752259074e-05
* tiled Rh29p6n1 series x4  each=18612.8578216045
Rh29p6n1t1 in6 Rh29p6n1n1 18677.8866120581
Rh29p6n1t2 Rh29p6n1n1 Rh29p6n1n2 18599.9795810729
Rh29p6n1t3 Rh29p6n1n2 Rh29p6n1n3 18606.308099816
Rh29p6n1t4 Rh29p6n1n3 h29p 18672.7802173432
* h29 input 7 w=+0.0126486175371352 w+  bank=f alpha=0.001 R=2635.33411738237 G_phys=0.000379458526114055 G_eff=3.79458526114055e-07
* tiled Rh29p7f1 parallel x4  each=10541.3364695295
Rh29p7f1t1 inf7 h29p 10592.2018053922
Rh29p7f1t2 inf7 h29p 10507.4940648717
Rh29p7f1t3 inf7 h29p 10566.6271586067
Rh29p7f1t4 inf7 h29p 10559.5732993718
* h29 input 8 w=+0.108364236263017 w+  bank=n alpha=1 R=307604.561088107 G_phys=3.25092708789052e-06 G_eff=3.25092708789052e-06
* tiled Rh29p8n1 series x4  each=76901.1402720267
Rh29p8n1t1 in8 Rh29p8n1n1 76759.5378908435
Rh29p8n1t2 Rh29p8n1n1 Rh29p8n1n2 76977.7996478574
Rh29p8n1t3 Rh29p8n1n2 Rh29p8n1n3 76523.2053142024
Rh29p8n1t4 Rh29p8n1n3 h29p 76810.1613510327
* h29 input 9 w=+0.430118110319429 w+  bank=n alpha=1 R=77498.0930437414 G_phys=1.29035433095829e-05 G_eff=1.29035433095829e-05
* tiled Rh29p9n1 series x4  each=19374.5232609354
Rh29p9n1t1 in9 Rh29p9n1n1 19369.6207922069
Rh29p9n1t2 Rh29p9n1n1 Rh29p9n1n2 19364.1738490348
Rh29p9n1t3 Rh29p9n1n2 Rh29p9n1n3 19398.6524275601
Rh29p9n1t4 Rh29p9n1n3 h29p 19323.7197581792
* h29 input 10 w=+0.849664650654267 w+  bank=n alpha=1 R=39231.1640924048 G_phys=2.5489939519628e-05 G_eff=2.5489939519628e-05
* tiled Rh29p10n1 series x4  each=9807.7910231012
Rh29p10n1t1 in10 Rh29p10n1n1 9775.73981029619
Rh29p10n1t2 Rh29p10n1n1 Rh29p10n1n2 9841.62288209028
Rh29p10n1t3 Rh29p10n1n2 Rh29p10n1n3 9787.62623903777
Rh29p10n1t4 Rh29p10n1n3 h29p 9769.23296029719
* h29 input 11 w=+0.430581993177771 w+  bank=n alpha=1 R=77414.6013104902 G_phys=1.29174597953331e-05 G_eff=1.29174597953331e-05
* tiled Rh29p11n1 series x4  each=19353.6503276226
Rh29p11n1t1 in11 Rh29p11n1n1 19427.9387149786
Rh29p11n1t2 Rh29p11n1n1 Rh29p11n1n2 19362.0674622522
Rh29p11n1t3 Rh29p11n1n2 Rh29p11n1n3 19274.3819075421
Rh29p11n1t4 Rh29p11n1n3 h29p 19257.0462711048
* h29 input 12 w=-0.974573192285427 w-  bank=n alpha=1 R=34203.006605553 G_phys=2.92371957685628e-05 G_eff=2.92371957685628e-05
* tiled Rh29n12n1 series x4  each=8550.75165138825
Rh29n12n1t1 in12 Rh29n12n1n1 8516.92164747053
Rh29n12n1t2 Rh29n12n1n1 Rh29n12n1n2 8554.15780856356
Rh29n12n1t3 Rh29n12n1n2 Rh29n12n1n3 8552.43956312846
Rh29n12n1t4 Rh29n12n1n3 h29n 8589.72660077568
* h29 input 13 w=+0.16029064712382 w+  bank=n alpha=1 R=207955.572776396 G_phys=4.80871941371461e-06 G_eff=4.80871941371461e-06
* tiled Rh29p13n1 series x4  each=51988.8931940991
Rh29p13n1t1 in13 Rh29p13n1n1 52058.8963598581
Rh29p13n1t2 Rh29p13n1n1 Rh29p13n1n2 51799.1412208039
Rh29p13n1t3 Rh29p13n1n2 Rh29p13n1n3 51928.8850994148
Rh29p13n1t4 Rh29p13n1n3 h29p 51757.6913658652
* h29 input 14 w=+0.466636118473806 w+  bank=n alpha=1 R=71433.2474784727 G_phys=1.39990835542142e-05 G_eff=1.39990835542142e-05
* tiled Rh29p14n1 series x4  each=17858.3118696182
Rh29p14n1t1 in14 Rh29p14n1n1 17923.7091134681
Rh29p14n1t2 Rh29p14n1n1 Rh29p14n1n2 17853.3858528801
Rh29p14n1t3 Rh29p14n1n2 Rh29p14n1n3 17792.6890702779
Rh29p14n1t4 Rh29p14n1n3 h29p 17889.5726185406
* h29 input 15 w=-0.0331745755104183 w-  bank=f alpha=0.001 R=1004.78552688233 G_phys=0.000995237265312548 G_eff=9.95237265312548e-07
* tiled Rh29n15f1 parallel x4  each=4019.14210752933
Rh29n15f1t1 inf15 h29n 4038.10679416309
Rh29n15f1t2 inf15 h29n 4019.61775425072
Rh29n15f1t3 inf15 h29n 4005.65883226001
Rh29n15f1t4 inf15 h29n 4016.75801007916
* h29 input 16 w=-0.589046477086867 w-  bank=n alpha=1 R=56588.6303202822 G_phys=1.7671394312606e-05 G_eff=1.7671394312606e-05
* tiled Rh29n16n1 series x4  each=14147.1575800706
Rh29n16n1t1 in16 Rh29n16n1n1 14162.3567106345
Rh29n16n1t2 Rh29n16n1n1 Rh29n16n1n2 14139.0406468741
Rh29n16n1t3 Rh29n16n1n2 Rh29n16n1n3 14121.6214080023
Rh29n16n1t4 Rh29n16n1n3 h29n 14103.7215417313
* h29 bias=-0.0665836653392507 b-  bank=n alpha=1 R=500623.285959049 G_phys=1.99750996017752e-06 G_eff=1.99750996017752e-06
* tiled Rh29bnn1 series x4  each=125155.821489762
Rh29bnn1t1 vref Rh29bnn1n1 124802.244130919
Rh29bnn1t2 Rh29bnn1n1 Rh29bnn1n2 125235.605325612
Rh29bnn1t3 Rh29bnn1n2 Rh29bnn1n3 125759.641637518
Rh29bnn1t4 Rh29bnn1n3 h29n 124913.430248878
Vh29p h29p 0 DC 0
Vh29n h29n 0 DC 0
Fh29p 0 h29d Vh29p 1.001
Fh29n h29d 0 Vh29n 1.001
* ratiometric I-to-V: V = I * R_IV,  R_IV=33333.3333333333 (weight ~ R_IV / R_w)
* tiled Rh29iv series x4  each=8333.33333333333
Rh29ivt1 h29d Rh29ivn1 8297.20319758135
Rh29ivt2 Rh29ivn1 Rh29ivn2 8355.06091563784
Rh29ivt3 Rh29ivn2 Rh29ivn3 8327.69206946798
Rh29ivt4 Rh29ivn3 0 8297.49073472822
Bh29leak 0 h29d I = 1e-08
Eh29sc h29raw 0 h29d 0 1
Eh29lin h29lin 0 h29raw 0 1
* direct bounded ReLU: y=max(0, min(15, v(h29lin))) no high-gain op-amp loop
Bh29relu h29y 0 V = max(0, min(15, (0.001) + v(h29lin)))
Eh29 h29buf 0 h29y 0 1

* h30 input 1 w=-0.507901838841989 w-  bank=n alpha=1 R=65629.4795256756 G_phys=1.52370551652597e-05 G_eff=1.52370551652597e-05
* tiled Rh30n1n1 series x4  each=16407.3698814189
Rh30n1n1t1 in1 Rh30n1n1n1 16373.3620266239
Rh30n1n1t2 Rh30n1n1n1 Rh30n1n1n2 16388.3670913736
Rh30n1n1t3 Rh30n1n1n2 Rh30n1n1n3 16438.226014653
Rh30n1n1t4 Rh30n1n1n3 h30n 16374.679428159
* h30 input 2 w=-0.0392944483392576 w-  bank=n alpha=1 R=848296.254105474 G_phys=1.17883345017773e-06 G_eff=1.17883345017773e-06
* tiled Rh30n2n1 series x4  each=212074.063526369
Rh30n2n1t1 in2 Rh30n2n1n1 212196.550388453
Rh30n2n1t2 Rh30n2n1n1 Rh30n2n1n2 212268.378663367
Rh30n2n1t3 Rh30n2n1n2 Rh30n2n1n3 211030.040615286
Rh30n2n1t4 Rh30n2n1n3 h30n 211722.842031539
* h30 input 3 w=+0.205776196534446 w+  bank=n alpha=1 R=161988.285791615 G_phys=6.17328589603337e-06 G_eff=6.17328589603337e-06
* tiled Rh30p3n1 series x4  each=40497.0714479038
Rh30p3n1t1 in3 Rh30p3n1n1 40407.4076459789
Rh30p3n1t2 Rh30p3n1n1 Rh30p3n1n2 40670.8722592271
Rh30p3n1t3 Rh30p3n1n2 Rh30p3n1n3 40352.3731832854
Rh30p3n1t4 Rh30p3n1n3 h30p 40420.2152742856
* h30 input 4 w=+0.172383143604269 w+  bank=n alpha=1 R=193367.707749053 G_phys=5.17149430812806e-06 G_eff=5.17149430812806e-06
* tiled Rh30p4n1 series x4  each=48341.9269372634
Rh30p4n1t1 in4 Rh30p4n1n1 48503.7403259919
Rh30p4n1t2 Rh30p4n1n1 Rh30p4n1n2 48543.8302365045
Rh30p4n1t3 Rh30p4n1n2 Rh30p4n1n3 48428.0811616832
Rh30p4n1t4 Rh30p4n1n3 h30p 48262.1650718795
* h30 input 5 w=-0.0737740397875715 w-  bank=n alpha=1 R=451830.121128177 G_phys=2.21322119362714e-06 G_eff=2.21322119362714e-06
* tiled Rh30n5n1 series x4  each=112957.530282044
Rh30n5n1t1 in5 Rh30n5n1n1 113249.497031187
Rh30n5n1t2 Rh30n5n1n1 Rh30n5n1n2 112794.678869229
Rh30n5n1t3 Rh30n5n1n2 Rh30n5n1n3 113103.747514193
Rh30n5n1t4 Rh30n5n1n3 h30n 113482.266513959
* h30 input 6 w=-0.113337981854853 w-  bank=n alpha=1 R=294105.583916448 G_phys=3.40013945564559e-06 G_eff=3.40013945564559e-06
* tiled Rh30n6n1 series x4  each=73526.3959791121
Rh30n6n1t1 in6 Rh30n6n1n1 73407.1973950267
Rh30n6n1t2 Rh30n6n1n1 Rh30n6n1n2 73435.2180753737
Rh30n6n1t3 Rh30n6n1n2 Rh30n6n1n3 73846.3159297607
Rh30n6n1t4 Rh30n6n1n3 h30n 73546.5315422056
* h30 input 7 w=-0.199472534274412 w-  bank=n alpha=1 R=167107.383753781 G_phys=5.98417602823235e-06 G_eff=5.98417602823235e-06
* tiled Rh30n7n1 series x4  each=41776.8459384452
Rh30n7n1t1 in7 Rh30n7n1n1 41943.7389672055
Rh30n7n1t2 Rh30n7n1n1 Rh30n7n1n2 41826.1619270948
Rh30n7n1t3 Rh30n7n1n2 Rh30n7n1n3 41685.5868830237
Rh30n7n1t4 Rh30n7n1n3 h30n 41979.562358335
* h30 input 8 w=+0.667476408484971 w+  bank=n alpha=1 R=49939.3430383448 G_phys=2.00242922545491e-05 G_eff=2.00242922545491e-05
* tiled Rh30p8n1 series x4  each=12484.8357595862
Rh30p8n1t1 in8 Rh30p8n1n1 12423.5506517692
Rh30p8n1t2 Rh30p8n1n1 Rh30p8n1n2 12530.0943819084
Rh30p8n1t3 Rh30p8n1n2 Rh30p8n1n3 12532.3259521046
Rh30p8n1t4 Rh30p8n1n3 h30p 12463.3542074385
* h30 input 9 w=+0.0327305955718174 w+  bank=f alpha=0.001 R=1018.41511744549 G_phys=0.000981917867154523 G_eff=9.81917867154523e-07
* tiled Rh30p9f1 parallel x4  each=4073.66046978196
Rh30p9f1t1 inf9 h30p 4068.7930550841
Rh30p9f1t2 inf9 h30p 4078.88898847087
Rh30p9f1t3 inf9 h30p 4077.94166312113
Rh30p9f1t4 inf9 h30p 4083.04834651626
* h30 input 10 w=-0.112124407230259 w-  bank=n alpha=1 R=297288.825481859 G_phys=3.36373221690776e-06 G_eff=3.36373221690776e-06
* tiled Rh30n10n1 series x4  each=74322.2063704648
Rh30n10n1t1 in10 Rh30n10n1n1 74335.0428289191
Rh30n10n1t2 Rh30n10n1n1 Rh30n10n1n2 74004.2518657701
Rh30n10n1t3 Rh30n10n1n2 Rh30n10n1n3 74358.3685430642
Rh30n10n1t4 Rh30n10n1n3 h30n 74276.5331660747
* h30 input 11 w=+0.283868618501327 w+  bank=n alpha=1 R=117425.214204076 G_phys=8.51605855503981e-06 G_eff=8.51605855503981e-06
* tiled Rh30p11n1 series x4  each=29356.3035510189
Rh30p11n1t1 in11 Rh30p11n1n1 29298.7574920939
Rh30p11n1t2 Rh30p11n1n1 Rh30p11n1n2 29294.9928235813
Rh30p11n1t3 Rh30p11n1n2 Rh30p11n1n3 29244.9013212131
Rh30p11n1t4 Rh30p11n1n3 h30p 29407.3862067121
* h30 input 12 w=-0.058671072800694 w-  bank=n alpha=1 R=568139.148342606 G_phys=1.76013218402082e-06 G_eff=1.76013218402082e-06
* tiled Rh30n12n1 series x4  each=142034.787085652
Rh30n12n1t1 in12 Rh30n12n1n1 142708.844526191
Rh30n12n1t2 Rh30n12n1n1 Rh30n12n1n2 141553.624337776
Rh30n12n1t3 Rh30n12n1n2 Rh30n12n1n3 141447.463477045
Rh30n12n1t4 Rh30n12n1n3 h30n 142520.920505268
* h30 input 13 w=-0.679698898194489 w-  bank=n alpha=1 R=49041.323182777 G_phys=2.03909669458347e-05 G_eff=2.03909669458347e-05
* tiled Rh30n13n1 series x4  each=12260.3307956942
Rh30n13n1t1 in13 Rh30n13n1n1 12318.9114835269
Rh30n13n1t2 Rh30n13n1n1 Rh30n13n1n2 12262.5557240658
Rh30n13n1t3 Rh30n13n1n2 Rh30n13n1n3 12259.5019780114
Rh30n13n1t4 Rh30n13n1n3 h30n 12287.7201277964
* h30 input 14 w=+0.213421552049108 w+  bank=n alpha=1 R=156185.413390975 G_phys=6.40264656147323e-06 G_eff=6.40264656147323e-06
* tiled Rh30p14n1 series x4  each=39046.3533477437
Rh30p14n1t1 in14 Rh30p14n1n1 39175.6752764029
Rh30p14n1t2 Rh30p14n1n1 Rh30p14n1n2 39156.1732348831
Rh30p14n1t3 Rh30p14n1n2 Rh30p14n1n3 39036.4813876831
Rh30p14n1t4 Rh30p14n1n3 h30p 38923.5536639019
* h30 input 15 w=+0.353043376484901 w+  bank=n alpha=1 R=94417.1043944198 G_phys=1.0591301294547e-05 G_eff=1.0591301294547e-05
* tiled Rh30p15n1 series x4  each=23604.276098605
Rh30p15n1t1 in15 Rh30p15n1n1 23713.9610593758
Rh30p15n1t2 Rh30p15n1n1 Rh30p15n1n2 23583.5119100137
Rh30p15n1t3 Rh30p15n1n2 Rh30p15n1n3 23716.0850914969
Rh30p15n1t4 Rh30p15n1n3 h30p 23588.8741872945
* h30 input 16 w=-0.0402310971621178 w-  bank=n alpha=1 R=828546.464915216 G_phys=1.20693291486354e-06 G_eff=1.20693291486354e-06
* tiled Rh30n16n1 series x4  each=207136.616228804
Rh30n16n1t1 in16 Rh30n16n1n1 207081.911454524
Rh30n16n1t2 Rh30n16n1n1 Rh30n16n1n2 208124.086904751
Rh30n16n1t3 Rh30n16n1n2 Rh30n16n1n3 207941.638792636
Rh30n16n1t4 Rh30n16n1n3 h30n 206621.975996182
* h30 bias=+0.0283807691184238 b+  bank=f alpha=0.001 R=1174.50422834716 G_phys=0.000851423073552715 G_eff=8.51423073552714e-07
* tiled Rh30bpf1 parallel x4  each=4698.01691338865
Rh30bpf1t1 vreff h30p 4699.56553526505
Rh30bpf1t2 vreff h30p 4679.2011229301
Rh30bpf1t3 vreff h30p 4684.36137266516
Rh30bpf1t4 vreff h30p 4711.07320871839
Vh30p h30p 0 DC 0
Vh30n h30n 0 DC 0
Fh30p 0 h30d Vh30p 1.001
Fh30n h30d 0 Vh30n 1.001
* ratiometric I-to-V: V = I * R_IV,  R_IV=33333.3333333333 (weight ~ R_IV / R_w)
* tiled Rh30iv series x4  each=8333.33333333333
Rh30ivt1 h30d Rh30ivn1 8330.98480905024
Rh30ivt2 Rh30ivn1 Rh30ivn2 8342.74889123538
Rh30ivt3 Rh30ivn2 Rh30ivn3 8352.80980249076
Rh30ivt4 Rh30ivn3 0 8316.23500708095
Bh30leak 0 h30d I = 1e-08
Eh30sc h30raw 0 h30d 0 1
Eh30lin h30lin 0 h30raw 0 1
* direct bounded ReLU: y=max(0, min(15, v(h30lin))) no high-gain op-amp loop
Bh30relu h30y 0 V = max(0, min(15, (0.001) + v(h30lin)))
Eh30 h30buf 0 h30y 0 1

* h31 input 1 w=+0.786523739677983 w+  bank=n alpha=1 R=42380.5813502598 G_phys=2.35957121903395e-05 G_eff=2.35957121903395e-05
* tiled Rh31p1n1 series x4  each=10595.145337565
Rh31p1n1t1 in1 Rh31p1n1n1 10643.9804920865
Rh31p1n1t2 Rh31p1n1n1 Rh31p1n1n2 10644.6233714611
Rh31p1n1t3 Rh31p1n1n2 Rh31p1n1n3 10620.4351853489
Rh31p1n1t4 Rh31p1n1n3 h31p 10545.6799228332
* h31 input 2 w=+0.575951127580127 w+  bank=n alpha=1 R=57875.2809693839 G_phys=1.72785338274038e-05 G_eff=1.72785338274038e-05
* tiled Rh31p2n1 series x4  each=14468.820242346
Rh31p2n1t1 in2 Rh31p2n1n1 14519.1264706712
Rh31p2n1t2 Rh31p2n1n1 Rh31p2n1n2 14419.7407223039
Rh31p2n1t3 Rh31p2n1n2 Rh31p2n1n3 14437.3433423484
Rh31p2n1t4 Rh31p2n1n3 h31p 14402.1357531267
* h31 input 3 w=+0.131568206508636 w+  bank=n alpha=1 R=253354.014756941 G_phys=3.94704619525908e-06 G_eff=3.94704619525908e-06
* tiled Rh31p3n1 series x4  each=63338.5036892354
Rh31p3n1t1 in3 Rh31p3n1n1 63647.2104380172
Rh31p3n1t2 Rh31p3n1n1 Rh31p3n1n2 63217.2970360613
Rh31p3n1t3 Rh31p3n1n2 Rh31p3n1n3 63569.7243776163
Rh31p3n1t4 Rh31p3n1n3 h31p 63277.3485031433
* h31 input 4 w=+0.217046331869883 w+  bank=n alpha=1 R=153577.040653773 G_phys=6.51138995609649e-06 G_eff=6.51138995609649e-06
* tiled Rh31p4n1 series x4  each=38394.2601634433
Rh31p4n1t1 in4 Rh31p4n1n1 38220.9667366586
Rh31p4n1t2 Rh31p4n1n1 Rh31p4n1n2 38318.2250564516
Rh31p4n1t3 Rh31p4n1n2 Rh31p4n1n3 38461.176160579
Rh31p4n1t4 Rh31p4n1n3 h31p 38523.3772589805
* h31 input 5 w=+0.0670548023806797 w+  bank=n alpha=1 R=497105.832093803 G_phys=2.01164407142039e-06 G_eff=2.01164407142039e-06
* tiled Rh31p5n1 series x4  each=124276.458023451
Rh31p5n1t1 in5 Rh31p5n1n1 123680.8601332
Rh31p5n1t2 Rh31p5n1n1 Rh31p5n1n2 124085.993004327
Rh31p5n1t3 Rh31p5n1n2 Rh31p5n1n3 123990.771213474
Rh31p5n1t4 Rh31p5n1n3 h31p 124870.359138456
* h31 input 6 w=-0.0924541633789126 w-  bank=n alpha=1 R=360539.018634786 G_phys=2.77362490136738e-06 G_eff=2.77362490136738e-06
* tiled Rh31n6n1 series x4  each=90134.7546586965
Rh31n6n1t1 in6 Rh31n6n1n1 89996.2225815468
Rh31n6n1t2 Rh31n6n1n1 Rh31n6n1n2 89887.4411168409
Rh31n6n1t3 Rh31n6n1n2 Rh31n6n1n3 90228.2528958742
Rh31n6n1t4 Rh31n6n1n3 h31n 90519.3229407627
* h31 input 7 w=+0.532768880755568 w+  bank=n alpha=1 R=62566.2168669842 G_phys=1.59830664226671e-05 G_eff=1.59830664226671e-05
* tiled Rh31p7n1 series x4  each=15641.554216746
Rh31p7n1t1 in7 Rh31p7n1n1 15587.7525602794
Rh31p7n1t2 Rh31p7n1n1 Rh31p7n1n2 15656.8207908497
Rh31p7n1t3 Rh31p7n1n2 Rh31p7n1n3 15629.1228435199
Rh31p7n1t4 Rh31p7n1n3 h31p 15632.0607094042
* h31 input 8 w=-0.213038536483163 w-  bank=n alpha=1 R=156466.214439883 G_phys=6.39115609449489e-06 G_eff=6.39115609449489e-06
* tiled Rh31n8n1 series x4  each=39116.5536099706
Rh31n8n1t1 in8 Rh31n8n1n1 39308.1311884635
Rh31n8n1t2 Rh31n8n1n1 Rh31n8n1n2 39070.2346260935
Rh31n8n1t3 Rh31n8n1n2 Rh31n8n1n3 39006.3762053162
Rh31n8n1t4 Rh31n8n1n3 h31n 39085.0049442417
* h31 input 9 w=+0.217996086164886 w+  bank=n alpha=1 R=152907.943989971 G_phys=6.53988258494657e-06 G_eff=6.53988258494657e-06
* tiled Rh31p9n1 series x4  each=38226.9859974928
Rh31p9n1t1 in9 Rh31p9n1n1 38131.9811477944
Rh31p9n1t2 Rh31p9n1n1 Rh31p9n1n2 38211.3612530979
Rh31p9n1t3 Rh31p9n1n2 Rh31p9n1n3 38066.1590083377
Rh31p9n1t4 Rh31p9n1n3 h31p 38169.5552607713
* h31 input 10 w=-0.173189336412784 w-  bank=n alpha=1 R=192467.58503587 G_phys=5.19568009238351e-06 G_eff=5.19568009238351e-06
* tiled Rh31n10n1 series x4  each=48116.8962589675
Rh31n10n1t1 in10 Rh31n10n1n1 47877.8463317938
Rh31n10n1t2 Rh31n10n1n1 Rh31n10n1n2 48073.1220703977
Rh31n10n1t3 Rh31n10n1n2 Rh31n10n1n3 48137.3122067086
Rh31n10n1t4 Rh31n10n1n3 h31n 48281.3253121342
* h31 input 11 w=+0.227561810267943 w+  bank=n alpha=1 R=146480.348763639 G_phys=6.8268543080383e-06 G_eff=6.8268543080383e-06
* tiled Rh31p11n1 series x4  each=36620.0871909097
Rh31p11n1t1 in11 Rh31p11n1n1 36664.1495754306
Rh31p11n1t2 Rh31p11n1n1 Rh31p11n1n2 36525.3768607102
Rh31p11n1t3 Rh31p11n1n2 Rh31p11n1n3 36802.341475741
Rh31p11n1t4 Rh31p11n1n3 h31p 36524.5006075033
* h31 input 12 w=+0.400647928830177 w+  bank=n alpha=1 R=83198.5664587384 G_phys=1.20194378649053e-05 G_eff=1.20194378649053e-05
* tiled Rh31p12n1 series x4  each=20799.6416146846
Rh31p12n1t1 in12 Rh31p12n1n1 20770.8492025905
Rh31p12n1t2 Rh31p12n1n1 Rh31p12n1n2 20735.7376808978
Rh31p12n1t3 Rh31p12n1n2 Rh31p12n1n3 20820.4457060797
Rh31p12n1t4 Rh31p12n1n3 h31p 20697.9864954174
* h31 input 13 w=+0.0924404555732517 w+  bank=n alpha=1 R=360592.482226781 G_phys=2.77321366719755e-06 G_eff=2.77321366719755e-06
* tiled Rh31p13n1 series x4  each=90148.1205566953
Rh31p13n1t1 in13 Rh31p13n1n1 89988.957020023
Rh31p13n1t2 Rh31p13n1n1 Rh31p13n1n2 90481.1824957611
Rh31p13n1t3 Rh31p13n1n2 Rh31p13n1n3 89861.549242755
Rh31p13n1t4 Rh31p13n1n3 h31p 89729.3679010077
* h31 input 14 w=+0.340918137300815 w+  bank=n alpha=1 R=97775.1832074605 G_phys=1.02275441190244e-05 G_eff=1.02275441190244e-05
* tiled Rh31p14n1 series x4  each=24443.7958018651
Rh31p14n1t1 in14 Rh31p14n1n1 24325.4280217594
Rh31p14n1t2 Rh31p14n1n1 Rh31p14n1n2 24535.1449900051
Rh31p14n1t3 Rh31p14n1n2 Rh31p14n1n3 24395.5591892549
Rh31p14n1t4 Rh31p14n1n3 h31p 24539.1451515041
* h31 input 15 w=+0.631456773568415 w+  bank=n alpha=1 R=52787.9891840638 G_phys=1.89437032070525e-05 G_eff=1.89437032070525e-05
* tiled Rh31p15n1 series x4  each=13196.9972960159
Rh31p15n1t1 in15 Rh31p15n1n1 13164.7464501329
Rh31p15n1t2 Rh31p15n1n1 Rh31p15n1n2 13248.7864111654
Rh31p15n1t3 Rh31p15n1n2 Rh31p15n1n3 13215.7395750291
Rh31p15n1t4 Rh31p15n1n3 h31p 13222.8885972536
* h31 input 16 w=+0.19173700817347 w+  bank=n alpha=1 R=173849.240951834 G_phys=5.75211024520409e-06 G_eff=5.75211024520409e-06
* tiled Rh31p16n1 series x4  each=43462.3102379586
Rh31p16n1t1 in16 Rh31p16n1n1 43600.2295507956
Rh31p16n1t2 Rh31p16n1n1 Rh31p16n1n2 43629.2503608747
Rh31p16n1t3 Rh31p16n1n2 Rh31p16n1n3 43485.7189723033
Rh31p16n1t4 Rh31p16n1n3 h31p 43402.8810229524
* h31 bias=-0.0537174074345555 b-  bank=n alpha=1 R=620531.31238591 G_phys=1.61152222303666e-06 G_eff=1.61152222303666e-06
* tiled Rh31bnn1 series x4  each=155132.828096477
Rh31bnn1t1 vref Rh31bnn1n1 154954.956518914
Rh31bnn1t2 Rh31bnn1n1 Rh31bnn1n2 155040.621443667
Rh31bnn1t3 Rh31bnn1n2 Rh31bnn1n3 155576.433047177
Rh31bnn1t4 Rh31bnn1n3 h31n 154439.585874321
Vh31p h31p 0 DC 0
Vh31n h31n 0 DC 0
Fh31p 0 h31d Vh31p 1.001
Fh31n h31d 0 Vh31n 1.001
* ratiometric I-to-V: V = I * R_IV,  R_IV=33333.3333333333 (weight ~ R_IV / R_w)
* tiled Rh31iv series x4  each=8333.33333333333
Rh31ivt1 h31d Rh31ivn1 8344.6826713071
Rh31ivt2 Rh31ivn1 Rh31ivn2 8315.54813205606
Rh31ivt3 Rh31ivn2 Rh31ivn3 8292.69879659515
Rh31ivt4 Rh31ivn3 0 8372.5191498805
Bh31leak 0 h31d I = 1e-08
Eh31sc h31raw 0 h31d 0 1
Eh31lin h31lin 0 h31raw 0 1
* direct bounded ReLU: y=max(0, min(15, v(h31lin))) no high-gain op-amp loop
Bh31relu h31y 0 V = max(0, min(15, (0.001) + v(h31lin)))
Eh31 h31buf 0 h31y 0 1

* h32 input 1 w=+0.018363806586789 w+  bank=f alpha=0.001 R=1815.16469234181 G_phys=0.000550914197603669 G_eff=5.50914197603669e-07
* tiled Rh32p1f1 parallel x4  each=7260.65876936725
Rh32p1f1t1 inf1 h32p 7294.49709204434
Rh32p1f1t2 inf1 h32p 7254.31955859536
Rh32p1f1t3 inf1 h32p 7291.32695925112
Rh32p1f1t4 inf1 h32p 7237.10096492824
* h32 input 2 w=+0.274234487929714 w+  bank=n alpha=1 R=121550.478880237 G_phys=8.22703463789143e-06 G_eff=8.22703463789143e-06
* tiled Rh32p2n1 series x4  each=30387.6197200592
Rh32p2n1t1 in2 Rh32p2n1n1 30537.5885925326
Rh32p2n1t2 Rh32p2n1n1 Rh32p2n1n2 30493.0041737139
Rh32p2n1t3 Rh32p2n1n2 Rh32p2n1n3 30293.5437889853
Rh32p2n1t4 Rh32p2n1n3 h32p 30337.4029822701
* h32 input 3 w=+0.286642259390481 w+  bank=n alpha=1 R=116288.970803585 G_phys=8.59926778171444e-06 G_eff=8.59926778171444e-06
* tiled Rh32p3n1 series x4  each=29072.2427008963
Rh32p3n1t1 in3 Rh32p3n1n1 28981.4467417292
Rh32p3n1t2 Rh32p3n1n1 Rh32p3n1n2 29065.3346206478
Rh32p3n1t3 Rh32p3n1n2 Rh32p3n1n3 28933.2591441341
Rh32p3n1t4 Rh32p3n1n3 h32p 29095.8939310173
* h32 input 4 w=-0.106012181190002 w-  bank=n alpha=1 R=314429.275571559 G_phys=3.18036543570007e-06 G_eff=3.18036543570007e-06
* tiled Rh32n4n1 series x4  each=78607.3188928898
Rh32n4n1t1 in4 Rh32n4n1n1 78495.0312261703
Rh32n4n1t2 Rh32n4n1n1 Rh32n4n1n2 78393.6618741389
Rh32n4n1t3 Rh32n4n1n2 Rh32n4n1n3 78739.9312795582
Rh32n4n1t4 Rh32n4n1n3 h32n 78331.17074065
* h32 input 5 w=-0.539184466126997 w-  bank=n alpha=1 R=61821.7612476287 G_phys=1.61755339838099e-05 G_eff=1.61755339838099e-05
* tiled Rh32n5n1 series x4  each=15455.4403119072
Rh32n5n1t1 in5 Rh32n5n1n1 15431.0695590893
Rh32n5n1t2 Rh32n5n1n1 Rh32n5n1n2 15507.6901527539
Rh32n5n1t3 Rh32n5n1n2 Rh32n5n1n3 15427.8522891569
Rh32n5n1t4 Rh32n5n1n3 h32n 15483.8428861431
* h32 input 6 w=-0.141969883388357 w-  bank=n alpha=1 R=234791.580705539 G_phys=4.25909650165071e-06 G_eff=4.25909650165071e-06
* tiled Rh32n6n1 series x4  each=58697.8951763847
Rh32n6n1t1 in6 Rh32n6n1n1 58698.5020954987
Rh32n6n1t2 Rh32n6n1n1 Rh32n6n1n2 58902.1756574711
Rh32n6n1t3 Rh32n6n1n2 Rh32n6n1n3 58789.5180854073
Rh32n6n1t4 Rh32n6n1n3 h32n 58686.5766009425
* h32 input 7 w=-0.343812430494534 w-  bank=n alpha=1 R=96952.0889206571 G_phys=1.0314372914836e-05 G_eff=1.0314372914836e-05
* tiled Rh32n7n1 series x4  each=24238.0222301643
Rh32n7n1t1 in7 Rh32n7n1n1 24321.0051643229
Rh32n7n1t2 Rh32n7n1n1 Rh32n7n1n2 24200.8255736263
Rh32n7n1t3 Rh32n7n1n2 Rh32n7n1n3 24183.0497876848
Rh32n7n1t4 Rh32n7n1n3 h32n 24211.4974876185
* h32 input 8 w=-0.197072814561277 w-  bank=n alpha=1 R=169142.219882229 G_phys=5.91218443683832e-06 G_eff=5.91218443683832e-06
* tiled Rh32n8n1 series x4  each=42285.5549705573
Rh32n8n1t1 in8 Rh32n8n1n1 42214.1615535395
Rh32n8n1t2 Rh32n8n1n1 Rh32n8n1n2 42317.7399999187
Rh32n8n1t3 Rh32n8n1n2 Rh32n8n1n3 42234.4865011525
Rh32n8n1t4 Rh32n8n1n3 h32n 42132.7636373243
* h32 input 9 w=-0.180430465047897 w-  bank=n alpha=1 R=184743.376482927 G_phys=5.41291395143692e-06 G_eff=5.41291395143692e-06
* tiled Rh32n9n1 series x4  each=46185.8441207318
Rh32n9n1t1 in9 Rh32n9n1n1 46272.427156305
Rh32n9n1t2 Rh32n9n1n1 Rh32n9n1n2 46384.9644050416
Rh32n9n1t3 Rh32n9n1n2 Rh32n9n1n3 46391.8491872353
Rh32n9n1t4 Rh32n9n1n3 h32n 46127.2714064947
* h32 input 10 w=+0.113268490856906 w+  bank=n alpha=1 R=294286.019714378 G_phys=3.39805472570718e-06 G_eff=3.39805472570718e-06
* tiled Rh32p10n1 series x4  each=73571.5049285945
Rh32p10n1t1 in10 Rh32p10n1n1 73880.7327630012
Rh32p10n1t2 Rh32p10n1n1 Rh32p10n1n2 73243.7398174799
Rh32p10n1t3 Rh32p10n1n2 Rh32p10n1n3 73840.730052658
Rh32p10n1t4 Rh32p10n1n3 h32p 73390.7765981527
* h32 input 11 w=+0.0737822862098911 w+  bank=n alpha=1 R=451779.621446112 G_phys=2.21346858629673e-06 G_eff=2.21346858629673e-06
* tiled Rh32p11n1 series x4  each=112944.905361528
Rh32p11n1t1 in11 Rh32p11n1n1 112455.693796108
Rh32p11n1t2 Rh32p11n1n1 Rh32p11n1n2 112613.777280482
Rh32p11n1t3 Rh32p11n1n2 Rh32p11n1n3 112501.807260942
Rh32p11n1t4 Rh32p11n1n3 h32p 112471.466312465
* h32 input 12 w=+0.131260687318804 w+  bank=n alpha=1 R=253947.575730529 G_phys=3.93782061956414e-06 G_eff=3.93782061956414e-06
* tiled Rh32p12n1 series x4  each=63486.8939326321
Rh32p12n1t1 in12 Rh32p12n1n1 63288.7492245743
Rh32p12n1t2 Rh32p12n1n1 Rh32p12n1n2 63789.0954300099
Rh32p12n1t3 Rh32p12n1n2 Rh32p12n1n3 63230.8378584678
Rh32p12n1t4 Rh32p12n1n3 h32p 63680.5087541524
* h32 input 13 w=-0.105796213840622 w-  bank=n alpha=1 R=315071.136511074 G_phys=3.17388641521865e-06 G_eff=3.17388641521865e-06
* tiled Rh32n13n1 series x4  each=78767.7841277686
Rh32n13n1t1 in13 Rh32n13n1n1 78969.2685125212
Rh32n13n1t2 Rh32n13n1n1 Rh32n13n1n2 78702.8126270916
Rh32n13n1t3 Rh32n13n1n2 Rh32n13n1n3 78711.8739448989
Rh32n13n1t4 Rh32n13n1n3 h32n 79109.3911926539
* h32 input 14 w=-0.365435123738796 w-  bank=n alpha=1 R=91215.4611529876 G_phys=1.09630537121639e-05 G_eff=1.09630537121639e-05
* tiled Rh32n14n1 series x4  each=22803.8652882469
Rh32n14n1t1 in14 Rh32n14n1n1 22767.8847428469
Rh32n14n1t2 Rh32n14n1n1 Rh32n14n1n2 22854.4488654801
Rh32n14n1t3 Rh32n14n1n2 Rh32n14n1n3 22707.3824556
Rh32n14n1t4 Rh32n14n1n3 h32n 22713.9552785674
* h32 input 15 w=-0.0205558893905 w-  bank=f alpha=0.001 R=1621.59528591055 G_phys=0.000616676681714999 G_eff=6.16676681714999e-07
* tiled Rh32n15f1 parallel x4  each=6486.38114364218
Rh32n15f1t1 inf15 h32n 6492.20073151795
Rh32n15f1t2 inf15 h32n 6481.45397857201
Rh32n15f1t3 inf15 h32n 6504.68577265208
Rh32n15f1t4 inf15 h32n 6472.87453541354
* h32 input 16 w=-0.212152037098157 w-  bank=n alpha=1 R=157120.024814614 G_phys=6.36456111294471e-06 G_eff=6.36456111294471e-06
* tiled Rh32n16n1 series x4  each=39280.0062036535
Rh32n16n1t1 in16 Rh32n16n1n1 39216.4976757199
Rh32n16n1t2 Rh32n16n1n1 Rh32n16n1n2 39166.4890209958
Rh32n16n1t3 Rh32n16n1n2 Rh32n16n1n3 39155.7202906537
Rh32n16n1t4 Rh32n16n1n3 h32n 39352.3139295227
* h32 bias=+0.00806132622522946 b+  bank=f alpha=0.001 R=4134.96891231251 G_phys=0.000241839786756884 G_eff=2.41839786756884e-07
* tiled Rh32bpf1 series x4  each=1033.74222807813
Rh32bpf1t1 vreff Rh32bpf1n1 1030.15552511126
Rh32bpf1t2 Rh32bpf1n1 Rh32bpf1n2 1035.04964729224
Rh32bpf1t3 Rh32bpf1n2 Rh32bpf1n3 1038.03629362928
Rh32bpf1t4 Rh32bpf1n3 h32p 1030.29544578221
Vh32p h32p 0 DC 0
Vh32n h32n 0 DC 0
Fh32p 0 h32d Vh32p 1.001
Fh32n h32d 0 Vh32n 1.001
* ratiometric I-to-V: V = I * R_IV,  R_IV=33333.3333333333 (weight ~ R_IV / R_w)
* tiled Rh32iv series x4  each=8333.33333333333
Rh32ivt1 h32d Rh32ivn1 8364.27613537423
Rh32ivt2 Rh32ivn1 Rh32ivn2 8329.46616886706
Rh32ivt3 Rh32ivn2 Rh32ivn3 8312.095320285
Rh32ivt4 Rh32ivn3 0 8344.50869523992
Bh32leak 0 h32d I = 1e-08
Eh32sc h32raw 0 h32d 0 1
Eh32lin h32lin 0 h32raw 0 1
* direct bounded ReLU: y=max(0, min(15, v(h32lin))) no high-gain op-amp loop
Bh32relu h32y 0 V = max(0, min(15, (0.001) + v(h32lin)))
Eh32 h32buf 0 h32y 0 1

* tiled Rdivh1a series x4  each=249750
Rdivh1at1 h1buf Rdivh1an1 249077.547646338
Rdivh1at2 Rdivh1an1 Rdivh1an2 249423.782707898
Rdivh1at3 Rdivh1an2 Rdivh1an3 249448.099806849
Rdivh1at4 Rdivh1an3 htap1 248949.754143877
* tiled Rdivh1b parallel x4  each=4004
Rdivh1bt1 htap1 0 4012.67419850397
Rdivh1bt2 htap1 0 4021.46091596253
Rdivh1bt3 htap1 0 4012.37117102692
Rdivh1bt4 htap1 0 4022.20373145598
Edivh1 h1f 0 htap1 0 1
* tiled Rdivh2a series x4  each=249750
Rdivh2at1 h2buf Rdivh2an1 249946.236460265
Rdivh2at2 Rdivh2an1 Rdivh2an2 250751.255953712
Rdivh2at3 Rdivh2an2 Rdivh2an3 250571.890411627
Rdivh2at4 Rdivh2an3 htap2 249947.407462678
* tiled Rdivh2b parallel x4  each=4004
Rdivh2bt1 htap2 0 4015.33704315691
Rdivh2bt2 htap2 0 3989.03574388047
Rdivh2bt3 htap2 0 4020.5390041189
Rdivh2bt4 htap2 0 3986.78873524193
Edivh2 h2f 0 htap2 0 1
* tiled Rdivh3a series x4  each=249750
Rdivh3at1 h3buf Rdivh3an1 249785.409979833
Rdivh3at2 Rdivh3an1 Rdivh3an2 250328.940975724
Rdivh3at3 Rdivh3an2 Rdivh3an3 250263.643468076
Rdivh3at4 Rdivh3an3 htap3 249223.397235899
* tiled Rdivh3b parallel x4  each=4004
Rdivh3bt1 htap3 0 3990.65326875063
Rdivh3bt2 htap3 0 3992.7941736732
Rdivh3bt3 htap3 0 3984.58554859637
Rdivh3bt4 htap3 0 3987.22350093931
Edivh3 h3f 0 htap3 0 1
* tiled Rdivh4a series x4  each=249750
Rdivh4at1 h4buf Rdivh4an1 249378.793401573
Rdivh4at2 Rdivh4an1 Rdivh4an2 250525.75062431
Rdivh4at3 Rdivh4an2 Rdivh4an3 248590.104983038
Rdivh4at4 Rdivh4an3 htap4 249486.925897345
* tiled Rdivh4b parallel x4  each=4004
Rdivh4bt1 htap4 0 4013.57024317759
Rdivh4bt2 htap4 0 4015.34233838739
Rdivh4bt3 htap4 0 3993.19394434555
Rdivh4bt4 htap4 0 3991.80578357671
Edivh4 h4f 0 htap4 0 1
* tiled Rdivh5a series x4  each=249750
Rdivh5at1 h5buf Rdivh5an1 249467.408679539
Rdivh5at2 Rdivh5an1 Rdivh5an2 248931.122271147
Rdivh5at3 Rdivh5an2 Rdivh5an3 248713.983386363
Rdivh5at4 Rdivh5an3 htap5 249192.338100736
* tiled Rdivh5b parallel x4  each=4004
Rdivh5bt1 htap5 0 4016.91902908666
Rdivh5bt2 htap5 0 4006.28750250421
Rdivh5bt3 htap5 0 3995.96464000716
Rdivh5bt4 htap5 0 4012.98762646627
Edivh5 h5f 0 htap5 0 1
* tiled Rdivh6a series x4  each=249750
Rdivh6at1 h6buf Rdivh6an1 248866.745698356
Rdivh6at2 Rdivh6an1 Rdivh6an2 249257.332825805
Rdivh6at3 Rdivh6an2 Rdivh6an3 249882.959732909
Rdivh6at4 Rdivh6an3 htap6 248546.26370128
* tiled Rdivh6b parallel x4  each=4004
Rdivh6bt1 htap6 0 4022.53665617506
Rdivh6bt2 htap6 0 4006.1535599486
Rdivh6bt3 htap6 0 3999.11135036535
Rdivh6bt4 htap6 0 3988.05802278431
Edivh6 h6f 0 htap6 0 1
* tiled Rdivh7a series x4  each=249750
Rdivh7at1 h7buf Rdivh7an1 249392.820051791
Rdivh7at2 Rdivh7an1 Rdivh7an2 250390.636772363
Rdivh7at3 Rdivh7an2 Rdivh7an3 249654.247359027
Rdivh7at4 Rdivh7an3 htap7 249070.435573852
* tiled Rdivh7b parallel x4  each=4004
Rdivh7bt1 htap7 0 3994.26074221666
Rdivh7bt2 htap7 0 4018.83166719688
Rdivh7bt3 htap7 0 4003.23199911761
Rdivh7bt4 htap7 0 4013.83153553154
Edivh7 h7f 0 htap7 0 1
* tiled Rdivh8a series x4  each=249750
Rdivh8at1 h8buf Rdivh8an1 249258.712161005
Rdivh8at2 Rdivh8an1 Rdivh8an2 250449.094779995
Rdivh8at3 Rdivh8an2 Rdivh8an3 249880.78532158
Rdivh8at4 Rdivh8an3 htap8 249349.216926979
* tiled Rdivh8b parallel x4  each=4004
Rdivh8bt1 htap8 0 3990.53520487701
Rdivh8bt2 htap8 0 4009.41054943504
Rdivh8bt3 htap8 0 3987.82352260838
Rdivh8bt4 htap8 0 3987.96440880632
Edivh8 h8f 0 htap8 0 1
* tiled Rdivh9a series x4  each=249750
Rdivh9at1 h9buf Rdivh9an1 250905.23524444
Rdivh9at2 Rdivh9an1 Rdivh9an2 248777.489271301
Rdivh9at3 Rdivh9an2 Rdivh9an3 249039.18238678
Rdivh9at4 Rdivh9an3 htap9 250417.676605571
* tiled Rdivh9b parallel x4  each=4004
Rdivh9bt1 htap9 0 4007.79717577014
Rdivh9bt2 htap9 0 4010.31650880406
Rdivh9bt3 htap9 0 4015.83923098858
Rdivh9bt4 htap9 0 3995.79258094713
Edivh9 h9f 0 htap9 0 1
* tiled Rdivh10a series x4  each=249750
Rdivh10at1 h10buf Rdivh10an1 249922.538602158
Rdivh10at2 Rdivh10an1 Rdivh10an2 250735.190631142
Rdivh10at3 Rdivh10an2 Rdivh10an3 248770.068810938
Rdivh10at4 Rdivh10an3 htap10 250620.063184261
* tiled Rdivh10b parallel x4  each=4004
Rdivh10bt1 htap10 0 4007.48477201694
Rdivh10bt2 htap10 0 3989.78929302685
Rdivh10bt3 htap10 0 3999.86148141924
Rdivh10bt4 htap10 0 3984.2507477327
Edivh10 h10f 0 htap10 0 1
* tiled Rdivh11a series x4  each=249750
Rdivh11at1 h11buf Rdivh11an1 249368.399650416
Rdivh11at2 Rdivh11an1 Rdivh11an2 250832.871808809
Rdivh11at3 Rdivh11an2 Rdivh11an3 249462.952693118
Rdivh11at4 Rdivh11an3 htap11 250367.909394424
* tiled Rdivh11b parallel x4  each=4004
Rdivh11bt1 htap11 0 3996.36398998394
Rdivh11bt2 htap11 0 3985.92302852215
Rdivh11bt3 htap11 0 4000.42153945108
Rdivh11bt4 htap11 0 4020.49152217028
Edivh11 h11f 0 htap11 0 1
* tiled Rdivh12a series x4  each=249750
Rdivh12at1 h12buf Rdivh12an1 249870.530826285
Rdivh12at2 Rdivh12an1 Rdivh12an2 248836.961448123
Rdivh12at3 Rdivh12an2 Rdivh12an3 250467.086242161
Rdivh12at4 Rdivh12an3 htap12 250203.403441855
* tiled Rdivh12b parallel x4  each=4004
Rdivh12bt1 htap12 0 3997.30864080882
Rdivh12bt2 htap12 0 3996.07277905609
Rdivh12bt3 htap12 0 4009.23429101449
Rdivh12bt4 htap12 0 4008.12563581183
Edivh12 h12f 0 htap12 0 1
* tiled Rdivh13a series x4  each=249750
Rdivh13at1 h13buf Rdivh13an1 248995.348396687
Rdivh13at2 Rdivh13an1 Rdivh13an2 248514.050673436
Rdivh13at3 Rdivh13an2 Rdivh13an3 249927.179430399
Rdivh13at4 Rdivh13an3 htap13 248621.280007195
* tiled Rdivh13b parallel x4  each=4004
Rdivh13bt1 htap13 0 4008.36916549961
Rdivh13bt2 htap13 0 3994.99528527455
Rdivh13bt3 htap13 0 3986.39990366367
Rdivh13bt4 htap13 0 4000.6414466837
Edivh13 h13f 0 htap13 0 1
* tiled Rdivh14a series x4  each=249750
Rdivh14at1 h14buf Rdivh14an1 249874.971323136
Rdivh14at2 Rdivh14an1 Rdivh14an2 249744.614676606
Rdivh14at3 Rdivh14an2 Rdivh14an3 248651.925446809
Rdivh14at4 Rdivh14an3 htap14 248984.820579953
* tiled Rdivh14b parallel x4  each=4004
Rdivh14bt1 htap14 0 4003.39198281714
Rdivh14bt2 htap14 0 4014.48319355069
Rdivh14bt3 htap14 0 4022.81287217074
Rdivh14bt4 htap14 0 3998.41915351206
Edivh14 h14f 0 htap14 0 1
* tiled Rdivh15a series x4  each=249750
Rdivh15at1 h15buf Rdivh15an1 249282.242090898
Rdivh15at2 Rdivh15an1 Rdivh15an2 249555.324569817
Rdivh15at3 Rdivh15an2 Rdivh15an3 249372.816420537
Rdivh15at4 Rdivh15an3 htap15 249905.905305029
* tiled Rdivh15b parallel x4  each=4004
Rdivh15bt1 htap15 0 4021.62214375514
Rdivh15bt2 htap15 0 3995.34618967282
Rdivh15bt3 htap15 0 4017.01153681894
Rdivh15bt4 htap15 0 3989.61531735179
Edivh15 h15f 0 htap15 0 1
* tiled Rdivh16a series x4  each=249750
Rdivh16at1 h16buf Rdivh16an1 250788.864987699
Rdivh16at2 Rdivh16an1 Rdivh16an2 249637.96509379
Rdivh16at3 Rdivh16an2 Rdivh16an3 249612.413221026
Rdivh16at4 Rdivh16an3 htap16 250792.022160932
* tiled Rdivh16b parallel x4  each=4004
Rdivh16bt1 htap16 0 3994.94679810402
Rdivh16bt2 htap16 0 3996.94926428903
Rdivh16bt3 htap16 0 4006.33986258762
Rdivh16bt4 htap16 0 4008.34788323868
Edivh16 h16f 0 htap16 0 1
* tiled Rdivh17a series x4  each=249750
Rdivh17at1 h17buf Rdivh17an1 250470.427005466
Rdivh17at2 Rdivh17an1 Rdivh17an2 249472.147467791
Rdivh17at3 Rdivh17an2 Rdivh17an3 250718.852064651
Rdivh17at4 Rdivh17an3 htap17 250092.468162445
* tiled Rdivh17b parallel x4  each=4004
Rdivh17bt1 htap17 0 4009.21807043277
Rdivh17bt2 htap17 0 4014.91923339243
Rdivh17bt3 htap17 0 3999.8001859595
Rdivh17bt4 htap17 0 4022.0770892671
Edivh17 h17f 0 htap17 0 1
* tiled Rdivh18a series x4  each=249750
Rdivh18at1 h18buf Rdivh18an1 250254.888807092
Rdivh18at2 Rdivh18an1 Rdivh18an2 250634.102498337
Rdivh18at3 Rdivh18an2 Rdivh18an3 250704.663216806
Rdivh18at4 Rdivh18an3 htap18 250618.331260515
* tiled Rdivh18b parallel x4  each=4004
Rdivh18bt1 htap18 0 3990.42332943772
Rdivh18bt2 htap18 0 4020.91913420003
Rdivh18bt3 htap18 0 4005.62634178939
Rdivh18bt4 htap18 0 4015.46625628168
Edivh18 h18f 0 htap18 0 1
* tiled Rdivh19a series x4  each=249750
Rdivh19at1 h19buf Rdivh19an1 250961.799762305
Rdivh19at2 Rdivh19an1 Rdivh19an2 250101.966104085
Rdivh19at3 Rdivh19an2 Rdivh19an3 249361.911415566
Rdivh19at4 Rdivh19an3 htap19 250799.335159736
* tiled Rdivh19b parallel x4  each=4004
Rdivh19bt1 htap19 0 4009.82386163105
Rdivh19bt2 htap19 0 4007.5466012506
Rdivh19bt3 htap19 0 4011.00112327524
Rdivh19bt4 htap19 0 4012.69107423384
Edivh19 h19f 0 htap19 0 1
* tiled Rdivh20a series x4  each=249750
Rdivh20at1 h20buf Rdivh20an1 248689.851572706
Rdivh20at2 Rdivh20an1 Rdivh20an2 250633.989727515
Rdivh20at3 Rdivh20an2 Rdivh20an3 250054.731626358
Rdivh20at4 Rdivh20an3 htap20 250576.001114692
* tiled Rdivh20b parallel x4  each=4004
Rdivh20bt1 htap20 0 3987.02548955638
Rdivh20bt2 htap20 0 3999.3820378944
Rdivh20bt3 htap20 0 3989.75300364602
Rdivh20bt4 htap20 0 4021.35708096903
Edivh20 h20f 0 htap20 0 1
* tiled Rdivh21a series x4  each=249750
Rdivh21at1 h21buf Rdivh21an1 249336.094260147
Rdivh21at2 Rdivh21an1 Rdivh21an2 250875.503233848
Rdivh21at3 Rdivh21an2 Rdivh21an3 248570.827117022
Rdivh21at4 Rdivh21an3 htap21 249277.746225091
* tiled Rdivh21b parallel x4  each=4004
Rdivh21bt1 htap21 0 3995.06456006533
Rdivh21bt2 htap21 0 4017.42659976112
Rdivh21bt3 htap21 0 3985.86660210106
Rdivh21bt4 htap21 0 4021.34085316599
Edivh21 h21f 0 htap21 0 1
* tiled Rdivh22a series x4  each=249750
Rdivh22at1 h22buf Rdivh22an1 249531.264955235
Rdivh22at2 Rdivh22an1 Rdivh22an2 249697.54134873
Rdivh22at3 Rdivh22an2 Rdivh22an3 250966.400560894
Rdivh22at4 Rdivh22an3 htap22 250954.722796951
* tiled Rdivh22b parallel x4  each=4004
Rdivh22bt1 htap22 0 4002.22988084079
Rdivh22bt2 htap22 0 3998.66858493507
Rdivh22bt3 htap22 0 3984.65532036486
Rdivh22bt4 htap22 0 3989.68297963872
Edivh22 h22f 0 htap22 0 1
* tiled Rdivh23a series x4  each=249750
Rdivh23at1 h23buf Rdivh23an1 250003.998690001
Rdivh23at2 Rdivh23an1 Rdivh23an2 248946.946711474
Rdivh23at3 Rdivh23an2 Rdivh23an3 249893.177636212
Rdivh23at4 Rdivh23an3 htap23 249868.108682486
* tiled Rdivh23b parallel x4  each=4004
Rdivh23bt1 htap23 0 4018.16330047486
Rdivh23bt2 htap23 0 3985.08367999588
Rdivh23bt3 htap23 0 3984.6442514459
Rdivh23bt4 htap23 0 4008.78762261445
Edivh23 h23f 0 htap23 0 1
* tiled Rdivh24a series x4  each=249750
Rdivh24at1 h24buf Rdivh24an1 249107.231847634
Rdivh24at2 Rdivh24an1 Rdivh24an2 248540.517709109
Rdivh24at3 Rdivh24an2 Rdivh24an3 250414.123979904
Rdivh24at4 Rdivh24an3 htap24 250048.640613418
* tiled Rdivh24b parallel x4  each=4004
Rdivh24bt1 htap24 0 4001.85558251322
Rdivh24bt2 htap24 0 4007.46825075077
Rdivh24bt3 htap24 0 4019.76728614541
Rdivh24bt4 htap24 0 4007.67886544098
Edivh24 h24f 0 htap24 0 1
* tiled Rdivh25a series x4  each=249750
Rdivh25at1 h25buf Rdivh25an1 249744.576013044
Rdivh25at2 Rdivh25an1 Rdivh25an2 249161.335771919
Rdivh25at3 Rdivh25an2 Rdivh25an3 248893.267223294
Rdivh25at4 Rdivh25an3 htap25 249432.281364458
* tiled Rdivh25b parallel x4  each=4004
Rdivh25bt1 htap25 0 3990.25006497596
Rdivh25bt2 htap25 0 3990.72330105419
Rdivh25bt3 htap25 0 3987.93261575445
Rdivh25bt4 htap25 0 4015.00281855457
Edivh25 h25f 0 htap25 0 1
* tiled Rdivh26a series x4  each=249750
Rdivh26at1 h26buf Rdivh26an1 249951.796941246
Rdivh26at2 Rdivh26an1 Rdivh26an2 250358.293673596
Rdivh26at3 Rdivh26an2 Rdivh26an3 249941.550763646
Rdivh26at4 Rdivh26an3 htap26 249574.856681958
* tiled Rdivh26b parallel x4  each=4004
Rdivh26bt1 htap26 0 3992.1914212963
Rdivh26bt2 htap26 0 4001.1712815851
Rdivh26bt3 htap26 0 4001.21900825086
Rdivh26bt4 htap26 0 3995.78496341876
Edivh26 h26f 0 htap26 0 1
* tiled Rdivh27a series x4  each=249750
Rdivh27at1 h27buf Rdivh27an1 248694.883861426
Rdivh27at2 Rdivh27an1 Rdivh27an2 248790.061384402
Rdivh27at3 Rdivh27an2 Rdivh27an3 248788.864814849
Rdivh27at4 Rdivh27an3 htap27 249648.938497752
* tiled Rdivh27b parallel x4  each=4004
Rdivh27bt1 htap27 0 3992.11348942894
Rdivh27bt2 htap27 0 3988.77061939331
Rdivh27bt3 htap27 0 4020.27655738568
Rdivh27bt4 htap27 0 4001.42797939706
Edivh27 h27f 0 htap27 0 1
* tiled Rdivh28a series x4  each=249750
Rdivh28at1 h28buf Rdivh28an1 249254.327977918
Rdivh28at2 Rdivh28an1 Rdivh28an2 250512.531618513
Rdivh28at3 Rdivh28an2 Rdivh28an3 248930.486091902
Rdivh28at4 Rdivh28an3 htap28 250117.806237219
* tiled Rdivh28b parallel x4  each=4004
Rdivh28bt1 htap28 0 3998.82718196989
Rdivh28bt2 htap28 0 4002.41561931455
Rdivh28bt3 htap28 0 4010.7289250722
Rdivh28bt4 htap28 0 3997.73019039824
Edivh28 h28f 0 htap28 0 1
* tiled Rdivh29a series x4  each=249750
Rdivh29at1 h29buf Rdivh29an1 249309.148720603
Rdivh29at2 Rdivh29an1 Rdivh29an2 250084.325596426
Rdivh29at3 Rdivh29an2 Rdivh29an3 250326.654981147
Rdivh29at4 Rdivh29an3 htap29 249492.915849034
* tiled Rdivh29b parallel x4  each=4004
Rdivh29bt1 htap29 0 4016.55791984628
Rdivh29bt2 htap29 0 4000.2072337966
Rdivh29bt3 htap29 0 4013.86097222991
Rdivh29bt4 htap29 0 3987.71789162884
Edivh29 h29f 0 htap29 0 1
* tiled Rdivh30a series x4  each=249750
Rdivh30at1 h30buf Rdivh30an1 249466.94737134
Rdivh30at2 Rdivh30an1 Rdivh30an2 250138.916844389
Rdivh30at3 Rdivh30an2 Rdivh30an3 249249.367695709
Rdivh30at4 Rdivh30an3 htap30 249016.377835893
* tiled Rdivh30b parallel x4  each=4004
Rdivh30bt1 htap30 0 3988.55402994681
Rdivh30bt2 htap30 0 4022.92071473546
Rdivh30bt3 htap30 0 3985.46079347691
Rdivh30bt4 htap30 0 3996.79043472152
Edivh30 h30f 0 htap30 0 1
* tiled Rdivh31a series x4  each=249750
Rdivh31at1 h31buf Rdivh31an1 249352.560668158
Rdivh31at2 Rdivh31an1 Rdivh31an2 249450.572287499
Rdivh31at3 Rdivh31an2 Rdivh31an3 250409.084705445
Rdivh31at4 Rdivh31an3 htap31 250551.012018963
* tiled Rdivh31b parallel x4  each=4004
Rdivh31bt1 htap31 0 3995.63761026948
Rdivh31bt2 htap31 0 4016.39478694779
Rdivh31bt3 htap31 0 3987.25909175402
Rdivh31bt4 htap31 0 3985.80722499994
Edivh31 h31f 0 htap31 0 1
* tiled Rdivh32a series x4  each=249750
Rdivh32at1 h32buf Rdivh32an1 249823.553278246
Rdivh32at2 Rdivh32an1 Rdivh32an2 249445.432198897
Rdivh32at3 Rdivh32an2 Rdivh32an3 249810.059733915
Rdivh32at4 Rdivh32an3 htap32 249968.239682584
* tiled Rdivh32b parallel x4  each=4004
Rdivh32bt1 htap32 0 3998.22901447683
Rdivh32bt2 htap32 0 4015.38191543532
Rdivh32bt3 htap32 0 3993.05777864771
Rdivh32bt4 htap32 0 4019.8813831302
Edivh32 h32f 0 htap32 0 1
* o1 input 1 w=+0.115109951768787 w+  bank=n alpha=1 R=289578.206064126 G_phys=3.4532985530636e-06 G_eff=3.4532985530636e-06
* tiled Ro1p1n1 series x4  each=72394.5515160316
Ro1p1n1t1 h1buf Ro1p1n1n1 72156.6683819185
Ro1p1n1t2 Ro1p1n1n1 Ro1p1n1n2 72552.1250342687
Ro1p1n1t3 Ro1p1n1n2 Ro1p1n1n3 72634.6801138925
Ro1p1n1t4 Ro1p1n1n3 o1p 72533.0445999681
* o1 input 2 w=+0.416557305918275 w+  bank=n alpha=1 R=80021.0027762017 G_phys=1.24967191775482e-05 G_eff=1.24967191775482e-05
* tiled Ro1p2n1 series x4  each=20005.2506940504
Ro1p2n1t1 h2buf Ro1p2n1n1 19942.951971064
Ro1p2n1t2 Ro1p2n1n1 Ro1p2n1n2 19905.9842454125
Ro1p2n1t3 Ro1p2n1n2 Ro1p2n1n3 20007.5743714464
Ro1p2n1t4 Ro1p2n1n3 o1p 20063.5404370777
* o1 input 3 w=+0.460762298204741 w+  bank=n alpha=1 R=72343.8820042555 G_phys=1.38228689461422e-05 G_eff=1.38228689461422e-05
* tiled Ro1p3n1 series x4  each=18085.9705010639
Ro1p3n1t1 h3buf Ro1p3n1n1 18082.1398919765
Ro1p3n1t2 Ro1p3n1n1 Ro1p3n1n2 18043.9516347556
Ro1p3n1t3 Ro1p3n1n2 Ro1p3n1n3 18016.9920512439
Ro1p3n1t4 Ro1p3n1n3 o1p 18073.6616285107
* o1 input 4 w=+0.128235529120638 w+  bank=n alpha=1 R=259938.361559493 G_phys=3.84706587361914e-06 G_eff=3.84706587361914e-06
* tiled Ro1p4n1 series x4  each=64984.5903898734
Ro1p4n1t1 h4buf Ro1p4n1n1 64966.4260668487
Ro1p4n1t2 Ro1p4n1n1 Ro1p4n1n2 64815.1329217691
Ro1p4n1t3 Ro1p4n1n2 Ro1p4n1n3 64946.4710386938
Ro1p4n1t4 Ro1p4n1n3 o1p 65290.6331914434
* o1 input 5 w=+0.25946188501651 w+  bank=n alpha=1 R=128471.021210735 G_phys=7.78385655049531e-06 G_eff=7.78385655049531e-06
* tiled Ro1p5n1 series x4  each=32117.7553026837
Ro1p5n1t1 h5buf Ro1p5n1n1 32082.5662495202
Ro1p5n1t2 Ro1p5n1n1 Ro1p5n1n2 31987.7427102887
Ro1p5n1t3 Ro1p5n1n2 Ro1p5n1n3 32035.8704029984
Ro1p5n1t4 Ro1p5n1n3 o1p 32275.0657046467
* o1 input 6 w=+0.0121141451968155 w+  bank=f alpha=0.001 R=2751.60424378073 G_phys=0.000363424355904464 G_eff=3.63424355904464e-07
* tiled Ro1p6f1 parallel x4  each=11006.4169751229
Ro1p6f1t1 h6f o1p 11057.025505114
Ro1p6f1t2 h6f o1p 11012.5126307948
Ro1p6f1t3 h6f o1p 10982.7073131124
Ro1p6f1t4 h6f o1p 11015.7400215478
* o1 input 7 w=-0.240253536162518 w-  bank=n alpha=1 R=138742.321406604 G_phys=7.20760608487554e-06 G_eff=7.20760608487554e-06
* tiled Ro1n7n1 series x4  each=34685.5803516511
Ro1n7n1t1 h7buf Ro1n7n1n1 34560.9828141842
Ro1n7n1t2 Ro1n7n1n1 Ro1n7n1n2 34788.8656910951
Ro1n7n1t3 Ro1n7n1n2 Ro1n7n1n3 34632.7282088853
Ro1n7n1t4 Ro1n7n1n3 o1n 34571.2715588658
* o1 input 8 w=+0.187475674056081 w+  bank=n alpha=1 R=177800.845369208 G_phys=5.62427022168244e-06 G_eff=5.62427022168244e-06
* tiled Ro1p8n1 series x4  each=44450.211342302
Ro1p8n1t1 h8buf Ro1p8n1n1 44315.0117126171
Ro1p8n1t2 Ro1p8n1n1 Ro1p8n1n2 44263.5458619844
Ro1p8n1t3 Ro1p8n1n2 Ro1p8n1n3 44588.6506240141
Ro1p8n1t4 Ro1p8n1n3 o1p 44551.0098376833
* o1 input 9 w=-0.249792136720497 w-  bank=n alpha=1 R=133444.28600101 G_phys=7.4937641016149e-06 G_eff=7.4937641016149e-06
* tiled Ro1n9n1 series x4  each=33361.0715002525
Ro1n9n1t1 h9buf Ro1n9n1n1 33269.2552399119
Ro1n9n1t2 Ro1n9n1n1 Ro1n9n1n2 33224.2528878161
Ro1n9n1t3 Ro1n9n1n2 Ro1n9n1n3 33429.1333093131
Ro1n9n1t4 Ro1n9n1n3 o1n 33348.9443936786
* o1 input 10 w=-0.0478130377197742 w-  bank=n alpha=1 R=697159.915433434 G_phys=1.43439113159322e-06 G_eff=1.43439113159322e-06
* tiled Ro1n10n1 series x4  each=174289.978858358
Ro1n10n1t1 h10buf Ro1n10n1n1 175154.488211959
Ro1n10n1t2 Ro1n10n1n1 Ro1n10n1n2 174137.663555347
Ro1n10n1t3 Ro1n10n1n2 Ro1n10n1n3 173806.30759801
Ro1n10n1t4 Ro1n10n1n3 o1n 173818.547258444
* o1 input 11 w=+0.103135444855694 w+  bank=n alpha=1 R=323199.588463238 G_phys=3.09406334567083e-06 G_eff=3.09406334567083e-06
* tiled Ro1p11n1 series x4  each=80799.8971158095
Ro1p11n1t1 h11buf Ro1p11n1n1 80915.2719770846
Ro1p11n1t2 Ro1p11n1n1 Ro1p11n1n2 80937.1039361165
Ro1p11n1t3 Ro1p11n1n2 Ro1p11n1n3 80491.3590530392
Ro1p11n1t4 Ro1p11n1n3 o1p 80410.2866086439
* o1 input 12 w=-0.0209153710838255 w-  bank=f alpha=0.001 R=1593.72421362923 G_phys=0.000627461132514765 G_eff=6.27461132514765e-07
* tiled Ro1n12f1 parallel x4  each=6374.89685451692
Ro1n12f1t1 h12f o1n 6382.17884258663
Ro1n12f1t2 h12f o1n 6388.14689444946
Ro1n12f1t3 h12f o1n 6348.53212729764
Ro1n12f1t4 h12f o1n 6357.67248492797
* o1 input 13 w=-0.0177641479719743 w-  bank=f alpha=0.001 R=1876.43862153827 G_phys=0.00053292443915923 G_eff=5.3292443915923e-07
* tiled Ro1n13f1 parallel x4  each=7505.75448615308
Ro1n13f1t1 h13f o1n 7529.64659641823
Ro1n13f1t2 h13f o1n 7542.602930089
Ro1n13f1t3 h13f o1n 7519.84587514584
Ro1n13f1t4 h13f o1n 7503.79408731041
* o1 input 14 w=-0.162077236015947 w-  bank=n alpha=1 R=205663.263717389 G_phys=4.86231708047842e-06 G_eff=4.86231708047842e-06
* tiled Ro1n14n1 series x4  each=51415.8159293474
Ro1n14n1t1 h14buf Ro1n14n1n1 51497.6907539565
Ro1n14n1t2 Ro1n14n1n1 Ro1n14n1n2 51264.9491948787
Ro1n14n1t3 Ro1n14n1n2 Ro1n14n1n3 51247.5746981881
Ro1n14n1t4 Ro1n14n1n3 o1n 51380.5300748889
* o1 input 15 w=+0.156787201998635 w+  bank=n alpha=1 R=212602.386600556 G_phys=4.70361605995906e-06 G_eff=4.70361605995906e-06
* tiled Ro1p15n1 series x4  each=53150.596650139
Ro1p15n1t1 h15buf Ro1p15n1n1 53393.556558298
Ro1p15n1t2 Ro1p15n1n1 Ro1p15n1n2 53055.0505142493
Ro1p15n1t3 Ro1p15n1n2 Ro1p15n1n3 53108.5441051993
Ro1p15n1t4 Ro1p15n1n3 o1p 53002.3766094865
* o1 input 16 w=-0.00694237968883333 w-  bank=f alpha=0.001 R=4801.42758353441 G_phys=0.000208271390665 G_eff=2.08271390665e-07
* tiled Ro1n16f1 series x4  each=1200.3568958836
Ro1n16f1t1 h16f Ro1n16f1n1 1205.29883027282
Ro1n16f1t2 Ro1n16f1n1 Ro1n16f1n2 1201.74428852591
Ro1n16f1t3 Ro1n16f1n2 Ro1n16f1n3 1196.44156325118
Ro1n16f1t4 Ro1n16f1n3 o1n 1194.74740423024
* o1 input 17 w=+0.263424706628807 w+  bank=n alpha=1 R=126538.37128612 G_phys=7.90274119886422e-06 G_eff=7.90274119886422e-06
* tiled Ro1p17n1 series x4  each=31634.5928215301
Ro1p17n1t1 h17buf Ro1p17n1n1 31530.4253853607
Ro1p17n1t2 Ro1p17n1n1 Ro1p17n1n2 31775.2960255943
Ro1p17n1t3 Ro1p17n1n2 Ro1p17n1n3 31728.6257310251
Ro1p17n1t4 Ro1p17n1n3 o1p 31558.1267945776
* o1 input 18 w=+0.403807796552332 w+  bank=n alpha=1 R=82547.5229005725 G_phys=1.211423389657e-05 G_eff=1.211423389657e-05
* tiled Ro1p18n1 series x4  each=20636.8807251431
Ro1p18n1t1 h18buf Ro1p18n1n1 20612.2628633414
Ro1p18n1t2 Ro1p18n1n1 Ro1p18n1n2 20629.0297644613
Ro1p18n1t3 Ro1p18n1n2 Ro1p18n1n3 20536.5388827624
Ro1p18n1t4 Ro1p18n1n3 o1p 20683.1482330822
* o1 input 19 w=+0.415931315874452 w+  bank=n alpha=1 R=80141.4369659891 G_phys=1.24779394762336e-05 G_eff=1.24779394762336e-05
* tiled Ro1p19n1 series x4  each=20035.3592414973
Ro1p19n1t1 h19buf Ro1p19n1n1 20000.8166760326
Ro1p19n1t2 Ro1p19n1n1 Ro1p19n1n2 19996.3917752922
Ro1p19n1t3 Ro1p19n1n2 Ro1p19n1n3 20022.2372677085
Ro1p19n1t4 Ro1p19n1n3 o1p 19978.7174258419
* o1 input 20 w=+0.0719298844689274 w+  bank=n alpha=1 R=463414.248186827 G_phys=2.15789653406782e-06 G_eff=2.15789653406782e-06
* tiled Ro1p20n1 series x4  each=115853.562046707
Ro1p20n1t1 h20buf Ro1p20n1n1 115788.369856295
Ro1p20n1t2 Ro1p20n1n1 Ro1p20n1n2 115612.811332761
Ro1p20n1t3 Ro1p20n1n2 Ro1p20n1n3 115931.61403424
Ro1p20n1t4 Ro1p20n1n3 o1p 115936.841154818
* o1 input 21 w=-0.387164693396724 w-  bank=n alpha=1 R=86096.0048833198 G_phys=1.16149408019017e-05 G_eff=1.16149408019017e-05
* tiled Ro1n21n1 series x4  each=21524.00122083
Ro1n21n1t1 h21buf Ro1n21n1n1 21465.4698150443
Ro1n21n1t2 Ro1n21n1n1 Ro1n21n1n2 21567.8840149967
Ro1n21n1t3 Ro1n21n1n2 Ro1n21n1n3 21540.0085567248
Ro1n21n1t4 Ro1n21n1n3 o1n 21614.2286010201
* o1 input 22 w=+0.13881898843949 w+  bank=n alpha=1 R=240120.848797735 G_phys=4.1645696531847e-06 G_eff=4.1645696531847e-06
* tiled Ro1p22n1 series x4  each=60030.2121994339
Ro1p22n1t1 h22buf Ro1p22n1n1 60278.1725563543
Ro1p22n1t2 Ro1p22n1n1 Ro1p22n1n2 60246.9487875562
Ro1p22n1t3 Ro1p22n1n2 Ro1p22n1n3 60262.0529598447
Ro1p22n1t4 Ro1p22n1n3 o1p 59765.2774380284
* o1 input 23 w=-0.118143194098524 w-  bank=n alpha=1 R=282143.491952108 G_phys=3.54429582295573e-06 G_eff=3.54429582295573e-06
* tiled Ro1n23n1 series x4  each=70535.8729880271
Ro1n23n1t1 h23buf Ro1n23n1n1 70508.5568664103
Ro1n23n1t2 Ro1n23n1n1 Ro1n23n1n2 70558.572352663
Ro1n23n1t3 Ro1n23n1n2 Ro1n23n1n3 70413.1568494762
Ro1n23n1t4 Ro1n23n1n3 o1n 70466.298623007
* o1 input 24 w=-0.494956544406075 w-  bank=n alpha=1 R=67345.9795815646 G_phys=1.48486963321823e-05 G_eff=1.48486963321823e-05
* tiled Ro1n24n1 series x4  each=16836.4948953912
Ro1n24n1t1 h24buf Ro1n24n1n1 16776.4786380184
Ro1n24n1t2 Ro1n24n1n1 Ro1n24n1n2 16824.2211541671
Ro1n24n1t3 Ro1n24n1n2 Ro1n24n1n3 16799.5734744235
Ro1n24n1t4 Ro1n24n1n3 o1n 16877.7505162528
* o1 input 25 w=-0.0137314432186455 w-  bank=f alpha=0.001 R=2427.51856469617 G_phys=0.000411943296559366 G_eff=4.11943296559366e-07
* tiled Ro1n25f1 parallel x4  each=9710.07425878466
Ro1n25f1t1 h25f o1n 9750.20356408933
Ro1n25f1t2 h25f o1n 9687.07752586274
Ro1n25f1t3 h25f o1n 9749.58481412992
Ro1n25f1t4 h25f o1n 9727.86526778778
* o1 input 26 w=+0.00762307525297978 w+  bank=f alpha=0.001 R=4372.68847901032 G_phys=0.000228692257589393 G_eff=2.28692257589393e-07
* tiled Ro1p26f1 series x4  each=1093.17211975258
Ro1p26f1t1 h26f Ro1p26f1n1 1095.99351560513
Ro1p26f1t2 Ro1p26f1n1 Ro1p26f1n2 1087.72215880444
Ro1p26f1t3 Ro1p26f1n2 Ro1p26f1n3 1087.77642728489
Ro1p26f1t4 Ro1p26f1n3 o1p 1098.19901187097
* o1 input 27 w=+0.187160704798257 w+  bank=n alpha=1 R=178100.063094247 G_phys=5.6148211439477e-06 G_eff=5.6148211439477e-06
* tiled Ro1p27n1 series x4  each=44525.0157735619
Ro1p27n1t1 h27buf Ro1p27n1n1 44378.6015707899
Ro1p27n1t2 Ro1p27n1n1 Ro1p27n1n2 44357.110134885
Ro1p27n1t3 Ro1p27n1n2 Ro1p27n1n3 44572.2920257561
Ro1p27n1t4 Ro1p27n1n3 o1p 44641.8722976289
* o1 input 28 w=+0.0939442280900053 w+  bank=n alpha=1 R=354820.450505992 G_phys=2.81832684270016e-06 G_eff=2.81832684270016e-06
* tiled Ro1p28n1 series x4  each=88705.1126264979
Ro1p28n1t1 h28buf Ro1p28n1n1 88638.2213402936
Ro1p28n1t2 Ro1p28n1n1 Ro1p28n1n2 88989.8306330612
Ro1p28n1t3 Ro1p28n1n2 Ro1p28n1n3 88797.0497037087
Ro1p28n1t4 Ro1p28n1n3 o1p 88470.4599023636
* o1 input 29 w=+0.0315398664392492 w+  bank=f alpha=0.001 R=1056.86349045069 G_phys=0.000946195993177476 G_eff=9.46195993177476e-07
* tiled Ro1p29f1 parallel x4  each=4227.45396180274
Ro1p29f1t1 h29f o1p 4219.28748188079
Ro1p29f1t2 h29f o1p 4237.64305115864
Ro1p29f1t3 h29f o1p 4232.51331902638
Ro1p29f1t4 h29f o1p 4235.53974340538
* o1 input 30 w=+0.183835448783735 w+  bank=n alpha=1 R=181321.576191471 G_phys=5.51506346351205e-06 G_eff=5.51506346351205e-06
* tiled Ro1p30n1 series x4  each=45330.3940478678
Ro1p30n1t1 h30buf Ro1p30n1n1 45553.0880442435
Ro1p30n1t2 Ro1p30n1n1 Ro1p30n1n2 45173.2144061366
Ro1p30n1t3 Ro1p30n1n2 Ro1p30n1n3 45505.895298378
Ro1p30n1t4 Ro1p30n1n3 o1p 45376.5908859678
* o1 input 31 w=-0.236627512253244 w-  bank=n alpha=1 R=140868.375853351 G_phys=7.09882536759733e-06 G_eff=7.09882536759733e-06
* tiled Ro1n31n1 series x4  each=35217.0939633376
Ro1n31n1t1 h31buf Ro1n31n1n1 35162.897812112
Ro1n31n1t2 Ro1n31n1n1 Ro1n31n1n2 35113.823979693
Ro1n31n1t3 Ro1n31n1n2 Ro1n31n1n3 35172.5997049516
Ro1n31n1t4 Ro1n31n1n3 o1n 35267.6398234616
* o1 input 32 w=-0.230869865069063 w-  bank=n alpha=1 R=144381.482283805 G_phys=6.92609595207188e-06 G_eff=6.92609595207188e-06
* tiled Ro1n32n1 series x4  each=36095.3705709513
Ro1n32n1t1 h32buf Ro1n32n1n1 35980.0938861904
Ro1n32n1t2 Ro1n32n1n1 Ro1n32n1n2 36273.5336953934
Ro1n32n1t3 Ro1n32n1n2 Ro1n32n1n3 36107.2636884815
Ro1n32n1t4 Ro1n32n1n3 o1n 36099.8006088015
* o1 bias=-0.0809652357124875 b-  bank=n alpha=1 R=411699.330459582 G_phys=2.42895707137462e-06 G_eff=2.42895707137462e-06
* tiled Ro1bnn1 series x4  each=102924.832614895
Ro1bnn1t1 vref Ro1bnn1n1 102455.571407906
Ro1bnn1t2 Ro1bnn1n1 Ro1bnn1n2 102742.3689957
Ro1bnn1t3 Ro1bnn1n2 Ro1bnn1n3 102867.471292282
Ro1bnn1t4 Ro1bnn1n3 o1n 103127.513798617
Vo1p o1p 0 DC 0
Vo1n o1n 0 DC 0
Fo1p 0 o1d Vo1p 1.001
Fo1n o1d 0 Vo1n 1.001
* ratiometric I-to-V: V = I * R_IV,  R_IV=33333.3333333333 (weight ~ R_IV / R_w)
* tiled Ro1iv series x4  each=8333.33333333333
Ro1ivt1 o1d Ro1ivn1 8354.49425384732
Ro1ivt2 Ro1ivn1 Ro1ivn2 8292.03053838719
Ro1ivt3 Ro1ivn2 Ro1ivn3 8363.48031062566
Ro1ivt4 Ro1ivn3 0 8339.47279761185
Bo1leak 0 o1d I = 1e-08
Eo1sc o1raw 0 o1d 0 1
Eo1lin o1lin 0 o1raw 0 1

* o2 input 1 w=-0.195521390350609 w-  bank=n alpha=1 R=170484.330505015 G_phys=5.86564171051827e-06 G_eff=5.86564171051827e-06
* tiled Ro2n1n1 series x4  each=42621.0826262538
Ro2n1n1t1 h1buf Ro2n1n1n1 42513.3941035892
Ro2n1n1t2 Ro2n1n1n1 Ro2n1n1n2 42531.9758277001
Ro2n1n1t3 Ro2n1n1n2 Ro2n1n1n3 42552.1621021548
Ro2n1n1t4 Ro2n1n1n3 o2n 42661.6883321663
* o2 input 2 w=+0.386445174905558 w+  bank=n alpha=1 R=86256.3061926689 G_phys=1.15933552471668e-05 G_eff=1.15933552471668e-05
* tiled Ro2p2n1 series x4  each=21564.0765481672
Ro2p2n1t1 h2buf Ro2p2n1n1 21658.6301245007
Ro2p2n1t2 Ro2p2n1n1 Ro2p2n1n2 21487.010639842
Ro2p2n1t3 Ro2p2n1n2 Ro2p2n1n3 21591.1578231862
Ro2p2n1t4 Ro2p2n1n3 o2p 21518.1563387456
* o2 input 3 w=+0.296294588630229 w+  bank=n alpha=1 R=112500.648383197 G_phys=8.88883765890688e-06 G_eff=8.88883765890688e-06
* tiled Ro2p3n1 series x4  each=28125.1620957992
Ro2p3n1t1 h3buf Ro2p3n1n1 28074.2664843019
Ro2p3n1t2 Ro2p3n1n1 Ro2p3n1n2 28215.8552181287
Ro2p3n1t3 Ro2p3n1n2 Ro2p3n1n3 28087.4312902371
Ro2p3n1t4 Ro2p3n1n3 o2p 28104.9379122093
* o2 input 4 w=-0.299308681857295 w-  bank=n alpha=1 R=111367.746256108 G_phys=8.97926045571886e-06 G_eff=8.97926045571886e-06
* tiled Ro2n4n1 series x4  each=27841.9365640269
Ro2n4n1t1 h4buf Ro2n4n1n1 27829.6529544394
Ro2n4n1t2 Ro2n4n1n1 Ro2n4n1n2 27729.9378517253
Ro2n4n1t3 Ro2n4n1n2 Ro2n4n1n3 27794.4306670499
Ro2n4n1t4 Ro2n4n1n3 o2n 27915.7588963097
* o2 input 5 w=+0.732671792857329 w+  bank=n alpha=1 R=45495.5870531571 G_phys=2.19801537857199e-05 G_eff=2.19801537857199e-05
* tiled Ro2p5n1 series x4  each=11373.8967632893
Ro2p5n1t1 h5buf Ro2p5n1n1 11380.7470953787
Ro2p5n1t2 Ro2p5n1n1 Ro2p5n1n2 11413.1716510374
Ro2p5n1t3 Ro2p5n1n2 Ro2p5n1n3 11321.0762419855
Ro2p5n1t4 Ro2p5n1n3 o2p 11358.4173868554
* o2 input 6 w=+0.124925987288217 w+  bank=n alpha=1 R=266824.65399637 G_phys=3.7477796186465e-06 G_eff=3.7477796186465e-06
* tiled Ro2p6n1 series x4  each=66706.1634990925
Ro2p6n1t1 h6buf Ro2p6n1n1 66640.5748464172
Ro2p6n1t2 Ro2p6n1n1 Ro2p6n1n2 66531.1581707752
Ro2p6n1t3 Ro2p6n1n2 Ro2p6n1n3 66758.8340363643
Ro2p6n1t4 Ro2p6n1n3 o2p 66566.7893363515
* o2 input 7 w=-0.0857938493267301 w-  bank=n alpha=1 R=388528.240601368 G_phys=2.5738154798019e-06 G_eff=2.5738154798019e-06
* tiled Ro2n7n1 series x4  each=97132.060150342
Ro2n7n1t1 h7buf Ro2n7n1n1 96710.3554549668
Ro2n7n1t2 Ro2n7n1n1 Ro2n7n1n2 97273.2812282964
Ro2n7n1t3 Ro2n7n1n2 Ro2n7n1n3 97271.7655475226
Ro2n7n1t4 Ro2n7n1n3 o2n 97063.2162326567
* o2 input 8 w=-0.0609936542707342 w-  bank=n alpha=1 R=546504.939438057 G_phys=1.82980962812202e-06 G_eff=1.82980962812202e-06
* tiled Ro2n8n1 series x4  each=136626.234859514
Ro2n8n1t1 h8buf Ro2n8n1n1 136537.697845885
Ro2n8n1t2 Ro2n8n1n1 Ro2n8n1n2 137297.97205821
Ro2n8n1t3 Ro2n8n1n2 Ro2n8n1n3 137212.970475411
Ro2n8n1t4 Ro2n8n1n3 o2n 136404.081985829
* o2 input 9 w=+0.256981204903229 w+  bank=n alpha=1 R=129711.172246568 G_phys=7.70943614709688e-06 G_eff=7.70943614709688e-06
* tiled Ro2p9n1 series x4  each=32427.793061642
Ro2p9n1t1 h9buf Ro2p9n1n1 32268.2182699882
Ro2p9n1t2 Ro2p9n1n1 Ro2p9n1n2 32353.8290474447
Ro2p9n1t3 Ro2p9n1n2 Ro2p9n1n3 32529.5110776034
Ro2p9n1t4 Ro2p9n1n3 o2p 32333.3263005111
* o2 input 10 w=+0.073638013162671 w+  bank=n alpha=1 R=452664.756987643 G_phys=2.20914039488013e-06 G_eff=2.20914039488013e-06
* tiled Ro2p10n1 series x4  each=113166.189246911
Ro2p10n1t1 h10buf Ro2p10n1n1 113226.162599641
Ro2p10n1t2 Ro2p10n1n1 Ro2p10n1n2 113461.279319759
Ro2p10n1t3 Ro2p10n1n2 Ro2p10n1n3 113506.292453994
Ro2p10n1t4 Ro2p10n1n3 o2p 113417.906439151
* o2 input 11 w=-0.149208279345328 w-  bank=n alpha=1 R=223401.365390634 G_phys=4.47624838035983e-06 G_eff=4.47624838035983e-06
* tiled Ro2n11n1 series x4  each=55850.3413476585
Ro2n11n1t1 h11buf Ro2n11n1n1 55774.5943353679
Ro2n11n1t2 Ro2n11n1n1 Ro2n11n1n2 56079.1847706282
Ro2n11n1t3 Ro2n11n1n2 Ro2n11n1n3 55652.8439884817
Ro2n11n1t4 Ro2n11n1n3 o2n 55671.8141118157
* o2 input 12 w=-0.475362564845884 w-  bank=n alpha=1 R=70121.9149306388 G_phys=1.42608769453765e-05 G_eff=1.42608769453765e-05
* tiled Ro2n12n1 series x4  each=17530.4787326597
Ro2n12n1t1 h12buf Ro2n12n1n1 17605.6387619245
Ro2n12n1t2 Ro2n12n1n1 Ro2n12n1n2 17599.0415282824
Ro2n12n1t3 Ro2n12n1n2 Ro2n12n1n3 17544.5334310878
Ro2n12n1t4 Ro2n12n1n3 o2n 17570.2846614455
* o2 input 13 w=-0.0533811781970356 w-  bank=n alpha=1 R=624439.820535554 G_phys=1.60143534591107e-06 G_eff=1.60143534591107e-06
* tiled Ro2n13n1 series x4  each=156109.955133889
Ro2n13n1t1 h13buf Ro2n13n1n1 156399.819579532
Ro2n13n1t2 Ro2n13n1n1 Ro2n13n1n2 155679.841638967
Ro2n13n1t3 Ro2n13n1n2 Ro2n13n1n3 156392.778118133
Ro2n13n1t4 Ro2n13n1n3 o2n 156793.865589855
* o2 input 14 w=+0.279456004632752 w+  bank=n alpha=1 R=119279.359830319 G_phys=8.38368013898257e-06 G_eff=8.38368013898257e-06
* tiled Ro2p14n1 series x4  each=29819.8399575797
Ro2p14n1t1 h14buf Ro2p14n1n1 29790.9202707927
Ro2p14n1t2 Ro2p14n1n1 Ro2p14n1n2 29675.6764069588
Ro2p14n1t3 Ro2p14n1n2 Ro2p14n1n3 29871.7723089354
Ro2p14n1t4 Ro2p14n1n3 o2p 29715.2008671378
* o2 input 15 w=-0.0744870090943736 w-  bank=n alpha=1 R=447505.326614748 G_phys=2.23461027283121e-06 G_eff=2.23461027283121e-06
* tiled Ro2n15n1 series x4  each=111876.331653687
Ro2n15n1t1 h15buf Ro2n15n1n1 112281.264749711
Ro2n15n1t2 Ro2n15n1n1 Ro2n15n1n2 111402.143852148
Ro2n15n1t3 Ro2n15n1n2 Ro2n15n1n3 111336.505190009
Ro2n15n1t4 Ro2n15n1n3 o2n 111618.069870345
* o2 input 16 w=-0.0222148593491043 w-  bank=f alpha=0.001 R=1500.49715865869 G_phys=0.000666445780473128 G_eff=6.66445780473128e-07
* tiled Ro2n16f1 parallel x4  each=6001.98863463475
Ro2n16f1t1 h16f o2n 5991.37428138442
Ro2n16f1t2 h16f o2n 5989.73674888788
Ro2n16f1t3 h16f o2n 5997.32970550679
Ro2n16f1t4 h16f o2n 6018.82535283455
* o2 input 17 w=+0.0088751960388594 w+  bank=f alpha=0.001 R=3755.78558348297 G_phys=0.000266255881165782 G_eff=2.66255881165782e-07
* tiled Ro2p17f1 parallel x4  each=15023.1423339319
Ro2p17f1t1 h17f o2p 15079.557943653
Ro2p17f1t2 h17f o2p 15043.8268638795
Ro2p17f1t3 h17f o2p 15007.0368682808
Ro2p17f1t4 h17f o2p 14984.8304093637
* o2 input 18 w=-0.194172060066752 w-  bank=n alpha=1 R=171669.051262443 G_phys=5.82516180200256e-06 G_eff=5.82516180200256e-06
* tiled Ro2n18n1 series x4  each=42917.2628156106
Ro2n18n1t1 h18buf Ro2n18n1n1 42984.0941142636
Ro2n18n1t2 Ro2n18n1n1 Ro2n18n1n2 42855.1083257271
Ro2n18n1t3 Ro2n18n1n2 Ro2n18n1n3 42900.293578994
Ro2n18n1t4 Ro2n18n1n3 o2n 42973.2563922926
* o2 input 19 w=+0.341327626188232 w+  bank=n alpha=1 R=97657.8828546125 G_phys=1.0239828785647e-05 G_eff=1.0239828785647e-05
* tiled Ro2p19n1 series x4  each=24414.4707136531
Ro2p19n1t1 h19buf Ro2p19n1n1 24400.2505809858
Ro2p19n1t2 Ro2p19n1n1 Ro2p19n1n2 24415.96393562
Ro2p19n1t3 Ro2p19n1n2 Ro2p19n1n3 24514.8838277135
Ro2p19n1t4 Ro2p19n1n3 o2p 24422.3747440254
* o2 input 20 w=-0.0323870183321868 w-  bank=f alpha=0.001 R=1029.21896024637 G_phys=0.000971610549965604 G_eff=9.71610549965604e-07
* tiled Ro2n20f1 parallel x4  each=4116.87584098547
Ro2n20f1t1 h20f o2n 4103.70714935382
Ro2n20f1t2 h20f o2n 4126.55702125534
Ro2n20f1t3 h20f o2n 4114.68723419817
Ro2n20f1t4 h20f o2n 4116.64534083365
* o2 input 21 w=-0.0999542141187652 w-  bank=n alpha=1 R=333486.022847689 G_phys=2.99862642356296e-06 G_eff=2.99862642356296e-06
* tiled Ro2n21n1 series x4  each=83371.5057119223
Ro2n21n1t1 h21buf Ro2n21n1n1 83590.3230320627
Ro2n21n1t2 Ro2n21n1n1 Ro2n21n1n2 83047.1036602514
Ro2n21n1t3 Ro2n21n1n2 Ro2n21n1n3 83554.7540635027
Ro2n21n1t4 Ro2n21n1n3 o2n 83024.7491399017
* o2 input 22 w=+0.693789300406694 w+  bank=n alpha=1 R=48045.3263170729 G_phys=2.08136790122008e-05 G_eff=2.08136790122008e-05
* tiled Ro2p22n1 series x4  each=12011.3315792682
Ro2p22n1t1 h22buf Ro2p22n1n1 12035.9675937663
Ro2p22n1t2 Ro2p22n1n1 Ro2p22n1n2 11986.7645358538
Ro2p22n1t3 Ro2p22n1n2 Ro2p22n1n3 12039.2641353552
Ro2p22n1t4 Ro2p22n1n3 o2p 11961.0797722063
* o2 input 23 w=+0.0972685864670828 w+  bank=n alpha=1 R=342693.715864925 G_phys=2.91805759401248e-06 G_eff=2.91805759401248e-06
* tiled Ro2p23n1 series x4  each=85673.4289662312
Ro2p23n1t1 h23buf Ro2p23n1n1 85375.0457963287
Ro2p23n1t2 Ro2p23n1n1 Ro2p23n1n2 85505.7284136621
Ro2p23n1t3 Ro2p23n1n2 Ro2p23n1n3 85414.5831557525
Ro2p23n1t4 Ro2p23n1n3 o2p 85974.808035727
* o2 input 24 w=-0.0293783170287994 w-  bank=f alpha=0.001 R=1134.6236512002 G_phys=0.000881349510863982 G_eff=8.81349510863982e-07
* tiled Ro2n24f1 parallel x4  each=4538.4946048008
Ro2n24f1t1 h24f o2n 4532.57687697299
Ro2n24f1t2 h24f o2n 4520.01640563138
Ro2n24f1t3 h24f o2n 4540.55603828713
Ro2n24f1t4 h24f o2n 4516.48260773538
* o2 input 25 w=+0.0497492024826392 w+  bank=n alpha=1 R=670027.491294269 G_phys=1.49247607447918e-06 G_eff=1.49247607447918e-06
* tiled Ro2p25n1 series x4  each=167506.872823567
Ro2p25n1t1 h25buf Ro2p25n1n1 167262.584838436
Ro2p25n1t2 Ro2p25n1n1 Ro2p25n1n2 166675.938916539
Ro2p25n1t3 Ro2p25n1n2 Ro2p25n1n3 166874.064521213
Ro2p25n1t4 Ro2p25n1n3 o2p 167152.233262163
* o2 input 26 w=-0.466063512962686 w-  bank=n alpha=1 R=71521.0103477937 G_phys=1.39819053888806e-05 G_eff=1.39819053888806e-05
* tiled Ro2n26n1 series x4  each=17880.2525869484
Ro2n26n1t1 h26buf Ro2n26n1n1 17831.4376936414
Ro2n26n1t2 Ro2n26n1n1 Ro2n26n1n2 17867.6554637673
Ro2n26n1t3 Ro2n26n1n2 Ro2n26n1n3 17837.503590065
Ro2n26n1t4 Ro2n26n1n3 o2n 17935.8524571743
* o2 input 27 w=+0.194887582685885 w+  bank=n alpha=1 R=171038.774630702 G_phys=5.84662748057655e-06 G_eff=5.84662748057655e-06
* tiled Ro2p27n1 series x4  each=42759.6936576754
Ro2p27n1t1 h27buf Ro2p27n1n1 42882.5862117788
Ro2p27n1t2 Ro2p27n1n1 Ro2p27n1n2 42800.328394623
Ro2p27n1t3 Ro2p27n1n2 Ro2p27n1n3 42879.1262160824
Ro2p27n1t4 Ro2p27n1n3 o2p 42684.883168782
* o2 input 28 w=+0.209047565197081 w+  bank=n alpha=1 R=159453.344036359 G_phys=6.27142695591242e-06 G_eff=6.27142695591242e-06
* tiled Ro2p28n1 series x4  each=39863.3360090898
Ro2p28n1t1 h28buf Ro2p28n1n1 39690.2990670826
Ro2p28n1t2 Ro2p28n1n1 Ro2p28n1n2 40047.78989151
Ro2p28n1t3 Ro2p28n1n2 Ro2p28n1n3 39753.7585610358
Ro2p28n1t4 Ro2p28n1n3 o2p 39997.2354870601
* o2 input 29 w=+0.00919963467526149 w+  bank=f alpha=0.001 R=3623.33228546229 G_phys=0.000275989040257845 G_eff=2.75989040257845e-07
* tiled Ro2p29f1 parallel x4  each=14493.3291418492
Ro2p29f1t1 h29f o2p 14471.8460716356
Ro2p29f1t2 h29f o2p 14442.5320308858
Ro2p29f1t3 h29f o2p 14431.7849954445
Ro2p29f1t4 h29f o2p 14558.4147597175
* o2 input 30 w=-0.379437042796868 w-  bank=n alpha=1 R=87849.4442388387 G_phys=1.13831112839061e-05 G_eff=1.13831112839061e-05
* tiled Ro2n30n1 series x4  each=21962.3610597097
Ro2n30n1t1 h30buf Ro2n30n1n1 21992.4491179992
Ro2n30n1t2 Ro2n30n1n1 Ro2n30n1n2 21857.793706814
Ro2n30n1t3 Ro2n30n1n2 Ro2n30n1n3 21990.6273702572
Ro2n30n1t4 Ro2n30n1n3 o2n 22043.3954296314
* o2 input 31 w=-0.216631724491884 w-  bank=n alpha=1 R=153870.96885979 G_phys=6.49895173475653e-06 G_eff=6.49895173475653e-06
* tiled Ro2n31n1 series x4  each=38467.7422149475
Ro2n31n1t1 h31buf Ro2n31n1n1 38646.1300212286
Ro2n31n1t2 Ro2n31n1n1 Ro2n31n1n2 38466.8738675836
Ro2n31n1t3 Ro2n31n1n2 Ro2n31n1n3 38395.0636769343
Ro2n31n1t4 Ro2n31n1n3 o2n 38556.5362436785
* o2 input 32 w=+0.139103822260271 w+  bank=n alpha=1 R=239629.169002738 G_phys=4.17311466780814e-06 G_eff=4.17311466780814e-06
* tiled Ro2p32n1 series x4  each=59907.2922506844
Ro2p32n1t1 h32buf Ro2p32n1n1 60020.6368690227
Ro2p32n1t2 Ro2p32n1n1 Ro2p32n1n2 59995.8100029428
Ro2p32n1t3 Ro2p32n1n2 Ro2p32n1n3 59888.6771984823
Ro2p32n1t4 Ro2p32n1n3 o2p 60166.5132314393
* o2 bias=+0.0322130531942455 b+  bank=f alpha=0.001 R=1034.77721072674 G_phys=0.000966391595827364 G_eff=9.66391595827364e-07
* tiled Ro2bpf1 parallel x4  each=4139.10884290695
Ro2bpf1t1 vreff o2p 4138.25138988675
Ro2bpf1t2 vreff o2p 4153.74494363495
Ro2bpf1t3 vreff o2p 4136.90281909474
Ro2bpf1t4 vreff o2p 4125.57573505002
Vo2p o2p 0 DC 0
Vo2n o2n 0 DC 0
Fo2p 0 o2d Vo2p 1.001
Fo2n o2d 0 Vo2n 1.001
* ratiometric I-to-V: V = I * R_IV,  R_IV=33333.3333333333 (weight ~ R_IV / R_w)
* tiled Ro2iv series x4  each=8333.33333333333
Ro2ivt1 o2d Ro2ivn1 8314.912643123
Ro2ivt2 Ro2ivn1 Ro2ivn2 8309.43084030089
Ro2ivt3 Ro2ivn2 Ro2ivn3 8321.84801142668
Ro2ivt4 Ro2ivn3 0 8341.08175684192
Bo2leak 0 o2d I = 1e-08
Eo2sc o2raw 0 o2d 0 1
Eo2lin o2lin 0 o2raw 0 1

* o3 input 1 w=-0.100595944434035 w-  bank=n alpha=1 R=331358.620080271 G_phys=3.01787833302104e-06 G_eff=3.01787833302104e-06
* tiled Ro3n1n1 series x4  each=82839.6550200678
Ro3n1n1t1 h1buf Ro3n1n1n1 82624.6939064016
Ro3n1n1t2 Ro3n1n1n1 Ro3n1n1n2 82944.0180595623
Ro3n1n1t3 Ro3n1n1n2 Ro3n1n1n3 82786.7249397071
Ro3n1n1t4 Ro3n1n1n3 o3n 82479.7161546327
* o3 input 2 w=-0.265315115107159 w-  bank=n alpha=1 R=125636.767132058 G_phys=7.95945345321476e-06 G_eff=7.95945345321476e-06
* tiled Ro3n2n1 series x4  each=31409.1917830146
Ro3n2n1t1 h2buf Ro3n2n1n1 31317.4671799053
Ro3n2n1t2 Ro3n2n1n1 Ro3n2n1n2 31416.5930433507
Ro3n2n1t3 Ro3n2n1n2 Ro3n2n1n3 31352.9747702412
Ro3n2n1t4 Ro3n2n1n3 o3n 31285.8034016966
* o3 input 3 w=-0.0591677372187977 w-  bank=n alpha=1 R=563370.088162562 G_phys=1.77503211656393e-06 G_eff=1.77503211656393e-06
* tiled Ro3n3n1 series x4  each=140842.52204064
Ro3n3n1t1 h3buf Ro3n3n1n1 141074.247718641
Ro3n3n1t2 Ro3n3n1n1 Ro3n3n1n2 140470.079737488
Ro3n3n1t3 Ro3n3n1n2 Ro3n3n1n3 140873.400673532
Ro3n3n1t4 Ro3n3n1n3 o3n 140271.588220558
* o3 input 4 w=-0.0695954531730398 w-  bank=n alpha=1 R=478958.492452868 G_phys=2.08786359519119e-06 G_eff=2.08786359519119e-06
* tiled Ro3n4n1 series x4  each=119739.623113217
Ro3n4n1t1 h4buf Ro3n4n1n1 119154.821743768
Ro3n4n1t2 Ro3n4n1n1 Ro3n4n1n2 120084.292557868
Ro3n4n1t3 Ro3n4n1n2 Ro3n4n1n3 119548.731284022
Ro3n4n1t4 Ro3n4n1n3 o3n 120306.123434247
* o3 input 5 w=-0.284313347850547 w-  bank=n alpha=1 R=117241.53503639 G_phys=8.52940043551641e-06 G_eff=8.52940043551641e-06
* tiled Ro3n5n1 series x4  each=29310.3837590976
Ro3n5n1t1 h5buf Ro3n5n1n1 29270.6347991827
Ro3n5n1t2 Ro3n5n1n1 Ro3n5n1n2 29271.3928835816
Ro3n5n1t3 Ro3n5n1n2 Ro3n5n1n3 29339.6815812103
Ro3n5n1t4 Ro3n5n1n3 o3n 29420.8845250752
* o3 input 6 w=+0.314440272159438 w+  bank=n alpha=1 R=106008.473737841 G_phys=9.43320816478313e-06 G_eff=9.43320816478313e-06
* tiled Ro3p6n1 series x4  each=26502.1184344602
Ro3p6n1t1 h6buf Ro3p6n1n1 26446.0572018357
Ro3p6n1t2 Ro3p6n1n1 Ro3p6n1n2 26510.0262814359
Ro3p6n1t3 Ro3p6n1n2 Ro3p6n1n3 26463.1398367161
Ro3p6n1t4 Ro3p6n1n3 o3p 26516.9871197158
* o3 input 7 w=-0.349535009995164 w-  bank=n alpha=1 R=95364.7914519193 G_phys=1.04860502998549e-05 G_eff=1.04860502998549e-05
* tiled Ro3n7n1 series x4  each=23841.1978629798
Ro3n7n1t1 h7buf Ro3n7n1n1 23933.0429530957
Ro3n7n1t2 Ro3n7n1n1 Ro3n7n1n2 23958.0066972646
Ro3n7n1t3 Ro3n7n1n2 Ro3n7n1n3 23773.7613040626
Ro3n7n1t4 Ro3n7n1n3 o3n 23896.7528973394
* o3 input 8 w=-0.295696300813859 w-  bank=n alpha=1 R=112728.273034152 G_phys=8.87088902441576e-06 G_eff=8.87088902441576e-06
* tiled Ro3n8n1 series x4  each=28182.068258538
Ro3n8n1t1 h8buf Ro3n8n1n1 28228.4130831423
Ro3n8n1t2 Ro3n8n1n1 Ro3n8n1n2 28153.55287042
Ro3n8n1t3 Ro3n8n1n2 Ro3n8n1n3 28116.5101067963
Ro3n8n1t4 Ro3n8n1n3 o3n 28252.4746517445
* o3 input 9 w=-0.735854867565559 w-  bank=n alpha=1 R=45298.7875769723 G_phys=2.20756460269668e-05 G_eff=2.20756460269668e-05
* tiled Ro3n9n1 series x4  each=11324.6968942431
Ro3n9n1t1 h9buf Ro3n9n1n1 11368.2414711895
Ro3n9n1t2 Ro3n9n1n1 Ro3n9n1n2 11343.3277534318
Ro3n9n1t3 Ro3n9n1n2 Ro3n9n1n3 11314.5158121697
Ro3n9n1t4 Ro3n9n1n3 o3n 11324.1058208382
* o3 input 10 w=-0.0859238760568894 w-  bank=n alpha=1 R=387940.289277262 G_phys=2.57771628170668e-06 G_eff=2.57771628170668e-06
* tiled Ro3n10n1 series x4  each=96985.0723193156
Ro3n10n1t1 h10buf Ro3n10n1n1 96595.2783917264
Ro3n10n1t2 Ro3n10n1n1 Ro3n10n1n2 97337.0303122073
Ro3n10n1t3 Ro3n10n1n2 Ro3n10n1n3 96904.398186695
Ro3n10n1t4 Ro3n10n1n3 o3n 97074.0930816609
* o3 input 11 w=-0.105996934570411 w-  bank=n alpha=1 R=314474.503139436 G_phys=3.17990803711233e-06 G_eff=3.17990803711233e-06
* tiled Ro3n11n1 series x4  each=78618.6257848591
Ro3n11n1t1 h11buf Ro3n11n1n1 78248.19468194
Ro3n11n1t2 Ro3n11n1n1 Ro3n11n1n2 78344.7562197679
Ro3n11n1t3 Ro3n11n1n2 Ro3n11n1n3 78450.2807766669
Ro3n11n1t4 Ro3n11n1n3 o3n 78576.5809997585
* o3 input 12 w=-0.193541479603888 w-  bank=n alpha=1 R=172228.36883109 G_phys=5.80624438811663e-06 G_eff=5.80624438811663e-06
* tiled Ro3n12n1 series x4  each=43057.0922077726
Ro3n12n1t1 h12buf Ro3n12n1n1 42906.803862774
Ro3n12n1t2 Ro3n12n1n1 Ro3n12n1n2 43118.4621061026
Ro3n12n1t3 Ro3n12n1n2 Ro3n12n1n3 43268.7741281
Ro3n12n1t4 Ro3n12n1n3 o3n 43094.5433912877
* o3 input 13 w=-0.351950930756974 w-  bank=n alpha=1 R=94710.172414206 G_phys=1.05585279227092e-05 G_eff=1.05585279227092e-05
* tiled Ro3n13n1 series x4  each=23677.5431035515
Ro3n13n1t1 h13buf Ro3n13n1n1 23744.8120993411
Ro3n13n1t2 Ro3n13n1n1 Ro3n13n1n2 23625.8597029007
Ro3n13n1t3 Ro3n13n1n2 Ro3n13n1n3 23625.0361198238
Ro3n13n1t4 Ro3n13n1n3 o3n 23771.4700714862
* o3 input 14 w=+0.0402342325324318 w+  bank=n alpha=1 R=828481.898007229 G_phys=1.20702697597296e-06 G_eff=1.20702697597296e-06
* tiled Ro3p14n1 series x4  each=207120.474501807
Ro3p14n1t1 h14buf Ro3p14n1n1 206126.40976804
Ro3p14n1t2 Ro3p14n1n1 Ro3p14n1n2 207371.720415444
Ro3p14n1t3 Ro3p14n1n2 Ro3p14n1n3 206456.929722373
Ro3p14n1t4 Ro3p14n1n3 o3p 207335.418916855
* o3 input 15 w=+0.188158881095559 w+  bank=n alpha=1 R=177155.248475381 G_phys=5.64476643286676e-06 G_eff=5.64476643286676e-06
* tiled Ro3p15n1 series x4  each=44288.8121188452
Ro3p15n1t1 h15buf Ro3p15n1n1 44186.3982283966
Ro3p15n1t2 Ro3p15n1n1 Ro3p15n1n2 44116.3087927744
Ro3p15n1t3 Ro3p15n1n2 Ro3p15n1n3 44423.8826691469
Ro3p15n1t4 Ro3p15n1n3 o3p 44340.6910242264
* o3 input 16 w=+0.204693314484602 w+  bank=n alpha=1 R=162845.246886853 G_phys=6.14079943453807e-06 G_eff=6.14079943453807e-06
* tiled Ro3p16n1 series x4  each=40711.3117217133
Ro3p16n1t1 h16buf Ro3p16n1n1 40581.7132886315
Ro3p16n1t2 Ro3p16n1n1 Ro3p16n1n2 40647.4546184529
Ro3p16n1t3 Ro3p16n1n2 Ro3p16n1n3 40818.7081664994
Ro3p16n1t4 Ro3p16n1n3 o3p 40599.5740137162
* o3 input 17 w=+0.153640089266272 w+  bank=n alpha=1 R=216957.263514496 G_phys=4.60920267798816e-06 G_eff=4.60920267798816e-06
* tiled Ro3p17n1 series x4  each=54239.3158786241
Ro3p17n1t1 h17buf Ro3p17n1n1 54363.8976531029
Ro3p17n1t2 Ro3p17n1n1 Ro3p17n1n2 54201.8792629866
Ro3p17n1t3 Ro3p17n1n2 Ro3p17n1n3 54472.0710327509
Ro3p17n1t4 Ro3p17n1n3 o3p 54057.0510485715
* o3 input 18 w=+0.463153650429953 w+  bank=n alpha=1 R=71970.3564948468 G_phys=1.38946095128986e-05 G_eff=1.38946095128986e-05
* tiled Ro3p18n1 series x4  each=17992.5891237117
Ro3p18n1t1 h18buf Ro3p18n1n1 18028.925966793
Ro3p18n1t2 Ro3p18n1n1 Ro3p18n1n2 17906.3667362397
Ro3p18n1t3 Ro3p18n1n2 Ro3p18n1n3 18067.0448799288
Ro3p18n1t4 Ro3p18n1n3 o3p 17994.1645043307
* o3 input 19 w=-0.0426705918571366 w-  bank=n alpha=1 R=781178.134227318 G_phys=1.2801177557141e-06 G_eff=1.2801177557141e-06
* tiled Ro3n19n1 series x4  each=195294.533556829
Ro3n19n1t1 h19buf Ro3n19n1n1 194338.836982165
Ro3n19n1t2 Ro3n19n1n1 Ro3n19n1n2 195780.454474858
Ro3n19n1t3 Ro3n19n1n2 Ro3n19n1n3 195415.405377093
Ro3n19n1t4 Ro3n19n1n3 o3n 195256.733932791
* o3 input 20 w=+0.210331327799834 w+  bank=n alpha=1 R=158480.116500076 G_phys=6.30993983399502e-06 G_eff=6.30993983399502e-06
* tiled Ro3p20n1 series x4  each=39620.029125019
Ro3p20n1t1 h20buf Ro3p20n1n1 39793.8807501541
Ro3p20n1t2 Ro3p20n1n1 Ro3p20n1n2 39692.0700108121
Ro3p20n1t3 Ro3p20n1n2 Ro3p20n1n3 39699.6693277971
Ro3p20n1t4 Ro3p20n1n3 o3p 39564.1213163333
* o3 input 21 w=-0.0625815721904128 w-  bank=n alpha=1 R=532638.157953466 G_phys=1.87744716571238e-06 G_eff=1.87744716571238e-06
* tiled Ro3n21n1 series x4  each=133159.539488367
Ro3n21n1t1 h21buf Ro3n21n1n1 133099.149330496
Ro3n21n1t2 Ro3n21n1n1 Ro3n21n1n2 133578.271314793
Ro3n21n1t3 Ro3n21n1n2 Ro3n21n1n3 133255.350587348
Ro3n21n1t4 Ro3n21n1n3 o3n 132700.395089155
* o3 input 22 w=+0.238697201684848 w+  bank=n alpha=1 R=139646.938037185 G_phys=7.16091605054544e-06 G_eff=7.16091605054544e-06
* tiled Ro3p22n1 series x4  each=34911.7345092962
Ro3p22n1t1 h22buf Ro3p22n1n1 34814.8021471779
Ro3p22n1t2 Ro3p22n1n1 Ro3p22n1n2 34928.2640507864
Ro3p22n1t3 Ro3p22n1n2 Ro3p22n1n3 34755.2951216017
Ro3p22n1t4 Ro3p22n1n3 o3p 35068.5164128419
* o3 input 23 w=-0.0558624260671465 w-  bank=n alpha=1 R=596704.004463873 G_phys=1.67587278201439e-06 G_eff=1.67587278201439e-06
* tiled Ro3n23n1 series x4  each=149176.001115968
Ro3n23n1t1 h23buf Ro3n23n1n1 149455.151919944
Ro3n23n1t2 Ro3n23n1n1 Ro3n23n1n2 148434.195541895
Ro3n23n1t3 Ro3n23n1n2 Ro3n23n1n3 149199.720692526
Ro3n23n1t4 Ro3n23n1n3 o3n 148450.628105497
* o3 input 24 w=+0.439236044835332 w+  bank=n alpha=1 R=75889.3395140872 G_phys=1.317708134506e-05 G_eff=1.317708134506e-05
* tiled Ro3p24n1 series x4  each=18972.3348785218
Ro3p24n1t1 h24buf Ro3p24n1n1 18979.1509670527
Ro3p24n1t2 Ro3p24n1n1 Ro3p24n1n2 19061.8793442178
Ro3p24n1t3 Ro3p24n1n2 Ro3p24n1n3 19058.0318416479
Ro3p24n1t4 Ro3p24n1n3 o3p 18991.0337480166
* o3 input 25 w=+0.113742741787302 w+  bank=n alpha=1 R=293058.992684265 G_phys=3.41228225361907e-06 G_eff=3.41228225361907e-06
* tiled Ro3p25n1 series x4  each=73264.7481710664
Ro3p25n1t1 h25buf Ro3p25n1n1 73463.4748822632
Ro3p25n1t2 Ro3p25n1n1 Ro3p25n1n2 73517.8071405352
Ro3p25n1t3 Ro3p25n1n2 Ro3p25n1n3 72934.2873096348
Ro3p25n1t4 Ro3p25n1n3 o3p 73050.7721771576
* o3 input 26 w=-0.433617266896606 w-  bank=n alpha=1 R=76872.7075190056 G_phys=1.30085180068982e-05 G_eff=1.30085180068982e-05
* tiled Ro3n26n1 series x4  each=19218.1768797514
Ro3n26n1t1 h26buf Ro3n26n1n1 19282.7517297195
Ro3n26n1t2 Ro3n26n1n1 Ro3n26n1n2 19191.0321531723
Ro3n26n1t3 Ro3n26n1n2 Ro3n26n1n3 19137.0660406601
Ro3n26n1t4 Ro3n26n1n3 o3n 19224.3313216076
* o3 input 27 w=+0.230315174630548 w+  bank=n alpha=1 R=144729.210252012 G_phys=6.90945523891643e-06 G_eff=6.90945523891643e-06
* tiled Ro3p27n1 series x4  each=36182.3025630029
Ro3p27n1t1 h27buf Ro3p27n1n1 36220.5844957432
Ro3p27n1t2 Ro3p27n1n1 Ro3p27n1n2 36247.2250553684
Ro3p27n1t3 Ro3p27n1n2 Ro3p27n1n3 36338.3475692022
Ro3p27n1t4 Ro3p27n1n3 o3p 36354.7944711015
* o3 input 28 w=-0.12398109066818 w-  bank=n alpha=1 R=268858.203728388 G_phys=3.71943272004541e-06 G_eff=3.71943272004541e-06
* tiled Ro3n28n1 series x4  each=67214.5509320969
Ro3n28n1t1 h28buf Ro3n28n1n1 67538.3131605642
Ro3n28n1t2 Ro3n28n1n1 Ro3n28n1n2 66938.9223915331
Ro3n28n1t3 Ro3n28n1n2 Ro3n28n1n3 67241.1882549135
Ro3n28n1t4 Ro3n28n1n3 o3n 67342.3604024895
* o3 input 29 w=-0.26178305647614 w-  bank=n alpha=1 R=127331.897572108 G_phys=7.85349169428421e-06 G_eff=7.85349169428421e-06
* tiled Ro3n29n1 series x4  each=31832.9743930271
Ro3n29n1t1 h29buf Ro3n29n1n1 31696.5605524709
Ro3n29n1t2 Ro3n29n1n1 Ro3n29n1n2 31763.1485184104
Ro3n29n1t3 Ro3n29n1n2 Ro3n29n1n3 31887.0251899106
Ro3n29n1t4 Ro3n29n1n3 o3n 31751.5743120222
* o3 input 30 w=-0.44647126763401 w-  bank=n alpha=1 R=74659.5262668906 G_phys=1.33941380290203e-05 G_eff=1.33941380290203e-05
* tiled Ro3n30n1 series x4  each=18664.8815667226
Ro3n30n1t1 h30buf Ro3n30n1n1 18640.6012089466
Ro3n30n1t2 Ro3n30n1n1 Ro3n30n1n2 18627.4347008325
Ro3n30n1t3 Ro3n30n1n2 Ro3n30n1n3 18754.7287357449
Ro3n30n1t4 Ro3n30n1n3 o3n 18729.8665300318
* o3 input 31 w=-0.53039390006668 w-  bank=n alpha=1 R=62846.3738537392 G_phys=1.59118170020004e-05 G_eff=1.59118170020004e-05
* tiled Ro3n31n1 series x4  each=15711.5934634348
Ro3n31n1t1 h31buf Ro3n31n1n1 15682.4921665433
Ro3n31n1t2 Ro3n31n1n1 Ro3n31n1n2 15725.957987479
Ro3n31n1t3 Ro3n31n1n2 Ro3n31n1n3 15680.4207032462
Ro3n31n1t4 Ro3n31n1n3 o3n 15769.3559486611
* o3 input 32 w=+0.288818654520262 w+  bank=n alpha=1 R=115412.674394946 G_phys=8.66455963560785e-06 G_eff=8.66455963560785e-06
* tiled Ro3p32n1 series x4  each=28853.1685987365
Ro3p32n1t1 h32buf Ro3p32n1n1 28950.0971432792
Ro3p32n1t2 Ro3p32n1n1 Ro3p32n1n2 28922.364484228
Ro3p32n1t3 Ro3p32n1n2 Ro3p32n1n3 28988.2467930114
Ro3p32n1t4 Ro3p32n1n3 o3p 28712.1203873635
* o3 bias=+0.0635007025703613 b+  bank=n alpha=1 R=524928.575339756 G_phys=1.90502107711084e-06 G_eff=1.90502107711084e-06
* tiled Ro3bpn1 series x4  each=131232.143834939
Ro3bpn1t1 vref Ro3bpn1n1 131668.101854802
Ro3bpn1t2 Ro3bpn1n1 Ro3bpn1n2 130617.87503084
Ro3bpn1t3 Ro3bpn1n2 Ro3bpn1n3 131760.847536273
Ro3bpn1t4 Ro3bpn1n3 o3p 131345.760329857
Vo3p o3p 0 DC 0
Vo3n o3n 0 DC 0
Fo3p 0 o3d Vo3p 1.001
Fo3n o3d 0 Vo3n 1.001
* ratiometric I-to-V: V = I * R_IV,  R_IV=33333.3333333333 (weight ~ R_IV / R_w)
* tiled Ro3iv series x4  each=8333.33333333333
Ro3ivt1 o3d Ro3ivn1 8301.49611614929
Ro3ivt2 Ro3ivn1 Ro3ivn2 8336.41921551405
Ro3ivt3 Ro3ivn2 Ro3ivn3 8353.37108699383
Ro3ivt4 Ro3ivn3 0 8328.13287291208
Bo3leak 0 o3d I = 1e-08
Eo3sc o3raw 0 o3d 0 1
Eo3lin o3lin 0 o3raw 0 1

* o4 input 1 w=+0.274757256178841 w+  bank=n alpha=1 R=121319.210261863 G_phys=8.24271768536522e-06 G_eff=8.24271768536522e-06
* tiled Ro4p1n1 series x4  each=30329.8025654657
Ro4p1n1t1 h1buf Ro4p1n1n1 30441.2077250107
Ro4p1n1t2 Ro4p1n1n1 Ro4p1n1n2 30352.963711988
Ro4p1n1t3 Ro4p1n1n2 Ro4p1n1n3 30257.7352249504
Ro4p1n1t4 Ro4p1n1n3 o4p 30404.0745862555
* o4 input 2 w=-0.133159767354893 w-  bank=n alpha=1 R=250325.860396666 G_phys=3.99479302064678e-06 G_eff=3.99479302064678e-06
* tiled Ro4n2n1 series x4  each=62581.4650991664
Ro4n2n1t1 h2buf Ro4n2n1n1 62599.9734059521
Ro4n2n1t2 Ro4n2n1n1 Ro4n2n1n2 62858.3249281889
Ro4n2n1t3 Ro4n2n1n2 Ro4n2n1n3 62759.4747965368
Ro4n2n1t4 Ro4n2n1n3 o4n 62350.7548063353
* o4 input 3 w=-0.106623598682841 w-  bank=n alpha=1 R=312626.226699453 G_phys=3.19870796048523e-06 G_eff=3.19870796048523e-06
* tiled Ro4n3n1 series x4  each=78156.5566748633
Ro4n3n1t1 h3buf Ro4n3n1n1 78219.7856689691
Ro4n3n1t2 Ro4n3n1n1 Ro4n3n1n2 77941.178804981
Ro4n3n1t3 Ro4n3n1n2 Ro4n3n1n3 77878.0853778004
Ro4n3n1t4 Ro4n3n1n3 o4n 78138.9178687786
* o4 input 4 w=+0.10049322803724 w+  bank=n alpha=1 R=331697.309205562 G_phys=3.01479684111719e-06 G_eff=3.01479684111719e-06
* tiled Ro4p4n1 series x4  each=82924.3273013906
Ro4p4n1t1 h4buf Ro4p4n1n1 82989.0015292204
Ro4p4n1t2 Ro4p4n1n1 Ro4p4n1n2 83227.5428153403
Ro4p4n1t3 Ro4p4n1n2 Ro4p4n1n3 83020.7334599801
Ro4p4n1t4 Ro4p4n1n3 o4p 82610.4900128545
* o4 input 5 w=-0.195742340683107 w-  bank=n alpha=1 R=170291.890947078 G_phys=5.87227022049321e-06 G_eff=5.87227022049321e-06
* tiled Ro4n5n1 series x4  each=42572.9727367694
Ro4n5n1t1 h5buf Ro4n5n1n1 42496.7653851182
Ro4n5n1t2 Ro4n5n1n1 Ro4n5n1n2 42646.3075429218
Ro4n5n1t3 Ro4n5n1n2 Ro4n5n1n3 42734.4940737599
Ro4n5n1t4 Ro4n5n1n3 o4n 42454.5055907759
* o4 input 6 w=-0.202179592890339 w-  bank=n alpha=1 R=164869.920137851 G_phys=6.06538778671016e-06 G_eff=6.06538778671016e-06
* tiled Ro4n6n1 series x4  each=41217.4800344627
Ro4n6n1t1 h6buf Ro4n6n1n1 41324.2154006518
Ro4n6n1t2 Ro4n6n1n1 Ro4n6n1n2 41251.3946218599
Ro4n6n1t3 Ro4n6n1n2 Ro4n6n1n3 41352.6795332171
Ro4n6n1t4 Ro4n6n1n3 o4n 41180.1908856184
* o4 input 7 w=-0.112561544712497 w-  bank=n alpha=1 R=296134.291853162 G_phys=3.37684634137491e-06 G_eff=3.37684634137491e-06
* tiled Ro4n7n1 series x4  each=74033.5729632906
Ro4n7n1t1 h7buf Ro4n7n1n1 73785.0052050759
Ro4n7n1t2 Ro4n7n1n1 Ro4n7n1n2 74146.6920430006
Ro4n7n1t3 Ro4n7n1n2 Ro4n7n1n3 74101.4759294503
Ro4n7n1t4 Ro4n7n1n3 o4n 74403.0509412817
* o4 input 8 w=+0.0264861793940817 w+  bank=f alpha=0.001 R=1258.5179930021 G_phys=0.000794585381822452 G_eff=7.94585381822452e-07
* tiled Ro4p8f1 parallel x4  each=5034.0719720084
Ro4p8f1t1 h8f o4p 5013.32889504528
Ro4p8f1t2 h8f o4p 5024.92489850978
Ro4p8f1t3 h8f o4p 5045.14764458452
Ro4p8f1t4 h8f o4p 5012.48150642958
* o4 input 9 w=-0.0974936293293829 w-  bank=n alpha=1 R=341902.681873874 G_phys=2.92480887988149e-06 G_eff=2.92480887988149e-06
* tiled Ro4n9n1 series x4  each=85475.6704684684
Ro4n9n1t1 h9buf Ro4n9n1n1 85455.6259178218
Ro4n9n1t2 Ro4n9n1n1 Ro4n9n1n2 85058.935010861
Ro4n9n1t3 Ro4n9n1n2 Ro4n9n1n3 85816.4559426581
Ro4n9n1t4 Ro4n9n1n3 o4n 85115.6789978196
* o4 input 10 w=-0.296895349286464 w-  bank=n alpha=1 R=112273.006005127 G_phys=8.90686047859392e-06 G_eff=8.90686047859392e-06
* tiled Ro4n10n1 series x4  each=28068.2515012816
Ro4n10n1t1 h10buf Ro4n10n1n1 27984.3576550912
Ro4n10n1t2 Ro4n10n1n1 Ro4n10n1n2 27932.975661638
Ro4n10n1t3 Ro4n10n1n2 Ro4n10n1n3 27932.9540256187
Ro4n10n1t4 Ro4n10n1n3 o4n 27972.7084036609
* o4 input 11 w=-0.580818210763829 w-  bank=n alpha=1 R=57390.303395441 G_phys=1.74245463229149e-05 G_eff=1.74245463229149e-05
* tiled Ro4n11n1 series x4  each=14347.5758488603
Ro4n11n1t1 h11buf Ro4n11n1n1 14372.7360247138
Ro4n11n1t2 Ro4n11n1n1 Ro4n11n1n2 14395.5307647596
Ro4n11n1t3 Ro4n11n1n2 Ro4n11n1n3 14275.9376686282
Ro4n11n1t4 Ro4n11n1n3 o4n 14293.8321131128
* o4 input 12 w=-0.276549005245937 w-  bank=n alpha=1 R=120533.188335607 G_phys=8.29647015737811e-06 G_eff=8.29647015737811e-06
* tiled Ro4n12n1 series x4  each=30133.2970839018
Ro4n12n1t1 h12buf Ro4n12n1n1 30251.0493319052
Ro4n12n1t2 Ro4n12n1n1 Ro4n12n1n2 30064.6944712013
Ro4n12n1t3 Ro4n12n1n2 Ro4n12n1n3 30251.9744572394
Ro4n12n1t4 Ro4n12n1n3 o4n 30245.3648018075
* o4 input 13 w=-0.164579538023522 w-  bank=n alpha=1 R=202536.316079398 G_phys=4.93738614070565e-06 G_eff=4.93738614070565e-06
* tiled Ro4n13n1 series x4  each=50634.0790198495
Ro4n13n1t1 h13buf Ro4n13n1n1 50707.7658708925
Ro4n13n1t2 Ro4n13n1n1 Ro4n13n1n2 50555.0403910826
Ro4n13n1t3 Ro4n13n1n2 Ro4n13n1n3 50679.4748681687
Ro4n13n1t4 Ro4n13n1n3 o4n 50518.6103599605
* o4 input 14 w=-0.00939321676538441 w-  bank=f alpha=0.001 R=3548.66007736267 G_phys=0.000281796502961532 G_eff=2.81796502961532e-07
* tiled Ro4n14f1 parallel x4  each=14194.6403094507
Ro4n14f1t1 h14f o4n 14214.1387578778
Ro4n14f1t2 h14f o4n 14203.2755866016
Ro4n14f1t3 h14f o4n 14144.883040622
Ro4n14f1t4 h14f o4n 14151.5850868667
* o4 input 15 w=-0.0690593814994067 w-  bank=n alpha=1 R=482676.395438319 G_phys=2.0717814449822e-06 G_eff=2.0717814449822e-06
* tiled Ro4n15n1 series x4  each=120669.09885958
Ro4n15n1t1 h15buf Ro4n15n1n1 120441.956156041
Ro4n15n1t2 Ro4n15n1n1 Ro4n15n1n2 121206.741380913
Ro4n15n1t3 Ro4n15n1n2 Ro4n15n1n3 121090.031915925
Ro4n15n1t4 Ro4n15n1n3 o4n 120667.634936914
* o4 input 16 w=-0.272869230842632 w-  bank=n alpha=1 R=122158.637052623 G_phys=8.18607692527895e-06 G_eff=8.18607692527895e-06
* tiled Ro4n16n1 series x4  each=30539.6592631556
Ro4n16n1t1 h16buf Ro4n16n1n1 30482.2443641025
Ro4n16n1t2 Ro4n16n1n1 Ro4n16n1n2 30642.2334742049
Ro4n16n1t3 Ro4n16n1n2 Ro4n16n1n3 30636.6663933128
Ro4n16n1t4 Ro4n16n1n3 o4n 30401.0205276686
* o4 input 17 w=+0.168866320874711 w+  bank=n alpha=1 R=197394.798208843 G_phys=5.06598962624132e-06 G_eff=5.06598962624132e-06
* tiled Ro4p17n1 series x4  each=49348.6995522109
Ro4p17n1t1 h17buf Ro4p17n1n1 49460.8354694066
Ro4p17n1t2 Ro4p17n1n1 Ro4p17n1n2 49165.7665639542
Ro4p17n1t3 Ro4p17n1n2 Ro4p17n1n3 49185.5141044639
Ro4p17n1t4 Ro4p17n1n3 o4p 49275.9630227518
* o4 input 18 w=-0.0339148293163791 w-  bank=n alpha=1 R=982854.226461786 G_phys=1.01744487949137e-06 G_eff=1.01744487949137e-06
* tiled Ro4n18n1 series x4  each=245713.556615447
Ro4n18n1t1 h18buf Ro4n18n1n1 245558.076117739
Ro4n18n1t2 Ro4n18n1n1 Ro4n18n1n2 244990.51059385
Ro4n18n1t3 Ro4n18n1n2 Ro4n18n1n3 246798.413863704
Ro4n18n1t4 Ro4n18n1n3 o4n 245820.195392941
* o4 input 19 w=-0.0805852645818897 w-  bank=n alpha=1 R=413640.552106898 G_phys=2.41755793745669e-06 G_eff=2.41755793745669e-06
* tiled Ro4n19n1 series x4  each=103410.138026725
Ro4n19n1t1 h19buf Ro4n19n1n1 103699.695003588
Ro4n19n1t2 Ro4n19n1n1 Ro4n19n1n2 103150.238527658
Ro4n19n1t3 Ro4n19n1n2 Ro4n19n1n3 103571.753036193
Ro4n19n1t4 Ro4n19n1n3 o4n 103153.657135433
* o4 input 20 w=+0.0499049155841609 w+  bank=n alpha=1 R=667936.874417093 G_phys=1.49714746752483e-06 G_eff=1.49714746752483e-06
* tiled Ro4p20n1 series x4  each=166984.218604273
Ro4p20n1t1 h20buf Ro4p20n1n1 167755.477975433
Ro4p20n1t2 Ro4p20n1n1 Ro4p20n1n2 167555.478424338
Ro4p20n1t3 Ro4p20n1n2 Ro4p20n1n3 166506.986643405
Ro4p20n1t4 Ro4p20n1n3 o4p 166527.104970791
* o4 input 21 w=+0.0630428027700635 w+  bank=n alpha=1 R=528741.29747864 G_phys=1.8912840831019e-06 G_eff=1.8912840831019e-06
* tiled Ro4p21n1 series x4  each=132185.32436966
Ro4p21n1t1 h21buf Ro4p21n1n1 132648.513024053
Ro4p21n1t2 Ro4p21n1n1 Ro4p21n1n2 132483.694980211
Ro4p21n1t3 Ro4p21n1n2 Ro4p21n1n3 132801.833015487
Ro4p21n1t4 Ro4p21n1n3 o4p 132131.833547607
* o4 input 22 w=+0.077534797791833 w+  bank=n alpha=1 R=429914.493655189 G_phys=2.32604393375499e-06 G_eff=2.32604393375499e-06
* tiled Ro4p22n1 series x4  each=107478.623413797
Ro4p22n1t1 h22buf Ro4p22n1n1 107366.477208798
Ro4p22n1t2 Ro4p22n1n1 Ro4p22n1n2 107994.09077919
Ro4p22n1t3 Ro4p22n1n2 Ro4p22n1n3 107512.794361582
Ro4p22n1t4 Ro4p22n1n3 o4p 107942.918123145
* o4 input 23 w=+0.0744829629231984 w+  bank=n alpha=1 R=447529.636645958 G_phys=2.23448888769595e-06 G_eff=2.23448888769595e-06
* tiled Ro4p23n1 series x4  each=111882.40916149
Ro4p23n1t1 h23buf Ro4p23n1n1 111487.6340472
Ro4p23n1t2 Ro4p23n1n1 Ro4p23n1n2 112220.560121131
Ro4p23n1t3 Ro4p23n1n2 Ro4p23n1n3 111934.454425265
Ro4p23n1t4 Ro4p23n1n3 o4p 111710.86918209
* o4 input 24 w=-0.00836970221956497 w-  bank=f alpha=0.001 R=3982.61879083506 G_phys=0.000251091066586949 G_eff=2.51091066586949e-07
* tiled Ro4n24f1 parallel x4  each=15930.4751633402
Ro4n24f1t1 h24f o4n 15960.9829243714
Ro4n24f1t2 h24f o4n 15898.8390604069
Ro4n24f1t3 h24f o4n 15977.7860397505
Ro4n24f1t4 h24f o4n 15884.3469020214
* o4 input 25 w=-0.0959555339157937 w-  bank=n alpha=1 R=347383.126048626 G_phys=2.87866601747381e-06 G_eff=2.87866601747381e-06
* tiled Ro4n25n1 series x4  each=86845.7815121564
Ro4n25n1t1 h25buf Ro4n25n1n1 87126.852888232
Ro4n25n1t2 Ro4n25n1n1 Ro4n25n1n2 86545.7174002363
Ro4n25n1t3 Ro4n25n1n2 Ro4n25n1n3 86997.3216689163
Ro4n25n1t4 Ro4n25n1n3 o4n 86906.8487005362
* o4 input 26 w=-0.27047998771669 w-  bank=n alpha=1 R=123237.706474047 G_phys=8.1143996315007e-06 G_eff=8.1143996315007e-06
* tiled Ro4n26n1 series x4  each=30809.4266185118
Ro4n26n1t1 h26buf Ro4n26n1n1 30741.4838856826
Ro4n26n1t2 Ro4n26n1n1 Ro4n26n1n2 30953.725394003
Ro4n26n1t3 Ro4n26n1n2 Ro4n26n1n3 30755.0150859915
Ro4n26n1t4 Ro4n26n1n3 o4n 30754.802736496
* o4 input 27 w=-0.0478904255869687 w-  bank=n alpha=1 R=696033.349563792 G_phys=1.43671276760906e-06 G_eff=1.43671276760906e-06
* tiled Ro4n27n1 series x4  each=174008.337390948
Ro4n27n1t1 h27buf Ro4n27n1n1 173345.586285708
Ro4n27n1t2 Ro4n27n1n1 Ro4n27n1n2 173776.648982762
Ro4n27n1t3 Ro4n27n1n2 Ro4n27n1n3 174330.325555392
Ro4n27n1t4 Ro4n27n1n3 o4n 174590.787112827
* o4 input 28 w=-0.311644423649809 w-  bank=n alpha=1 R=106959.505140351 G_phys=9.34933270949427e-06 G_eff=9.34933270949427e-06
* tiled Ro4n28n1 series x4  each=26739.8762850876
Ro4n28n1t1 h28buf Ro4n28n1n1 26805.5043318123
Ro4n28n1t2 Ro4n28n1n1 Ro4n28n1n2 26756.5545292366
Ro4n28n1t3 Ro4n28n1n2 Ro4n28n1n3 26699.8760974078
Ro4n28n1t4 Ro4n28n1n3 o4n 26776.5462253441
* o4 input 29 w=-0.0286856006407659 w-  bank=f alpha=0.001 R=1162.02319591532 G_phys=0.000860568019222978 G_eff=8.60568019222978e-07
* tiled Ro4n29f1 parallel x4  each=4648.09278366127
Ro4n29f1t1 h29f o4n 4663.97847920329
Ro4n29f1t2 h29f o4n 4667.55439234782
Ro4n29f1t3 h29f o4n 4640.44203524935
Ro4n29f1t4 h29f o4n 4670.13156177351
* o4 input 30 w=-0.016265879828258 w-  bank=f alpha=0.001 R=2049.27945400314 G_phys=0.000487976394847741 G_eff=4.87976394847741e-07
* tiled Ro4n30f1 parallel x4  each=8197.11781601257
Ro4n30f1t1 h30f o4n 8171.45251888171
Ro4n30f1t2 h30f o4n 8201.4320032832
Ro4n30f1t3 h30f o4n 8197.95085881658
Ro4n30f1t4 h30f o4n 8202.69647238578
* o4 input 31 w=-0.119685509607977 w-  bank=n alpha=1 R=278507.677683913 G_phys=3.59056528823931e-06 G_eff=3.59056528823931e-06
* tiled Ro4n31n1 series x4  each=69626.9194209782
Ro4n31n1t1 h31buf Ro4n31n1n1 69516.4926190932
Ro4n31n1t2 Ro4n31n1n1 Ro4n31n1n2 69340.6417725849
Ro4n31n1t3 Ro4n31n1n2 Ro4n31n1n3 69800.394472052
Ro4n31n1t4 Ro4n31n1n3 o4n 69483.3502086171
* o4 input 32 w=-0.0356690164245122 w-  bank=n alpha=1 R=934517.872223306 G_phys=1.07007049273537e-06 G_eff=1.07007049273537e-06
* tiled Ro4n32n1 series x4  each=233629.468055827
Ro4n32n1t1 h32buf Ro4n32n1n1 234795.774608003
Ro4n32n1t2 Ro4n32n1n1 Ro4n32n1n2 234541.465152778
Ro4n32n1t3 Ro4n32n1n2 Ro4n32n1n3 234742.76900123
Ro4n32n1t4 Ro4n32n1n3 o4n 232931.14577655
* o4 bias=+0.0671312079863495 b+  bank=n alpha=1 R=496540.049452281 G_phys=2.01393623959048e-06 G_eff=2.01393623959048e-06
* tiled Ro4bpn1 series x4  each=124135.01236307
Ro4bpn1t1 vref Ro4bpn1n1 123907.636565511
Ro4bpn1t2 Ro4bpn1n1 Ro4bpn1n2 124440.945465206
Ro4bpn1t3 Ro4bpn1n2 Ro4bpn1n3 123571.57695185
Ro4bpn1t4 Ro4bpn1n3 o4p 124212.222544472
Vo4p o4p 0 DC 0
Vo4n o4n 0 DC 0
Fo4p 0 o4d Vo4p 1.001
Fo4n o4d 0 Vo4n 1.001
* ratiometric I-to-V: V = I * R_IV,  R_IV=33333.3333333333 (weight ~ R_IV / R_w)
* tiled Ro4iv series x4  each=8333.33333333333
Ro4ivt1 o4d Ro4ivn1 8371.59526349902
Ro4ivt2 Ro4ivn1 Ro4ivn2 8319.64350695883
Ro4ivt3 Ro4ivn2 Ro4ivn3 8347.55616837284
Ro4ivt4 Ro4ivn3 0 8339.9645408759
Bo4leak 0 o4d I = 1e-08
Eo4sc o4raw 0 o4d 0 1
Eo4lin o4lin 0 o4raw 0 1

* o5 input 1 w=+0.0860510418468527 w+  bank=n alpha=1 R=387366.99309995 G_phys=2.58153125540558e-06 G_eff=2.58153125540558e-06
* tiled Ro5p1n1 series x4  each=96841.7482749875
Ro5p1n1t1 h1buf Ro5p1n1n1 96586.036487822
Ro5p1n1t2 Ro5p1n1n1 Ro5p1n1n2 96828.7696104344
Ro5p1n1t3 Ro5p1n1n2 Ro5p1n1n3 96380.2163936602
Ro5p1n1t4 Ro5p1n1n3 o5p 96514.2459967485
* o5 input 2 w=-0.140209371980717 w-  bank=n alpha=1 R=237739.695017803 G_phys=4.20628115942151e-06 G_eff=4.20628115942151e-06
* tiled Ro5n2n1 series x4  each=59434.9237544507
Ro5n2n1t1 h2buf Ro5n2n1n1 59185.7384908104
Ro5n2n1t2 Ro5n2n1n1 Ro5n2n1n2 59651.1108232492
Ro5n2n1t3 Ro5n2n1n2 Ro5n2n1n3 59393.7507473791
Ro5n2n1t4 Ro5n2n1n3 o5n 59488.7525678793
* o5 input 3 w=-0.298670153474102 w-  bank=n alpha=1 R=111605.839906008 G_phys=8.96010460422305e-06 G_eff=8.96010460422305e-06
* tiled Ro5n3n1 series x4  each=27901.4599765019
Ro5n3n1t1 h3buf Ro5n3n1n1 27912.6210940619
Ro5n3n1t2 Ro5n3n1n1 Ro5n3n1n2 27822.0824205825
Ro5n3n1t3 Ro5n3n1n2 Ro5n3n1n3 27864.5254934242
Ro5n3n1t4 Ro5n3n1n3 o5n 28029.507245087
* o5 input 4 w=+0.194023589749981 w+  bank=n alpha=1 R=171800.415487038 G_phys=5.82070769249943e-06 G_eff=5.82070769249943e-06
* tiled Ro5p4n1 series x4  each=42950.1038717595
Ro5p4n1t1 h4buf Ro5p4n1n1 42960.6030838624
Ro5p4n1t2 Ro5p4n1n1 Ro5p4n1n2 43156.5718926948
Ro5p4n1t3 Ro5p4n1n2 Ro5p4n1n3 43014.6219434055
Ro5p4n1t4 Ro5p4n1n3 o5p 42842.9467498789
* o5 input 5 w=+0.104223096266613 w+  bank=n alpha=1 R=319826.74212694 G_phys=3.1266928879984e-06 G_eff=3.1266928879984e-06
* tiled Ro5p5n1 series x4  each=79956.6855317349
Ro5p5n1t1 h5buf Ro5p5n1n1 79760.6162333293
Ro5p5n1t2 Ro5p5n1n1 Ro5p5n1n2 79770.7180132737
Ro5p5n1t3 Ro5p5n1n2 Ro5p5n1n3 80137.8387359069
Ro5p5n1t4 Ro5p5n1n3 o5p 80150.1704097644
* o5 input 6 w=+0.179601423642336 w+  bank=n alpha=1 R=185596.153178131 G_phys=5.38804270927008e-06 G_eff=5.38804270927008e-06
* tiled Ro5p6n1 series x4  each=46399.0382945326
Ro5p6n1t1 h6buf Ro5p6n1n1 46508.498827201
Ro5p6n1t2 Ro5p6n1n1 Ro5p6n1n2 46430.2946671159
Ro5p6n1t3 Ro5p6n1n2 Ro5p6n1n3 46319.2776257649
Ro5p6n1t4 Ro5p6n1n3 o5p 46312.6621386198
* o5 input 7 w=-0.15816414054373 w-  bank=n alpha=1 R=210751.521923626 G_phys=4.74492421631189e-06 G_eff=4.74492421631189e-06
* tiled Ro5n7n1 series x4  each=52687.8804809066
Ro5n7n1t1 h7buf Ro5n7n1n1 52767.6270089972
Ro5n7n1t2 Ro5n7n1n1 Ro5n7n1n2 52761.7879029261
Ro5n7n1t3 Ro5n7n1n2 Ro5n7n1n3 52705.5161648463
Ro5n7n1t4 Ro5n7n1n3 o5n 52590.6276057393
* o5 input 8 w=-0.249576912278698 w-  bank=n alpha=1 R=133559.362638923 G_phys=7.48730736836095e-06 G_eff=7.48730736836095e-06
* tiled Ro5n8n1 series x4  each=33389.8406597307
Ro5n8n1t1 h8buf Ro5n8n1n1 33490.7350250971
Ro5n8n1t2 Ro5n8n1n1 Ro5n8n1n2 33452.3804064867
Ro5n8n1t3 Ro5n8n1n2 Ro5n8n1n3 33394.9652648968
Ro5n8n1t4 Ro5n8n1n3 o5n 33548.0489774314
* o5 input 9 w=-0.031381439286146 w-  bank=f alpha=0.001 R=1062.19899697364 G_phys=0.00094144317858438 G_eff=9.41443178584379e-07
* tiled Ro5n9f1 parallel x4  each=4248.79598789455
Ro5n9f1t1 h9f o5n 4247.22581569053
Ro5n9f1t2 h9f o5n 4243.05547248897
Ro5n9f1t3 h9f o5n 4269.84434571282
Ro5n9f1t4 h9f o5n 4238.81306430149
* o5 input 10 w=+0.375618440651073 w+  bank=n alpha=1 R=88742.5369094113 G_phys=1.12685532195322e-05 G_eff=1.12685532195322e-05
* tiled Ro5p10n1 series x4  each=22185.6342273528
Ro5p10n1t1 h10buf Ro5p10n1n1 22235.3007438236
Ro5p10n1t2 Ro5p10n1n1 Ro5p10n1n2 22279.9092383214
Ro5p10n1t3 Ro5p10n1n2 Ro5p10n1n3 22085.7139660746
Ro5p10n1t4 Ro5p10n1n3 o5p 22091.6167440161
* o5 input 11 w=+0.0953608962368974 w+  bank=n alpha=1 R=349549.287482848 G_phys=2.86082688710692e-06 G_eff=2.86082688710692e-06
* tiled Ro5p11n1 series x4  each=87387.3218707121
Ro5p11n1t1 h11buf Ro5p11n1n1 87343.8747298567
Ro5p11n1t2 Ro5p11n1n1 Ro5p11n1n2 87814.3819087804
Ro5p11n1t3 Ro5p11n1n2 Ro5p11n1n3 87481.7030303759
Ro5p11n1t4 Ro5p11n1n3 o5p 87494.2327179973
* o5 input 12 w=+0.235920649298708 w+  bank=n alpha=1 R=141290.44419138 G_phys=7.07761947896125e-06 G_eff=7.07761947896125e-06
* tiled Ro5p12n1 series x4  each=35322.6110478451
Ro5p12n1t1 h12buf Ro5p12n1n1 35300.4787338726
Ro5p12n1t2 Ro5p12n1n1 Ro5p12n1n2 35418.3153594113
Ro5p12n1t3 Ro5p12n1n2 Ro5p12n1n3 35224.9557017992
Ro5p12n1t4 Ro5p12n1n3 o5p 35475.5558570387
* o5 input 13 w=-0.0940916695355706 w-  bank=n alpha=1 R=354264.447616502 G_phys=2.82275008606712e-06 G_eff=2.82275008606712e-06
* tiled Ro5n13n1 series x4  each=88566.1119041254
Ro5n13n1t1 h13buf Ro5n13n1n1 88868.3681339288
Ro5n13n1t2 Ro5n13n1n1 Ro5n13n1n2 88604.1940036311
Ro5n13n1t3 Ro5n13n1n2 Ro5n13n1n3 88442.4763376626
Ro5n13n1t4 Ro5n13n1n3 o5n 88633.5300295432
* o5 input 14 w=+0.00295126144933853 w+  bank=f alpha=0.001 R=11294.6053426762 G_phys=8.85378434801559e-05 G_eff=8.85378434801559e-08
* tiled Ro5p14f1 series x4  each=2823.65133566905
Ro5p14f1t1 h14f Ro5p14f1n1 2833.79758137704
Ro5p14f1t2 Ro5p14f1n1 Ro5p14f1n2 2832.65263141289
Ro5p14f1t3 Ro5p14f1n2 Ro5p14f1n3 2813.86160545289
Ro5p14f1t4 Ro5p14f1n3 o5p 2811.10702035804
* o5 input 15 w=+0.529616924207031 w+  bank=n alpha=1 R=62938.572786815 G_phys=1.58885077262109e-05 G_eff=1.58885077262109e-05
* tiled Ro5p15n1 series x4  each=15734.6431967038
Ro5p15n1t1 h15buf Ro5p15n1n1 15694.5625396303
Ro5p15n1t2 Ro5p15n1n1 Ro5p15n1n2 15666.6731477076
Ro5p15n1t3 Ro5p15n1n2 Ro5p15n1n3 15805.3435904073
Ro5p15n1t4 Ro5p15n1n3 o5p 15743.605987764
* o5 input 16 w=+0.319042125899952 w+  bank=n alpha=1 R=104479.410796637 G_phys=9.57126377699856e-06 G_eff=9.57126377699856e-06
* tiled Ro5p16n1 series x4  each=26119.8526991592
Ro5p16n1t1 h16buf Ro5p16n1n1 26244.1975913598
Ro5p16n1t2 Ro5p16n1n1 Ro5p16n1n2 26235.0518441761
Ro5p16n1t3 Ro5p16n1n2 Ro5p16n1n3 26069.9625415811
Ro5p16n1t4 Ro5p16n1n3 o5p 26149.5478451805
* o5 input 17 w=-0.466616152697173 w-  bank=n alpha=1 R=71436.3039956017 G_phys=1.39984845809152e-05 G_eff=1.39984845809152e-05
* tiled Ro5n17n1 series x4  each=17859.0759989004
Ro5n17n1t1 h17buf Ro5n17n1n1 17938.1792444008
Ro5n17n1t2 Ro5n17n1n1 Ro5n17n1n2 17793.0938027152
Ro5n17n1t3 Ro5n17n1n2 Ro5n17n1n3 17921.8897586244
Ro5n17n1t4 Ro5n17n1n3 o5n 17869.8644104779
* o5 input 18 w=-0.243973793531226 w-  bank=n alpha=1 R=136626.696051546 G_phys=7.31921380593677e-06 G_eff=7.31921380593677e-06
* tiled Ro5n18n1 series x4  each=34156.6740128864
Ro5n18n1t1 h18buf Ro5n18n1n1 34153.6467815924
Ro5n18n1t2 Ro5n18n1n1 Ro5n18n1n2 34259.0318181522
Ro5n18n1t3 Ro5n18n1n2 Ro5n18n1n3 34260.0479533873
Ro5n18n1t4 Ro5n18n1n3 o5n 34213.524303852
* o5 input 19 w=-0.167620412829882 w-  bank=n alpha=1 R=198862.01668745 G_phys=5.02861238489647e-06 G_eff=5.02861238489647e-06
* tiled Ro5n19n1 series x4  each=49715.5041718625
Ro5n19n1t1 h19buf Ro5n19n1n1 49812.3738746827
Ro5n19n1t2 Ro5n19n1n1 Ro5n19n1n2 49600.2709376418
Ro5n19n1t3 Ro5n19n1n2 Ro5n19n1n3 49710.6773649636
Ro5n19n1t4 Ro5n19n1n3 o5n 49673.7555855028
* o5 input 20 w=+0.191248887162316 w+  bank=n alpha=1 R=174292.953166534 G_phys=5.73746661486949e-06 G_eff=5.73746661486949e-06
* tiled Ro5p20n1 series x4  each=43573.2382916334
Ro5p20n1t1 h20buf Ro5p20n1n1 43646.0289713334
Ro5p20n1t2 Ro5p20n1n1 Ro5p20n1n2 43594.0663342806
Ro5p20n1t3 Ro5p20n1n2 Ro5p20n1n3 43681.9127290427
Ro5p20n1t4 Ro5p20n1n3 o5p 43478.8869998185
* o5 input 21 w=+0.174220054558956 w+  bank=n alpha=1 R=191328.91111599 G_phys=5.22660163676868e-06 G_eff=5.22660163676868e-06
* tiled Ro5p21n1 series x4  each=47832.2277789974
Ro5p21n1t1 h21buf Ro5p21n1n1 47671.3718001776
Ro5p21n1t2 Ro5p21n1n1 Ro5p21n1n2 47844.8531320139
Ro5p21n1t3 Ro5p21n1n2 Ro5p21n1n3 47743.2504928818
Ro5p21n1t4 Ro5p21n1n3 o5p 48062.3226325697
* o5 input 22 w=-0.14737880105185 w-  bank=n alpha=1 R=226174.545426015 G_phys=4.4213640315555e-06 G_eff=4.4213640315555e-06
* tiled Ro5n22n1 series x4  each=56543.6363565038
Ro5n22n1t1 h22buf Ro5n22n1n1 56762.4876636022
Ro5n22n1t2 Ro5n22n1n1 Ro5n22n1n2 56405.3949073461
Ro5n22n1t3 Ro5n22n1n2 Ro5n22n1n3 56793.0610365873
Ro5n22n1t4 Ro5n22n1n3 o5n 56682.4388180505
* o5 input 23 w=-0.261133636281725 w-  bank=n alpha=1 R=127648.562659203 G_phys=7.83400908845174e-06 G_eff=7.83400908845174e-06
* tiled Ro5n23n1 series x4  each=31912.1406648008
Ro5n23n1t1 h23buf Ro5n23n1n1 31842.6363743751
Ro5n23n1t2 Ro5n23n1n1 Ro5n23n1n2 31980.2512336574
Ro5n23n1t3 Ro5n23n1n2 Ro5n23n1n3 31992.9111611051
Ro5n23n1t4 Ro5n23n1n3 o5n 31946.2011194498
* o5 input 24 w=+0.130521837388059 w+  bank=n alpha=1 R=255385.106434174 G_phys=3.91565512164177e-06 G_eff=3.91565512164177e-06
* tiled Ro5p24n1 series x4  each=63846.2766085434
Ro5p24n1t1 h24buf Ro5p24n1n1 63963.2732509095
Ro5p24n1t2 Ro5p24n1n1 Ro5p24n1n2 64157.8690823428
Ro5p24n1t3 Ro5p24n1n2 Ro5p24n1n3 63622.8109645384
Ro5p24n1t4 Ro5p24n1n3 o5p 63876.0313677637
* o5 input 25 w=-0.326372621774105 w-  bank=n alpha=1 R=102132.749837101 G_phys=9.79117865322314e-06 G_eff=9.79117865322314e-06
* tiled Ro5n25n1 series x4  each=25533.1874592752
Ro5n25n1t1 h25buf Ro5n25n1n1 25472.9615266031
Ro5n25n1t2 Ro5n25n1n1 Ro5n25n1n2 25500.4838628313
Ro5n25n1t3 Ro5n25n1n2 Ro5n25n1n3 25591.1442922058
Ro5n25n1t4 Ro5n25n1n3 o5n 25416.1292263403
* o5 input 26 w=+0.16696553546102 w+  bank=n alpha=1 R=199641.99941799 G_phys=5.00896606383059e-06 G_eff=5.00896606383059e-06
* tiled Ro5p26n1 series x4  each=49910.4998544976
Ro5p26n1t1 h26buf Ro5p26n1n1 49870.0555446668
Ro5p26n1t2 Ro5p26n1n1 Ro5p26n1n2 49922.7436286336
Ro5p26n1t3 Ro5p26n1n2 Ro5p26n1n3 49857.585645296
Ro5p26n1t4 Ro5p26n1n3 o5p 49874.6512877081
* o5 input 27 w=-0.105618085709112 w-  bank=n alpha=1 R=315602.513618153 G_phys=3.16854257127337e-06 G_eff=3.16854257127337e-06
* tiled Ro5n27n1 series x4  each=78900.6284045382
Ro5n27n1t1 h27buf Ro5n27n1n1 79198.9655747324
Ro5n27n1t2 Ro5n27n1n1 Ro5n27n1n2 79148.9870776062
Ro5n27n1t3 Ro5n27n1n2 Ro5n27n1n3 78635.0589230646
Ro5n27n1t4 Ro5n27n1n3 o5n 78535.4075046295
* o5 input 28 w=+0.0630335864648206 w+  bank=n alpha=1 R=528818.606124163 G_phys=1.89100759394462e-06 G_eff=1.89100759394462e-06
* tiled Ro5p28n1 series x4  each=132204.651531041
Ro5p28n1t1 h28buf Ro5p28n1n1 132829.130457061
Ro5p28n1t2 Ro5p28n1n1 Ro5p28n1n2 132463.973341533
Ro5p28n1t3 Ro5p28n1n2 Ro5p28n1n3 132183.095770092
Ro5p28n1t4 Ro5p28n1n3 o5p 131696.465824733
* o5 input 29 w=+0.231531157265063 w+  bank=n alpha=1 R=143969.104318744 G_phys=6.94593471795189e-06 G_eff=6.94593471795189e-06
* tiled Ro5p29n1 series x4  each=35992.2760796859
Ro5p29n1t1 h29buf Ro5p29n1n1 36095.8162720625
Ro5p29n1t2 Ro5p29n1n1 Ro5p29n1n2 36035.7287829614
Ro5p29n1t3 Ro5p29n1n2 Ro5p29n1n3 36041.9234173511
Ro5p29n1t4 Ro5p29n1n3 o5p 35840.445433939
* o5 input 30 w=-0.0894419530377066 w-  bank=n alpha=1 R=372681.188203491 G_phys=2.6832585911312e-06 G_eff=2.6832585911312e-06
* tiled Ro5n30n1 series x4  each=93170.2970508728
Ro5n30n1t1 h30buf Ro5n30n1n1 93044.6585835939
Ro5n30n1t2 Ro5n30n1n1 Ro5n30n1n2 92775.111753725
Ro5n30n1t3 Ro5n30n1n2 Ro5n30n1n3 93550.2944448921
Ro5n30n1t4 Ro5n30n1n3 o5n 92706.492081076
* o5 input 31 w=+0.216486138811528 w+  bank=n alpha=1 R=153974.446199316 G_phys=6.49458416434585e-06 G_eff=6.49458416434585e-06
* tiled Ro5p31n1 series x4  each=38493.611549829
Ro5p31n1t1 h31buf Ro5p31n1n1 38346.9017081066
Ro5p31n1t2 Ro5p31n1n1 Ro5p31n1n2 38674.2096276341
Ro5p31n1t3 Ro5p31n1n2 Ro5p31n1n3 38414.2057265239
Ro5p31n1t4 Ro5p31n1n3 o5p 38343.2334015099
* o5 input 32 w=-0.32037829849107 w-  bank=n alpha=1 R=104043.668033472 G_phys=9.6113489547321e-06 G_eff=9.6113489547321e-06
* tiled Ro5n32n1 series x4  each=26010.9170083679
Ro5n32n1t1 h32buf Ro5n32n1n1 25933.1574514078
Ro5n32n1t2 Ro5n32n1n1 Ro5n32n1n2 26074.1245570408
Ro5n32n1t3 Ro5n32n1n2 Ro5n32n1n3 25894.4346994796
Ro5n32n1t4 Ro5n32n1n3 o5n 26023.0894991647
* o5 bias=+0.0022999314168152 b+  bank=f alpha=0.001 R=14493.185792249 G_phys=6.89979425044561e-05 G_eff=6.89979425044561e-08
* tiled Ro5bpf1 series x4  each=3623.29644806226
Ro5bpf1t1 vreff Ro5bpf1n1 3633.47045561124
Ro5bpf1t2 Ro5bpf1n1 Ro5bpf1n2 3621.02349408044
Ro5bpf1t3 Ro5bpf1n2 Ro5bpf1n3 3605.77633829869
Ro5bpf1t4 Ro5bpf1n3 o5p 3606.12947462945
Vo5p o5p 0 DC 0
Vo5n o5n 0 DC 0
Fo5p 0 o5d Vo5p 1.001
Fo5n o5d 0 Vo5n 1.001
* ratiometric I-to-V: V = I * R_IV,  R_IV=33333.3333333333 (weight ~ R_IV / R_w)
* tiled Ro5iv series x4  each=8333.33333333333
Ro5ivt1 o5d Ro5ivn1 8312.51682906833
Ro5ivt2 Ro5ivn1 Ro5ivn2 8349.3828211761
Ro5ivt3 Ro5ivn2 Ro5ivn3 8304.65445978338
Ro5ivt4 Ro5ivn3 0 8355.07878014735
Bo5leak 0 o5d I = 1e-08
Eo5sc o5raw 0 o5d 0 1
Eo5lin o5lin 0 o5raw 0 1

* o6 input 1 w=+0.177051530119574 w+  bank=n alpha=1 R=188269.106236028 G_phys=5.31154590358722e-06 G_eff=5.31154590358722e-06
* tiled Ro6p1n1 series x4  each=47067.2765590069
Ro6p1n1t1 h1buf Ro6p1n1n1 47158.1952689227
Ro6p1n1t2 Ro6p1n1n1 Ro6p1n1n2 47087.963129723
Ro6p1n1t3 Ro6p1n1n2 Ro6p1n1n3 46836.1814795301
Ro6p1n1t4 Ro6p1n1n3 o6p 46928.5509926485
* o6 input 2 w=+0.301592495922723 w+  bank=n alpha=1 R=110524.412191855 G_phys=9.04777487768168e-06 G_eff=9.04777487768168e-06
* tiled Ro6p2n1 series x4  each=27631.1030479637
Ro6p2n1t1 h2buf Ro6p2n1n1 27687.0264871241
Ro6p2n1t2 Ro6p2n1n1 Ro6p2n1n2 27701.6760239246
Ro6p2n1t3 Ro6p2n1n2 Ro6p2n1n3 27716.488567718
Ro6p2n1t4 Ro6p2n1n3 o6p 27748.937551527
* o6 input 3 w=+0.171870982949934 w+  bank=n alpha=1 R=193943.92678282 G_phys=5.15612948849803e-06 G_eff=5.15612948849803e-06
* tiled Ro6p3n1 series x4  each=48485.9816957049
Ro6p3n1t1 h3buf Ro6p3n1n1 48394.4141766759
Ro6p3n1t2 Ro6p3n1n1 Ro6p3n1n2 48458.3291881146
Ro6p3n1t3 Ro6p3n1n2 Ro6p3n1n3 48355.5577063121
Ro6p3n1t4 Ro6p3n1n3 o6p 48366.2090212951
* o6 input 4 w=-0.3405205591368 w-  bank=n alpha=1 R=97889.3415946205 G_phys=1.0215616774104e-05 G_eff=1.0215616774104e-05
* tiled Ro6n4n1 series x4  each=24472.3353986551
Ro6n4n1t1 h4buf Ro6n4n1n1 24374.7067941472
Ro6n4n1t2 Ro6n4n1n1 Ro6n4n1n2 24408.2556583725
Ro6n4n1t3 Ro6n4n1n2 Ro6n4n1n3 24499.5338187711
Ro6n4n1t4 Ro6n4n1n3 o6n 24545.2227790566
* o6 input 5 w=-0.19025500833844 w-  bank=n alpha=1 R=175203.447333368 G_phys=5.70765025015321e-06 G_eff=5.70765025015321e-06
* tiled Ro6n5n1 series x4  each=43800.8618333419
Ro6n5n1t1 h5buf Ro6n5n1n1 43895.050777736
Ro6n5n1t2 Ro6n5n1n1 Ro6n5n1n2 43901.7608385112
Ro6n5n1t3 Ro6n5n1n2 Ro6n5n1n3 43995.5283937019
Ro6n5n1t4 Ro6n5n1n3 o6n 43833.216888478
* o6 input 6 w=+0.141724280050197 w+  bank=n alpha=1 R=235198.466497956 G_phys=4.25172840150592e-06 G_eff=4.25172840150592e-06
* tiled Ro6p6n1 series x4  each=58799.6166244891
Ro6p6n1t1 h6buf Ro6p6n1n1 58604.6615055548
Ro6p6n1t2 Ro6p6n1n1 Ro6p6n1n2 59077.7646020165
Ro6p6n1t3 Ro6p6n1n2 Ro6p6n1n3 58741.7063405413
Ro6p6n1t4 Ro6p6n1n3 o6p 58858.2412264058
* o6 input 7 w=-0.0326153624876146 w-  bank=f alpha=0.001 R=1022.01327199694 G_phys=0.000978460874628438 G_eff=9.78460874628438e-07
* tiled Ro6n7f1 parallel x4  each=4088.05308798777
Ro6n7f1t1 h7f o6n 4096.83046898198
Ro6n7f1t2 h7f o6n 4101.29384566547
Ro6n7f1t3 h7f o6n 4072.99905605654
Ro6n7f1t4 h7f o6n 4069.3354853806
* o6 input 8 w=+0.106637930601 w+  bank=n alpha=1 R=312584.210378712 G_phys=3.19913791802999e-06 G_eff=3.19913791802999e-06
* tiled Ro6p8n1 series x4  each=78146.052594678
Ro6p8n1t1 h8buf Ro6p8n1n1 78476.4305091044
Ro6p8n1t2 Ro6p8n1n1 Ro6p8n1n2 78090.9525135612
Ro6p8n1t3 Ro6p8n1n2 Ro6p8n1n3 78192.2840690696
Ro6p8n1t4 Ro6p8n1n3 o6p 78194.2531667025
* o6 input 9 w=+0.167194950685368 w+  bank=n alpha=1 R=199368.062233296 G_phys=5.01584852056104e-06 G_eff=5.01584852056104e-06
* tiled Ro6p9n1 series x4  each=49842.015558324
Ro6p9n1t1 h9buf Ro6p9n1n1 50058.7583300069
Ro6p9n1t2 Ro6p9n1n1 Ro6p9n1n2 50089.4661720591
Ro6p9n1t3 Ro6p9n1n2 Ro6p9n1n3 49663.2464184599
Ro6p9n1t4 Ro6p9n1n3 o6p 49878.2006768077
* o6 input 10 w=-0.113695758135469 w-  bank=n alpha=1 R=293180.096425556 G_phys=3.41087274406406e-06 G_eff=3.41087274406406e-06
* tiled Ro6n10n1 series x4  each=73295.0241063889
Ro6n10n1t1 h10buf Ro6n10n1n1 73118.9061699566
Ro6n10n1t2 Ro6n10n1n1 Ro6n10n1n2 73362.910825584
Ro6n10n1t3 Ro6n10n1n2 Ro6n10n1n3 73632.601666261
Ro6n10n1t4 Ro6n10n1n3 o6n 73072.9755019539
* o6 input 11 w=+0.174899957381211 w+  bank=n alpha=1 R=190585.142686343 G_phys=5.24699872143633e-06 G_eff=5.24699872143633e-06
* tiled Ro6p11n1 series x4  each=47646.2856715857
Ro6p11n1t1 h11buf Ro6p11n1n1 47768.9117267376
Ro6p11n1t2 Ro6p11n1n1 Ro6p11n1n2 47444.156235149
Ro6p11n1t3 Ro6p11n1n2 Ro6p11n1n3 47812.641042726
Ro6p11n1t4 Ro6p11n1n3 o6p 47729.7089269345
* o6 input 12 w=-0.244360694504916 w-  bank=n alpha=1 R=136410.372383611 G_phys=7.33082083514748e-06 G_eff=7.33082083514748e-06
* tiled Ro6n12n1 series x4  each=34102.5930959027
Ro6n12n1t1 h12buf Ro6n12n1n1 34251.4651218807
Ro6n12n1t2 Ro6n12n1n1 Ro6n12n1n2 33980.3435315361
Ro6n12n1t3 Ro6n12n1n2 Ro6n12n1n3 34214.4227699971
Ro6n12n1t4 Ro6n12n1n3 o6n 34022.7377376783
* o6 input 13 w=+0.255772583539878 w+  bank=n alpha=1 R=130324.106172764 G_phys=7.67317750619635e-06 G_eff=7.67317750619635e-06
* tiled Ro6p13n1 series x4  each=32581.0265431911
Ro6p13n1t1 h13buf Ro6p13n1n1 32468.5257063629
Ro6p13n1t2 Ro6p13n1n1 Ro6p13n1n2 32432.7370694768
Ro6p13n1t3 Ro6p13n1n2 Ro6p13n1n3 32541.3327091109
Ro6p13n1t4 Ro6p13n1n3 o6p 32565.4255983082
* o6 input 14 w=+0.139949769298614 w+  bank=n alpha=1 R=238180.695119327 G_phys=4.19849307895843e-06 G_eff=4.19849307895843e-06
* tiled Ro6p14n1 series x4  each=59545.1737798317
Ro6p14n1t1 h14buf Ro6p14n1n1 59632.7619651964
Ro6p14n1t2 Ro6p14n1n1 Ro6p14n1n2 59800.8891104967
Ro6p14n1t3 Ro6p14n1n2 Ro6p14n1n3 59402.4470448468
Ro6p14n1t4 Ro6p14n1n3 o6p 59425.6401607466
* o6 input 15 w=-0.401168375335584 w-  bank=n alpha=1 R=83090.6307244419 G_phys=1.20350512600675e-05 G_eff=1.20350512600675e-05
* tiled Ro6n15n1 series x4  each=20772.6576811105
Ro6n15n1t1 h15buf Ro6n15n1n1 20677.9478591438
Ro6n15n1t2 Ro6n15n1n1 Ro6n15n1n2 20770.891153004
Ro6n15n1t3 Ro6n15n1n2 Ro6n15n1n3 20750.3449771397
Ro6n15n1t4 Ro6n15n1n3 o6n 20800.0758606599
* o6 input 16 w=+0.405832076822582 w+  bank=n alpha=1 R=82135.777916603 G_phys=1.21749623046775e-05 G_eff=1.21749623046775e-05
* tiled Ro6p16n1 series x4  each=20533.9444791507
Ro6p16n1t1 h16buf Ro6p16n1n1 20590.8064285951
Ro6p16n1t2 Ro6p16n1n1 Ro6p16n1n2 20576.7851258782
Ro6p16n1t3 Ro6p16n1n2 Ro6p16n1n3 20471.6368710519
Ro6p16n1t4 Ro6p16n1n3 o6p 20441.0620268287
* o6 input 17 w=-0.113061682974004 w-  bank=n alpha=1 R=294824.315864798 G_phys=3.39185048922012e-06 G_eff=3.39185048922012e-06
* tiled Ro6n17n1 series x4  each=73706.0789661994
Ro6n17n1t1 h17buf Ro6n17n1n1 73375.2214440463
Ro6n17n1t2 Ro6n17n1n1 Ro6n17n1n2 73691.9870424175
Ro6n17n1t3 Ro6n17n1n2 Ro6n17n1n3 73369.3776678118
Ro6n17n1t4 Ro6n17n1n3 o6n 73726.4675104859
* o6 input 18 w=-0.197513353657142 w-  bank=n alpha=1 R=168764.960526141 G_phys=5.92540060971425e-06 G_eff=5.92540060971425e-06
* tiled Ro6n18n1 series x4  each=42191.2401315354
Ro6n18n1t1 h18buf Ro6n18n1n1 42393.9161580595
Ro6n18n1t2 Ro6n18n1n1 Ro6n18n1n2 42276.0832851425
Ro6n18n1t3 Ro6n18n1n2 Ro6n18n1n3 42003.9078844999
Ro6n18n1t4 Ro6n18n1n3 o6n 42005.3033159108
* o6 input 19 w=-0.228990652840289 w-  bank=n alpha=1 R=145566.349193222 G_phys=6.86971958520868e-06 G_eff=6.86971958520868e-06
* tiled Ro6n19n1 series x4  each=36391.5872983054
Ro6n19n1t1 h19buf Ro6n19n1n1 36541.3239438395
Ro6n19n1t2 Ro6n19n1n1 Ro6n19n1n2 36564.2993936308
Ro6n19n1t3 Ro6n19n1n2 Ro6n19n1n3 36492.3183377763
Ro6n19n1t4 Ro6n19n1n3 o6n 36531.1745075167
* o6 input 20 w=-0.216778558754084 w-  bank=n alpha=1 R=153766.744852045 G_phys=6.50335676262251e-06 G_eff=6.50335676262251e-06
* tiled Ro6n20n1 series x4  each=38441.6862130114
Ro6n20n1t1 h20buf Ro6n20n1n1 38522.2354118927
Ro6n20n1t2 Ro6n20n1n1 Ro6n20n1n2 38355.6000833033
Ro6n20n1t3 Ro6n20n1n2 Ro6n20n1n3 38608.7435942974
Ro6n20n1t4 Ro6n20n1n3 o6n 38476.1564427115
* o6 input 21 w=-0.139531541535413 w-  bank=n alpha=1 R=238894.610971336 G_phys=4.18594624606239e-06 G_eff=4.18594624606239e-06
* tiled Ro6n21n1 series x4  each=59723.6527428341
Ro6n21n1t1 h21buf Ro6n21n1n1 59997.3374998643
Ro6n21n1t2 Ro6n21n1n1 Ro6n21n1n2 59879.1164209498
Ro6n21n1t3 Ro6n21n1n2 Ro6n21n1n3 60020.2756853608
Ro6n21n1t4 Ro6n21n1n3 o6n 59817.0803072804
* o6 input 22 w=-0.394983843934915 w-  bank=n alpha=1 R=84391.6373927081 G_phys=1.18495153180474e-05 G_eff=1.18495153180474e-05
* tiled Ro6n22n1 series x4  each=21097.909348177
Ro6n22n1t1 h22buf Ro6n22n1n1 21017.6024708781
Ro6n22n1t2 Ro6n22n1n1 Ro6n22n1n2 21118.8413470024
Ro6n22n1t3 Ro6n22n1n2 Ro6n22n1n3 21013.2274512114
Ro6n22n1t4 Ro6n22n1n3 o6n 21164.953473943
* o6 input 23 w=-0.193849822273603 w-  bank=n alpha=1 R=171954.41781879 G_phys=5.81549466820809e-06 G_eff=5.81549466820809e-06
* tiled Ro6n23n1 series x4  each=42988.6044546975
Ro6n23n1t1 h23buf Ro6n23n1n1 42928.0361433324
Ro6n23n1t2 Ro6n23n1n1 Ro6n23n1n2 43140.5866981954
Ro6n23n1t3 Ro6n23n1n2 Ro6n23n1n3 43160.4396991327
Ro6n23n1t4 Ro6n23n1n3 o6n 42958.9621828648
* o6 input 24 w=-0.0741873589980665 w-  bank=n alpha=1 R=449312.844984846 G_phys=2.22562076994199e-06 G_eff=2.22562076994199e-06
* tiled Ro6n24n1 series x4  each=112328.211246211
Ro6n24n1t1 h24buf Ro6n24n1n1 112321.396961746
Ro6n24n1t2 Ro6n24n1n1 Ro6n24n1n2 111853.224885241
Ro6n24n1t3 Ro6n24n1n2 Ro6n24n1n3 111791.564251336
Ro6n24n1t4 Ro6n24n1n3 o6n 112339.835219286
* o6 input 25 w=-0.172655508406202 w-  bank=n alpha=1 R=193062.669364194 G_phys=5.17966525218605e-06 G_eff=5.17966525218605e-06
* tiled Ro6n25n1 series x4  each=48265.6673410485
Ro6n25n1t1 h25buf Ro6n25n1n1 48416.1882936733
Ro6n25n1t2 Ro6n25n1n1 Ro6n25n1n2 48411.7353519576
Ro6n25n1t3 Ro6n25n1n2 Ro6n25n1n3 48164.6138635077
Ro6n25n1t4 Ro6n25n1n3 o6n 48195.4767959876
* o6 input 26 w=+0.0670699610875517 w+  bank=n alpha=1 R=496993.479537295 G_phys=2.01209883262655e-06 G_eff=2.01209883262655e-06
* tiled Ro6p26n1 series x4  each=124248.369884324
Ro6p26n1t1 h26buf Ro6p26n1n1 124377.074671865
Ro6p26n1t2 Ro6p26n1n1 Ro6p26n1n2 124003.361001141
Ro6p26n1t3 Ro6p26n1n2 Ro6p26n1n3 123680.304034646
Ro6p26n1t4 Ro6p26n1n3 o6p 123627.950589996
* o6 input 27 w=+0.25363855276468 w+  bank=n alpha=1 R=131420.610037384 G_phys=7.60915658294039e-06 G_eff=7.60915658294039e-06
* tiled Ro6p27n1 series x4  each=32855.1525093459
Ro6p27n1t1 h27buf Ro6p27n1n1 32730.2287211746
Ro6p27n1t2 Ro6p27n1n1 Ro6p27n1n2 32955.9863853579
Ro6p27n1t3 Ro6p27n1n2 Ro6p27n1n3 32959.3562088714
Ro6p27n1t4 Ro6p27n1n3 o6p 32954.0100228222
* o6 input 28 w=-0.179185579156039 w-  bank=n alpha=1 R=186026.874988115 G_phys=5.37556737468116e-06 G_eff=5.37556737468116e-06
* tiled Ro6n28n1 series x4  each=46506.7187470287
Ro6n28n1t1 h28buf Ro6n28n1n1 46317.6934269247
Ro6n28n1t2 Ro6n28n1n1 Ro6n28n1n2 46386.0356167139
Ro6n28n1t3 Ro6n28n1n2 Ro6n28n1n3 46319.5882725371
Ro6n28n1t4 Ro6n28n1n3 o6n 46467.1613871824
* o6 input 29 w=-0.129923130427228 w-  bank=n alpha=1 R=256561.962629155 G_phys=3.89769391281685e-06 G_eff=3.89769391281685e-06
* tiled Ro6n29n1 series x4  each=64140.4906572887
Ro6n29n1t1 h29buf Ro6n29n1n1 64435.8133079068
Ro6n29n1t2 Ro6n29n1n1 Ro6n29n1n2 64035.0508454558
Ro6n29n1t3 Ro6n29n1n2 Ro6n29n1n3 64458.2207268969
Ro6n29n1t4 Ro6n29n1n3 o6n 64263.7460851116
* o6 input 30 w=-0.169171092451912 w-  bank=n alpha=1 R=197039.179981701 G_phys=5.07513277355737e-06 G_eff=5.07513277355737e-06
* tiled Ro6n30n1 series x4  each=49259.7949954253
Ro6n30n1t1 h30buf Ro6n30n1n1 49349.7396307895
Ro6n30n1t2 Ro6n30n1n1 Ro6n30n1n2 49193.4736919308
Ro6n30n1t3 Ro6n30n1n2 Ro6n30n1n3 49189.0928585612
Ro6n30n1t4 Ro6n30n1n3 o6n 49064.6935663979
* o6 input 31 w=+0.218686712022964 w+  bank=n alpha=1 R=152425.051458238 G_phys=6.56060136068893e-06 G_eff=6.56060136068893e-06
* tiled Ro6p31n1 series x4  each=38106.2628645596
Ro6p31n1t1 h31buf Ro6p31n1n1 38260.4501575492
Ro6p31n1t2 Ro6p31n1n1 Ro6p31n1n2 38102.570342739
Ro6p31n1t3 Ro6p31n1n2 Ro6p31n1n3 38199.1037160307
Ro6p31n1t4 Ro6p31n1n3 o6p 37985.6784110753
* o6 input 32 w=+0.133370937368681 w+  bank=n alpha=1 R=249929.512313385 G_phys=4.00112812106042e-06 G_eff=4.00112812106042e-06
* tiled Ro6p32n1 series x4  each=62482.3780783462
Ro6p32n1t1 h32buf Ro6p32n1n1 62615.1986121015
Ro6p32n1t2 Ro6p32n1n1 Ro6p32n1n2 62773.0937966935
Ro6p32n1t3 Ro6p32n1n2 Ro6p32n1n3 62184.5236536353
Ro6p32n1t4 Ro6p32n1n3 o6p 62194.8836302005
* o6 bias=+0.0648246120847975 b+  bank=n alpha=1 R=514207.987696552 G_phys=1.94473836254393e-06 G_eff=1.94473836254393e-06
* tiled Ro6bpn1 series x4  each=128551.996924138
Ro6bpn1t1 vref Ro6bpn1n1 128826.634136352
Ro6bpn1t2 Ro6bpn1n1 Ro6bpn1n2 128227.636852219
Ro6bpn1t3 Ro6bpn1n2 Ro6bpn1n3 127911.254108924
Ro6bpn1t4 Ro6bpn1n3 o6p 128153.696234385
Vo6p o6p 0 DC 0
Vo6n o6n 0 DC 0
Fo6p 0 o6d Vo6p 1.001
Fo6n o6d 0 Vo6n 1.001
* ratiometric I-to-V: V = I * R_IV,  R_IV=33333.3333333333 (weight ~ R_IV / R_w)
* tiled Ro6iv series x4  each=8333.33333333333
Ro6ivt1 o6d Ro6ivn1 8318.07700658829
Ro6ivt2 Ro6ivn1 Ro6ivn2 8302.66177604489
Ro6ivt3 Ro6ivn2 Ro6ivn3 8351.61702003468
Ro6ivt4 Ro6ivn3 0 8309.63860507186
Bo6leak 0 o6d I = 1e-08
Eo6sc o6raw 0 o6d 0 1
Eo6lin o6lin 0 o6raw 0 1

* o7 input 1 w=+0.130193574665561 w+  bank=n alpha=1 R=256029.020010853 G_phys=3.90580723996683e-06 G_eff=3.90580723996683e-06
* tiled Ro7p1n1 series x4  each=64007.2550027132
Ro7p1n1t1 h1buf Ro7p1n1n1 64189.7980621773
Ro7p1n1t2 Ro7p1n1n1 Ro7p1n1n2 63881.9116182827
Ro7p1n1t3 Ro7p1n1n2 Ro7p1n1n3 63763.0258129848
Ro7p1n1t4 Ro7p1n1n3 o7p 63861.7779806121
* o7 input 2 w=+0.394190134763453 w+  bank=n alpha=1 R=84561.5615249634 G_phys=1.18257040429036e-05 G_eff=1.18257040429036e-05
* tiled Ro7p2n1 series x4  each=21140.3903812409
Ro7p2n1t1 h2buf Ro7p2n1n1 21098.7086832319
Ro7p2n1t2 Ro7p2n1n1 Ro7p2n1n2 21193.0635675741
Ro7p2n1t3 Ro7p2n1n2 Ro7p2n1n3 21150.3076020705
Ro7p2n1t4 Ro7p2n1n3 o7p 21118.9903550413
* o7 input 3 w=+0.206617853142924 w+  bank=n alpha=1 R=161328.427463021 G_phys=6.19853559428773e-06 G_eff=6.19853559428773e-06
* tiled Ro7p3n1 series x4  each=40332.1068657552
Ro7p3n1t1 h3buf Ro7p3n1n1 40170.7596602771
Ro7p3n1t2 Ro7p3n1n1 Ro7p3n1n2 40420.5212558644
Ro7p3n1t3 Ro7p3n1n2 Ro7p3n1n3 40343.6303845393
Ro7p3n1t4 Ro7p3n1n3 o7p 40430.9850555514
* o7 input 4 w=-0.378033462280536 w-  bank=n alpha=1 R=88175.6158098959 G_phys=1.13410038684161e-05 G_eff=1.13410038684161e-05
* tiled Ro7n4n1 series x4  each=22043.903952474
Ro7n4n1t1 h4buf Ro7n4n1n1 22122.1339091629
Ro7n4n1t2 Ro7n4n1n1 Ro7n4n1n2 22146.4410697662
Ro7n4n1t3 Ro7n4n1n2 Ro7n4n1n3 22031.9116407538
Ro7n4n1t4 Ro7n4n1n3 o7n 22111.5844162298
* o7 input 5 w=-0.580108461232067 w-  bank=n alpha=1 R=57460.5191286783 G_phys=1.7403253836962e-05 G_eff=1.7403253836962e-05
* tiled Ro7n5n1 series x4  each=14365.1297821696
Ro7n5n1t1 h5buf Ro7n5n1n1 14435.115099638
Ro7n5n1t2 Ro7n5n1n1 Ro7n5n1n2 14372.6074227107
Ro7n5n1t3 Ro7n5n1n2 Ro7n5n1n3 14391.3581502898
Ro7n5n1t4 Ro7n5n1n3 o7n 14339.5847922909
* o7 input 6 w=+0.107934080055711 w+  bank=n alpha=1 R=308830.476121427 G_phys=3.23802240167132e-06 G_eff=3.23802240167132e-06
* tiled Ro7p6n1 series x4  each=77207.6190303568
Ro7p6n1t1 h6buf Ro7p6n1n1 77482.6145716022
Ro7p6n1t2 Ro7p6n1n1 Ro7p6n1n2 77160.9304997028
Ro7p6n1t3 Ro7p6n1n2 Ro7p6n1n3 77341.2635194995
Ro7p6n1t4 Ro7p6n1n3 o7p 77157.4648361784
* o7 input 7 w=+0.101501144533757 w+  bank=n alpha=1 R=328403.521816913 G_phys=3.04503433601271e-06 G_eff=3.04503433601271e-06
* tiled Ro7p7n1 series x4  each=82100.8804542282
Ro7p7n1t1 h7buf Ro7p7n1n1 81866.9053647228
Ro7p7n1t2 Ro7p7n1n1 Ro7p7n1n2 81826.2935291702
Ro7p7n1t3 Ro7p7n1n2 Ro7p7n1n3 81761.2926818897
Ro7p7n1t4 Ro7p7n1n3 o7p 82481.3895115387
* o7 input 8 w=+0.0692471666647439 w+  bank=n alpha=1 R=481367.468718463 G_phys=2.07741499994232e-06 G_eff=2.07741499994232e-06
* tiled Ro7p8n1 series x4  each=120341.867179616
Ro7p8n1t1 h8buf Ro7p8n1n1 120913.196684935
Ro7p8n1t2 Ro7p8n1n1 Ro7p8n1n2 120208.951649411
Ro7p8n1t3 Ro7p8n1n2 Ro7p8n1n3 120063.190743928
Ro7p8n1t4 Ro7p8n1n3 o7p 120899.005303057
* o7 input 9 w=-0.335430638558454 w-  bank=n alpha=1 R=99374.7424999297 G_phys=1.00629191567536e-05 G_eff=1.00629191567536e-05
* tiled Ro7n9n1 series x4  each=24843.6856249824
Ro7n9n1t1 h9buf Ro7n9n1n1 24795.8683048044
Ro7n9n1t2 Ro7n9n1n1 Ro7n9n1n2 24860.6836767007
Ro7n9n1t3 Ro7n9n1n2 Ro7n9n1n3 24795.5222645646
Ro7n9n1t4 Ro7n9n1n3 o7n 24899.471236733
* o7 input 10 w=+0.101094797691112 w+  bank=n alpha=1 R=329723.527764315 G_phys=3.03284393073337e-06 G_eff=3.03284393073337e-06
* tiled Ro7p10n1 series x4  each=82430.8819410788
Ro7p10n1t1 h10buf Ro7p10n1n1 82096.1416779719
Ro7p10n1t2 Ro7p10n1n1 Ro7p10n1n2 82258.4661169127
Ro7p10n1t3 Ro7p10n1n2 Ro7p10n1n3 82035.0237044057
Ro7p10n1t4 Ro7p10n1n3 o7p 82480.4488547623
* o7 input 11 w=-0.148243371766924 w-  bank=n alpha=1 R=224855.472025703 G_phys=4.44730115300771e-06 G_eff=4.44730115300771e-06
* tiled Ro7n11n1 series x4  each=56213.8680064256
Ro7n11n1t1 h11buf Ro7n11n1n1 56432.0069673628
Ro7n11n1t2 Ro7n11n1n1 Ro7n11n1n2 56231.5110994058
Ro7n11n1t3 Ro7n11n1n2 Ro7n11n1n3 56418.7542303393
Ro7n11n1t4 Ro7n11n1n3 o7n 55945.9502898361
* o7 input 12 w=-0.334713947003149 w-  bank=n alpha=1 R=99587.5243077928 G_phys=1.00414184100945e-05 G_eff=1.00414184100945e-05
* tiled Ro7n12n1 series x4  each=24896.8810769482
Ro7n12n1t1 h12buf Ro7n12n1n1 24929.6921372639
Ro7n12n1t2 Ro7n12n1n1 Ro7n12n1n2 24832.777774337
Ro7n12n1t3 Ro7n12n1n2 Ro7n12n1n3 24824.1990871556
Ro7n12n1t4 Ro7n12n1n3 o7n 24842.5596576417
* o7 input 13 w=-0.322800486422993 w-  bank=n alpha=1 R=103262.958809962 G_phys=9.68401459268979e-06 G_eff=9.68401459268979e-06
* tiled Ro7n13n1 series x4  each=25815.7397024906
Ro7n13n1t1 h13buf Ro7n13n1n1 25903.6501567775
Ro7n13n1t2 Ro7n13n1n1 Ro7n13n1n2 25796.4469143291
Ro7n13n1t3 Ro7n13n1n2 Ro7n13n1n3 25867.3488457131
Ro7n13n1t4 Ro7n13n1n3 o7n 25937.7711329349
* o7 input 14 w=-0.104357857187523 w-  bank=n alpha=1 R=319413.73876081 G_phys=3.13073571562568e-06 G_eff=3.13073571562568e-06
* tiled Ro7n14n1 series x4  each=79853.4346902026
Ro7n14n1t1 h14buf Ro7n14n1n1 80228.0755256207
Ro7n14n1t2 Ro7n14n1n1 Ro7n14n1n2 79797.2718973267
Ro7n14n1t3 Ro7n14n1n2 Ro7n14n1n3 79879.366298331
Ro7n14n1t4 Ro7n14n1n3 o7n 79572.264723107
* o7 input 15 w=+0.182195051802482 w+  bank=n alpha=1 R=182954.108816688 G_phys=5.46585155407446e-06 G_eff=5.46585155407446e-06
* tiled Ro7p15n1 series x4  each=45738.5272041719
Ro7p15n1t1 h15buf Ro7p15n1n1 45854.6328323474
Ro7p15n1t2 Ro7p15n1n1 Ro7p15n1n2 45596.1774258525
Ro7p15n1t3 Ro7p15n1n2 Ro7p15n1n3 45534.856696877
Ro7p15n1t4 Ro7p15n1n3 o7p 45741.5100189208
* o7 input 16 w=+0.0146234127477982 w+  bank=f alpha=0.001 R=2279.44966802309 G_phys=0.000438702382433947 G_eff=4.38702382433947e-07
* tiled Ro7p16f1 parallel x4  each=9117.79867209237
Ro7p16f1t1 h16f o7p 9144.8545298611
Ro7p16f1t2 h16f o7p 9085.70630976691
Ro7p16f1t3 h16f o7p 9072.7899728851
Ro7p16f1t4 h16f o7p 9091.6225980234
* o7 input 17 w=-0.0268461940667064 w-  bank=f alpha=0.001 R=1241.64092871071 G_phys=0.000805385822001192 G_eff=8.05385822001192e-07
* tiled Ro7n17f1 parallel x4  each=4966.56371484285
Ro7n17f1t1 h17f o7n 4983.85035593957
Ro7n17f1t2 h17f o7n 4951.52730126382
Ro7n17f1t3 h17f o7n 4951.19200821057
Ro7n17f1t4 h17f o7n 4960.58877653071
* o7 input 18 w=+0.263886686193095 w+  bank=n alpha=1 R=126316.843847674 G_phys=7.91660058579284e-06 G_eff=7.91660058579284e-06
* tiled Ro7p18n1 series x4  each=31579.2109619185
Ro7p18n1t1 h18buf Ro7p18n1n1 31449.7941890234
Ro7p18n1t2 Ro7p18n1n1 Ro7p18n1n2 31579.4974090277
Ro7p18n1t3 Ro7p18n1n2 Ro7p18n1n3 31452.544031384
Ro7p18n1t4 Ro7p18n1n3 o7p 31645.2089497769
* o7 input 19 w=+0.184182739421503 w+  bank=n alpha=1 R=180979.680495738 G_phys=5.52548218264508e-06 G_eff=5.52548218264508e-06
* tiled Ro7p19n1 series x4  each=45244.9201239345
Ro7p19n1t1 h19buf Ro7p19n1n1 45462.803159118
Ro7p19n1t2 Ro7p19n1n1 Ro7p19n1n2 45239.8673344458
Ro7p19n1t3 Ro7p19n1n2 Ro7p19n1n3 45247.216725882
Ro7p19n1t4 Ro7p19n1n3 o7p 45151.8021316016
* o7 input 20 w=-0.16994338127458 w-  bank=n alpha=1 R=196143.757311009 G_phys=5.09830143823739e-06 G_eff=5.09830143823739e-06
* tiled Ro7n20n1 series x4  each=49035.9393277522
Ro7n20n1t1 h20buf Ro7n20n1n1 49064.733825724
Ro7n20n1t2 Ro7n20n1n1 Ro7n20n1n2 49276.9173445525
Ro7n20n1t3 Ro7n20n1n2 Ro7n20n1n3 48981.2760546349
Ro7n20n1t4 Ro7n20n1n3 o7n 48867.3263290521
* o7 input 21 w=-0.17515931490212 w-  bank=n alpha=1 R=190302.94421944 G_phys=5.25477944706359e-06 G_eff=5.25477944706359e-06
* tiled Ro7n21n1 series x4  each=47575.7360548599
Ro7n21n1t1 h21buf Ro7n21n1n1 47647.3274806985
Ro7n21n1t2 Ro7n21n1n1 Ro7n21n1n2 47789.641861437
Ro7n21n1t3 Ro7n21n1n2 Ro7n21n1n3 47425.1138605907
Ro7n21n1t4 Ro7n21n1n3 o7n 47602.451204466
* o7 input 22 w=+0.170460541565249 w+  bank=n alpha=1 R=195548.67670401 G_phys=5.11381624695746e-06 G_eff=5.11381624695746e-06
* tiled Ro7p22n1 series x4  each=48887.1691760025
Ro7p22n1t1 h22buf Ro7p22n1n1 48984.2077878106
Ro7p22n1t2 Ro7p22n1n1 Ro7p22n1n2 48900.3113788578
Ro7p22n1t3 Ro7p22n1n2 Ro7p22n1n3 48934.2410682642
Ro7p22n1t4 Ro7p22n1n3 o7p 48856.1640024451
* o7 input 23 w=-0.342102206419994 w-  bank=n alpha=1 R=97436.7680412165 G_phys=1.02630661925998e-05 G_eff=1.02630661925998e-05
* tiled Ro7n23n1 series x4  each=24359.1920103041
Ro7n23n1t1 h23buf Ro7n23n1n1 24350.7932377757
Ro7n23n1t2 Ro7n23n1n1 Ro7n23n1n2 24290.3656118192
Ro7n23n1t3 Ro7n23n1n2 Ro7n23n1n3 24421.9435925723
Ro7n23n1t4 Ro7n23n1n3 o7n 24451.5062498916
* o7 input 24 w=-0.0940891241579366 w-  bank=n alpha=1 R=354274.031474461 G_phys=2.8226737247381e-06 G_eff=2.8226737247381e-06
* tiled Ro7n24n1 series x4  each=88568.5078686153
Ro7n24n1t1 h24buf Ro7n24n1n1 88780.0265094397
Ro7n24n1t2 Ro7n24n1n1 Ro7n24n1n2 88421.3694371791
Ro7n24n1t3 Ro7n24n1n2 Ro7n24n1n3 88556.0334114481
Ro7n24n1t4 Ro7n24n1n3 o7n 88171.918514157
* o7 input 25 w=-0.147263798833488 w-  bank=n alpha=1 R=226351.171145758 G_phys=4.41791396500465e-06 G_eff=4.41791396500465e-06
* tiled Ro7n25n1 series x4  each=56587.7927864394
Ro7n25n1t1 h25buf Ro7n25n1n1 56422.8894469144
Ro7n25n1t2 Ro7n25n1n1 Ro7n25n1n2 56495.1658706476
Ro7n25n1t3 Ro7n25n1n2 Ro7n25n1n3 56795.3625626566
Ro7n25n1t4 Ro7n25n1n3 o7n 56456.856588356
* o7 input 26 w=-0.0975787524659246 w-  bank=n alpha=1 R=341604.421976738 G_phys=2.92736257397774e-06 G_eff=2.92736257397774e-06
* tiled Ro7n26n1 series x4  each=85401.1054941844
Ro7n26n1t1 h26buf Ro7n26n1n1 85641.401075223
Ro7n26n1t2 Ro7n26n1n1 Ro7n26n1n2 85035.0394293606
Ro7n26n1t3 Ro7n26n1n2 Ro7n26n1n3 85117.0019454541
Ro7n26n1t4 Ro7n26n1n3 o7n 85249.5156750604
* o7 input 27 w=-0.201262065009158 w-  bank=n alpha=1 R=165621.540908947 G_phys=6.03786195027474e-06 G_eff=6.03786195027474e-06
* tiled Ro7n27n1 series x4  each=41405.3852272367
Ro7n27n1t1 h27buf Ro7n27n1n1 41610.0032342025
Ro7n27n1t2 Ro7n27n1n1 Ro7n27n1n2 41323.3798726903
Ro7n27n1t3 Ro7n27n1n2 Ro7n27n1n3 41520.6465003639
Ro7n27n1t4 Ro7n27n1n3 o7n 41433.5362077014
* o7 input 28 w=-0.060609790215781 w-  bank=n alpha=1 R=549966.155874506 G_phys=1.81829370647343e-06 G_eff=1.81829370647343e-06
* tiled Ro7n28n1 series x4  each=137491.538968626
Ro7n28n1t1 h28buf Ro7n28n1n1 137467.206696408
Ro7n28n1t2 Ro7n28n1n1 Ro7n28n1n2 137095.673351826
Ro7n28n1t3 Ro7n28n1n2 Ro7n28n1n3 138031.065511277
Ro7n28n1t4 Ro7n28n1n3 o7n 138162.269459972
* o7 input 29 w=-0.355920486311588 w-  bank=n alpha=1 R=93653.8766811862 G_phys=1.06776145893477e-05 G_eff=1.06776145893477e-05
* tiled Ro7n29n1 series x4  each=23413.4691702966
Ro7n29n1t1 h29buf Ro7n29n1n1 23437.2025693585
Ro7n29n1t2 Ro7n29n1n1 Ro7n29n1n2 23515.1735809033
Ro7n29n1t3 Ro7n29n1n2 Ro7n29n1n3 23305.5322746348
Ro7n29n1t4 Ro7n29n1n3 o7n 23418.8088370424
* o7 input 30 w=+0.0702967455487947 w+  bank=n alpha=1 R=474180.320484337 G_phys=2.10890236646384e-06 G_eff=2.10890236646384e-06
* tiled Ro7p30n1 series x4  each=118545.080121084
Ro7p30n1t1 h30buf Ro7p30n1n1 119001.95086941
Ro7p30n1t2 Ro7p30n1n1 Ro7p30n1n2 117985.083337622
Ro7p30n1t3 Ro7p30n1n2 Ro7p30n1n3 117999.762582113
Ro7p30n1t4 Ro7p30n1n3 o7p 118971.477865139
* o7 input 31 w=+0.188674793501044 w+  bank=n alpha=1 R=176670.835116874 G_phys=5.66024380503133e-06 G_eff=5.66024380503133e-06
* tiled Ro7p31n1 series x4  each=44167.7087792186
Ro7p31n1t1 h31buf Ro7p31n1n1 44251.2880983201
Ro7p31n1t2 Ro7p31n1n1 Ro7p31n1n2 44221.4027309979
Ro7p31n1t3 Ro7p31n1n2 Ro7p31n1n3 44222.8907285895
Ro7p31n1t4 Ro7p31n1n3 o7p 44123.345447617
* o7 input 32 w=-0.221533996080022 w-  bank=n alpha=1 R=150465.995843332 G_phys=6.64601988240065e-06 G_eff=6.64601988240065e-06
* tiled Ro7n32n1 series x4  each=37616.4989608331
Ro7n32n1t1 h32buf Ro7n32n1n1 37635.2016420627
Ro7n32n1t2 Ro7n32n1n1 Ro7n32n1n2 37707.2879764866
Ro7n32n1t3 Ro7n32n1n2 Ro7n32n1n3 37716.117942871
Ro7n32n1t4 Ro7n32n1n3 o7n 37479.9004436747
* o7 bias=+0.0479731403374592 b+  bank=n alpha=1 R=694833.256669366 G_phys=1.43919421012378e-06 G_eff=1.43919421012378e-06
* tiled Ro7bpn1 series x4  each=173708.314167342
Ro7bpn1t1 vref Ro7bpn1n1 174459.816829896
Ro7bpn1t2 Ro7bpn1n1 Ro7bpn1n2 174221.791723201
Ro7bpn1t3 Ro7bpn1n2 Ro7bpn1n3 173654.010708588
Ro7bpn1t4 Ro7bpn1n3 o7p 173049.949830738
Vo7p o7p 0 DC 0
Vo7n o7n 0 DC 0
Fo7p 0 o7d Vo7p 1.001
Fo7n o7d 0 Vo7n 1.001
* ratiometric I-to-V: V = I * R_IV,  R_IV=33333.3333333333 (weight ~ R_IV / R_w)
* tiled Ro7iv series x4  each=8333.33333333333
Ro7ivt1 o7d Ro7ivn1 8358.91860200614
Ro7ivt2 Ro7ivn1 Ro7ivn2 8370.79110311269
Ro7ivt3 Ro7ivn2 Ro7ivn3 8303.80520125335
Ro7ivt4 Ro7ivn3 0 8338.2275487619
Bo7leak 0 o7d I = 1e-08
Eo7sc o7raw 0 o7d 0 1
Eo7lin o7lin 0 o7raw 0 1

* o8 input 1 w=-0.264579445854062 w-  bank=n alpha=1 R=125986.103061534 G_phys=7.93738337562187e-06 G_eff=7.93738337562187e-06
* tiled Ro8n1n1 series x4  each=31496.5257653834
Ro8n1n1t1 h1buf Ro8n1n1n1 31563.3127581903
Ro8n1n1t2 Ro8n1n1n1 Ro8n1n1n2 31445.2718532923
Ro8n1n1t3 Ro8n1n1n2 Ro8n1n1n3 31472.1055887493
Ro8n1n1t4 Ro8n1n1n3 o8n 31447.4943188276
* o8 input 2 w=-0.461651647659873 w-  bank=n alpha=1 R=72204.5150327114 G_phys=1.38495494297962e-05 G_eff=1.38495494297962e-05
* tiled Ro8n2n1 series x4  each=18051.1287581779
Ro8n2n1t1 h2buf Ro8n2n1n1 18088.114276501
Ro8n2n1t2 Ro8n2n1n1 Ro8n2n1n2 18104.0011620269
Ro8n2n1t3 Ro8n2n1n2 Ro8n2n1n3 18057.2228851955
Ro8n2n1t4 Ro8n2n1n3 o8n 18094.3278895988
* o8 input 3 w=-0.248506615035073 w-  bank=n alpha=1 R=134134.591663199 G_phys=7.45519845105219e-06 G_eff=7.45519845105219e-06
* tiled Ro8n3n1 series x4  each=33533.6479157998
Ro8n3n1t1 h3buf Ro8n3n1n1 33366.9490766477
Ro8n3n1t2 Ro8n3n1n1 Ro8n3n1n2 33444.0635895104
Ro8n3n1t3 Ro8n3n1n2 Ro8n3n1n3 33539.2741982081
Ro8n3n1t4 Ro8n3n1n3 o8n 33388.6595177231
* o8 input 4 w=-0.0596907059046396 w-  bank=n alpha=1 R=558434.22905043 G_phys=1.79072117713919e-06 G_eff=1.79072117713919e-06
* tiled Ro8n4n1 series x4  each=139608.557262607
Ro8n4n1t1 h4buf Ro8n4n1n1 140164.871392252
Ro8n4n1t2 Ro8n4n1n1 Ro8n4n1n2 139651.228627555
Ro8n4n1t3 Ro8n4n1n2 Ro8n4n1n3 139497.703042131
Ro8n4n1t4 Ro8n4n1n3 o8n 139983.902675696
* o8 input 5 w=-0.142952779428107 w-  bank=n alpha=1 R=233177.231437442 G_phys=4.28858338284322e-06 G_eff=4.28858338284322e-06
* tiled Ro8n5n1 series x4  each=58294.3078593604
Ro8n5n1t1 h5buf Ro8n5n1n1 58290.8624140742
Ro8n5n1t2 Ro8n5n1n1 Ro8n5n1n2 58344.7833613872
Ro8n5n1t3 Ro8n5n1n2 Ro8n5n1n3 58461.028993649
Ro8n5n1t4 Ro8n5n1n3 o8n 58259.6733337839
* o8 input 6 w=+0.230947580946818 w+  bank=n alpha=1 R=144332.896654195 G_phys=6.92842742840454e-06 G_eff=6.92842742840454e-06
* tiled Ro8p6n1 series x4  each=36083.2241635486
Ro8p6n1t1 h6buf Ro8p6n1n1 36094.4475835964
Ro8p6n1t2 Ro8p6n1n1 Ro8p6n1n2 35910.4738022596
Ro8p6n1t3 Ro8p6n1n2 Ro8p6n1n3 36239.5455447738
Ro8p6n1t4 Ro8p6n1n3 o8p 36159.1218249647
* o8 input 7 w=+0.224542704495923 w+  bank=n alpha=1 R=148449.861277673 G_phys=6.7362811348777e-06 G_eff=6.7362811348777e-06
* tiled Ro8p7n1 series x4  each=37112.4653194183
Ro8p7n1t1 h7buf Ro8p7n1n1 37248.3071551099
Ro8p7n1t2 Ro8p7n1n1 Ro8p7n1n2 37156.0870620114
Ro8p7n1t3 Ro8p7n1n2 Ro8p7n1n3 36952.4127645498
Ro8p7n1t4 Ro8p7n1n3 o8p 37158.8901869403
* o8 input 8 w=-0.0814289785611842 w-  bank=n alpha=1 R=409354.678424307 G_phys=2.44286935683553e-06 G_eff=2.44286935683553e-06
* tiled Ro8n8n1 series x4  each=102338.669606077
Ro8n8n1t1 h8buf Ro8n8n1n1 102094.013477321
Ro8n8n1t2 Ro8n8n1n1 Ro8n8n1n2 102336.762113437
Ro8n8n1t3 Ro8n8n1n2 Ro8n8n1n3 101974.958224586
Ro8n8n1t4 Ro8n8n1n3 o8n 102203.010066274
* o8 input 9 w=+0.151871407153412 w+  bank=n alpha=1 R=219483.93024147 G_phys=4.55614221460235e-06 G_eff=4.55614221460235e-06
* tiled Ro8p9n1 series x4  each=54870.9825603676
Ro8p9n1t1 h9buf Ro8p9n1n1 54956.0709027411
Ro8p9n1t2 Ro8p9n1n1 Ro8p9n1n2 54793.8288640787
Ro8p9n1t3 Ro8p9n1n2 Ro8p9n1n3 54718.2852936569
Ro8p9n1t4 Ro8p9n1n3 o8p 55057.6933332737
* o8 input 10 w=-0.0439376442611886 w-  bank=n alpha=1 R=758650.899333209 G_phys=1.31812932783566e-06 G_eff=1.31812932783566e-06
* tiled Ro8n10n1 series x4  each=189662.724833302
Ro8n10n1t1 h10buf Ro8n10n1n1 189836.779922446
Ro8n10n1t2 Ro8n10n1n1 Ro8n10n1n2 189097.88631997
Ro8n10n1t3 Ro8n10n1n2 Ro8n10n1n3 189630.01745431
Ro8n10n1t4 Ro8n10n1n3 o8n 189858.065591136
* o8 input 11 w=-0.0114777570667242 w-  bank=f alpha=0.001 R=2904.16787352748 G_phys=0.000344332712001725 G_eff=3.44332712001725e-07
* tiled Ro8n11f1 parallel x4  each=11616.6714941099
Ro8n11f1t1 h11f o8n 11659.6604398816
Ro8n11f1t2 h11f o8n 11595.4985315123
Ro8n11f1t3 h11f o8n 11627.2885894846
Ro8n11f1t4 h11f o8n 11590.0254852874
* o8 input 12 w=-0.184091969163629 w-  bank=n alpha=1 R=181068.91617692 G_phys=5.52275907490888e-06 G_eff=5.52275907490888e-06
* tiled Ro8n12n1 series x4  each=45267.22904423
Ro8n12n1t1 h12buf Ro8n12n1n1 45203.4304091075
Ro8n12n1t2 Ro8n12n1n1 Ro8n12n1n2 45125.9131300667
Ro8n12n1t3 Ro8n12n1n2 Ro8n12n1n3 45157.5457747722
Ro8n12n1t4 Ro8n12n1n3 o8n 45162.5581236917
* o8 input 13 w=+0.167375709493599 w+  bank=n alpha=1 R=199152.753014069 G_phys=5.02127128480798e-06 G_eff=5.02127128480798e-06
* tiled Ro8p13n1 series x4  each=49788.1882535172
Ro8p13n1t1 h13buf Ro8p13n1n1 49701.4222643683
Ro8p13n1t2 Ro8p13n1n1 Ro8p13n1n2 49851.4355481148
Ro8p13n1t3 Ro8p13n1n2 Ro8p13n1n3 49619.834633005
Ro8p13n1t4 Ro8p13n1n3 o8p 49928.3866586039
* o8 input 14 w=+0.639794426458427 w+  bank=n alpha=1 R=52100.068326399 G_phys=1.91938327937528e-05 G_eff=1.91938327937528e-05
* tiled Ro8p14n1 series x4  each=13025.0170815998
Ro8p14n1t1 h14buf Ro8p14n1n1 12967.8307346015
Ro8p14n1t2 Ro8p14n1n1 Ro8p14n1n2 12970.2816086726
Ro8p14n1t3 Ro8p14n1n2 Ro8p14n1n3 13034.5065285145
Ro8p14n1t4 Ro8p14n1n3 o8p 13086.4210405019
* o8 input 15 w=+0.00251732875304732 w+  bank=f alpha=0.001 R=13241.5495167177 G_phys=7.55198625914195e-05 G_eff=7.55198625914195e-08
* tiled Ro8p15f1 series x4  each=3310.38737917943
Ro8p15f1t1 h15f Ro8p15f1n1 3320.44683911296
Ro8p15f1t2 Ro8p15f1n1 Ro8p15f1n2 3310.83396487118
Ro8p15f1t3 Ro8p15f1n2 Ro8p15f1n3 3324.44307237394
Ro8p15f1t4 Ro8p15f1n3 o8p 3295.2480391794
* o8 input 16 w=+0.510552134317183 w+  bank=n alpha=1 R=65288.7944106113 G_phys=1.53165640295155e-05 G_eff=1.53165640295155e-05
* tiled Ro8p16n1 series x4  each=16322.1986026528
Ro8p16n1t1 h16buf Ro8p16n1n1 16242.0019066126
Ro8p16n1t2 Ro8p16n1n1 Ro8p16n1n2 16369.3338900557
Ro8p16n1t3 Ro8p16n1n2 Ro8p16n1n3 16372.9316991158
Ro8p16n1t4 Ro8p16n1n3 o8p 16373.8684489305
* o8 input 17 w=-0.402994248540282 w-  bank=n alpha=1 R=82714.166403299 G_phys=1.20898274562085e-05 G_eff=1.20898274562085e-05
* tiled Ro8n17n1 series x4  each=20678.5416008248
Ro8n17n1t1 h17buf Ro8n17n1n1 20761.2265821612
Ro8n17n1t2 Ro8n17n1n1 Ro8n17n1n2 20731.93615477
Ro8n17n1t3 Ro8n17n1n2 Ro8n17n1n3 20617.3652820226
Ro8n17n1t4 Ro8n17n1n3 o8n 20644.1382936951
* o8 input 18 w=+0.141582671709231 w+  bank=n alpha=1 R=235433.707606466 G_phys=4.24748015127692e-06 G_eff=4.24748015127692e-06
* tiled Ro8p18n1 series x4  each=58858.4269016165
Ro8p18n1t1 h18buf Ro8p18n1n1 58600.2877654044
Ro8p18n1t2 Ro8p18n1n1 Ro8p18n1n2 58923.8089164768
Ro8p18n1t3 Ro8p18n1n2 Ro8p18n1n3 58786.6161540774
Ro8p18n1t4 Ro8p18n1n3 o8p 59032.4597158827
* o8 input 19 w=+0.181760587882604 w+  bank=n alpha=1 R=183391.425620073 G_phys=5.45281763647812e-06 G_eff=5.45281763647812e-06
* tiled Ro8p19n1 series x4  each=45847.8564050183
Ro8p19n1t1 h19buf Ro8p19n1n1 45734.7090179706
Ro8p19n1t2 Ro8p19n1n1 Ro8p19n1n2 45800.6485743133
Ro8p19n1t3 Ro8p19n1n2 Ro8p19n1n3 45919.4003369524
Ro8p19n1t4 Ro8p19n1n3 o8p 45825.0212805433
* o8 input 20 w=+0.465247625040388 w+  bank=n alpha=1 R=71646.4341552301 G_phys=1.39574287512116e-05 G_eff=1.39574287512116e-05
* tiled Ro8p20n1 series x4  each=17911.6085388075
Ro8p20n1t1 h20buf Ro8p20n1n1 17846.9681621149
Ro8p20n1t2 Ro8p20n1n1 Ro8p20n1n2 17950.6551850945
Ro8p20n1t3 Ro8p20n1n2 Ro8p20n1n3 17845.169142555
Ro8p20n1t4 Ro8p20n1n3 o8p 17838.5727005831
* o8 input 21 w=-0.129997678502292 w-  bank=n alpha=1 R=256414.835382969 G_phys=3.89993035506876e-06 G_eff=3.89993035506876e-06
* tiled Ro8n21n1 series x4  each=64103.7088457423
Ro8n21n1t1 h21buf Ro8n21n1n1 64190.8032746693
Ro8n21n1t2 Ro8n21n1n1 Ro8n21n1n2 64068.9055064569
Ro8n21n1t3 Ro8n21n1n2 Ro8n21n1n3 64396.5578406708
Ro8n21n1t4 Ro8n21n1n3 o8n 64263.726046406
* o8 input 22 w=+0.727771195072513 w+  bank=n alpha=1 R=45801.9409932982 G_phys=2.18331358521754e-05 G_eff=2.18331358521754e-05
* tiled Ro8p22n1 series x4  each=11450.4852483245
Ro8p22n1t1 h22buf Ro8p22n1n1 11403.378402095
Ro8p22n1t2 Ro8p22n1n1 Ro8p22n1n2 11438.6779318184
Ro8p22n1t3 Ro8p22n1n2 Ro8p22n1n3 11453.0757468962
Ro8p22n1t4 Ro8p22n1n3 o8p 11408.6679314122
* o8 input 23 w=+0.0590279674258587 w+  bank=n alpha=1 R=564704.068036922 G_phys=1.77083902277576e-06 G_eff=1.77083902277576e-06
* tiled Ro8p23n1 series x4  each=141176.017009231
Ro8p23n1t1 h23buf Ro8p23n1n1 141827.092341973
Ro8p23n1t2 Ro8p23n1n1 Ro8p23n1n2 141391.788155458
Ro8p23n1t3 Ro8p23n1n2 Ro8p23n1n3 140523.9358032
Ro8p23n1t4 Ro8p23n1n3 o8p 141217.686313431
* o8 input 24 w=-0.0219880792573176 w-  bank=f alpha=0.001 R=1515.97294803456 G_phys=0.000659642377719527 G_eff=6.59642377719527e-07
* tiled Ro8n24f1 parallel x4  each=6063.89179213825
Ro8n24f1t1 h24f o8n 6077.13473952624
Ro8n24f1t2 h24f o8n 6083.93017420712
Ro8n24f1t3 h24f o8n 6073.02776402489
Ro8n24f1t4 h24f o8n 6088.18560613576
* o8 input 25 w=-0.000673889145733125 w-  bank=f alpha=0.001 R=49464.1196469635 G_phys=2.02166743719938e-05 G_eff=2.02166743719938e-08
* tiled Ro8n25f1 series x4  each=12366.0299117409
Ro8n25f1t1 h25f Ro8n25f1n1 12399.9501315708
Ro8n25f1t2 Ro8n25f1n1 Ro8n25f1n2 12338.8535494729
Ro8n25f1t3 Ro8n25f1n2 Ro8n25f1n3 12363.688796324
Ro8n25f1t4 Ro8n25f1n3 o8n 12418.5518092738
* o8 input 26 w=-0.0895992045192751 w-  bank=n alpha=1 R=372027.112430027 G_phys=2.68797613557825e-06 G_eff=2.68797613557825e-06
* tiled Ro8n26n1 series x4  each=93006.7781075068
Ro8n26n1t1 h26buf Ro8n26n1n1 93095.8755657501
Ro8n26n1t2 Ro8n26n1n1 Ro8n26n1n2 92992.6634124734
Ro8n26n1t3 Ro8n26n1n2 Ro8n26n1n3 93075.5756397088
Ro8n26n1t4 Ro8n26n1n3 o8n 93308.7081744835
* o8 input 27 w=-0.161030155307918 w-  bank=n alpha=1 R=207000.56625788 G_phys=4.83090465923753e-06 G_eff=4.83090465923753e-06
* tiled Ro8n27n1 series x4  each=51750.1415644701
Ro8n27n1t1 h27buf Ro8n27n1n1 51546.5807794681
Ro8n27n1t2 Ro8n27n1n1 Ro8n27n1n2 51835.1557379995
Ro8n27n1t3 Ro8n27n1n2 Ro8n27n1n3 51595.4509862568
Ro8n27n1t4 Ro8n27n1n3 o8n 51698.2274228448
* o8 input 28 w=-0.0515875057732319 w-  bank=n alpha=1 R=646151.288644577 G_phys=1.54762517319696e-06 G_eff=1.54762517319696e-06
* tiled Ro8n28n1 series x4  each=161537.822161144
Ro8n28n1t1 h28buf Ro8n28n1n1 161432.135106299
Ro8n28n1t2 Ro8n28n1n1 Ro8n28n1n2 162233.723548458
Ro8n28n1t3 Ro8n28n1n2 Ro8n28n1n3 161808.487757276
Ro8n28n1t4 Ro8n28n1n3 o8n 161324.589966579
* o8 input 29 w=-0.167333727666792 w-  bank=n alpha=1 R=199202.71781496 G_phys=5.02001183000377e-06 G_eff=5.02001183000377e-06
* tiled Ro8n29n1 series x4  each=49800.6794537399
Ro8n29n1t1 h29buf Ro8n29n1n1 49874.7624824517
Ro8n29n1t2 Ro8n29n1n1 Ro8n29n1n2 49884.3236058898
Ro8n29n1t3 Ro8n29n1n2 Ro8n29n1n3 49891.7334926172
Ro8n29n1t4 Ro8n29n1n3 o8n 49673.5394264004
* o8 input 30 w=+0.117154510339097 w+  bank=n alpha=1 R=284524.541452582 G_phys=3.5146353101729e-06 G_eff=3.5146353101729e-06
* tiled Ro8p30n1 series x4  each=71131.1353631456
Ro8p30n1t1 h30buf Ro8p30n1n1 71255.6939168138
Ro8p30n1t2 Ro8p30n1n1 Ro8p30n1n2 70778.7259690494
Ro8p30n1t3 Ro8p30n1n2 Ro8p30n1n3 70888.6410874358
Ro8p30n1t4 Ro8p30n1n3 o8p 71397.1003159233
* o8 input 31 w=-0.114263857072683 w-  bank=n alpha=1 R=291722.458766031 G_phys=3.42791571218049e-06 G_eff=3.42791571218049e-06
* tiled Ro8n31n1 series x4  each=72930.6146915077
Ro8n31n1t1 h31buf Ro8n31n1n1 72724.4723429066
Ro8n31n1t2 Ro8n31n1n1 Ro8n31n1n2 73134.7384724923
Ro8n31n1t3 Ro8n31n1n2 Ro8n31n1n3 72812.8040748803
Ro8n31n1t4 Ro8n31n1n3 o8n 72614.920387544
* o8 input 32 w=+0.185068242761295 w+  bank=n alpha=1 R=180113.739861503 G_phys=5.55204728283885e-06 G_eff=5.55204728283885e-06
* tiled Ro8p32n1 series x4  each=45028.4349653757
Ro8p32n1t1 h32buf Ro8p32n1n1 44889.9685589318
Ro8p32n1t2 Ro8p32n1n1 Ro8p32n1n2 45172.2142324049
Ro8p32n1t3 Ro8p32n1n2 Ro8p32n1n3 44971.1315306351
Ro8p32n1t4 Ro8p32n1n3 o8p 44978.4928672376
* o8 bias=+0.070334250370477 b+  bank=n alpha=1 R=473927.47001289 G_phys=2.11002751111431e-06 G_eff=2.11002751111431e-06
* tiled Ro8bpn1 series x4  each=118481.867503222
Ro8bpn1t1 vref Ro8bpn1n1 119008.488358582
Ro8bpn1t2 Ro8bpn1n1 Ro8bpn1n2 118811.69654626
Ro8bpn1t3 Ro8bpn1n2 Ro8bpn1n3 117941.882494511
Ro8bpn1t4 Ro8bpn1n3 o8p 118326.716231605
Vo8p o8p 0 DC 0
Vo8n o8n 0 DC 0
Fo8p 0 o8d Vo8p 1.001
Fo8n o8d 0 Vo8n 1.001
* ratiometric I-to-V: V = I * R_IV,  R_IV=33333.3333333333 (weight ~ R_IV / R_w)
* tiled Ro8iv series x4  each=8333.33333333333
Ro8ivt1 o8d Ro8ivn1 8331.36278910438
Ro8ivt2 Ro8ivn1 Ro8ivn2 8328.28196622274
Ro8ivt3 Ro8ivn2 Ro8ivn3 8297.77938327461
Ro8ivt4 Ro8ivn3 0 8352.2892571142
Bo8leak 0 o8d I = 1e-08
Eo8sc o8raw 0 o8d 0 1
Eo8lin o8lin 0 o8raw 0 1

* o9 input 1 w=-0.342788496026982 w-  bank=n alpha=1 R=97241.6919461309 G_phys=1.02836548808095e-05 G_eff=1.02836548808095e-05
* tiled Ro9n1n1 series x4  each=24310.4229865327
Ro9n1n1t1 h1buf Ro9n1n1n1 24306.7583146761
Ro9n1n1t2 Ro9n1n1n1 Ro9n1n1n2 24262.0789098314
Ro9n1n1t3 Ro9n1n1n2 Ro9n1n1n3 24275.4751957447
Ro9n1n1t4 Ro9n1n1n3 o9n 24248.7702874191
* o9 input 2 w=+0.117901804588507 w+  bank=n alpha=1 R=282721.146208671 G_phys=3.5370541376552e-06 G_eff=3.5370541376552e-06
* tiled Ro9p2n1 series x4  each=70680.2865521678
Ro9p2n1t1 h2buf Ro9p2n1n1 70556.8226715045
Ro9p2n1t2 Ro9p2n1n1 Ro9p2n1n2 70374.8357422809
Ro9p2n1t3 Ro9p2n1n2 Ro9p2n1n3 70545.3900091318
Ro9p2n1t4 Ro9p2n1n3 o9p 70737.8636158198
* o9 input 3 w=-0.555835720214104 w-  bank=n alpha=1 R=59969.7574680763 G_phys=1.66750716064231e-05 G_eff=1.66750716064231e-05
* tiled Ro9n3n1 series x4  each=14992.4393670191
Ro9n3n1t1 h3buf Ro9n3n1n1 14990.6224886534
Ro9n3n1t2 Ro9n3n1n1 Ro9n3n1n2 14918.3840543439
Ro9n3n1t3 Ro9n3n1n2 Ro9n3n1n3 15042.5647576923
Ro9n3n1t4 Ro9n3n1n3 o9n 15046.4073425944
* o9 input 4 w=+0.355136587925528 w+  bank=n alpha=1 R=93860.6003060526 G_phys=1.06540976377658e-05 G_eff=1.06540976377658e-05
* tiled Ro9p4n1 series x4  each=23465.1500765132
Ro9p4n1t1 h4buf Ro9p4n1n1 23490.2946895807
Ro9p4n1t2 Ro9p4n1n1 Ro9p4n1n2 23566.0467938911
Ro9p4n1t3 Ro9p4n1n2 Ro9p4n1n3 23580.5755741405
Ro9p4n1t4 Ro9p4n1n3 o9p 23545.6511468766
* o9 input 5 w=+0.236432436172994 w+  bank=n alpha=1 R=140984.603774686 G_phys=7.09297308518982e-06 G_eff=7.09297308518982e-06
* tiled Ro9p5n1 series x4  each=35246.1509436716
Ro9p5n1t1 h5buf Ro9p5n1n1 35199.5572198803
Ro9p5n1t2 Ro9p5n1n1 Ro9p5n1n2 35162.6608427504
Ro9p5n1t3 Ro9p5n1n2 Ro9p5n1n3 35359.9380025128
Ro9p5n1t4 Ro9p5n1n3 o9p 35206.1654544222
* o9 input 6 w=-0.00589463242951189 w-  bank=f alpha=0.001 R=5654.86206848924 G_phys=0.000176838972885357 G_eff=1.76838972885357e-07
* tiled Ro9n6f1 series x4  each=1413.71551712231
Ro9n6f1t1 h6f Ro9n6f1n1 1406.7269523678
Ro9n6f1t2 Ro9n6f1n1 Ro9n6f1n2 1409.17489855942
Ro9n6f1t3 Ro9n6f1n2 Ro9n6f1n3 1411.1897745412
Ro9n6f1t4 Ro9n6f1n3 o9n 1410.99266732421
* o9 input 7 w=-0.175810166557473 w-  bank=n alpha=1 R=189598.440101794 G_phys=5.27430499672418e-06 G_eff=5.27430499672418e-06
* tiled Ro9n7n1 series x4  each=47399.6100254484
Ro9n7n1t1 h7buf Ro9n7n1n1 47349.7616368616
Ro9n7n1t2 Ro9n7n1n1 Ro9n7n1n2 47498.5197699276
Ro9n7n1t3 Ro9n7n1n2 Ro9n7n1n3 47519.6172656249
Ro9n7n1t4 Ro9n7n1n3 o9n 47635.7813668485
* o9 input 8 w=+0.162552656301944 w+  bank=n alpha=1 R=205061.757166343 G_phys=4.87657968905832e-06 G_eff=4.87657968905832e-06
* tiled Ro9p8n1 series x4  each=51265.4392915858
Ro9p8n1t1 h8buf Ro9p8n1n1 51191.3266750391
Ro9p8n1t2 Ro9p8n1n1 Ro9p8n1n2 51138.6502013652
Ro9p8n1t3 Ro9p8n1n2 Ro9p8n1n3 51246.6176955428
Ro9p8n1t4 Ro9p8n1n3 o9p 51499.2631779447
* o9 input 9 w=-0.443497798175432 w-  bank=n alpha=1 R=75160.0875370025 G_phys=1.3304933945263e-05 G_eff=1.3304933945263e-05
* tiled Ro9n9n1 series x4  each=18790.0218842506
Ro9n9n1t1 h9buf Ro9n9n1n1 18720.3209732671
Ro9n9n1t2 Ro9n9n1n1 Ro9n9n1n2 18725.6153314087
Ro9n9n1t3 Ro9n9n1n2 Ro9n9n1n3 18836.1166988409
Ro9n9n1t4 Ro9n9n1n3 o9n 18773.6543941861
* o9 input 10 w=+0.114863161009978 w+  bank=n alpha=1 R=290200.383136224 G_phys=3.44589483029933e-06 G_eff=3.44589483029933e-06
* tiled Ro9p10n1 series x4  each=72550.0957840561
Ro9p10n1t1 h10buf Ro9p10n1n1 72228.8416736263
Ro9p10n1t2 Ro9p10n1n1 Ro9p10n1n2 72244.8513081386
Ro9p10n1t3 Ro9p10n1n2 Ro9p10n1n3 72271.6704789009
Ro9p10n1t4 Ro9p10n1n3 o9p 72572.2094238232
* o9 input 11 w=-0.051706338551111 w-  bank=n alpha=1 R=644666.287874624 G_phys=1.55119015653333e-06 G_eff=1.55119015653333e-06
* tiled Ro9n11n1 series x4  each=161166.571968656
Ro9n11n1t1 h11buf Ro9n11n1n1 160925.127262251
Ro9n11n1t2 Ro9n11n1n1 Ro9n11n1n2 160561.66147872
Ro9n11n1t3 Ro9n11n1n2 Ro9n11n1n3 161007.773443356
Ro9n11n1t4 Ro9n11n1n3 o9n 161496.280309427
* o9 input 12 w=-0.247913853258797 w-  bank=n alpha=1 R=134455.307338298 G_phys=7.43741559776392e-06 G_eff=7.43741559776392e-06
* tiled Ro9n12n1 series x4  each=33613.8268345745
Ro9n12n1t1 h12buf Ro9n12n1n1 33531.3664751211
Ro9n12n1t2 Ro9n12n1n1 Ro9n12n1n2 33642.6092113075
Ro9n12n1t3 Ro9n12n1n2 Ro9n12n1n3 33557.9131877079
Ro9n12n1t4 Ro9n12n1n3 o9n 33759.3267373871
* o9 input 13 w=+0.0720916431840902 w+  bank=n alpha=1 R=462374.442599605 G_phys=2.16274929552271e-06 G_eff=2.16274929552271e-06
* tiled Ro9p13n1 series x4  each=115593.610649901
Ro9p13n1t1 h13buf Ro9p13n1n1 115434.576340166
Ro9p13n1t2 Ro9p13n1n1 Ro9p13n1n2 115220.274087522
Ro9p13n1t3 Ro9p13n1n2 Ro9p13n1n3 115744.938097917
Ro9p13n1t4 Ro9p13n1n3 o9p 115431.421352599
* o9 input 14 w=+0.00473033723811417 w+  bank=f alpha=0.001 R=7046.71393505597 G_phys=0.000141910117143425 G_eff=1.41910117143425e-07
* tiled Ro9p14f1 series x4  each=1761.67848376399
Ro9p14f1t1 h14f Ro9p14f1n1 1759.98772774869
Ro9p14f1t2 Ro9p14f1n1 Ro9p14f1n2 1763.60962808136
Ro9p14f1t3 Ro9p14f1n2 Ro9p14f1n3 1754.61195773614
Ro9p14f1t4 Ro9p14f1n3 o9p 1763.51785918762
* o9 input 15 w=-0.290577914446662 w-  bank=n alpha=1 R=114713.925856371 G_phys=8.71733743339986e-06 G_eff=8.71733743339986e-06
* tiled Ro9n15n1 series x4  each=28678.4814640928
Ro9n15n1t1 h15buf Ro9n15n1n1 28735.6689822826
Ro9n15n1t2 Ro9n15n1n1 Ro9n15n1n2 28704.4813257083
Ro9n15n1t3 Ro9n15n1n2 Ro9n15n1n3 28736.7572483268
Ro9n15n1t4 Ro9n15n1n3 o9n 28593.7425215646
* o9 input 16 w=-0.0531648681945055 w-  bank=n alpha=1 R=626980.456556052 G_phys=1.59494604583516e-06 G_eff=1.59494604583516e-06
* tiled Ro9n16n1 series x4  each=156745.114139013
Ro9n16n1t1 h16buf Ro9n16n1n1 157488.369028633
Ro9n16n1t2 Ro9n16n1n1 Ro9n16n1n2 156512.634766663
Ro9n16n1t3 Ro9n16n1n2 Ro9n16n1n3 157236.198369055
Ro9n16n1t4 Ro9n16n1n3 o9n 156996.520591454
* o9 input 17 w=+0.0157425177085947 w+  bank=f alpha=0.001 R=2117.40802521917 G_phys=0.000472275531257841 G_eff=4.72275531257841e-07
* tiled Ro9p17f1 parallel x4  each=8469.63210087668
Ro9p17f1t1 h17f o9p 8503.29516251193
Ro9p17f1t2 h17f o9p 8488.10683477359
Ro9p17f1t3 h17f o9p 8441.47253771619
Ro9p17f1t4 h17f o9p 8510.97536934361
* o9 input 18 w=-0.104777957691913 w-  bank=n alpha=1 R=318133.06985183 G_phys=3.14333873075738e-06 G_eff=3.14333873075738e-06
* tiled Ro9n18n1 series x4  each=79533.2674629575
Ro9n18n1t1 h18buf Ro9n18n1n1 79753.9823114284
Ro9n18n1t2 Ro9n18n1n1 Ro9n18n1n2 79551.8575778064
Ro9n18n1t3 Ro9n18n1n2 Ro9n18n1n3 79739.5860657688
Ro9n18n1t4 Ro9n18n1n3 o9n 79573.7473367469
* o9 input 19 w=-0.368259428743895 w-  bank=n alpha=1 R=90515.8992046201 G_phys=1.10477828623168e-05 G_eff=1.10477828623168e-05
* tiled Ro9n19n1 series x4  each=22628.974801155
Ro9n19n1t1 h19buf Ro9n19n1n1 22562.9366904526
Ro9n19n1t2 Ro9n19n1n1 Ro9n19n1n2 22680.2648377066
Ro9n19n1t3 Ro9n19n1n2 Ro9n19n1n3 22546.4595144311
Ro9n19n1t4 Ro9n19n1n3 o9n 22588.5848909935
* o9 input 20 w=+0.100989358745228 w+  bank=n alpha=1 R=330067.778897631 G_phys=3.02968076235683e-06 G_eff=3.02968076235683e-06
* tiled Ro9p20n1 series x4  each=82516.9447244078
Ro9p20n1t1 h20buf Ro9p20n1n1 82421.8380346303
Ro9p20n1t2 Ro9p20n1n1 Ro9p20n1n2 82774.6208628324
Ro9p20n1t3 Ro9p20n1n2 Ro9p20n1n3 82154.5972861031
Ro9p20n1t4 Ro9p20n1n3 o9p 82473.3434647141
* o9 input 21 w=+0.084258883556939 w+  bank=n alpha=1 R=395606.15956664 G_phys=2.52776650670817e-06 G_eff=2.52776650670817e-06
* tiled Ro9p21n1 series x4  each=98901.53989166
Ro9p21n1t1 h21buf Ro9p21n1n1 98511.221814933
Ro9p21n1t2 Ro9p21n1n1 Ro9p21n1n2 99329.6668477647
Ro9p21n1t3 Ro9p21n1n2 Ro9p21n1n3 98638.6327488633
Ro9p21n1t4 Ro9p21n1n3 o9p 98814.4095389064
* o9 input 22 w=+0.093068688723566 w+  bank=n alpha=1 R=358158.40741391 G_phys=2.79206066170698e-06 G_eff=2.79206066170698e-06
* tiled Ro9p22n1 series x4  each=89539.6018534776
Ro9p22n1t1 h22buf Ro9p22n1n1 89923.0941186553
Ro9p22n1t2 Ro9p22n1n1 Ro9p22n1n2 89336.0218836434
Ro9p22n1t3 Ro9p22n1n2 Ro9p22n1n3 89749.9593709833
Ro9p22n1t4 Ro9p22n1n3 o9p 89693.9673321513
* o9 input 23 w=+0.153137872499505 w+  bank=n alpha=1 R=217668.776438311 G_phys=4.59413617498515e-06 G_eff=4.59413617498515e-06
* tiled Ro9p23n1 series x4  each=54417.1941095778
Ro9p23n1t1 h23buf Ro9p23n1n1 54639.7915275321
Ro9p23n1t2 Ro9p23n1n1 Ro9p23n1n2 54248.9322810608
Ro9p23n1t3 Ro9p23n1n2 Ro9p23n1n3 54501.725179312
Ro9p23n1t4 Ro9p23n1n3 o9p 54295.9478397159
* o9 input 24 w=+0.0107021071757068 w+  bank=f alpha=0.001 R=3114.65142201137 G_phys=0.000321063215271205 G_eff=3.21063215271205e-07
* tiled Ro9p24f1 parallel x4  each=12458.6056880455
Ro9p24f1t1 h24f o9p 12505.1692244815
Ro9p24f1t2 h24f o9p 12493.8724075091
Ro9p24f1t3 h24f o9p 12457.3692624934
Ro9p24f1t4 h24f o9p 12432.9725941227
* o9 input 25 w=+0.151859492007221 w+  bank=n alpha=1 R=219501.151312611 G_phys=4.55578476021664e-06 G_eff=4.55578476021664e-06
* tiled Ro9p25n1 series x4  each=54875.2878281528
Ro9p25n1t1 h25buf Ro9p25n1n1 54697.9907961048
Ro9p25n1t2 Ro9p25n1n1 Ro9p25n1n2 54680.8235848406
Ro9p25n1t3 Ro9p25n1n2 Ro9p25n1n3 54851.6041683617
Ro9p25n1t4 Ro9p25n1n3 o9p 54806.2669761084
* o9 input 26 w=-0.0745603298060184 w-  bank=n alpha=1 R=447065.261380358 G_phys=2.23680989418055e-06 G_eff=2.23680989418055e-06
* tiled Ro9n26n1 series x4  each=111766.31534509
Ro9n26n1t1 h26buf Ro9n26n1n1 111264.92150994
Ro9n26n1t2 Ro9n26n1n1 Ro9n26n1n2 111918.483146859
Ro9n26n1t3 Ro9n26n1n2 Ro9n26n1n3 111770.917719713
Ro9n26n1t4 Ro9n26n1n3 o9n 111815.664353665
* o9 input 27 w=+0.475223780202243 w+  bank=n alpha=1 R=70142.3933775947 G_phys=1.42567134060673e-05 G_eff=1.42567134060673e-05
* tiled Ro9p27n1 series x4  each=17535.5983443987
Ro9p27n1t1 h27buf Ro9p27n1n1 17510.7131204307
Ro9p27n1t2 Ro9p27n1n1 Ro9p27n1n2 17582.1651802199
Ro9p27n1t3 Ro9p27n1n2 Ro9p27n1n3 17577.0959408393
Ro9p27n1t4 Ro9p27n1n3 o9p 17615.8495304747
* o9 input 28 w=+0.715956917954612 w+  bank=n alpha=1 R=46557.736223238 G_phys=2.14787075386384e-05 G_eff=2.14787075386384e-05
* tiled Ro9p28n1 series x4  each=11639.4340558095
Ro9p28n1t1 h28buf Ro9p28n1n1 11653.7550187562
Ro9p28n1t2 Ro9p28n1n1 Ro9p28n1n2 11594.9106193367
Ro9p28n1t3 Ro9p28n1n2 Ro9p28n1n3 11694.1793467234
Ro9p28n1t4 Ro9p28n1n3 o9p 11581.525044329
* o9 input 29 w=-0.520384445309866 w-  bank=n alpha=1 R=64055.2069412544 G_phys=1.5611533359296e-05 G_eff=1.5611533359296e-05
* tiled Ro9n29n1 series x4  each=16013.8017353136
Ro9n29n1t1 h29buf Ro9n29n1n1 16048.841676826
Ro9n29n1t2 Ro9n29n1n1 Ro9n29n1n2 15977.7811915636
Ro9n29n1t3 Ro9n29n1n2 Ro9n29n1n3 15950.3050082039
Ro9n29n1t4 Ro9n29n1n3 o9n 15979.0342737192
* o9 input 30 w=+0.217731604854565 w+  bank=n alpha=1 R=153093.683186685 G_phys=6.53194814563695e-06 G_eff=6.53194814563695e-06
* tiled Ro9p30n1 series x4  each=38273.4207966714
Ro9p30n1t1 h30buf Ro9p30n1n1 38380.4893516164
Ro9p30n1t2 Ro9p30n1n1 Ro9p30n1n2 38309.7122262707
Ro9p30n1t3 Ro9p30n1n2 Ro9p30n1n3 38243.9794722247
Ro9p30n1t4 Ro9p30n1n3 o9p 38103.0871962241
* o9 input 31 w=-0.123913004875871 w-  bank=n alpha=1 R=269005.931756111 G_phys=3.71739014627614e-06 G_eff=3.71739014627614e-06
* tiled Ro9n31n1 series x4  each=67251.4829390278
Ro9n31n1t1 h31buf Ro9n31n1n1 67466.7707756749
Ro9n31n1t2 Ro9n31n1n1 Ro9n31n1n2 67053.9720985551
Ro9n31n1t3 Ro9n31n1n2 Ro9n31n1n3 67354.1453500023
Ro9n31n1t4 Ro9n31n1n3 o9n 67288.5799833445
* o9 input 32 w=+0.0869405958454977 w+  bank=n alpha=1 R=383403.552841644 G_phys=2.60821787536493e-06 G_eff=2.60821787536493e-06
* tiled Ro9p32n1 series x4  each=95850.8882104111
Ro9p32n1t1 h32buf Ro9p32n1n1 95799.5580106269
Ro9p32n1t2 Ro9p32n1n1 Ro9p32n1n2 95566.7303343004
Ro9p32n1t3 Ro9p32n1n2 Ro9p32n1n3 95981.859766809
Ro9p32n1t4 Ro9p32n1n3 o9p 95793.2116988613
* o9 bias=-0.00785769582167887 b-  bank=f alpha=0.001 R=4242.12569305226 G_phys=0.000235730874650366 G_eff=2.35730874650366e-07
* tiled Ro9bnf1 series x4  each=1060.53142326307
Ro9bnf1t1 vreff Ro9bnf1n1 1057.15840340491
Ro9bnf1t2 Ro9bnf1n1 Ro9bnf1n2 1058.54513631336
Ro9bnf1t3 Ro9bnf1n2 Ro9bnf1n3 1059.51218097056
Ro9bnf1t4 Ro9bnf1n3 o9n 1055.30241944301
Vo9p o9p 0 DC 0
Vo9n o9n 0 DC 0
Fo9p 0 o9d Vo9p 1.001
Fo9n o9d 0 Vo9n 1.001
* ratiometric I-to-V: V = I * R_IV,  R_IV=33333.3333333333 (weight ~ R_IV / R_w)
* tiled Ro9iv series x4  each=8333.33333333333
Ro9ivt1 o9d Ro9ivn1 8329.53776322479
Ro9ivt2 Ro9ivn1 Ro9ivn2 8321.80231884176
Ro9ivt3 Ro9ivn2 Ro9ivn3 8335.49391340155
Ro9ivt4 Ro9ivn3 0 8356.21590791836
Bo9leak 0 o9d I = 1e-08
Eo9sc o9raw 0 o9d 0 1
Eo9lin o9lin 0 o9raw 0 1

* o10 input 1 w=-0.0381763956958746 w-  bank=n alpha=1 R=873139.874148344 G_phys=1.14529187087624e-06 G_eff=1.14529187087624e-06
* tiled Ro10n1n1 series x4  each=218284.968537086
Ro10n1n1t1 h1buf Ro10n1n1n1 218937.853923274
Ro10n1n1t2 Ro10n1n1n1 Ro10n1n1n2 219153.089657298
Ro10n1n1t3 Ro10n1n1n2 Ro10n1n1n3 218797.81783024
Ro10n1n1t4 Ro10n1n1n3 o10n 218442.50417327
* o10 input 2 w=+0.410781186996451 w+  bank=n alpha=1 R=81146.2023785947 G_phys=1.23234356098935e-05 G_eff=1.23234356098935e-05
* tiled Ro10p2n1 series x4  each=20286.5505946487
Ro10p2n1t1 h2buf Ro10p2n1n1 20289.1126712024
Ro10p2n1t2 Ro10p2n1n1 Ro10p2n1n2 20329.2946780037
Ro10p2n1t3 Ro10p2n1n2 Ro10p2n1n3 20348.8490250883
Ro10p2n1t4 Ro10p2n1n3 o10p 20341.8928263563
* o10 input 3 w=+0.475033421735393 w+  bank=n alpha=1 R=70170.5012913827 G_phys=1.42510026520618e-05 G_eff=1.42510026520618e-05
* tiled Ro10p3n1 series x4  each=17542.6253228457
Ro10p3n1t1 h3buf Ro10p3n1n1 17497.746420311
Ro10p3n1t2 Ro10p3n1n1 Ro10p3n1n2 17600.6514281504
Ro10p3n1t3 Ro10p3n1n2 Ro10p3n1n3 17563.3810281077
Ro10p3n1t4 Ro10p3n1n3 o10p 17471.0101871069
* o10 input 4 w=+0.0271427582394968 w+  bank=f alpha=0.001 R=1228.07465030685 G_phys=0.000814282747184905 G_eff=8.14282747184905e-07
* tiled Ro10p4f1 parallel x4  each=4912.29860122738
Ro10p4f1t1 h4f o10p 4907.68745405264
Ro10p4f1t2 h4f o10p 4889.0797321031
Ro10p4f1t3 h4f o10p 4923.04646573818
Ro10p4f1t4 h4f o10p 4897.49370925162
* o10 input 5 w=+0.0212799641995083 w+  bank=f alpha=0.001 R=1566.41867537087 G_phys=0.00063839892598525 G_eff=6.3839892598525e-07
* tiled Ro10p5f1 parallel x4  each=6265.67470148347
Ro10p5f1t1 h5f o10p 6273.81792833824
Ro10p5f1t2 h5f o10p 6245.45854406399
Ro10p5f1t3 h5f o10p 6270.81816033874
Ro10p5f1t4 h5f o10p 6293.65343832947
* o10 input 6 w=+0.0201273268189427 w+  bank=f alpha=0.001 R=1656.12322158758 G_phys=0.00060381980456828 G_eff=6.0381980456828e-07
* tiled Ro10p6f1 parallel x4  each=6624.49288635031
Ro10p6f1t1 h6f o10p 6642.98911328538
Ro10p6f1t2 h6f o10p 6612.70808621325
Ro10p6f1t3 h6f o10p 6630.57200508318
Ro10p6f1t4 h6f o10p 6606.61674954153
* o10 input 7 w=-0.036291550108304 w-  bank=n alpha=1 R=918487.450490747 G_phys=1.08874650324912e-06 G_eff=1.08874650324912e-06
* tiled Ro10n7n1 series x4  each=229621.862622687
Ro10n7n1t1 h7buf Ro10n7n1n1 229989.506538611
Ro10n7n1t2 Ro10n7n1n1 Ro10n7n1n2 229361.141718709
Ro10n7n1t3 Ro10n7n1n2 Ro10n7n1n3 230348.138365014
Ro10n7n1t4 Ro10n7n1n3 o10n 229019.77716577
* o10 input 8 w=+0.0509688710938526 w+  bank=n alpha=1 R=653993.949992621 G_phys=1.52906613281558e-06 G_eff=1.52906613281558e-06
* tiled Ro10p8n1 series x4  each=163498.487498155
Ro10p8n1t1 h8buf Ro10p8n1n1 162928.413942049
Ro10p8n1t2 Ro10p8n1n1 Ro10p8n1n2 162976.43136972
Ro10p8n1t3 Ro10p8n1n2 Ro10p8n1n3 163106.166198714
Ro10p8n1t4 Ro10p8n1n3 o10p 163393.440127858
* o10 input 9 w=-0.135969386219015 w-  bank=n alpha=1 R=245153.223532546 G_phys=4.07908158657046e-06 G_eff=4.07908158657046e-06
* tiled Ro10n9n1 series x4  each=61288.3058831365
Ro10n9n1t1 h9buf Ro10n9n1n1 61290.2054455551
Ro10n9n1t2 Ro10n9n1n1 Ro10n9n1n2 61294.4258857561
Ro10n9n1t3 Ro10n9n1n2 Ro10n9n1n3 61086.9339025992
Ro10n9n1t4 Ro10n9n1n3 o10n 61064.7566784393
* o10 input 10 w=+0.542965243347564 w+  bank=n alpha=1 R=61391.2837731971 G_phys=1.62889573004269e-05 G_eff=1.62889573004269e-05
* tiled Ro10p10n1 series x4  each=15347.8209432993
Ro10p10n1t1 h10buf Ro10p10n1n1 15277.4503799204
Ro10p10n1t2 Ro10p10n1n1 Ro10p10n1n2 15337.1839276394
Ro10p10n1t3 Ro10p10n1n2 Ro10p10n1n3 15418.6492609392
Ro10p10n1t4 Ro10p10n1n3 o10p 15376.7711484334
* o10 input 11 w=+0.200790198383509 w+  bank=n alpha=1 R=166010.759497666 G_phys=6.02370595150528e-06 G_eff=6.02370595150528e-06
* tiled Ro10p11n1 series x4  each=41502.6898744164
Ro10p11n1t1 h11buf Ro10p11n1n1 41690.4974113239
Ro10p11n1t2 Ro10p11n1n1 Ro10p11n1n2 41516.245259534
Ro10p11n1t3 Ro10p11n1n2 Ro10p11n1n3 41326.351154374
Ro10p11n1t4 Ro10p11n1n3 o10p 41390.429266082
* o10 input 12 w=-0.0602452386161185 w-  bank=n alpha=1 R=553294.071017507 G_phys=1.80735715848356e-06 G_eff=1.80735715848356e-06
* tiled Ro10n12n1 series x4  each=138323.517754377
Ro10n12n1t1 h12buf Ro10n12n1n1 138704.087464225
Ro10n12n1t2 Ro10n12n1n1 Ro10n12n1n2 138435.962770341
Ro10n12n1t3 Ro10n12n1n2 Ro10n12n1n3 137958.771119817
Ro10n12n1t4 Ro10n12n1n3 o10n 138614.759800132
* o10 input 13 w=-0.18784742953156 w-  bank=n alpha=1 R=177448.972373258 G_phys=5.6354228859468e-06 G_eff=5.6354228859468e-06
* tiled Ro10n13n1 series x4  each=44362.2430933145
Ro10n13n1t1 h13buf Ro10n13n1n1 44231.2342500224
Ro10n13n1t2 Ro10n13n1n1 Ro10n13n1n2 44412.9234645721
Ro10n13n1t3 Ro10n13n1n2 Ro10n13n1n3 44573.1135774053
Ro10n13n1t4 Ro10n13n1n3 o10n 44490.4975932527
* o10 input 14 w=-0.0121063802780956 w-  bank=f alpha=0.001 R=2753.36909692523 G_phys=0.000363191408342867 G_eff=3.63191408342867e-07
* tiled Ro10n14f1 parallel x4  each=11013.4763877009
Ro10n14f1t1 h14f o10n 10991.8696051608
Ro10n14f1t2 h14f o10n 10975.4722072103
Ro10n14f1t3 h14f o10n 11058.863200481
Ro10n14f1t4 h14f o10n 10976.109556022
* o10 input 15 w=+0.162912924713055 w+  bank=n alpha=1 R=204608.280110646 G_phys=4.88738774139165e-06 G_eff=4.88738774139165e-06
* tiled Ro10p15n1 series x4  each=51152.0700276614
Ro10p15n1t1 h15buf Ro10p15n1n1 51164.7570297269
Ro10p15n1t2 Ro10p15n1n1 Ro10p15n1n2 51308.4704708734
Ro10p15n1t3 Ro10p15n1n2 Ro10p15n1n3 51287.9472704985
Ro10p15n1t4 Ro10p15n1n3 o10p 51054.3753704518
* o10 input 16 w=+0.000496602144198326 w+  bank=f alpha=0.001 R=67122.8139522916 G_phys=1.48980643259498e-05 G_eff=1.48980643259498e-08
* tiled Ro10p16f1 series x4  each=16780.7034880729
Ro10p16f1t1 h16f Ro10p16f1n1 16774.2192886996
Ro10p16f1t2 Ro10p16f1n1 Ro10p16f1n2 16846.0815371669
Ro10p16f1t3 Ro10p16f1n2 Ro10p16f1n3 16738.9402644695
Ro10p16f1t4 Ro10p16f1n3 o10p 16747.8756955426
* o10 input 17 w=+0.150471984074884 w+  bank=n alpha=1 R=221525.179841748 G_phys=4.51415952224652e-06 G_eff=4.51415952224652e-06
* tiled Ro10p17n1 series x4  each=55381.294960437
Ro10p17n1t1 h17buf Ro10p17n1n1 55153.3428126542
Ro10p17n1t2 Ro10p17n1n1 Ro10p17n1n2 55198.1821379786
Ro10p17n1t3 Ro10p17n1n2 Ro10p17n1n3 55343.9679425917
Ro10p17n1t4 Ro10p17n1n3 o10p 55385.4654293589
* o10 input 18 w=-0.0993574349593851 w-  bank=n alpha=1 R=335489.068804556 G_phys=2.98072304878155e-06 G_eff=2.98072304878155e-06
* tiled Ro10n18n1 series x4  each=83872.267201139
Ro10n18n1t1 h18buf Ro10n18n1n1 83751.3775784107
Ro10n18n1t2 Ro10n18n1n1 Ro10n18n1n2 83645.4104277985
Ro10n18n1t3 Ro10n18n1n2 Ro10n18n1n3 84094.4623655148
Ro10n18n1t4 Ro10n18n1n3 o10n 84241.2372290512
* o10 input 19 w=-0.0430450321763909 w-  bank=n alpha=1 R=774382.818364248 G_phys=1.29135096529173e-06 G_eff=1.29135096529173e-06
* tiled Ro10n19n1 series x4  each=193595.704591062
Ro10n19n1t1 h19buf Ro10n19n1n1 194198.04885227
Ro10n19n1t2 Ro10n19n1n1 Ro10n19n1n2 193380.477968238
Ro10n19n1t3 Ro10n19n1n2 Ro10n19n1n3 193132.595293624
Ro10n19n1t4 Ro10n19n1n3 o10n 193626.381004986
* o10 input 20 w=-0.498578232263262 w-  bank=n alpha=1 R=66856.7762816658 G_phys=1.49573469678979e-05 G_eff=1.49573469678979e-05
* tiled Ro10n20n1 series x4  each=16714.1940704164
Ro10n20n1t1 h20buf Ro10n20n1n1 16693.1547302974
Ro10n20n1t2 Ro10n20n1n1 Ro10n20n1n2 16791.9492436595
Ro10n20n1t3 Ro10n20n1n2 Ro10n20n1n3 16786.3073656161
Ro10n20n1t4 Ro10n20n1n3 o10n 16636.8046674061
* o10 input 21 w=-0.135185117923925 w-  bank=n alpha=1 R=246575.465149141 G_phys=4.05555353771776e-06 G_eff=4.05555353771776e-06
* tiled Ro10n21n1 series x4  each=61643.8662872852
Ro10n21n1t1 h21buf Ro10n21n1n1 61820.6415816176
Ro10n21n1t2 Ro10n21n1n1 Ro10n21n1n2 61526.3986765304
Ro10n21n1t3 Ro10n21n1n2 Ro10n21n1n3 61389.3354190177
Ro10n21n1t4 Ro10n21n1n3 o10n 61757.1740527655
* o10 input 22 w=+0.00794231626553338 w+  bank=f alpha=0.001 R=4196.92848016985 G_phys=0.000238269487966002 G_eff=2.38269487966002e-07
* tiled Ro10p22f1 series x4  each=1049.23212004246
Ro10p22f1t1 h22f Ro10p22f1n1 1051.36295922929
Ro10p22f1t2 Ro10p22f1n1 Ro10p22f1n2 1049.4550216974
Ro10p22f1t3 Ro10p22f1n2 Ro10p22f1n3 1045.1584573625
Ro10p22f1t4 Ro10p22f1n3 o10p 1053.71742080526
* o10 input 23 w=-0.411689837989046 w-  bank=n alpha=1 R=80967.1025550556 G_phys=1.23506951396714e-05 G_eff=1.23506951396714e-05
* tiled Ro10n23n1 series x4  each=20241.7756387639
Ro10n23n1t1 h23buf Ro10n23n1n1 20145.8502549552
Ro10n23n1t2 Ro10n23n1n1 Ro10n23n1n2 20233.9225037224
Ro10n23n1t3 Ro10n23n1n2 Ro10n23n1n3 20325.9114690261
Ro10n23n1t4 Ro10n23n1n3 o10n 20190.7846316869
* o10 input 24 w=+0.321047972853849 w+  bank=n alpha=1 R=103826.643217921 G_phys=9.63143918561547e-06 G_eff=9.63143918561547e-06
* tiled Ro10p24n1 series x4  each=25956.6608044802
Ro10p24n1t1 h24buf Ro10p24n1n1 25946.9125009265
Ro10p24n1t2 Ro10p24n1n1 Ro10p24n1n2 25966.0718591209
Ro10p24n1t3 Ro10p24n1n2 Ro10p24n1n3 25977.8906168508
Ro10p24n1t4 Ro10p24n1n3 o10p 26067.7355860326
* o10 input 25 w=-0.130972309748016 w-  bank=n alpha=1 R=254506.722813891 G_phys=3.92916929244047e-06 G_eff=3.92916929244047e-06
* tiled Ro10n25n1 series x4  each=63626.6807034727
Ro10n25n1t1 h25buf Ro10n25n1n1 63567.2934386839
Ro10n25n1t2 Ro10n25n1n1 Ro10n25n1n2 63598.9695494884
Ro10n25n1t3 Ro10n25n1n2 Ro10n25n1n3 63777.4495514513
Ro10n25n1t4 Ro10n25n1n3 o10n 63823.5784911652
* o10 input 26 w=+0.0365278526067883 w+  bank=n alpha=1 R=912545.659120916 G_phys=1.09583557820365e-06 G_eff=1.09583557820365e-06
* tiled Ro10p26n1 series x4  each=228136.414780229
Ro10p26n1t1 h26buf Ro10p26n1n1 228490.161607924
Ro10p26n1t2 Ro10p26n1n1 Ro10p26n1n2 228777.543165461
Ro10p26n1t3 Ro10p26n1n2 Ro10p26n1n3 227541.203601054
Ro10p26n1t4 Ro10p26n1n3 o10p 227230.078034545
* o10 input 27 w=-0.205674584301975 w-  bank=n alpha=1 R=162068.315083563 G_phys=6.17023752905924e-06 G_eff=6.17023752905924e-06
* tiled Ro10n27n1 series x4  each=40517.0787708908
Ro10n27n1t1 h27buf Ro10n27n1n1 40370.4128225334
Ro10n27n1t2 Ro10n27n1n1 Ro10n27n1n2 40660.7803596029
Ro10n27n1t3 Ro10n27n1n2 Ro10n27n1n3 40401.6648654041
Ro10n27n1t4 Ro10n27n1n3 o10n 40712.6065879106
* o10 input 28 w=-0.0123163999797875 w-  bank=f alpha=0.001 R=2706.41854665624 G_phys=0.000369491999393624 G_eff=3.69491999393624e-07
* tiled Ro10n28f1 parallel x4  each=10825.674186625
Ro10n28f1t1 h28f o10n 10794.836010926
Ro10n28f1t2 h28f o10n 10792.6851766527
Ro10n28f1t3 h28f o10n 10827.1338805941
Ro10n28f1t4 h28f o10n 10844.940501454
* o10 input 29 w=-0.120487475126756 w-  bank=n alpha=1 R=276653.928537102 G_phys=3.61462425380267e-06 G_eff=3.61462425380267e-06
* tiled Ro10n29n1 series x4  each=69163.4821342756
Ro10n29n1t1 h29buf Ro10n29n1n1 69494.1050683173
Ro10n29n1t2 Ro10n29n1n1 Ro10n29n1n2 69406.9332032292
Ro10n29n1t3 Ro10n29n1n2 Ro10n29n1n3 68912.3029030828
Ro10n29n1t4 Ro10n29n1n3 o10n 69255.4376285408
* o10 input 30 w=-0.421650115672696 w-  bank=n alpha=1 R=79054.486396034 G_phys=1.26495034701809e-05 G_eff=1.26495034701809e-05
* tiled Ro10n30n1 series x4  each=19763.6215990085
Ro10n30n1t1 h30buf Ro10n30n1n1 19690.8637816337
Ro10n30n1t2 Ro10n30n1n1 Ro10n30n1n2 19760.1447116104
Ro10n30n1t3 Ro10n30n1n2 Ro10n30n1n3 19768.979162286
Ro10n30n1t4 Ro10n30n1n3 o10n 19712.994363687
* o10 input 31 w=+0.15176529701113 w+  bank=n alpha=1 R=219637.387398838 G_phys=4.55295891033391e-06 G_eff=4.55295891033391e-06
* tiled Ro10p31n1 series x4  each=54909.3468497095
Ro10p31n1t1 h31buf Ro10p31n1n1 54720.0742419509
Ro10p31n1t2 Ro10p31n1n1 Ro10p31n1n2 54846.6072512249
Ro10p31n1t3 Ro10p31n1n2 Ro10p31n1n3 54653.3921763535
Ro10p31n1t4 Ro10p31n1n3 o10p 54824.2330763174
* o10 input 32 w=+0.00307524765960727 w+  bank=f alpha=0.001 R=10839.2354122107 G_phys=9.22574297882182e-05 G_eff=9.22574297882182e-08
* tiled Ro10p32f1 series x4  each=2709.80885305268
Ro10p32f1t1 h32f Ro10p32f1n1 2721.45679478508
Ro10p32f1t2 Ro10p32f1n1 Ro10p32f1n2 2713.79519202249
Ro10p32f1t3 Ro10p32f1n2 Ro10p32f1n3 2714.65037251998
Ro10p32f1t4 Ro10p32f1n3 o10p 2705.98609153
* o10 bias=-0.031263579434271 b-  bank=f alpha=0.001 R=1066.20335663783 G_phys=0.000937907383028131 G_eff=9.37907383028131e-07
* tiled Ro10bnf1 parallel x4  each=4264.81342655134
Ro10bnf1t1 vreff o10n 4281.71364538679
Ro10bnf1t2 vreff o10n 4270.16497092309
Ro10bnf1t3 vreff o10n 4274.08496196211
Ro10bnf1t4 vreff o10n 4261.31604163735
Vo10p o10p 0 DC 0
Vo10n o10n 0 DC 0
Fo10p 0 o10d Vo10p 1.001
Fo10n o10d 0 Vo10n 1.001
* ratiometric I-to-V: V = I * R_IV,  R_IV=33333.3333333333 (weight ~ R_IV / R_w)
* tiled Ro10iv series x4  each=8333.33333333333
Ro10ivt1 o10d Ro10ivn1 8355.24591131285
Ro10ivt2 Ro10ivn1 Ro10ivn2 8350.97783155852
Ro10ivt3 Ro10ivn2 Ro10ivn3 8348.44204513857
Ro10ivt4 Ro10ivn3 0 8333.27117639912
Bo10leak 0 o10d I = 1e-08
Eo10sc o10raw 0 o10d 0 1
Eo10lin o10lin 0 o10raw 0 1

* o11 input 1 w=-0.160102279955593 w-  bank=n alpha=1 R=208200.241386812 G_phys=4.80306839866778e-06 G_eff=4.80306839866778e-06
* tiled Ro11n1n1 series x4  each=52050.060346703
Ro11n1n1t1 h1buf Ro11n1n1n1 51941.4779747745
Ro11n1n1t2 Ro11n1n1n1 Ro11n1n1n2 52029.4946379714
Ro11n1n1t3 Ro11n1n1n2 Ro11n1n1n3 51942.1795367951
Ro11n1n1t4 Ro11n1n1n3 o11n 52036.3025974646
* o11 input 2 w=+0.011469223690656 w+  bank=f alpha=0.001 R=2906.32864371544 G_phys=0.00034407671071968 G_eff=3.4407671071968e-07
* tiled Ro11p2f1 parallel x4  each=11625.3145748618
Ro11p2f1t1 h2f o11p 11683.1367184748
Ro11p2f1t2 h2f o11p 11592.173502903
Ro11p2f1t3 h2f o11p 11661.0585258771
Ro11p2f1t4 h2f o11p 11659.6661159688
* o11 input 3 w=+0.0176041755498141 w+  bank=f alpha=0.001 R=1893.49016879608 G_phys=0.000528125266494424 G_eff=5.28125266494424e-07
* tiled Ro11p3f1 parallel x4  each=7573.9606751843
Ro11p3f1t1 h3f o11p 7565.59642570889
Ro11p3f1t2 h3f o11p 7604.15687069633
Ro11p3f1t3 h3f o11p 7576.98324082837
Ro11p3f1t4 h3f o11p 7584.50607181034
* o11 input 4 w=-0.0193710750418404 w-  bank=f alpha=0.001 R=1720.77870027013 G_phys=0.000581132251255212 G_eff=5.81132251255212e-07
* tiled Ro11n4f1 parallel x4  each=6883.11480108053
Ro11n4f1t1 h4f o11n 6876.16513051075
Ro11n4f1t2 h4f o11n 6900.53809178042
Ro11n4f1t3 h4f o11n 6853.19336734483
Ro11n4f1t4 h4f o11n 6905.38587920052
* o11 input 5 w=+0.112602634979867 w+  bank=n alpha=1 R=296026.228331984 G_phys=3.37807904939602e-06 G_eff=3.37807904939602e-06
* tiled Ro11p5n1 series x4  each=74006.5570829961
Ro11p5n1t1 h5buf Ro11p5n1n1 73766.3027028789
Ro11p5n1t2 Ro11p5n1n1 Ro11p5n1n2 73936.9427324749
Ro11p5n1t3 Ro11p5n1n2 Ro11p5n1n3 74020.8612184356
Ro11p5n1t4 Ro11p5n1n3 o11p 73983.693788043
* o11 input 6 w=+0.00163262396170036 w+  bank=f alpha=0.001 R=20417.0305687643 G_phys=4.89787188510109e-05 G_eff=4.89787188510109e-08
* tiled Ro11p6f1 series x4  each=5104.25764219107
Ro11p6f1t1 h6f Ro11p6f1n1 5104.07136889234
Ro11p6f1t2 Ro11p6f1n1 Ro11p6f1n2 5097.66157268914
Ro11p6f1t3 Ro11p6f1n2 Ro11p6f1n3 5126.70895667282
Ro11p6f1t4 Ro11p6f1n3 o11p 5126.16074247237
* o11 input 7 w=-0.0344149127536822 w-  bank=n alpha=1 R=968572.361984759 G_phys=1.03244738261047e-06 G_eff=1.03244738261047e-06
* tiled Ro11n7n1 series x4  each=242143.09049619
Ro11n7n1t1 h7buf Ro11n7n1n1 241054.306900878
Ro11n7n1t2 Ro11n7n1n1 Ro11n7n1n2 241219.980261166
Ro11n7n1t3 Ro11n7n1n2 Ro11n7n1n3 241244.581904148
Ro11n7n1t4 Ro11n7n1n3 o11n 241762.330844662
* o11 input 8 w=+0.0140339587694358 w+  bank=f alpha=0.001 R=2375.19105485255 G_phys=0.000421018763083073 G_eff=4.21018763083073e-07
* tiled Ro11p8f1 parallel x4  each=9500.7642194102
Ro11p8f1t1 h8f o11p 9486.8863259589
Ro11p8f1t2 h8f o11p 9546.70105112045
Ro11p8f1t3 h8f o11p 9526.85700208718
Ro11p8f1t4 h8f o11p 9536.90910189358
* o11 input 9 w=+0.200472625000294 w+  bank=n alpha=1 R=166273.741032146 G_phys=6.01417875000882e-06 G_eff=6.01417875000882e-06
* tiled Ro11p9n1 series x4  each=41568.4352580364
Ro11p9n1t1 h9buf Ro11p9n1n1 41502.3461931654
Ro11p9n1t2 Ro11p9n1n1 Ro11p9n1n2 41460.3765097381
Ro11p9n1t3 Ro11p9n1n2 Ro11p9n1n3 41474.0284844273
Ro11p9n1t4 Ro11p9n1n3 o11p 41390.1593235513
* o11 input 10 w=+0.127220756971711 w+  bank=n alpha=1 R=262011.751280064 G_phys=3.81662270915132e-06 G_eff=3.81662270915132e-06
* tiled Ro11p10n1 series x4  each=65502.937820016
Ro11p10n1t1 h10buf Ro11p10n1n1 65346.2651701685
Ro11p10n1t2 Ro11p10n1n1 Ro11p10n1n2 65794.0208035537
Ro11p10n1t3 Ro11p10n1n2 Ro11p10n1n3 65439.0805104532
Ro11p10n1t4 Ro11p10n1n3 o11p 65469.4672170218
* o11 input 11 w=-0.215899699488286 w-  bank=n alpha=1 R=154392.680547209 G_phys=6.47699098464857e-06 G_eff=6.47699098464857e-06
* tiled Ro11n11n1 series x4  each=38598.1701368023
Ro11n11n1t1 h11buf Ro11n11n1n1 38748.5361398749
Ro11n11n1t2 Ro11n11n1n1 Ro11n11n1n2 38419.3851851239
Ro11n11n1t3 Ro11n11n1n2 Ro11n11n1n3 38632.252702378
Ro11n11n1t4 Ro11n11n1n3 o11n 38734.3834662062
* o11 input 12 w=-0.0276713436872213 w-  bank=f alpha=0.001 R=1204.61563811687 G_phys=0.000830140310616638 G_eff=8.30140310616639e-07
* tiled Ro11n12f1 parallel x4  each=4818.46255246749
Ro11n12f1t1 h12f o11n 4810.02195689663
Ro11n12f1t2 h12f o11n 4810.64895094928
Ro11n12f1t3 h12f o11n 4833.36047124502
Ro11n12f1t4 h12f o11n 4813.72763076394
* o11 input 13 w=+0.188664634231365 w+  bank=n alpha=1 R=176680.34854087 G_phys=5.65993902694096e-06 G_eff=5.65993902694096e-06
* tiled Ro11p13n1 series x4  each=44170.0871352174
Ro11p13n1t1 h13buf Ro11p13n1n1 44247.55947951
Ro11p13n1t2 Ro11p13n1n1 Ro11p13n1n2 43977.2253293227
Ro11p13n1t3 Ro11p13n1n2 Ro11p13n1n3 44097.1874596879
Ro11p13n1t4 Ro11p13n1n3 o11p 44373.2028592376
* o11 input 14 w=-0.119078372545684 w-  bank=n alpha=1 R=279927.686453265 G_phys=3.57235117637052e-06 G_eff=3.57235117637052e-06
* tiled Ro11n14n1 series x4  each=69981.9216133163
Ro11n14n1t1 h14buf Ro11n14n1n1 69718.3301224486
Ro11n14n1t2 Ro11n14n1n1 Ro11n14n1n2 69673.7916728556
Ro11n14n1t3 Ro11n14n1n2 Ro11n14n1n3 69802.4483139342
Ro11n14n1t4 Ro11n14n1n3 o11n 70118.3009172947
* o11 input 15 w=+0.15422975355602 w+  bank=n alpha=1 R=216127.774082359 G_phys=4.6268926066806e-06 G_eff=4.6268926066806e-06
* tiled Ro11p15n1 series x4  each=54031.9435205897
Ro11p15n1t1 h15buf Ro11p15n1n1 53783.3271944865
Ro11p15n1t2 Ro11p15n1n1 Ro11p15n1n2 53925.6110049205
Ro11p15n1t3 Ro11p15n1n2 Ro11p15n1n3 53988.8416715688
Ro11p15n1t4 Ro11p15n1n3 o11p 54107.983793258
* o11 input 16 w=-0.104607206722078 w-  bank=n alpha=1 R=318652.360366468 G_phys=3.13821620166235e-06 G_eff=3.13821620166235e-06
* tiled Ro11n16n1 series x4  each=79663.0900916171
Ro11n16n1t1 h16buf Ro11n16n1n1 79779.6869508514
Ro11n16n1t2 Ro11n16n1n1 Ro11n16n1n2 79559.3927100172
Ro11n16n1t3 Ro11n16n1n2 Ro11n16n1n3 79346.1076996353
Ro11n16n1t4 Ro11n16n1n3 o11n 79673.6897942003
* o11 input 17 w=+0.106639727219858 w+  bank=n alpha=1 R=312578.944098482 G_phys=3.19919181659573e-06 G_eff=3.19919181659573e-06
* tiled Ro11p17n1 series x4  each=78144.7360246206
Ro11p17n1t1 h17buf Ro11p17n1n1 77797.3490839425
Ro11p17n1t2 Ro11p17n1n1 Ro11p17n1n2 77758.0923896299
Ro11p17n1t3 Ro11p17n1n2 Ro11p17n1n3 77935.0669653206
Ro11p17n1t4 Ro11p17n1n3 o11p 78131.9079117127
* o11 input 18 w=+0.310905721051453 w+  bank=n alpha=1 R=107213.637692492 G_phys=9.32717163154358e-06 G_eff=9.32717163154358e-06
* tiled Ro11p18n1 series x4  each=26803.4094231229
Ro11p18n1t1 h18buf Ro11p18n1n1 26743.4815444371
Ro11p18n1t2 Ro11p18n1n1 Ro11p18n1n2 26872.3017864078
Ro11p18n1t3 Ro11p18n1n2 Ro11p18n1n3 26935.5513116038
Ro11p18n1t4 Ro11p18n1n3 o11p 26729.1445561677
* o11 input 19 w=+0.210141672521531 w+  bank=n alpha=1 R=158623.146629415 G_phys=6.30425017564592e-06 G_eff=6.30425017564592e-06
* tiled Ro11p19n1 series x4  each=39655.7866573538
Ro11p19n1t1 h19buf Ro11p19n1n1 39744.0739312793
Ro11p19n1t2 Ro11p19n1n1 Ro11p19n1n2 39783.6313176643
Ro11p19n1t3 Ro11p19n1n2 Ro11p19n1n3 39576.4592746684
Ro11p19n1t4 Ro11p19n1n3 o11p 39824.3059927951
* o11 input 20 w=+0.009349861892821 w+  bank=f alpha=0.001 R=3565.11504826903 G_phys=0.00028049585678463 G_eff=2.8049585678463e-07
* tiled Ro11p20f1 parallel x4  each=14260.4601930761
Ro11p20f1t1 h20f o11p 14211.0015021218
Ro11p20f1t2 h20f o11p 14252.0766283012
Ro11p20f1t3 h20f o11p 14319.5811174721
Ro11p20f1t4 h20f o11p 14257.0709414233
* o11 input 21 w=-0.148461029214851 w-  bank=n alpha=1 R=224525.81333714 G_phys=4.45383087644554e-06 G_eff=4.45383087644554e-06
* tiled Ro11n21n1 series x4  each=56131.4533342849
Ro11n21n1t1 h21buf Ro11n21n1n1 56373.717619779
Ro11n21n1t2 Ro11n21n1n1 Ro11n21n1n2 56096.9080219074
Ro11n21n1t3 Ro11n21n1n2 Ro11n21n1n3 56038.494727553
Ro11n21n1t4 Ro11n21n1n3 o11n 55966.1376236759
* o11 input 22 w=-0.118671866129314 w-  bank=n alpha=1 R=280886.56916384 G_phys=3.56015598387941e-06 G_eff=3.56015598387941e-06
* tiled Ro11n22n1 series x4  each=70221.6422909599
Ro11n22n1t1 h22buf Ro11n22n1n1 70042.193495403
Ro11n22n1t2 Ro11n22n1n1 Ro11n22n1n2 70450.4818503751
Ro11n22n1t3 Ro11n22n1n2 Ro11n22n1n3 70404.7792687106
Ro11n22n1t4 Ro11n22n1n3 o11n 70066.0892646283
* o11 input 23 w=-0.109207143921327 w-  bank=n alpha=1 R=305230.336921427 G_phys=3.2762143176398e-06 G_eff=3.2762143176398e-06
* tiled Ro11n23n1 series x4  each=76307.5842303568
Ro11n23n1t1 h23buf Ro11n23n1n1 76600.5792641109
Ro11n23n1t2 Ro11n23n1n1 Ro11n23n1n2 76643.1799640653
Ro11n23n1t3 Ro11n23n1n2 Ro11n23n1n3 76612.4132074282
Ro11n23n1t4 Ro11n23n1n3 o11n 76408.0958409818
* o11 input 24 w=-0.0902417819363344 w-  bank=n alpha=1 R=369378.048816124 G_phys=2.70725345809003e-06 G_eff=2.70725345809003e-06
* tiled Ro11n24n1 series x4  each=92344.512204031
Ro11n24n1t1 h24buf Ro11n24n1n1 91991.2747393743
Ro11n24n1t2 Ro11n24n1n1 Ro11n24n1n2 92786.468154741
Ro11n24n1t3 Ro11n24n1n2 Ro11n24n1n3 92291.3732449588
Ro11n24n1t4 Ro11n24n1n3 o11n 91978.3839517375
* o11 input 25 w=+0.314745464583241 w+  bank=n alpha=1 R=105905.68279505 G_phys=9.44236393749723e-06 G_eff=9.44236393749723e-06
* tiled Ro11p25n1 series x4  each=26476.4206987625
Ro11p25n1t1 h25buf Ro11p25n1n1 26414.7781726261
Ro11p25n1t2 Ro11p25n1n1 Ro11p25n1n2 26535.6829741148
Ro11p25n1t3 Ro11p25n1n2 Ro11p25n1n3 26520.9098468253
Ro11p25n1t4 Ro11p25n1n3 o11p 26503.2766687437
* o11 input 26 w=+0.0956381358816812 w+  bank=n alpha=1 R=348536.000059346 G_phys=2.86914407645044e-06 G_eff=2.86914407645044e-06
* tiled Ro11p26n1 series x4  each=87134.0000148364
Ro11p26n1t1 h26buf Ro11p26n1n1 87052.1524846174
Ro11p26n1t2 Ro11p26n1n1 Ro11p26n1n2 86820.9567211928
Ro11p26n1t3 Ro11p26n1n2 Ro11p26n1n3 86717.795394225
Ro11p26n1t4 Ro11p26n1n3 o11p 86931.7721870872
* o11 input 27 w=-0.150311342322866 w-  bank=n alpha=1 R=221761.929726726 G_phys=4.50934026968598e-06 G_eff=4.50934026968598e-06
* tiled Ro11n27n1 series x4  each=55440.4824316816
Ro11n27n1t1 h27buf Ro11n27n1n1 55699.8817911692
Ro11n27n1t2 Ro11n27n1n1 Ro11n27n1n2 55643.9540259771
Ro11n27n1t3 Ro11n27n1n2 Ro11n27n1n3 55469.8731275733
Ro11n27n1t4 Ro11n27n1n3 o11n 55580.5196739571
* o11 input 28 w=-0.0832874521070705 w-  bank=n alpha=1 R=400220.351205864 G_phys=2.49862356321211e-06 G_eff=2.49862356321211e-06
* tiled Ro11n28n1 series x4  each=100055.087801466
Ro11n28n1t1 h28buf Ro11n28n1n1 99803.5242642198
Ro11n28n1t2 Ro11n28n1n1 Ro11n28n1n2 100200.555549206
Ro11n28n1t3 Ro11n28n1n2 Ro11n28n1n3 100278.953013036
Ro11n28n1t4 Ro11n28n1n3 o11n 99637.3386270205
* o11 input 29 w=+0.0404370827831914 w+  bank=n alpha=1 R=824325.86722574 G_phys=1.21311248349574e-06 G_eff=1.21311248349574e-06
* tiled Ro11p29n1 series x4  each=206081.466806435
Ro11p29n1t1 h29buf Ro11p29n1n1 206870.374077956
Ro11p29n1t2 Ro11p29n1n1 Ro11p29n1n2 205261.872713575
Ro11p29n1t3 Ro11p29n1n2 Ro11p29n1n3 205608.659618859
Ro11p29n1t4 Ro11p29n1n3 o11p 207027.804255858
* o11 input 30 w=-0.0722629324126473 w-  bank=n alpha=1 R=461278.448305807 G_phys=2.16788797237942e-06 G_eff=2.16788797237942e-06
* tiled Ro11n30n1 series x4  each=115319.612076452
Ro11n30n1t1 h30buf Ro11n30n1n1 115254.017447335
Ro11n30n1t2 Ro11n30n1n1 Ro11n30n1n2 115280.558960619
Ro11n30n1t3 Ro11n30n1n2 Ro11n30n1n3 115470.223212683
Ro11n30n1t4 Ro11n30n1n3 o11n 115134.027985345
* o11 input 31 w=-0.0830409064130833 w-  bank=n alpha=1 R=401408.592140338 G_phys=2.4912271923925e-06 G_eff=2.4912271923925e-06
* tiled Ro11n31n1 series x4  each=100352.148035084
Ro11n31n1t1 h31buf Ro11n31n1n1 100727.308039363
Ro11n31n1t2 Ro11n31n1n1 Ro11n31n1n2 100389.597596697
Ro11n31n1t3 Ro11n31n1n2 Ro11n31n1n3 100605.275279791
Ro11n31n1t4 Ro11n31n1n3 o11n 100773.982676584
* o11 input 32 w=-0.390143512242536 w-  bank=n alpha=1 R=85438.6457479045 G_phys=1.17043053672761e-05 G_eff=1.17043053672761e-05
* tiled Ro11n32n1 series x4  each=21359.6614369761
Ro11n32n1t1 h32buf Ro11n32n1n1 21411.0500238142
Ro11n32n1t2 Ro11n32n1n1 Ro11n32n1n2 21278.7379910778
Ro11n32n1t3 Ro11n32n1n2 Ro11n32n1n3 21350.1231664499
Ro11n32n1t4 Ro11n32n1n3 o11n 21449.737127935
* o11 bias=-0.00144268984703634 b-  bank=f alpha=0.001 R=23104.9891990359 G_phys=4.32806954110901e-05 G_eff=4.32806954110902e-08
* tiled Ro11bnf1 series x4  each=5776.24729975897
Ro11bnf1t1 vreff Ro11bnf1n1 5750.15494602442
Ro11bnf1t2 Ro11bnf1n1 Ro11bnf1n2 5785.57933889508
Ro11bnf1t3 Ro11bnf1n2 Ro11bnf1n3 5774.79266462143
Ro11bnf1t4 Ro11bnf1n3 o11n 5787.92771135032
Vo11p o11p 0 DC 0
Vo11n o11n 0 DC 0
Fo11p 0 o11d Vo11p 1.001
Fo11n o11d 0 Vo11n 1.001
* ratiometric I-to-V: V = I * R_IV,  R_IV=33333.3333333333 (weight ~ R_IV / R_w)
* tiled Ro11iv series x4  each=8333.33333333333
Ro11ivt1 o11d Ro11ivn1 8354.46943825735
Ro11ivt2 Ro11ivn1 Ro11ivn2 8331.42958843345
Ro11ivt3 Ro11ivn2 Ro11ivn3 8370.00024491202
Ro11ivt4 Ro11ivn3 0 8294.56960605049
Bo11leak 0 o11d I = 1e-08
Eo11sc o11raw 0 o11d 0 1
Eo11lin o11lin 0 o11raw 0 1

* o12 input 1 w=-0.0568819810826339 w-  bank=n alpha=1 R=586008.656852319 G_phys=1.70645943247902e-06 G_eff=1.70645943247902e-06
* tiled Ro12n1n1 series x4  each=146502.16421308
Ro12n1n1t1 h1buf Ro12n1n1n1 145981.894940837
Ro12n1n1t2 Ro12n1n1n1 Ro12n1n1n2 146202.433439809
Ro12n1n1t3 Ro12n1n1n2 Ro12n1n1n3 146999.486537343
Ro12n1n1t4 Ro12n1n1n3 o12n 146607.294846886
* o12 input 2 w=-0.116449760348513 w-  bank=n alpha=1 R=286246.47430422 G_phys=3.4934928104554e-06 G_eff=3.4934928104554e-06
* tiled Ro12n2n1 series x4  each=71561.618576055
Ro12n2n1t1 h2buf Ro12n2n1n1 71678.3843924918
Ro12n2n1t2 Ro12n2n1n1 Ro12n2n1n2 71772.80448514
Ro12n2n1t3 Ro12n2n1n2 Ro12n2n1n3 71694.3785576916
Ro12n2n1t4 Ro12n2n1n3 o12n 71626.4228834393
* o12 input 3 w=-0.394245634375715 w-  bank=n alpha=1 R=84549.6574391152 G_phys=1.18273690312714e-05 G_eff=1.18273690312714e-05
* tiled Ro12n3n1 series x4  each=21137.4143597788
Ro12n3n1t1 h3buf Ro12n3n1n1 21143.6203016188
Ro12n3n1t2 Ro12n3n1n1 Ro12n3n1n2 21210.4912537472
Ro12n3n1t3 Ro12n3n1n2 Ro12n3n1n3 21074.0282432796
Ro12n3n1t4 Ro12n3n1n3 o12n 21156.9385201685
* o12 input 4 w=-0.0304757769901363 w-  bank=f alpha=0.001 R=1093.76483966666 G_phys=0.000914273309704088 G_eff=9.14273309704088e-07
* tiled Ro12n4f1 parallel x4  each=4375.05935866665
Ro12n4f1t1 h4f o12n 4391.47734735257
Ro12n4f1t2 h4f o12n 4381.5510082835
Ro12n4f1t3 h4f o12n 4386.44025276139
Ro12n4f1t4 h4f o12n 4373.44726070656
* o12 input 5 w=-0.225077356892672 w-  bank=n alpha=1 R=148097.231074329 G_phys=6.75232070678017e-06 G_eff=6.75232070678017e-06
* tiled Ro12n5n1 series x4  each=37024.3077685822
Ro12n5n1t1 h5buf Ro12n5n1n1 36841.2655102085
Ro12n5n1t2 Ro12n5n1n1 Ro12n5n1n2 37201.559212622
Ro12n5n1t3 Ro12n5n1n2 Ro12n5n1n3 37000.3964889032
Ro12n5n1t4 Ro12n5n1n3 o12n 37178.7191712432
* o12 input 6 w=-0.48876360312342 w-  bank=n alpha=1 R=68199.2953655269 G_phys=1.46629080937026e-05 G_eff=1.46629080937026e-05
* tiled Ro12n6n1 series x4  each=17049.8238413817
Ro12n6n1t1 h6buf Ro12n6n1n1 16989.0664699532
Ro12n6n1t2 Ro12n6n1n1 Ro12n6n1n2 17003.9864521139
Ro12n6n1t3 Ro12n6n1n2 Ro12n6n1n3 17004.348655747
Ro12n6n1t4 Ro12n6n1n3 o12n 16980.419024055
* o12 input 7 w=+0.269859073889073 w+  bank=n alpha=1 R=123521.261868093 G_phys=8.09577221667219e-06 G_eff=8.09577221667219e-06
* tiled Ro12p7n1 series x4  each=30880.3154670233
Ro12p7n1t1 h7buf Ro12p7n1n1 31023.3178373964
Ro12p7n1t2 Ro12p7n1n1 Ro12p7n1n2 30740.9153943572
Ro12p7n1t3 Ro12p7n1n2 Ro12p7n1n3 30873.3588109777
Ro12p7n1t4 Ro12p7n1n3 o12p 30998.0420644665
* o12 input 8 w=-0.0167144075003679 w-  bank=f alpha=0.001 R=1994.28746323192 G_phys=0.000501432225011038 G_eff=5.01432225011038e-07
* tiled Ro12n8f1 parallel x4  each=7977.14985292768
Ro12n8f1t1 h8f o12n 7954.20363894553
Ro12n8f1t2 h8f o12n 7937.52084914128
Ro12n8f1t3 h8f o12n 7944.96720998775
Ro12n8f1t4 h8f o12n 7950.31223519264
* o12 input 9 w=-0.271168635938693 w-  bank=n alpha=1 R=122924.737287352 G_phys=8.13505907816079e-06 G_eff=8.13505907816079e-06
* tiled Ro12n9n1 series x4  each=30731.1843218379
Ro12n9n1t1 h9buf Ro12n9n1n1 30596.4767262734
Ro12n9n1t2 Ro12n9n1n1 Ro12n9n1n2 30768.6551978458
Ro12n9n1t3 Ro12n9n1n2 Ro12n9n1n3 30771.5294074429
Ro12n9n1t4 Ro12n9n1n3 o12n 30746.622982254
* o12 input 10 w=-0.229866523415109 w-  bank=n alpha=1 R=145011.691298509 G_phys=6.89599570245327e-06 G_eff=6.89599570245327e-06
* tiled Ro12n10n1 series x4  each=36252.9228246273
Ro12n10n1t1 h10buf Ro12n10n1n1 36202.1170886946
Ro12n10n1t2 Ro12n10n1n1 Ro12n10n1n2 36137.8691706516
Ro12n10n1t3 Ro12n10n1n2 Ro12n10n1n3 36290.0196980265
Ro12n10n1t4 Ro12n10n1n3 o12n 36156.0960937697
* o12 input 11 w=+0.111794037161303 w+  bank=n alpha=1 R=298167.363660355 G_phys=3.35382111483908e-06 G_eff=3.35382111483908e-06
* tiled Ro12p11n1 series x4  each=74541.8409150887
Ro12p11n1t1 h11buf Ro12p11n1n1 74655.0418384736
Ro12p11n1t2 Ro12p11n1n1 Ro12p11n1n2 74376.562794619
Ro12p11n1t3 Ro12p11n1n2 Ro12p11n1n3 74557.9522116925
Ro12p11n1t4 Ro12p11n1n3 o12p 74888.9038869663
* o12 input 12 w=-0.187970289472281 w-  bank=n alpha=1 R=177332.989308658 G_phys=5.63910868416843e-06 G_eff=5.63910868416843e-06
* tiled Ro12n12n1 series x4  each=44333.2473271645
Ro12n12n1t1 h12buf Ro12n12n1n1 44500.4603162111
Ro12n12n1t2 Ro12n12n1n1 Ro12n12n1n2 44544.1147239565
Ro12n12n1t3 Ro12n12n1n2 Ro12n12n1n3 44354.9444854114
Ro12n12n1t4 Ro12n12n1n3 o12n 44418.6856710998
* o12 input 13 w=+0.219867348390274 w+  bank=n alpha=1 R=151606.564491628 G_phys=6.59602045170821e-06 G_eff=6.59602045170821e-06
* tiled Ro12p13n1 series x4  each=37901.6411229071
Ro12p13n1t1 h13buf Ro12p13n1n1 37951.7992718879
Ro12p13n1t2 Ro12p13n1n1 Ro12p13n1n2 38030.0845441516
Ro12p13n1t3 Ro12p13n1n2 Ro12p13n1n3 38080.0881407933
Ro12p13n1t4 Ro12p13n1n3 o12p 37862.518992463
* o12 input 14 w=-0.127058880326711 w-  bank=n alpha=1 R=262345.561739739 G_phys=3.81176640980134e-06 G_eff=3.81176640980134e-06
* tiled Ro12n14n1 series x4  each=65586.3904349348
Ro12n14n1t1 h14buf Ro12n14n1n1 65303.3630139667
Ro12n14n1t2 Ro12n14n1n1 Ro12n14n1n2 65625.0673985518
Ro12n14n1t3 Ro12n14n1n2 Ro12n14n1n3 65842.08244982
Ro12n14n1t4 Ro12n14n1n3 o12n 65888.0938499083
* o12 input 15 w=+0.40629100094033 w+  bank=n alpha=1 R=82043.0018291959 G_phys=1.21887300282099e-05 G_eff=1.21887300282099e-05
* tiled Ro12p15n1 series x4  each=20510.750457299
Ro12p15n1t1 h15buf Ro12p15n1n1 20530.1682520289
Ro12p15n1t2 Ro12p15n1n1 Ro12p15n1n2 20518.5654851397
Ro12p15n1t3 Ro12p15n1n2 Ro12p15n1n3 20565.9441896733
Ro12p15n1t4 Ro12p15n1n3 o12p 20527.1243607268
* o12 input 16 w=-0.479164967789437 w-  bank=n alpha=1 R=69565.4640344684 G_phys=1.43749490336831e-05 G_eff=1.43749490336831e-05
* tiled Ro12n16n1 series x4  each=17391.3660086171
Ro12n16n1t1 h16buf Ro12n16n1n1 17396.920725933
Ro12n16n1t2 Ro12n16n1n1 Ro12n16n1n2 17310.7329759641
Ro12n16n1t3 Ro12n16n1n2 Ro12n16n1n3 17440.1216942096
Ro12n16n1t4 Ro12n16n1n3 o12n 17361.4227058849
* o12 input 17 w=-0.142691971348636 w-  bank=n alpha=1 R=233603.425744892 G_phys=4.28075914045907e-06 G_eff=4.28075914045907e-06
* tiled Ro12n17n1 series x4  each=58400.8564362231
Ro12n17n1t1 h17buf Ro12n17n1n1 58468.8516736637
Ro12n17n1t2 Ro12n17n1n1 Ro12n17n1n2 58531.1240859697
Ro12n17n1t3 Ro12n17n1n2 Ro12n17n1n3 58614.1097826875
Ro12n17n1t4 Ro12n17n1n3 o12n 58568.6483993807
* o12 input 18 w=+0.0750962927559542 w+  bank=n alpha=1 R=443874.552391808 G_phys=2.25288878267863e-06 G_eff=2.25288878267863e-06
* tiled Ro12p18n1 series x4  each=110968.638097952
Ro12p18n1t1 h18buf Ro12p18n1n1 110533.373386971
Ro12p18n1t2 Ro12p18n1n1 Ro12p18n1n2 111060.576069522
Ro12p18n1t3 Ro12p18n1n2 Ro12p18n1n3 110576.596237206
Ro12p18n1t4 Ro12p18n1n3 o12p 110835.41490945
* o12 input 19 w=-0.0357891000093011 w-  bank=n alpha=1 R=931382.273504235 G_phys=1.07367300027903e-06 G_eff=1.07367300027903e-06
* tiled Ro12n19n1 series x4  each=232845.568376059
Ro12n19n1t1 h19buf Ro12n19n1n1 232613.646177904
Ro12n19n1t2 Ro12n19n1n1 Ro12n19n1n2 233561.161807553
Ro12n19n1t3 Ro12n19n1n2 Ro12n19n1n3 232100.971042374
Ro12n19n1t4 Ro12n19n1n3 o12n 233672.699038548
* o12 input 20 w=-0.274882313904053 w-  bank=n alpha=1 R=121264.016079871 G_phys=8.24646941712159e-06 G_eff=8.24646941712159e-06
* tiled Ro12n20n1 series x4  each=30316.0040199678
Ro12n20n1t1 h20buf Ro12n20n1n1 30278.0961637584
Ro12n20n1t2 Ro12n20n1n1 Ro12n20n1n2 30368.2630542149
Ro12n20n1t3 Ro12n20n1n2 Ro12n20n1n3 30230.3937042649
Ro12n20n1t4 Ro12n20n1n3 o12n 30272.3355392275
* o12 input 21 w=+0.0723735016816067 w+  bank=n alpha=1 R=460573.726002328 G_phys=2.1712050504482e-06 G_eff=2.1712050504482e-06
* tiled Ro12p21n1 series x4  each=115143.431500582
Ro12p21n1t1 h21buf Ro12p21n1n1 115373.713109638
Ro12p21n1t2 Ro12p21n1n1 Ro12p21n1n2 115291.457582883
Ro12p21n1t3 Ro12p21n1n2 Ro12p21n1n3 115023.191832236
Ro12p21n1t4 Ro12p21n1n3 o12p 115215.524791528
* o12 input 22 w=-0.42830678611073 w-  bank=n alpha=1 R=77825.8351589968 G_phys=1.28492035833219e-05 G_eff=1.28492035833219e-05
* tiled Ro12n22n1 series x4  each=19456.4587897492
Ro12n22n1t1 h22buf Ro12n22n1n1 19534.437946812
Ro12n22n1t2 Ro12n22n1n1 Ro12n22n1n2 19479.2487382233
Ro12n22n1t3 Ro12n22n1n2 Ro12n22n1n3 19371.1361195707
Ro12n22n1t4 Ro12n22n1n3 o12n 19438.3464614568
* o12 input 23 w=-0.495732058756383 w-  bank=n alpha=1 R=67240.6247377966 G_phys=1.48719617626915e-05 G_eff=1.48719617626915e-05
* tiled Ro12n23n1 series x4  each=16810.1561844492
Ro12n23n1t1 h23buf Ro12n23n1n1 16836.7735377298
Ro12n23n1t2 Ro12n23n1n1 Ro12n23n1n2 16849.2156477012
Ro12n23n1t3 Ro12n23n1n2 Ro12n23n1n3 16787.3054839895
Ro12n23n1t4 Ro12n23n1n3 o12n 16883.3584844239
* o12 input 24 w=-0.0511653226482421 w-  bank=n alpha=1 R=651482.910847599 G_phys=1.53495967944726e-06 G_eff=1.53495967944726e-06
* tiled Ro12n24n1 series x4  each=162870.7277119
Ro12n24n1t1 h24buf Ro12n24n1n1 162355.898490827
Ro12n24n1t2 Ro12n24n1n1 Ro12n24n1n2 163269.604762839
Ro12n24n1t3 Ro12n24n1n2 Ro12n24n1n3 162844.728201972
Ro12n24n1t4 Ro12n24n1n3 o12n 163653.134912442
* o12 input 25 w=+0.0558940521557335 w+  bank=n alpha=1 R=596366.376165735 G_phys=1.676821564672e-06 G_eff=1.676821564672e-06
* tiled Ro12p25n1 series x4  each=149091.594041434
Ro12p25n1t1 h25buf Ro12p25n1n1 149289.427565601
Ro12p25n1t2 Ro12p25n1n1 Ro12p25n1n2 148433.968259255
Ro12p25n1t3 Ro12p25n1n2 Ro12p25n1n3 149832.571273821
Ro12p25n1t4 Ro12p25n1n3 o12p 148946.368012537
* o12 input 26 w=+0.307817092263132 w+  bank=n alpha=1 R=108289.416576123 G_phys=9.23451276789396e-06 G_eff=9.23451276789396e-06
* tiled Ro12p26n1 series x4  each=27072.3541440309
Ro12p26n1t1 h26buf Ro12p26n1n1 27008.394535278
Ro12p26n1t2 Ro12p26n1n1 Ro12p26n1n2 26986.9843999931
Ro12p26n1t3 Ro12p26n1n2 Ro12p26n1n3 26962.1896484583
Ro12p26n1t4 Ro12p26n1n3 o12p 27001.2108717603
* o12 input 27 w=-0.124284155438311 w-  bank=n alpha=1 R=268202.597634244 G_phys=3.72852466314934e-06 G_eff=3.72852466314934e-06
* tiled Ro12n27n1 series x4  each=67050.6494085611
Ro12n27n1t1 h27buf Ro12n27n1n1 67126.6137598596
Ro12n27n1t2 Ro12n27n1n1 Ro12n27n1n2 66717.6031139237
Ro12n27n1t3 Ro12n27n1n2 Ro12n27n1n3 67147.6395600466
Ro12n27n1t4 Ro12n27n1n3 o12n 67343.6490092475
* o12 input 28 w=+0.511620988407946 w+  bank=n alpha=1 R=65152.3961850343 G_phys=1.53486296522384e-05 G_eff=1.53486296522384e-05
* tiled Ro12p28n1 series x4  each=16288.0990462586
Ro12p28n1t1 h28buf Ro12p28n1n1 16287.6275977698
Ro12p28n1t2 Ro12p28n1n1 Ro12p28n1n2 16301.8582465574
Ro12p28n1t3 Ro12p28n1n2 Ro12p28n1n3 16367.8668417698
Ro12p28n1t4 Ro12p28n1n3 o12p 16215.205677081
* o12 input 29 w=-0.110998740438628 w-  bank=n alpha=1 R=300303.70796652 G_phys=3.32996221315884e-06 G_eff=3.32996221315884e-06
* tiled Ro12n29n1 series x4  each=75075.92699163
Ro12n29n1t1 h29buf Ro12n29n1n1 74918.6572266952
Ro12n29n1t2 Ro12n29n1n1 Ro12n29n1n2 75253.767324802
Ro12n29n1t3 Ro12n29n1n2 Ro12n29n1n3 75421.2547096159
Ro12n29n1t4 Ro12n29n1n3 o12n 74880.8086014578
* o12 input 30 w=+0.0696620617055659 w+  bank=n alpha=1 R=478500.528368227 G_phys=2.08986185116698e-06 G_eff=2.08986185116698e-06
* tiled Ro12p30n1 series x4  each=119625.132092057
Ro12p30n1t1 h30buf Ro12p30n1n1 119187.29384245
Ro12p30n1t2 Ro12p30n1n1 Ro12p30n1n2 119763.169986885
Ro12p30n1t3 Ro12p30n1n2 Ro12p30n1n3 119377.740174165
Ro12p30n1t4 Ro12p30n1n3 o12p 120077.197584302
* o12 input 31 w=+0.219973071991933 w+  bank=n alpha=1 R=151533.699245496 G_phys=6.59919215975798e-06 G_eff=6.59919215975798e-06
* tiled Ro12p31n1 series x4  each=37883.424811374
Ro12p31n1t1 h31buf Ro12p31n1n1 37925.081272317
Ro12p31n1t2 Ro12p31n1n1 Ro12p31n1n2 37906.2464580673
Ro12p31n1t3 Ro12p31n1n2 Ro12p31n1n3 37886.3154851912
Ro12p31n1t4 Ro12p31n1n3 o12p 37728.3842278949
* o12 input 32 w=+0.138023444689957 w+  bank=n alpha=1 R=241504.864685924 G_phys=4.14070334069872e-06 G_eff=4.14070334069872e-06
* tiled Ro12p32n1 series x4  each=60376.2161714811
Ro12p32n1t1 h32buf Ro12p32n1n1 60618.8168602097
Ro12p32n1t2 Ro12p32n1n1 Ro12p32n1n2 60248.2367069572
Ro12p32n1t3 Ro12p32n1n2 Ro12p32n1n3 60499.0191803575
Ro12p32n1t4 Ro12p32n1n3 o12p 60293.1060511434
* o12 bias=+0.00625312847600372 b+  bank=f alpha=0.001 R=5330.66503610944 G_phys=0.000187593854280111 G_eff=1.87593854280111e-07
* tiled Ro12bpf1 series x4  each=1332.66625902736
Ro12bpf1t1 vreff Ro12bpf1n1 1327.3110549204
Ro12bpf1t2 Ro12bpf1n1 Ro12bpf1n2 1331.03246198294
Ro12bpf1t3 Ro12bpf1n2 Ro12bpf1n3 1328.94201131527
Ro12bpf1t4 Ro12bpf1n3 o12p 1334.19791733078
Vo12p o12p 0 DC 0
Vo12n o12n 0 DC 0
Fo12p 0 o12d Vo12p 1.001
Fo12n o12d 0 Vo12n 1.001
* ratiometric I-to-V: V = I * R_IV,  R_IV=33333.3333333333 (weight ~ R_IV / R_w)
* tiled Ro12iv series x4  each=8333.33333333333
Ro12ivt1 o12d Ro12ivn1 8333.18769602078
Ro12ivt2 Ro12ivn1 Ro12ivn2 8313.64256205343
Ro12ivt3 Ro12ivn2 Ro12ivn3 8298.85558431341
Ro12ivt4 Ro12ivn3 0 8342.28081482942
Bo12leak 0 o12d I = 1e-08
Eo12sc o12raw 0 o12d 0 1
Eo12lin o12lin 0 o12raw 0 1

* o13 input 1 w=+0.00200007413415942 w+  bank=f alpha=0.001 R=16666.0489049035 G_phys=6.00022240247825e-05 G_eff=6.00022240247825e-08
* tiled Ro13p1f1 series x4  each=4166.51222622587
Ro13p1f1t1 h1f Ro13p1f1n1 4183.91920700428
Ro13p1f1t2 Ro13p1f1n1 Ro13p1f1n2 4180.44460112389
Ro13p1f1t3 Ro13p1f1n2 Ro13p1f1n3 4171.90748483048
Ro13p1f1t4 Ro13p1f1n3 o13p 4153.91881658763
* o13 input 2 w=-0.0237460165980216 w-  bank=f alpha=0.001 R=1403.74421098108 G_phys=0.000712380497940648 G_eff=7.12380497940648e-07
* tiled Ro13n2f1 parallel x4  each=5614.9768439243
Ro13n2f1t1 h2f o13n 5588.94692916774
Ro13n2f1t2 h2f o13n 5589.30343944614
Ro13n2f1t3 h2f o13n 5642.80139472262
Ro13n2f1t4 h2f o13n 5604.96932575795
* o13 input 3 w=-0.481641955158027 w-  bank=n alpha=1 R=69207.7028929023 G_phys=1.44492586547408e-05 G_eff=1.44492586547408e-05
* tiled Ro13n3n1 series x4  each=17301.9257232256
Ro13n3n1t1 h3buf Ro13n3n1n1 17287.3063839172
Ro13n3n1t2 Ro13n3n1n1 Ro13n3n1n2 17363.9306190006
Ro13n3n1t3 Ro13n3n1n2 Ro13n3n1n3 17351.9442429315
Ro13n3n1t4 Ro13n3n1n3 o13n 17302.4316609687
* o13 input 4 w=-0.401500412219866 w-  bank=n alpha=1 R=83021.9155916573 G_phys=1.2045012366596e-05 G_eff=1.2045012366596e-05
* tiled Ro13n4n1 series x4  each=20755.4788979143
Ro13n4n1t1 h4buf Ro13n4n1n1 20672.1868056857
Ro13n4n1t2 Ro13n4n1n1 Ro13n4n1n2 20819.7784685704
Ro13n4n1t3 Ro13n4n1n2 Ro13n4n1n3 20690.1381819743
Ro13n4n1t4 Ro13n4n1n3 o13n 20681.1584371855
* o13 input 5 w=-0.324731283585407 w-  bank=n alpha=1 R=102648.974762441 G_phys=9.7419385075622e-06 G_eff=9.7419385075622e-06
* tiled Ro13n5n1 series x4  each=25662.2436906101
Ro13n5n1t1 h5buf Ro13n5n1n1 25682.709200592
Ro13n5n1t2 Ro13n5n1n1 Ro13n5n1n2 25731.2870836247
Ro13n5n1t3 Ro13n5n1n2 Ro13n5n1n3 25694.7793276815
Ro13n5n1t4 Ro13n5n1n3 o13n 25566.8110061252
* o13 input 6 w=+0.0791891194793975 w+  bank=n alpha=1 R=420933.248815901 G_phys=2.37567358438193e-06 G_eff=2.37567358438193e-06
* tiled Ro13p6n1 series x4  each=105233.312203975
Ro13p6n1t1 h6buf Ro13p6n1n1 105562.794632258
Ro13p6n1t2 Ro13p6n1n1 Ro13p6n1n2 105030.619684334
Ro13p6n1t3 Ro13p6n1n2 Ro13p6n1n3 105063.06279428
Ro13p6n1t4 Ro13p6n1n3 o13p 105540.483699934
* o13 input 7 w=+0.286949833874567 w+  bank=n alpha=1 R=116164.323509956 G_phys=8.60849501623701e-06 G_eff=8.60849501623701e-06
* tiled Ro13p7n1 series x4  each=29041.080877489
Ro13p7n1t1 h7buf Ro13p7n1n1 29179.9993338333
Ro13p7n1t2 Ro13p7n1n1 Ro13p7n1n2 28930.0355733195
Ro13p7n1t3 Ro13p7n1n2 Ro13p7n1n3 29136.8683189866
Ro13p7n1t4 Ro13p7n1n3 o13p 29164.7743449862
* o13 input 8 w=-0.153846131933853 w-  bank=n alpha=1 R=216666.697526495 G_phys=4.61538395801558e-06 G_eff=4.61538395801558e-06
* tiled Ro13n8n1 series x4  each=54166.6743816238
Ro13n8n1t1 h8buf Ro13n8n1n1 53903.3966685158
Ro13n8n1t2 Ro13n8n1n1 Ro13n8n1n2 53975.611818636
Ro13n8n1t3 Ro13n8n1n2 Ro13n8n1n3 54256.1785130457
Ro13n8n1t4 Ro13n8n1n3 o13n 54104.4138070322
* o13 input 9 w=-0.0455077430770376 w-  bank=n alpha=1 R=732476.081639671 G_phys=1.36523229231113e-06 G_eff=1.36523229231113e-06
* tiled Ro13n9n1 series x4  each=183119.020409918
Ro13n9n1t1 h9buf Ro13n9n1n1 182487.071586843
Ro13n9n1t2 Ro13n9n1n1 Ro13n9n1n2 183769.751194355
Ro13n9n1t3 Ro13n9n1n2 Ro13n9n1n3 182824.37183861
Ro13n9n1t4 Ro13n9n1n3 o13n 182694.343758372
* o13 input 10 w=+0.122909253832841 w+  bank=n alpha=1 R=271202.796322133 G_phys=3.68727761498523e-06 G_eff=3.68727761498523e-06
* tiled Ro13p10n1 series x4  each=67800.6990805332
Ro13p10n1t1 h10buf Ro13p10n1n1 67990.1148376721
Ro13p10n1t2 Ro13p10n1n1 Ro13p10n1n2 67732.1834703237
Ro13p10n1t3 Ro13p10n1n2 Ro13p10n1n3 67513.8529915843
Ro13p10n1t4 Ro13p10n1n3 o13p 67560.9155786076
* o13 input 11 w=+0.0797228425783465 w+  bank=n alpha=1 R=418115.213347736 G_phys=2.3916852773504e-06 G_eff=2.3916852773504e-06
* tiled Ro13p11n1 series x4  each=104528.803336934
Ro13p11n1t1 h11buf Ro13p11n1n1 104159.099614719
Ro13p11n1t2 Ro13p11n1n1 Ro13p11n1n2 104560.869855347
Ro13p11n1t3 Ro13p11n1n2 Ro13p11n1n3 104346.583274831
Ro13p11n1t4 Ro13p11n1n3 o13p 104892.141638437
* o13 input 12 w=-0.0916703213430956 w-  bank=n alpha=1 R=363621.866324394 G_phys=2.75010964029287e-06 G_eff=2.75010964029287e-06
* tiled Ro13n12n1 series x4  each=90905.4665810984
Ro13n12n1t1 h12buf Ro13n12n1n1 90651.8869521539
Ro13n12n1t2 Ro13n12n1n1 Ro13n12n1n2 90618.2628612613
Ro13n12n1t3 Ro13n12n1n2 Ro13n12n1n3 90597.1399509975
Ro13n12n1t4 Ro13n12n1n3 o13n 90832.9070271754
* o13 input 13 w=-0.00253109868008519 w-  bank=f alpha=0.001 R=13169.5115625486 G_phys=7.59329604025557e-05 G_eff=7.59329604025556e-08
* tiled Ro13n13f1 series x4  each=3292.37789063714
Ro13n13f1t1 h13f Ro13n13f1n1 3293.49813451309
Ro13n13f1t2 Ro13n13f1n1 Ro13n13f1n2 3301.01021144935
Ro13n13f1t3 Ro13n13f1n2 Ro13n13f1n3 3300.27173719209
Ro13n13f1t4 Ro13n13f1n3 o13n 3281.83517562308
* o13 input 14 w=+0.523873822520012 w+  bank=n alpha=1 R=63628.5530988905 G_phys=1.57162146756004e-05 G_eff=1.57162146756004e-05
* tiled Ro13p14n1 series x4  each=15907.1382747226
Ro13p14n1t1 h14buf Ro13p14n1n1 15851.5182338707
Ro13p14n1t2 Ro13p14n1n1 Ro13p14n1n2 15956.8195636409
Ro13p14n1t3 Ro13p14n1n2 Ro13p14n1n3 15969.3489726472
Ro13p14n1t4 Ro13p14n1n3 o13p 15907.475322274
* o13 input 15 w=+0.0718975606852002 w+  bank=n alpha=1 R=463622.590469816 G_phys=2.15692682055601e-06 G_eff=2.15692682055601e-06
* tiled Ro13p15n1 series x4  each=115905.647617454
Ro13p15n1t1 h15buf Ro13p15n1n1 115876.910661871
Ro13p15n1t2 Ro13p15n1n1 Ro13p15n1n2 115839.920203647
Ro13p15n1t3 Ro13p15n1n2 Ro13p15n1n3 115492.740283072
Ro13p15n1t4 Ro13p15n1n3 o13p 115937.973510314
* o13 input 16 w=+0.212010526629755 w+  bank=n alpha=1 R=157224.897570982 G_phys=6.36031579889266e-06 G_eff=6.36031579889266e-06
* tiled Ro13p16n1 series x4  each=39306.2243927456
Ro13p16n1t1 h16buf Ro13p16n1n1 39271.5402177682
Ro13p16n1t2 Ro13p16n1n1 Ro13p16n1n2 39252.2432009886
Ro13p16n1t3 Ro13p16n1n2 Ro13p16n1n3 39236.6845993508
Ro13p16n1t4 Ro13p16n1n3 o13p 39213.778635866
* o13 input 17 w=+0.50252589011925 w+  bank=n alpha=1 R=66331.5741312817 G_phys=1.50757767035775e-05 G_eff=1.50757767035775e-05
* tiled Ro13p17n1 series x4  each=16582.8935328204
Ro13p17n1t1 h17buf Ro13p17n1n1 16577.6063227196
Ro13p17n1t2 Ro13p17n1n1 Ro13p17n1n2 16604.5355710026
Ro13p17n1t3 Ro13p17n1n2 Ro13p17n1n3 16587.7994512516
Ro13p17n1t4 Ro13p17n1n3 o13p 16584.262283144
* o13 input 18 w=-0.0631368164337741 w-  bank=n alpha=1 R=527953.97703173 G_phys=1.89410449301322e-06 G_eff=1.89410449301322e-06
* tiled Ro13n18n1 series x4  each=131988.494257933
Ro13n18n1t1 h18buf Ro13n18n1n1 132512.761337094
Ro13n18n1t2 Ro13n18n1n1 Ro13n18n1n2 132148.17344789
Ro13n18n1t3 Ro13n18n1n2 Ro13n18n1n3 131428.630283455
Ro13n18n1t4 Ro13n18n1n3 o13n 132133.054980515
* o13 input 19 w=+0.124615759492256 w+  bank=n alpha=1 R=267488.907254983 G_phys=3.73847278476769e-06 G_eff=3.73847278476769e-06
* tiled Ro13p19n1 series x4  each=66872.2268137456
Ro13p19n1t1 h19buf Ro13p19n1n1 67163.6702025092
Ro13p19n1t2 Ro13p19n1n1 Ro13p19n1n2 66761.4823635511
Ro13p19n1t3 Ro13p19n1n2 Ro13p19n1n3 66865.7285688795
Ro13p19n1t4 Ro13p19n1n3 o13p 67134.6154955396
* o13 input 20 w=-0.0825374863137293 w-  bank=n alpha=1 R=403856.899719863 G_phys=2.47612458941188e-06 G_eff=2.47612458941188e-06
* tiled Ro13n20n1 series x4  each=100964.224929966
Ro13n20n1t1 h20buf Ro13n20n1n1 101206.136052045
Ro13n20n1t2 Ro13n20n1n1 Ro13n20n1n2 100890.544406077
Ro13n20n1t3 Ro13n20n1n2 Ro13n20n1n3 100663.800925891
Ro13n20n1t4 Ro13n20n1n3 o13n 100478.815206975
* o13 input 21 w=-0.0332297714786912 w-  bank=f alpha=0.001 R=1003.11653827377 G_phys=0.000996893144360737 G_eff=9.96893144360737e-07
* tiled Ro13n21f1 parallel x4  each=4012.4661530951
Ro13n21f1t1 h21f o13n 4017.40897133974
Ro13n21f1t2 h21f o13n 4025.52619291728
Ro13n21f1t3 h21f o13n 3997.06719290958
Ro13n21f1t4 h21f o13n 4005.28249985337
* o13 input 22 w=+0.217350752944783 w+  bank=n alpha=1 R=153361.940925972 G_phys=6.5205225883435e-06 G_eff=6.5205225883435e-06
* tiled Ro13p22n1 series x4  each=38340.4852314929
Ro13p22n1t1 h22buf Ro13p22n1n1 38524.506225122
Ro13p22n1t2 Ro13p22n1n1 Ro13p22n1n2 38193.8140211307
Ro13p22n1t3 Ro13p22n1n2 Ro13p22n1n3 38351.8148439788
Ro13p22n1t4 Ro13p22n1n3 o13p 38466.1947762524
* o13 input 23 w=+0.00620341639632115 w+  bank=f alpha=0.001 R=5373.38318174179 G_phys=0.000186102491889634 G_eff=1.86102491889634e-07
* tiled Ro13p23f1 series x4  each=1343.34579543545
Ro13p23f1t1 h23f Ro13p23f1n1 1349.19018871585
Ro13p23f1t2 Ro13p23f1n1 Ro13p23f1n2 1346.95451891485
Ro13p23f1t3 Ro13p23f1n2 Ro13p23f1n3 1340.58133524798
Ro13p23f1t4 Ro13p23f1n3 o13p 1343.00032355121
* o13 input 24 w=-0.56329887647671 w-  bank=n alpha=1 R=59175.2171455139 G_phys=1.68989662943013e-05 G_eff=1.68989662943013e-05
* tiled Ro13n24n1 series x4  each=14793.8042863785
Ro13n24n1t1 h24buf Ro13n24n1n1 14793.9263445045
Ro13n24n1t2 Ro13n24n1n1 Ro13n24n1n2 14745.2693066609
Ro13n24n1t3 Ro13n24n1n2 Ro13n24n1n3 14796.5635995534
Ro13n24n1t4 Ro13n24n1n3 o13n 14731.482483111
* o13 input 25 w=+0.121217122487375 w+  bank=n alpha=1 R=274988.653824918 G_phys=3.63651367462124e-06 G_eff=3.63651367462124e-06
* tiled Ro13p25n1 series x4  each=68747.1634562294
Ro13p25n1t1 h25buf Ro13p25n1n1 68835.1214165218
Ro13p25n1t2 Ro13p25n1n1 Ro13p25n1n2 68877.3538956572
Ro13p25n1t3 Ro13p25n1n2 Ro13p25n1n3 68840.4631775533
Ro13p25n1t4 Ro13p25n1n3 o13p 68669.2768411684
* o13 input 26 w=-0.0619389520134905 w-  bank=n alpha=1 R=538164.309368251 G_phys=1.85816856040471e-06 G_eff=1.85816856040471e-06
* tiled Ro13n26n1 series x4  each=134541.077342063
Ro13n26n1t1 h26buf Ro13n26n1n1 135107.124693118
Ro13n26n1t2 Ro13n26n1n1 Ro13n26n1n2 135120.955996448
Ro13n26n1t3 Ro13n26n1n2 Ro13n26n1n3 134781.994019927
Ro13n26n1t4 Ro13n26n1n3 o13n 134340.041272239
* o13 input 27 w=-0.148385692307615 w-  bank=n alpha=1 R=224639.807349019 G_phys=4.45157076922844e-06 G_eff=4.45157076922844e-06
* tiled Ro13n27n1 series x4  each=56159.9518372547
Ro13n27n1t1 h27buf Ro13n27n1n1 56221.7562566983
Ro13n27n1t2 Ro13n27n1n1 Ro13n27n1n2 56007.390339573
Ro13n27n1t3 Ro13n27n1n2 Ro13n27n1n3 56024.7179972805
Ro13n27n1t4 Ro13n27n1n3 o13n 56001.2224795409
* o13 input 28 w=+0.0960859107643036 w+  bank=n alpha=1 R=346911.769563169 G_phys=2.88257732292911e-06 G_eff=2.88257732292911e-06
* tiled Ro13p28n1 series x4  each=86727.9423907923
Ro13p28n1t1 h28buf Ro13p28n1n1 86885.3600360397
Ro13p28n1t2 Ro13p28n1n1 Ro13p28n1n2 86627.5880250113
Ro13p28n1t3 Ro13p28n1n2 Ro13p28n1n3 86313.0111494149
Ro13p28n1t4 Ro13p28n1n3 o13p 86933.4034496503
* o13 input 29 w=-0.0967464729103534 w-  bank=n alpha=1 R=344543.137652372 G_phys=2.9023941873106e-06 G_eff=2.9023941873106e-06
* tiled Ro13n29n1 series x4  each=86135.7844130929
Ro13n29n1t1 h29buf Ro13n29n1n1 86312.8403219561
Ro13n29n1t2 Ro13n29n1n1 Ro13n29n1n2 86504.3707496414
Ro13n29n1t3 Ro13n29n1n2 Ro13n29n1n3 86335.2310622188
Ro13n29n1t4 Ro13n29n1n3 o13n 86532.6313210026
* o13 input 30 w=+0.0502110731232858 w+  bank=n alpha=1 R=663864.188910847 G_phys=1.50633219369857e-06 G_eff=1.50633219369857e-06
* tiled Ro13p30n1 series x4  each=165966.047227712
Ro13p30n1t1 h30buf Ro13p30n1n1 165958.719796176
Ro13p30n1t2 Ro13p30n1n1 Ro13p30n1n2 166287.173881606
Ro13p30n1t3 Ro13p30n1n2 Ro13p30n1n3 165191.547796805
Ro13p30n1t4 Ro13p30n1n3 o13p 165341.31751881
* o13 input 31 w=+0.0717291842082243 w+  bank=n alpha=1 R=464710.894195719 G_phys=2.15187552624673e-06 G_eff=2.15187552624673e-06
* tiled Ro13p31n1 series x4  each=116177.72354893
Ro13p31n1t1 h31buf Ro13p31n1n1 116027.009235252
Ro13p31n1t2 Ro13p31n1n1 Ro13p31n1n2 116681.00053398
Ro13p31n1t3 Ro13p31n1n2 Ro13p31n1n3 116456.525165129
Ro13p31n1t4 Ro13p31n1n3 o13p 115665.727602863
* o13 input 32 w=+0.117218732023777 w+  bank=n alpha=1 R=284368.656424059 G_phys=3.51656196071332e-06 G_eff=3.51656196071332e-06
* tiled Ro13p32n1 series x4  each=71092.1641060147
Ro13p32n1t1 h32buf Ro13p32n1n1 71263.9029827214
Ro13p32n1t2 Ro13p32n1n1 Ro13p32n1n2 71385.6505679322
Ro13p32n1t3 Ro13p32n1n2 Ro13p32n1n3 70911.0686907122
Ro13p32n1t4 Ro13p32n1n3 o13p 71040.5331179835
* o13 bias=+0.00474280842399728 b+  bank=f alpha=0.001 R=7028.1846436546 G_phys=0.000142284252719918 G_eff=1.42284252719918e-07
* tiled Ro13bpf1 series x4  each=1757.04616091365
Ro13bpf1t1 vreff Ro13bpf1n1 1765.23278346439
Ro13bpf1t2 Ro13bpf1n1 Ro13bpf1n2 1761.53449471118
Ro13bpf1t3 Ro13bpf1n2 Ro13bpf1n3 1756.12120334863
Ro13bpf1t4 Ro13bpf1n3 o13p 1754.70671332969
Vo13p o13p 0 DC 0
Vo13n o13n 0 DC 0
Fo13p 0 o13d Vo13p 1.001
Fo13n o13d 0 Vo13n 1.001
* ratiometric I-to-V: V = I * R_IV,  R_IV=33333.3333333333 (weight ~ R_IV / R_w)
* tiled Ro13iv series x4  each=8333.33333333333
Ro13ivt1 o13d Ro13ivn1 8295.14860866482
Ro13ivt2 Ro13ivn1 Ro13ivn2 8368.37612907076
Ro13ivt3 Ro13ivn2 Ro13ivn3 8309.98924953209
Ro13ivt4 Ro13ivn3 0 8299.57321874391
Bo13leak 0 o13d I = 1e-08
Eo13sc o13raw 0 o13d 0 1
Eo13lin o13lin 0 o13raw 0 1

* o14 input 1 w=-0.25477230027339 w-  bank=n alpha=1 R=130835.782765882 G_phys=7.64316900820172e-06 G_eff=7.64316900820172e-06
* tiled Ro14n1n1 series x4  each=32708.9456914705
Ro14n1n1t1 h1buf Ro14n1n1n1 32618.5947211575
Ro14n1n1t2 Ro14n1n1n1 Ro14n1n1n2 32755.729338867
Ro14n1n1t3 Ro14n1n1n2 Ro14n1n1n3 32691.1320221534
Ro14n1n1t4 Ro14n1n1n3 o14n 32650.6142970965
* o14 input 2 w=+0.102637632071701 w+  bank=n alpha=1 R=324767.170291372 G_phys=3.07912896215104e-06 G_eff=3.07912896215104e-06
* tiled Ro14p2n1 series x4  each=81191.7925728429
Ro14p2n1t1 h2buf Ro14p2n1n1 81588.2596129148
Ro14p2n1t2 Ro14p2n1n1 Ro14p2n1n2 81516.8757973853
Ro14p2n1t3 Ro14p2n1n2 Ro14p2n1n3 81111.9574657378
Ro14p2n1t4 Ro14p2n1n3 o14p 81020.6605679974
* o14 input 3 w=+0.107208211835011 w+  bank=n alpha=1 R=310921.456134648 G_phys=3.21624635505032e-06 G_eff=3.21624635505032e-06
* tiled Ro14p3n1 series x4  each=77730.364033662
Ro14p3n1t1 h3buf Ro14p3n1n1 77485.0751517643
Ro14p3n1t2 Ro14p3n1n1 Ro14p3n1n2 78014.9412481332
Ro14p3n1t3 Ro14p3n1n2 Ro14p3n1n3 77472.6246322727
Ro14p3n1t4 Ro14p3n1n3 o14p 77351.9435782572
* o14 input 4 w=-0.361346054145307 w-  bank=n alpha=1 R=92247.6749114552 G_phys=1.08403816243592e-05 G_eff=1.08403816243592e-05
* tiled Ro14n4n1 series x4  each=23061.9187278638
Ro14n4n1t1 h4buf Ro14n4n1n1 22966.3615923971
Ro14n4n1t2 Ro14n4n1n1 Ro14n4n1n2 23045.7677673249
Ro14n4n1t3 Ro14n4n1n2 Ro14n4n1n3 23100.6306198348
Ro14n4n1t4 Ro14n4n1n3 o14n 23175.8111628482
* o14 input 5 w=+0.0565127294479513 w+  bank=n alpha=1 R=589837.611082537 G_phys=1.69538188343854e-06 G_eff=1.69538188343854e-06
* tiled Ro14p5n1 series x4  each=147459.402770634
Ro14p5n1t1 h5buf Ro14p5n1n1 147183.573157833
Ro14p5n1t2 Ro14p5n1n1 Ro14p5n1n2 146752.998691722
Ro14p5n1t3 Ro14p5n1n2 Ro14p5n1n3 147038.472140636
Ro14p5n1t4 Ro14p5n1n3 o14p 147910.853137757
* o14 input 6 w=-0.166023137794918 w-  bank=n alpha=1 R=200775.22793545 G_phys=4.98069413384754e-06 G_eff=4.98069413384754e-06
* tiled Ro14n6n1 series x4  each=50193.8069838626
Ro14n6n1t1 h6buf Ro14n6n1n1 50264.9101828771
Ro14n6n1t2 Ro14n6n1n1 Ro14n6n1n2 50150.9322781729
Ro14n6n1t3 Ro14n6n1n2 Ro14n6n1n3 50328.2471185338
Ro14n6n1t4 Ro14n6n1n3 o14n 50043.7700785992
* o14 input 7 w=+0.0533068959488943 w+  bank=n alpha=1 R=625309.96674971 G_phys=1.59920687846683e-06 G_eff=1.59920687846683e-06
* tiled Ro14p7n1 series x4  each=156327.491687427
Ro14p7n1t1 h7buf Ro14p7n1n1 155802.866863018
Ro14p7n1t2 Ro14p7n1n1 Ro14p7n1n2 156596.755374717
Ro14p7n1t3 Ro14p7n1n2 Ro14p7n1n3 156321.046956847
Ro14p7n1t4 Ro14p7n1n3 o14p 157000.723917693
* o14 input 8 w=-0.334728977765226 w-  bank=n alpha=1 R=99583.0524022118 G_phys=1.00418693329568e-05 G_eff=1.00418693329568e-05
* tiled Ro14n8n1 series x4  each=24895.7631005529
Ro14n8n1t1 h8buf Ro14n8n1n1 25001.9946884887
Ro14n8n1t2 Ro14n8n1n1 Ro14n8n1n2 24820.047966321
Ro14n8n1t3 Ro14n8n1n2 Ro14n8n1n3 24857.4934888581
Ro14n8n1t4 Ro14n8n1n3 o14n 24819.3082716084
* o14 input 9 w=-0.184424571200296 w-  bank=n alpha=1 R=180742.365924394 G_phys=5.53273713600887e-06 G_eff=5.53273713600887e-06
* tiled Ro14n9n1 series x4  each=45185.5914810985
Ro14n9n1t1 h9buf Ro14n9n1n1 45348.7889516226
Ro14n9n1t2 Ro14n9n1n1 Ro14n9n1n2 45071.496501056
Ro14n9n1t3 Ro14n9n1n2 Ro14n9n1n3 45212.9996578175
Ro14n9n1t4 Ro14n9n1n3 o14n 45362.1488189778
* o14 input 10 w=+0.263838736865495 w+  bank=n alpha=1 R=126339.800324039 G_phys=7.91516210596486e-06 G_eff=7.91516210596486e-06
* tiled Ro14p10n1 series x4  each=31584.9500810097
Ro14p10n1t1 h10buf Ro14p10n1n1 31638.0742591303
Ro14p10n1t2 Ro14p10n1n1 Ro14p10n1n2 31622.9240526565
Ro14p10n1t3 Ro14p10n1n2 Ro14p10n1n3 31602.7489503712
Ro14p10n1t4 Ro14p10n1n3 o14p 31742.2321691493
* o14 input 11 w=+0.0215454170832462 w+  bank=f alpha=0.001 R=1547.11942704759 G_phys=0.000646362512497387 G_eff=6.46362512497387e-07
* tiled Ro14p11f1 parallel x4  each=6188.47770819037
Ro14p11f1t1 h11f o14p 6174.16951458255
Ro14p11f1t2 h11f o14p 6187.0283852191
Ro14p11f1t3 h11f o14p 6160.1162944716
Ro14p11f1t4 h11f o14p 6176.73159010606
* o14 input 12 w=-0.0509620245346412 w-  bank=n alpha=1 R=654081.811657133 G_phys=1.52886073603923e-06 G_eff=1.52886073603923e-06
* tiled Ro14n12n1 series x4  each=163520.452914283
Ro14n12n1t1 h12buf Ro14n12n1n1 164301.191271001
Ro14n12n1t2 Ro14n12n1n1 Ro14n12n1n2 163182.084083171
Ro14n12n1t3 Ro14n12n1n2 Ro14n12n1n3 162771.489975157
Ro14n12n1t4 Ro14n12n1n3 o14n 163146.50548325
* o14 input 13 w=-0.289718223355261 w-  bank=n alpha=1 R=115054.320530121 G_phys=8.69154670065782e-06 G_eff=8.69154670065782e-06
* tiled Ro14n13n1 series x4  each=28763.5801325302
Ro14n13n1t1 h13buf Ro14n13n1n1 28710.1715185426
Ro14n13n1t2 Ro14n13n1n1 Ro14n13n1n2 28637.283845232
Ro14n13n1t3 Ro14n13n1n2 Ro14n13n1n3 28723.1775035204
Ro14n13n1t4 Ro14n13n1n3 o14n 28666.7822250734
* o14 input 14 w=+0.114352462647064 w+  bank=n alpha=1 R=291496.41871914 G_phys=3.43057387941191e-06 G_eff=3.43057387941191e-06
* tiled Ro14p14n1 series x4  each=72874.1046797851
Ro14p14n1t1 h14buf Ro14p14n1n1 72770.0893911857
Ro14p14n1t2 Ro14p14n1n1 Ro14p14n1n2 72986.6194949048
Ro14p14n1t3 Ro14p14n1n2 Ro14p14n1n3 72584.4808539486
Ro14p14n1t4 Ro14p14n1n3 o14p 72822.3675299545
* o14 input 15 w=-0.172686817087866 w-  bank=n alpha=1 R=193027.666474232 G_phys=5.18060451263599e-06 G_eff=5.18060451263599e-06
* tiled Ro14n15n1 series x4  each=48256.916618558
Ro14n15n1t1 h15buf Ro14n15n1n1 48351.0605502938
Ro14n15n1t2 Ro14n15n1n1 Ro14n15n1n2 48162.2035184238
Ro14n15n1t3 Ro14n15n1n2 Ro14n15n1n3 48245.6459938239
Ro14n15n1t4 Ro14n15n1n3 o14n 48016.7325588487
* o14 input 16 w=-0.0880371911025684 w-  bank=n alpha=1 R=378627.860746921 G_phys=2.64111573307705e-06 G_eff=2.64111573307705e-06
* tiled Ro14n16n1 series x4  each=94656.9651867302
Ro14n16n1t1 h16buf Ro14n16n1n1 94381.6937685983
Ro14n16n1t2 Ro14n16n1n1 Ro14n16n1n2 94815.6791840268
Ro14n16n1t3 Ro14n16n1n2 Ro14n16n1n3 94650.1910622911
Ro14n16n1t4 Ro14n16n1n3 o14n 94376.0491802835
* o14 input 17 w=-0.0970577820037651 w-  bank=n alpha=1 R=343438.028823286 G_phys=2.91173346011295e-06 G_eff=2.91173346011295e-06
* tiled Ro14n17n1 series x4  each=85859.5072058216
Ro14n17n1t1 h17buf Ro14n17n1n1 86091.6001478756
Ro14n17n1t2 Ro14n17n1n1 Ro14n17n1n2 85936.8994253429
Ro14n17n1t3 Ro14n17n1n2 Ro14n17n1n3 85899.4195717882
Ro14n17n1t4 Ro14n17n1n3 o14n 86178.5042125897
* o14 input 18 w=+0.279065168461303 w+  bank=n alpha=1 R=119446.412883145 G_phys=8.3719550538391e-06 G_eff=8.3719550538391e-06
* tiled Ro14p18n1 series x4  each=29861.6032207863
Ro14p18n1t1 h18buf Ro14p18n1n1 29853.3978172201
Ro14p18n1t2 Ro14p18n1n1 Ro14p18n1n2 29907.2667628955
Ro14p18n1t3 Ro14p18n1n2 Ro14p18n1n3 29716.2689081136
Ro14p18n1t4 Ro14p18n1n3 o14p 29967.943723277
* o14 input 19 w=+0.12574844379754 w+  bank=n alpha=1 R=265079.489866303 G_phys=3.7724533139262e-06 G_eff=3.7724533139262e-06
* tiled Ro14p19n1 series x4  each=66269.8724665757
Ro14p19n1t1 h19buf Ro14p19n1n1 66024.7422270618
Ro14p19n1t2 Ro14p19n1n1 Ro14p19n1n2 66598.7459712514
Ro14p19n1t3 Ro14p19n1n2 Ro14p19n1n3 66264.2578708575
Ro14p19n1t4 Ro14p19n1n3 o14p 66357.1225582478
* o14 input 20 w=+0.196093228285189 w+  bank=n alpha=1 R=169987.172044793 G_phys=5.88279684855566e-06 G_eff=5.88279684855566e-06
* tiled Ro14p20n1 series x4  each=42496.7930111984
Ro14p20n1t1 h20buf Ro14p20n1n1 42474.5996248936
Ro14p20n1t2 Ro14p20n1n1 Ro14p20n1n2 42642.9812081098
Ro14p20n1t3 Ro14p20n1n2 Ro14p20n1n3 42663.1325532046
Ro14p20n1t4 Ro14p20n1n3 o14p 42462.9540651722
* o14 input 21 w=+0.0606582432664274 w+  bank=n alpha=1 R=549526.849746115 G_phys=1.81974729799282e-06 G_eff=1.81974729799282e-06
* tiled Ro14p21n1 series x4  each=137381.712436529
Ro14p21n1t1 h21buf Ro14p21n1n1 137651.432656619
Ro14p21n1t2 Ro14p21n1n1 Ro14p21n1n2 138054.729465736
Ro14p21n1t3 Ro14p21n1n2 Ro14p21n1n3 137012.842328077
Ro14p21n1t4 Ro14p21n1n3 o14p 137862.976689527
* o14 input 22 w=+0.471542863591523 w+  bank=n alpha=1 R=70689.9327867011 G_phys=1.41462859077457e-05 G_eff=1.41462859077457e-05
* tiled Ro14p22n1 series x4  each=17672.4831966753
Ro14p22n1t1 h22buf Ro14p22n1n1 17720.9587156628
Ro14p22n1t2 Ro14p22n1n1 Ro14p22n1n2 17584.9705046058
Ro14p22n1t3 Ro14p22n1n2 Ro14p22n1n3 17656.1700048324
Ro14p22n1t4 Ro14p22n1n3 o14p 17741.3398441659
* o14 input 23 w=+0.132895212526076 w+  bank=n alpha=1 R=250824.184707127 G_phys=3.98685637578228e-06 G_eff=3.98685637578228e-06
* tiled Ro14p23n1 series x4  each=62706.0461767817
Ro14p23n1t1 h23buf Ro14p23n1n1 62864.5934539199
Ro14p23n1t2 Ro14p23n1n1 Ro14p23n1n2 62760.5254769254
Ro14p23n1t3 Ro14p23n1n2 Ro14p23n1n3 62597.6212822805
Ro14p23n1t4 Ro14p23n1n3 o14p 62759.2136496429
* o14 input 24 w=-0.150700282102261 w-  bank=n alpha=1 R=221189.588156937 G_phys=4.52100846306782e-06 G_eff=4.52100846306782e-06
* tiled Ro14n24n1 series x4  each=55297.3970392343
Ro14n24n1t1 h24buf Ro14n24n1n1 55169.6981271546
Ro14n24n1t2 Ro14n24n1n1 Ro14n24n1n2 55335.4892925724
Ro14n24n1t3 Ro14n24n1n2 Ro14n24n1n3 55394.1497289987
Ro14n24n1t4 Ro14n24n1n3 o14n 55340.1663531389
* o14 input 25 w=-0.172018927572569 w-  bank=n alpha=1 R=193777.125597247 G_phys=5.16056782717707e-06 G_eff=5.16056782717707e-06
* tiled Ro14n25n1 series x4  each=48444.2813993116
Ro14n25n1t1 h25buf Ro14n25n1n1 48607.4311186858
Ro14n25n1t2 Ro14n25n1n1 Ro14n25n1n2 48420.3418404592
Ro14n25n1t3 Ro14n25n1n2 Ro14n25n1n3 48549.3120771208
Ro14n25n1t4 Ro14n25n1n3 o14n 48419.5656011811
* o14 input 26 w=-0.144277203051731 w-  bank=n alpha=1 R=231036.730878278 G_phys=4.32831609155192e-06 G_eff=4.32831609155192e-06
* tiled Ro14n26n1 series x4  each=57759.1827195695
Ro14n26n1t1 h26buf Ro14n26n1n1 57904.3268681138
Ro14n26n1t2 Ro14n26n1n1 Ro14n26n1n2 57618.6214549108
Ro14n26n1t3 Ro14n26n1n2 Ro14n26n1n3 57991.8791921869
Ro14n26n1t4 Ro14n26n1n3 o14n 57956.8768680502
* o14 input 27 w=-0.0456897569368309 w-  bank=n alpha=1 R=729558.12348529 G_phys=1.37069270810493e-06 G_eff=1.37069270810493e-06
* tiled Ro14n27n1 series x4  each=182389.530871323
Ro14n27n1t1 h27buf Ro14n27n1n1 183149.146196475
Ro14n27n1t2 Ro14n27n1n1 Ro14n27n1n2 183278.713117283
Ro14n27n1t3 Ro14n27n1n2 Ro14n27n1n3 181788.912425954
Ro14n27n1t4 Ro14n27n1n3 o14n 183134.581668321
* o14 input 28 w=-0.269930966859316 w-  bank=n alpha=1 R=123488.363418141 G_phys=8.09792900577949e-06 G_eff=8.09792900577949e-06
* tiled Ro14n28n1 series x4  each=30872.0908545352
Ro14n28n1t1 h28buf Ro14n28n1n1 30748.9615620197
Ro14n28n1t2 Ro14n28n1n1 Ro14n28n1n2 30873.6684836597
Ro14n28n1t3 Ro14n28n1n2 Ro14n28n1n3 30777.1401378586
Ro14n28n1t4 Ro14n28n1n3 o14n 30864.6808746538
* o14 input 29 w=-0.380176315173873 w-  bank=n alpha=1 R=87678.6164811146 G_phys=1.14052894552162e-05 G_eff=1.14052894552162e-05
* tiled Ro14n29n1 series x4  each=21919.6541202786
Ro14n29n1t1 h29buf Ro14n29n1n1 21977.1990531155
Ro14n29n1t2 Ro14n29n1n1 Ro14n29n1n2 21933.8661582476
Ro14n29n1t3 Ro14n29n1n2 Ro14n29n1n3 21984.3041291352
Ro14n29n1t4 Ro14n29n1n3 o14n 22007.480843726
* o14 input 30 w=+0.211443520189348 w+  bank=n alpha=1 R=157646.511482042 G_phys=6.34330560568043e-06 G_eff=6.34330560568043e-06
* tiled Ro14p30n1 series x4  each=39411.6278705105
Ro14p30n1t1 h30buf Ro14p30n1n1 39388.2090034457
Ro14p30n1t2 Ro14p30n1n1 Ro14p30n1n2 39473.3526696343
Ro14p30n1t3 Ro14p30n1n2 Ro14p30n1n3 39331.2779236063
Ro14p30n1t4 Ro14p30n1n3 o14p 39378.8059209111
* o14 input 31 w=+0.0784944631218348 w+  bank=n alpha=1 R=424658.402741034 G_phys=2.35483389365504e-06 G_eff=2.35483389365504e-06
* tiled Ro14p31n1 series x4  each=106164.600685258
Ro14p31n1t1 h31buf Ro14p31n1n1 106607.42092539
Ro14p31n1t2 Ro14p31n1n1 Ro14p31n1n2 106691.659111204
Ro14p31n1t3 Ro14p31n1n2 Ro14p31n1n3 105879.709887168
Ro14p31n1t4 Ro14p31n1n3 o14p 106372.99068418
* o14 input 32 w=+0.0843025902123393 w+  bank=n alpha=1 R=395401.057658776 G_phys=2.52907770637018e-06 G_eff=2.52907770637018e-06
* tiled Ro14p32n1 series x4  each=98850.264414694
Ro14p32n1t1 h32buf Ro14p32n1n1 99144.0537095318
Ro14p32n1t2 Ro14p32n1n1 Ro14p32n1n2 98945.6307084905
Ro14p32n1t3 Ro14p32n1n2 Ro14p32n1n3 98389.5978193028
Ro14p32n1t4 Ro14p32n1n3 o14p 99256.7760756259
* o14 bias=-0.0124822366617376 b-  bank=f alpha=0.001 R=2670.46157164376 G_phys=0.00037446709985213 G_eff=3.74467099852129e-07
* tiled Ro14bnf1 parallel x4  each=10681.8462865751
Ro14bnf1t1 vreff o14n 10682.75448714
Ro14bnf1t2 vreff o14n 10672.4032277366
Ro14bnf1t3 vreff o14n 10684.253066236
Ro14bnf1t4 vreff o14n 10685.576944719
Vo14p o14p 0 DC 0
Vo14n o14n 0 DC 0
Fo14p 0 o14d Vo14p 1.001
Fo14n o14d 0 Vo14n 1.001
* ratiometric I-to-V: V = I * R_IV,  R_IV=33333.3333333333 (weight ~ R_IV / R_w)
* tiled Ro14iv series x4  each=8333.33333333333
Ro14ivt1 o14d Ro14ivn1 8361.95833455582
Ro14ivt2 Ro14ivn1 Ro14ivn2 8365.80121120698
Ro14ivt3 Ro14ivn2 Ro14ivn3 8328.32842250862
Ro14ivt4 Ro14ivn3 0 8313.6543498295
Bo14leak 0 o14d I = 1e-08
Eo14sc o14raw 0 o14d 0 1
Eo14lin o14lin 0 o14raw 0 1

* o15 input 1 w=-0.113449668897813 w-  bank=n alpha=1 R=293816.047743229 G_phys=3.40349006693439e-06 G_eff=3.40349006693439e-06
* tiled Ro15n1n1 series x4  each=73454.0119358073
Ro15n1n1t1 h1buf Ro15n1n1n1 73096.0641806393
Ro15n1n1t2 Ro15n1n1n1 Ro15n1n1n2 73218.6369724816
Ro15n1n1t3 Ro15n1n1n2 Ro15n1n1n3 73798.0746617181
Ro15n1n1t4 Ro15n1n1n3 o15n 73247.6134479255
* o15 input 2 w=-0.169978823552936 w-  bank=n alpha=1 R=196102.85938326 G_phys=5.09936470658807e-06 G_eff=5.09936470658807e-06
* tiled Ro15n2n1 series x4  each=49025.7148458151
Ro15n2n1t1 h2buf Ro15n2n1n1 49259.6775555075
Ro15n2n1t2 Ro15n2n1n1 Ro15n2n1n2 49019.9739771548
Ro15n2n1t3 Ro15n2n1n2 Ro15n2n1n3 49104.2045587883
Ro15n2n1t4 Ro15n2n1n3 o15n 48862.6584944618
* o15 input 3 w=+0.0133598434574407 w+  bank=f alpha=0.001 R=2495.03921505672 G_phys=0.00040079530372322 G_eff=4.0079530372322e-07
* tiled Ro15p3f1 parallel x4  each=9980.15686022687
Ro15p3f1t1 h3f o15p 9997.51625355327
Ro15p3f1t2 h3f o15p 9993.68695269779
Ro15p3f1t3 h3f o15p 9973.76831639879
Ro15p3f1t4 h3f o15p 9959.93058864812
* o15 input 4 w=-0.169966115485037 w-  bank=n alpha=1 R=196117.52164959 G_phys=5.0989834645511e-06 G_eff=5.0989834645511e-06
* tiled Ro15n4n1 series x4  each=49029.3804123974
Ro15n4n1t1 h4buf Ro15n4n1n1 48978.8053190565
Ro15n4n1t2 Ro15n4n1n1 Ro15n4n1n2 49189.0903967417
Ro15n4n1t3 Ro15n4n1n2 Ro15n4n1n3 48893.3067699849
Ro15n4n1t4 Ro15n4n1n3 o15n 48842.1123785395
* o15 input 5 w=-0.0418903282162887 w-  bank=n alpha=1 R=795728.626455878 G_phys=1.25670984648866e-06 G_eff=1.25670984648866e-06
* tiled Ro15n5n1 series x4  each=198932.15661397
Ro15n5n1t1 h5buf Ro15n5n1n1 198348.697537245
Ro15n5n1t2 Ro15n5n1n1 Ro15n5n1n2 198341.817774613
Ro15n5n1t3 Ro15n5n1n2 Ro15n5n1n3 199587.550911345
Ro15n5n1t4 Ro15n5n1n3 o15n 199863.650534851
* o15 input 6 w=-0.324291927905124 w-  bank=n alpha=1 R=102788.045168628 G_phys=9.72875783715372e-06 G_eff=9.72875783715372e-06
* tiled Ro15n6n1 series x4  each=25697.011292157
Ro15n6n1t1 h6buf Ro15n6n1n1 25737.4911525989
Ro15n6n1t2 Ro15n6n1n1 Ro15n6n1n2 25722.1222049446
Ro15n6n1t3 Ro15n6n1n2 Ro15n6n1n3 25667.7794387237
Ro15n6n1t4 Ro15n6n1n3 o15n 25717.0148703006
* o15 input 7 w=+0.558916704640692 w+  bank=n alpha=1 R=59639.1788911769 G_phys=1.67675011392208e-05 G_eff=1.67675011392208e-05
* tiled Ro15p7n1 series x4  each=14909.7947227942
Ro15p7n1t1 h7buf Ro15p7n1n1 14840.7367257836
Ro15p7n1t2 Ro15p7n1n1 Ro15p7n1n2 14891.9721850892
Ro15p7n1t3 Ro15p7n1n2 Ro15p7n1n3 14981.548622858
Ro15p7n1t4 Ro15p7n1n3 o15p 14936.6913926484
* o15 input 8 w=-0.047599242693459 w-  bank=n alpha=1 R=700291.253539501 G_phys=1.42797728080377e-06 G_eff=1.42797728080377e-06
* tiled Ro15n8n1 series x4  each=175072.813384875
Ro15n8n1t1 h8buf Ro15n8n1n1 174307.766228648
Ro15n8n1t2 Ro15n8n1n1 Ro15n8n1n2 174568.393033363
Ro15n8n1t3 Ro15n8n1n2 Ro15n8n1n3 175714.814678384
Ro15n8n1t4 Ro15n8n1n3 o15n 174699.374475173
* o15 input 9 w=-0.103084990895521 w-  bank=n alpha=1 R=323357.775402217 G_phys=3.09254972686562e-06 G_eff=3.09254972686562e-06
* tiled Ro15n9n1 series x4  each=80839.4438505541
Ro15n9n1t1 h9buf Ro15n9n1n1 80744.5551235327
Ro15n9n1t2 Ro15n9n1n1 Ro15n9n1n2 80884.9505204732
Ro15n9n1t3 Ro15n9n1n2 Ro15n9n1n3 81120.5502328512
Ro15n9n1t4 Ro15n9n1n3 o15n 80981.9808579235
* o15 input 10 w=-0.115049291784761 w-  bank=n alpha=1 R=289730.886789766 G_phys=3.45147875354283e-06 G_eff=3.45147875354283e-06
* tiled Ro15n10n1 series x4  each=72432.7216974415
Ro15n10n1t1 h10buf Ro15n10n1n1 72273.9548567962
Ro15n10n1t2 Ro15n10n1n1 Ro15n10n1n2 72512.8551188693
Ro15n10n1t3 Ro15n10n1n2 Ro15n10n1n3 72744.8284656524
Ro15n10n1t4 Ro15n10n1n3 o15n 72573.0365629377
* o15 input 11 w=+0.0920546297717411 w+  bank=n alpha=1 R=362103.822653861 G_phys=2.76163889315223e-06 G_eff=2.76163889315223e-06
* tiled Ro15p11n1 series x4  each=90525.9556634652
Ro15p11n1t1 h11buf Ro15p11n1n1 90619.1758993903
Ro15p11n1t2 Ro15p11n1n1 Ro15p11n1n2 90285.9424059462
Ro15p11n1t3 Ro15p11n1n2 Ro15p11n1n3 90777.3941516786
Ro15p11n1t4 Ro15p11n1n3 o15p 90788.4094592944
* o15 input 12 w=+0.0505985364133342 w+  bank=n alpha=1 R=658780.583316418 G_phys=1.51795609240003e-06 G_eff=1.51795609240003e-06
* tiled Ro15p12n1 series x4  each=164695.145829105
Ro15p12n1t1 h12buf Ro15p12n1n1 164497.080486573
Ro15p12n1t2 Ro15p12n1n1 Ro15p12n1n2 164690.175111126
Ro15p12n1t3 Ro15p12n1n2 Ro15p12n1n3 165351.764726675
Ro15p12n1t4 Ro15p12n1n3 o15p 165093.397121184
* o15 input 13 w=-0.145296396139138 w-  bank=n alpha=1 R=229416.105416771 G_phys=4.35889188417414e-06 G_eff=4.35889188417414e-06
* tiled Ro15n13n1 series x4  each=57354.0263541926
Ro15n13n1t1 h13buf Ro15n13n1n1 57400.7201749013
Ro15n13n1t2 Ro15n13n1n1 Ro15n13n1n2 57073.273465478
Ro15n13n1t3 Ro15n13n1n2 Ro15n13n1n3 57357.2561809668
Ro15n13n1t4 Ro15n13n1n3 o15n 57185.7597522512
* o15 input 14 w=-0.379881852318272 w-  bank=n alpha=1 R=87746.579969306 G_phys=1.13964555695482e-05 G_eff=1.13964555695482e-05
* tiled Ro15n14n1 series x4  each=21936.6449923265
Ro15n14n1t1 h14buf Ro15n14n1n1 21870.3232251552
Ro15n14n1t2 Ro15n14n1n1 Ro15n14n1n2 21911.5765654107
Ro15n14n1t3 Ro15n14n1n2 Ro15n14n1n3 21929.4081868928
Ro15n14n1t4 Ro15n14n1n3 o15n 21882.4788176089
* o15 input 15 w=+0.223112491519187 w+  bank=n alpha=1 R=149401.466078231 G_phys=6.69337474557561e-06 G_eff=6.69337474557561e-06
* tiled Ro15p15n1 series x4  each=37350.3665195576
Ro15p15n1t1 h15buf Ro15p15n1n1 37375.699697072
Ro15p15n1t2 Ro15p15n1n1 Ro15p15n1n2 37313.4696202648
Ro15p15n1t3 Ro15p15n1n2 Ro15p15n1n3 37252.9781257566
Ro15p15n1t4 Ro15p15n1n3 o15p 37231.6152376553
* o15 input 16 w=-0.14757878301826 w-  bank=n alpha=1 R=225868.059429714 G_phys=4.42736349054781e-06 G_eff=4.42736349054781e-06
* tiled Ro15n16n1 series x4  each=56467.0148574286
Ro15n16n1t1 h16buf Ro15n16n1n1 56696.5764471461
Ro15n16n1t2 Ro15n16n1n1 Ro15n16n1n2 56712.5314382891
Ro15n16n1t3 Ro15n16n1n2 Ro15n16n1n3 56544.3932326481
Ro15n16n1t4 Ro15n16n1n3 o15n 56431.7794314006
* o15 input 17 w=+0.173921977011029 w+  bank=n alpha=1 R=191656.821674811 G_phys=5.21765931033087e-06 G_eff=5.21765931033087e-06
* tiled Ro15p17n1 series x4  each=47914.2054187027
Ro15p17n1t1 h17buf Ro15p17n1n1 47714.831450611
Ro15p17n1t2 Ro15p17n1n1 Ro15p17n1n2 47753.6403758154
Ro15p17n1t3 Ro15p17n1n2 Ro15p17n1n3 48086.4482668185
Ro15p17n1t4 Ro15p17n1n3 o15p 47697.9407637951
* o15 input 18 w=+0.133725887369399 w+  bank=n alpha=1 R=249266.121833648 G_phys=4.01177662108198e-06 G_eff=4.01177662108198e-06
* tiled Ro15p18n1 series x4  each=62316.5304584119
Ro15p18n1t1 h18buf Ro15p18n1n1 62596.9184608859
Ro15p18n1t2 Ro15p18n1n1 Ro15p18n1n2 62530.5914410212
Ro15p18n1t3 Ro15p18n1n2 Ro15p18n1n3 62377.2419311179
Ro15p18n1t4 Ro15p18n1n3 o15p 62026.1071036561
* o15 input 19 w=+0.209560948195519 w+  bank=n alpha=1 R=159062.714787077 G_phys=6.28682844586558e-06 G_eff=6.28682844586558e-06
* tiled Ro15p19n1 series x4  each=39765.6786967693
Ro15p19n1t1 h19buf Ro15p19n1n1 39727.6627538061
Ro15p19n1t2 Ro15p19n1n1 Ro15p19n1n2 39754.7490550712
Ro15p19n1t3 Ro15p19n1n2 Ro15p19n1n3 39658.0292796862
Ro15p19n1t4 Ro15p19n1n3 o15p 39926.4438526571
* o15 input 20 w=-0.0239329977507233 w-  bank=f alpha=0.001 R=1392.7771890726 G_phys=0.000717989932521699 G_eff=7.179899325217e-07
* tiled Ro15n20f1 parallel x4  each=5571.10875629041
Ro15n20f1t1 h20f o15n 5558.59722693902
Ro15n20f1t2 h20f o15n 5587.82733019487
Ro15n20f1t3 h20f o15n 5562.9526801942
Ro15n20f1t4 h20f o15n 5569.60857229606
* o15 input 21 w=+0.196041920231295 w+  bank=n alpha=1 R=170031.661054972 G_phys=5.88125760693885e-06 G_eff=5.88125760693885e-06
* tiled Ro15p21n1 series x4  each=42507.9152637429
Ro15p21n1t1 h21buf Ro15p21n1n1 42566.6439117429
Ro15p21n1t2 Ro15p21n1n1 Ro15p21n1n2 42378.8185892919
Ro15p21n1t3 Ro15p21n1n2 Ro15p21n1n3 42564.6760658672
Ro15p21n1t4 Ro15p21n1n3 o15p 42351.7952297923
* o15 input 22 w=-0.0995510863910355 w-  bank=n alpha=1 R=334836.459769011 G_phys=2.98653259173107e-06 G_eff=2.98653259173107e-06
* tiled Ro15n22n1 series x4  each=83709.1149422528
Ro15n22n1t1 h22buf Ro15n22n1n1 83926.5529831511
Ro15n22n1t2 Ro15n22n1n1 Ro15n22n1n2 83654.7025623422
Ro15n22n1t3 Ro15n22n1n2 Ro15n22n1n3 84087.6439482283
Ro15n22n1t4 Ro15n22n1n3 o15n 83545.9136544338
* o15 input 23 w=+0.102107365264583 w+  bank=n alpha=1 R=326453.760186243 G_phys=3.06322095793749e-06 G_eff=3.06322095793749e-06
* tiled Ro15p23n1 series x4  each=81613.4400465607
Ro15p23n1t1 h23buf Ro15p23n1n1 81315.3011435091
Ro15p23n1t2 Ro15p23n1n1 Ro15p23n1n2 81600.0311308677
Ro15p23n1t3 Ro15p23n1n2 Ro15p23n1n3 81636.0054130544
Ro15p23n1t4 Ro15p23n1n3 o15p 81843.9910780692
* o15 input 24 w=-0.21795159550845 w-  bank=n alpha=1 R=152939.157226958 G_phys=6.53854786525351e-06 G_eff=6.53854786525351e-06
* tiled Ro15n24n1 series x4  each=38234.7893067396
Ro15n24n1t1 h24buf Ro15n24n1n1 38113.7208607438
Ro15n24n1t2 Ro15n24n1n1 Ro15n24n1n2 38213.1043581011
Ro15n24n1t3 Ro15n24n1n2 Ro15n24n1n3 38050.8988127416
Ro15n24n1t4 Ro15n24n1n3 o15n 38409.194108417
* o15 input 25 w=+0.202525001628457 w+  bank=n alpha=1 R=164588.732577744 G_phys=6.07575004885372e-06 G_eff=6.07575004885372e-06
* tiled Ro15p25n1 series x4  each=41147.183144436
Ro15p25n1t1 h25buf Ro15p25n1n1 41208.6050923508
Ro15p25n1t2 Ro15p25n1n1 Ro15p25n1n2 41125.9538625848
Ro15p25n1t3 Ro15p25n1n2 Ro15p25n1n3 41103.5000827281
Ro15p25n1t4 Ro15p25n1n3 o15p 41185.065909364
* o15 input 26 w=-0.281017181998367 w-  bank=n alpha=1 R=118616.709114701 G_phys=8.43051545995101e-06 G_eff=8.43051545995101e-06
* tiled Ro15n26n1 series x4  each=29654.1772786753
Ro15n26n1t1 h26buf Ro15n26n1n1 29556.9917996118
Ro15n26n1t2 Ro15n26n1n1 Ro15n26n1n2 29729.2269025025
Ro15n26n1t3 Ro15n26n1n2 Ro15n26n1n3 29556.9268076712
Ro15n26n1t4 Ro15n26n1n3 o15n 29529.190194056
* o15 input 27 w=+0.141610254018665 w+  bank=n alpha=1 R=235387.850719764 G_phys=4.24830762055994e-06 G_eff=4.24830762055994e-06
* tiled Ro15p27n1 series x4  each=58846.9626799411
Ro15p27n1t1 h27buf Ro15p27n1n1 58736.4751393533
Ro15p27n1t2 Ro15p27n1n1 Ro15p27n1n2 59088.7027725659
Ro15p27n1t3 Ro15p27n1n2 Ro15p27n1n3 58988.3036262668
Ro15p27n1t4 Ro15p27n1n3 o15p 59040.4993106713
* o15 input 28 w=+0.444984802739648 w+  bank=n alpha=1 R=74908.9252669063 G_phys=1.33495440821894e-05 G_eff=1.33495440821894e-05
* tiled Ro15p28n1 series x4  each=18727.2313167266
Ro15p28n1t1 h28buf Ro15p28n1n1 18793.6598261219
Ro15p28n1t2 Ro15p28n1n1 Ro15p28n1n2 18708.4718938444
Ro15p28n1t3 Ro15p28n1n2 Ro15p28n1n3 18808.3087404088
Ro15p28n1t4 Ro15p28n1n3 o15p 18679.5276234422
* o15 input 29 w=-0.120073433142323 w-  bank=n alpha=1 R=277607.897608986 G_phys=3.60220299426968e-06 G_eff=3.60220299426968e-06
* tiled Ro15n29n1 series x4  each=69401.9744022465
Ro15n29n1t1 h29buf Ro15n29n1n1 69317.5739659577
Ro15n29n1t2 Ro15n29n1n1 Ro15n29n1n2 69435.1271343496
Ro15n29n1t3 Ro15n29n1n2 Ro15n29n1n3 69503.8361568799
Ro15n29n1t4 Ro15n29n1n3 o15n 69529.2401195798
* o15 input 30 w=-0.0538706707421541 w-  bank=n alpha=1 R=618765.886411172 G_phys=1.61612012226462e-06 G_eff=1.61612012226462e-06
* tiled Ro15n30n1 series x4  each=154691.471602793
Ro15n30n1t1 h30buf Ro15n30n1n1 154544.387602319
Ro15n30n1t2 Ro15n30n1n1 Ro15n30n1n2 154481.631837032
Ro15n30n1t3 Ro15n30n1n2 Ro15n30n1n3 155102.423856038
Ro15n30n1t4 Ro15n30n1n3 o15n 154560.882505242
* o15 input 31 w=+0.148090323839994 w+  bank=n alpha=1 R=225087.854959036 G_phys=4.44270971519983e-06 G_eff=4.44270971519983e-06
* tiled Ro15p31n1 series x4  each=56271.9637397591
Ro15p31n1t1 h31buf Ro15p31n1n1 56366.2419787562
Ro15p31n1t2 Ro15p31n1n1 Ro15p31n1n2 56159.8499253404
Ro15p31n1t3 Ro15p31n1n2 Ro15p31n1n3 56039.8041718051
Ro15p31n1t4 Ro15p31n1n3 o15p 56522.6365420643
* o15 input 32 w=-0.347735979661958 w-  bank=n alpha=1 R=95858.1662033862 G_phys=1.04320793898588e-05 G_eff=1.04320793898588e-05
* tiled Ro15n32n1 series x4  each=23964.5415508465
Ro15n32n1t1 h32buf Ro15n32n1n1 23879.5610993774
Ro15n32n1t2 Ro15n32n1n1 Ro15n32n1n2 23881.995187202
Ro15n32n1t3 Ro15n32n1n2 Ro15n32n1n3 24070.7339024416
Ro15n32n1t4 Ro15n32n1n3 o15n 23871.7448694267
* o15 bias=+0.0711229172621247 b+  bank=n alpha=1 R=468672.189169108 G_phys=2.13368751786374e-06 G_eff=2.13368751786374e-06
* tiled Ro15bpn1 series x4  each=117168.047292277
Ro15bpn1t1 vref Ro15bpn1n1 116628.454075651
Ro15bpn1t2 Ro15bpn1n1 Ro15bpn1n2 117113.534657639
Ro15bpn1t3 Ro15bpn1n2 Ro15bpn1n3 117078.447364847
Ro15bpn1t4 Ro15bpn1n3 o15p 116833.50158354
Vo15p o15p 0 DC 0
Vo15n o15n 0 DC 0
Fo15p 0 o15d Vo15p 1.001
Fo15n o15d 0 Vo15n 1.001
* ratiometric I-to-V: V = I * R_IV,  R_IV=33333.3333333333 (weight ~ R_IV / R_w)
* tiled Ro15iv series x4  each=8333.33333333333
Ro15ivt1 o15d Ro15ivn1 8347.48649568983
Ro15ivt2 Ro15ivn1 Ro15ivn2 8310.35509615028
Ro15ivt3 Ro15ivn2 Ro15ivn3 8328.24357247513
Ro15ivt4 Ro15ivn3 0 8335.29371749361
Bo15leak 0 o15d I = 1e-08
Eo15sc o15raw 0 o15d 0 1
Eo15lin o15lin 0 o15raw 0 1

* o16 input 1 w=-0.0239168211298723 w-  bank=f alpha=0.001 R=1393.71922181162 G_phys=0.000717504633896169 G_eff=7.17504633896169e-07
* tiled Ro16n1f1 parallel x4  each=5574.87688724648
Ro16n1f1t1 h1f o16n 5597.06767667532
Ro16n1f1t2 h1f o16n 5572.89386955556
Ro16n1f1t3 h1f o16n 5577.65877719466
Ro16n1f1t4 h1f o16n 5601.95151437099
* o16 input 2 w=-0.455843018824687 w-  bank=n alpha=1 R=73124.5888535874 G_phys=1.36752905647406e-05 G_eff=1.36752905647406e-05
* tiled Ro16n2n1 series x4  each=18281.1472133969
Ro16n2n1t1 h2buf Ro16n2n1n1 18195.0155532296
Ro16n2n1t2 Ro16n2n1n1 Ro16n2n1n2 18351.4974037266
Ro16n2n1t3 Ro16n2n1n2 Ro16n2n1n3 18247.2289270772
Ro16n2n1t4 Ro16n2n1n3 o16n 18324.883051594
* o16 input 3 w=-0.360558107273835 w-  bank=n alpha=1 R=92449.2686778431 G_phys=1.0816743218215e-05 G_eff=1.0816743218215e-05
* tiled Ro16n3n1 series x4  each=23112.3171694608
Ro16n3n1t1 h3buf Ro16n3n1n1 23059.360961489
Ro16n3n1t2 Ro16n3n1n1 Ro16n3n1n2 23162.1553548831
Ro16n3n1t3 Ro16n3n1n2 Ro16n3n1n3 23093.1166226371
Ro16n3n1t4 Ro16n3n1n3 o16n 23099.0973564643
* o16 input 4 w=+0.281324980833712 w+  bank=n alpha=1 R=118486.930078336 G_phys=8.43974942501135e-06 G_eff=8.43974942501135e-06
* tiled Ro16p4n1 series x4  each=29621.7325195841
Ro16p4n1t1 h4buf Ro16p4n1n1 29723.4645590877
Ro16p4n1t2 Ro16p4n1n1 Ro16p4n1n2 29717.6164415767
Ro16p4n1t3 Ro16p4n1n2 Ro16p4n1n3 29743.4861087238
Ro16p4n1t4 Ro16p4n1n3 o16p 29574.1909986761
* o16 input 5 w=-0.0789059543438914 w-  bank=n alpha=1 R=422443.827091407 G_phys=2.36717863031674e-06 G_eff=2.36717863031674e-06
* tiled Ro16n5n1 series x4  each=105610.956772852
Ro16n5n1t1 h5buf Ro16n5n1n1 105995.880391567
Ro16n5n1t2 Ro16n5n1n1 Ro16n5n1n2 105908.420395599
Ro16n5n1t3 Ro16n5n1n2 Ro16n5n1n3 105683.444964619
Ro16n5n1t4 Ro16n5n1n3 o16n 105815.946774877
* o16 input 6 w=+0.0459206910877794 w+  bank=n alpha=1 R=725889.191641633 G_phys=1.37762073263338e-06 G_eff=1.37762073263338e-06
* tiled Ro16p6n1 series x4  each=181472.297910408
Ro16p6n1t1 h6buf Ro16p6n1n1 180841.251536491
Ro16p6n1t2 Ro16p6n1n1 Ro16p6n1n2 182277.64408621
Ro16p6n1t3 Ro16p6n1n2 Ro16p6n1n3 182234.744309951
Ro16p6n1t4 Ro16p6n1n3 o16p 182366.855022547
* o16 input 7 w=-0.348093944852844 w-  bank=n alpha=1 R=95759.5896918717 G_phys=1.04428183455853e-05 G_eff=1.04428183455853e-05
* tiled Ro16n7n1 series x4  each=23939.8974229679
Ro16n7n1t1 h7buf Ro16n7n1n1 23936.9610366601
Ro16n7n1t2 Ro16n7n1n1 Ro16n7n1n2 24046.1362178855
Ro16n7n1t3 Ro16n7n1n2 Ro16n7n1n3 23870.0127425525
Ro16n7n1t4 Ro16n7n1n3 o16n 24048.2374170419
* o16 input 8 w=-0.0796710739452782 w-  bank=n alpha=1 R=418386.896055 G_phys=2.39013221835835e-06 G_eff=2.39013221835835e-06
* tiled Ro16n8n1 series x4  each=104596.72401375
Ro16n8n1t1 h8buf Ro16n8n1n1 105066.037744597
Ro16n8n1t2 Ro16n8n1n1 Ro16n8n1n2 104119.929980646
Ro16n8n1t3 Ro16n8n1n2 Ro16n8n1n3 104556.479127527
Ro16n8n1t4 Ro16n8n1n3 o16n 104984.702459503
* o16 input 9 w=-0.173339228342165 w-  bank=n alpha=1 R=192301.15220967 G_phys=5.20017685026494e-06 G_eff=5.20017685026494e-06
* tiled Ro16n9n1 series x4  each=48075.2880524174
Ro16n9n1t1 h9buf Ro16n9n1n1 48288.8617394646
Ro16n9n1t2 Ro16n9n1n1 Ro16n9n1n2 48303.1066542014
Ro16n9n1t3 Ro16n9n1n2 Ro16n9n1n3 48109.216956697
Ro16n9n1t4 Ro16n9n1n3 o16n 48105.2559334945
* o16 input 10 w=+0.194262181446587 w+  bank=n alpha=1 R=171589.411202501 G_phys=5.82786544339762e-06 G_eff=5.82786544339762e-06
* tiled Ro16p10n1 series x4  each=42897.3528006253
Ro16p10n1t1 h10buf Ro16p10n1n1 42910.8672762416
Ro16p10n1t2 Ro16p10n1n1 Ro16p10n1n2 43070.285778472
Ro16p10n1t3 Ro16p10n1n2 Ro16p10n1n3 43048.2913640703
Ro16p10n1t4 Ro16p10n1n3 o16p 43033.9563442625
* o16 input 11 w=+0.155708231075043 w+  bank=n alpha=1 R=214075.602190025 G_phys=4.67124693225129e-06 G_eff=4.67124693225129e-06
* tiled Ro16p11n1 series x4  each=53518.9005475061
Ro16p11n1t1 h11buf Ro16p11n1n1 53402.4360707137
Ro16p11n1t2 Ro16p11n1n1 Ro16p11n1n2 53337.1109817309
Ro16p11n1t3 Ro16p11n1n2 Ro16p11n1n3 53417.8812555343
Ro16p11n1t4 Ro16p11n1n3 o16p 53500.9794849395
* o16 input 12 w=+0.124882648574468 w+  bank=n alpha=1 R=266917.251626487 G_phys=3.74647945723404e-06 G_eff=3.74647945723404e-06
* tiled Ro16p12n1 series x4  each=66729.3129066216
Ro16p12n1t1 h12buf Ro16p12n1n1 67055.3102698126
Ro16p12n1t2 Ro16p12n1n1 Ro16p12n1n2 66630.1706414317
Ro16p12n1t3 Ro16p12n1n2 Ro16p12n1n3 66567.7236936504
Ro16p12n1t4 Ro16p12n1n3 o16p 66994.1056144178
* o16 input 13 w=+0.270423516346849 w+  bank=n alpha=1 R=123263.441669694 G_phys=8.11270549040547e-06 G_eff=8.11270549040547e-06
* tiled Ro16p13n1 series x4  each=30815.8604174235
Ro16p13n1t1 h13buf Ro16p13n1n1 30700.8902797672
Ro16p13n1t2 Ro16p13n1n1 Ro16p13n1n2 30702.8242417066
Ro16p13n1t3 Ro16p13n1n2 Ro16p13n1n3 30964.087481932
Ro16p13n1t4 Ro16p13n1n3 o16p 30812.0441606867
* o16 input 14 w=-0.22936067173287 w-  bank=n alpha=1 R=145331.512510374 G_phys=6.88082015198609e-06 G_eff=6.88082015198609e-06
* tiled Ro16n14n1 series x4  each=36332.8781275935
Ro16n14n1t1 h14buf Ro16n14n1n1 36271.0645381213
Ro16n14n1t2 Ro16n14n1n1 Ro16n14n1n2 36304.3492894666
Ro16n14n1t3 Ro16n14n1n2 Ro16n14n1n3 36256.8260772708
Ro16n14n1t4 Ro16n14n1n3 o16n 36473.7292737902
* o16 input 15 w=+0.0349795005301705 w+  bank=n alpha=1 R=952939.087983336 G_phys=1.04938501590512e-06 G_eff=1.04938501590512e-06
* tiled Ro16p15n1 series x4  each=238234.771995834
Ro16p15n1t1 h15buf Ro16p15n1n1 239009.272402752
Ro16p15n1t2 Ro16p15n1n1 Ro16p15n1n2 237493.269580571
Ro16p15n1t3 Ro16p15n1n2 Ro16p15n1n3 238877.073835067
Ro16p15n1t4 Ro16p15n1n3 o16p 238577.972825229
* o16 input 16 w=+0.104322324768401 w+  bank=n alpha=1 R=319522.531800691 G_phys=3.12966974305203e-06 G_eff=3.12966974305203e-06
* tiled Ro16p16n1 series x4  each=79880.6329501726
Ro16p16n1t1 h16buf Ro16p16n1n1 79766.5065508823
Ro16p16n1t2 Ro16p16n1n1 Ro16p16n1n2 80017.0993140131
Ro16p16n1t3 Ro16p16n1n2 Ro16p16n1n3 80202.8769082234
Ro16p16n1t4 Ro16p16n1n3 o16p 79570.7791405841
* o16 input 17 w=-0.351176137449102 w-  bank=n alpha=1 R=94919.129686494 G_phys=1.05352841234731e-05 G_eff=1.05352841234731e-05
* tiled Ro16n17n1 series x4  each=23729.7824216235
Ro16n17n1t1 h17buf Ro16n17n1n1 23822.3227001958
Ro16n17n1t2 Ro16n17n1n1 Ro16n17n1n2 23742.6654941434
Ro16n17n1t3 Ro16n17n1n2 Ro16n17n1n3 23792.9918837282
Ro16n17n1t4 Ro16n17n1n3 o16n 23797.827506662
* o16 input 18 w=+0.119462358831177 w+  bank=n alpha=1 R=279027.918580107 G_phys=3.58387076493532e-06 G_eff=3.58387076493532e-06
* tiled Ro16p18n1 series x4  each=69756.9796450269
Ro16p18n1t1 h18buf Ro16p18n1n1 69880.794901167
Ro16p18n1t2 Ro16p18n1n1 Ro16p18n1n2 70054.296066713
Ro16p18n1t3 Ro16p18n1n2 Ro16p18n1n3 69484.0508144798
Ro16p18n1t4 Ro16p18n1n3 o16p 69607.3939197309
* o16 input 19 w=+0.230688311648174 w+  bank=n alpha=1 R=144495.111586626 G_phys=6.92064934944523e-06 G_eff=6.92064934944523e-06
* tiled Ro16p19n1 series x4  each=36123.7778966566
Ro16p19n1t1 h19buf Ro16p19n1n1 36006.3464950898
Ro16p19n1t2 Ro16p19n1n1 Ro16p19n1n2 36049.573950348
Ro16p19n1t3 Ro16p19n1n2 Ro16p19n1n3 36091.2712490152
Ro16p19n1t4 Ro16p19n1n3 o16p 36101.4687141033
* o16 input 20 w=-0.0614748986253126 w-  bank=n alpha=1 R=542226.731214294 G_phys=1.84424695875938e-06 G_eff=1.84424695875938e-06
* tiled Ro16n20n1 series x4  each=135556.682803574
Ro16n20n1t1 h20buf Ro16n20n1n1 135276.475918425
Ro16n20n1t2 Ro16n20n1n1 Ro16n20n1n2 135254.585687445
Ro16n20n1t3 Ro16n20n1n2 Ro16n20n1n3 135320.125374582
Ro16n20n1t4 Ro16n20n1n3 o16n 135764.66466454
* o16 input 21 w=+0.36727529530057 w+  bank=n alpha=1 R=90758.4413104999 G_phys=1.10182588590171e-05 G_eff=1.10182588590171e-05
* tiled Ro16p21n1 series x4  each=22689.610327625
Ro16p21n1t1 h21buf Ro16p21n1n1 22671.4243344761
Ro16p21n1t2 Ro16p21n1n1 Ro16p21n1n2 22628.3001770515
Ro16p21n1t3 Ro16p21n1n2 Ro16p21n1n3 22617.0364147837
Ro16p21n1t4 Ro16p21n1n3 o16p 22623.4553364357
* o16 input 22 w=+0.579638140801163 w+  bank=n alpha=1 R=57507.1427964708 G_phys=1.73891442240349e-05 G_eff=1.73891442240349e-05
* tiled Ro16p22n1 series x4  each=14376.7856991177
Ro16p22n1t1 h22buf Ro16p22n1n1 14410.8434969173
Ro16p22n1t2 Ro16p22n1n1 Ro16p22n1n2 14367.3304703643
Ro16p22n1t3 Ro16p22n1n2 Ro16p22n1n3 14355.2812933685
Ro16p22n1t4 Ro16p22n1n3 o16p 14336.9314354416
* o16 input 23 w=-0.0387096142803063 w-  bank=n alpha=1 R=861112.515664923 G_phys=1.16128842840919e-06 G_eff=1.16128842840919e-06
* tiled Ro16n23n1 series x4  each=215278.128916231
Ro16n23n1t1 h23buf Ro16n23n1n1 215744.394288244
Ro16n23n1t2 Ro16n23n1n1 Ro16n23n1n2 215562.101979889
Ro16n23n1t3 Ro16n23n1n2 Ro16n23n1n3 214583.431239235
Ro16n23n1t4 Ro16n23n1n3 o16n 216279.767218814
* o16 input 24 w=+0.0384174368738491 w+  bank=n alpha=1 R=867661.563232072 G_phys=1.15252310621547e-06 G_eff=1.15252310621547e-06
* tiled Ro16p24n1 series x4  each=216915.390808018
Ro16p24n1t1 h24buf Ro16p24n1n1 216815.40956646
Ro16p24n1t2 Ro16p24n1n1 Ro16p24n1n2 217536.34679145
Ro16p24n1t3 Ro16p24n1n2 Ro16p24n1n3 216060.78633141
Ro16p24n1t4 Ro16p24n1n3 o16p 216189.44622228
* o16 input 25 w=+0.201641208818347 w+  bank=n alpha=1 R=165310.12449624 G_phys=6.04923626455041e-06 G_eff=6.04923626455041e-06
* tiled Ro16p25n1 series x4  each=41327.5311240601
Ro16p25n1t1 h25buf Ro16p25n1n1 41270.6931578958
Ro16p25n1t2 Ro16p25n1n1 Ro16p25n1n2 41521.4583209779
Ro16p25n1t3 Ro16p25n1n2 Ro16p25n1n3 41336.8962764539
Ro16p25n1t4 Ro16p25n1n3 o16p 41393.5806996866
* o16 input 26 w=-0.606109769372092 w-  bank=n alpha=1 R=54995.5387913735 G_phys=1.81832930811628e-05 G_eff=1.81832930811628e-05
* tiled Ro16n26n1 series x4  each=13748.8846978434
Ro16n26n1t1 h26buf Ro16n26n1n1 13701.0790972881
Ro16n26n1t2 Ro16n26n1n1 Ro16n26n1n2 13710.8876248813
Ro16n26n1t3 Ro16n26n1n2 Ro16n26n1n3 13721.8505818888
Ro16n26n1t4 Ro16n26n1n3 o16n 13693.9128363825
* o16 input 27 w=-0.101484914332963 w-  bank=n alpha=1 R=328456.04248105 G_phys=3.04454742998888e-06 G_eff=3.04454742998888e-06
* tiled Ro16n27n1 series x4  each=82114.0106202624
Ro16n27n1t1 h27buf Ro16n27n1n1 82365.0711949909
Ro16n27n1t2 Ro16n27n1n1 Ro16n27n1n2 82229.0413812133
Ro16n27n1t3 Ro16n27n1n2 Ro16n27n1n3 82057.3760486454
Ro16n27n1t4 Ro16n27n1n3 o16n 82443.9609448524
* o16 input 28 w=+0.04265872854179 w+  bank=n alpha=1 R=781395.378455286 G_phys=1.2797618562537e-06 G_eff=1.2797618562537e-06
* tiled Ro16p28n1 series x4  each=195348.844613821
Ro16p28n1t1 h28buf Ro16p28n1n1 194777.43681359
Ro16p28n1t2 Ro16p28n1n1 Ro16p28n1n2 196259.273614417
Ro16p28n1t3 Ro16p28n1n2 Ro16p28n1n3 194841.85835289
Ro16p28n1t4 Ro16p28n1n3 o16p 196224.722816164
* o16 input 29 w=+0.0889131834636398 w+  bank=n alpha=1 R=374897.535267812 G_phys=2.66739550390919e-06 G_eff=2.66739550390919e-06
* tiled Ro16p29n1 series x4  each=93724.383816953
Ro16p29n1t1 h29buf Ro16p29n1n1 93672.2092633276
Ro16p29n1t2 Ro16p29n1n1 Ro16p29n1n2 93274.2547099523
Ro16p29n1t3 Ro16p29n1n2 Ro16p29n1n3 93617.5168962919
Ro16p29n1t4 Ro16p29n1n3 o16p 93709.9242762414
* o16 input 30 w=+0.0420485970959956 w+  bank=n alpha=1 R=792733.54250641 G_phys=1.26145791287987e-06 G_eff=1.26145791287987e-06
* tiled Ro16p30n1 series x4  each=198183.385626602
Ro16p30n1t1 h30buf Ro16p30n1n1 198705.564726411
Ro16p30n1t2 Ro16p30n1n1 Ro16p30n1n2 197575.452203785
Ro16p30n1t3 Ro16p30n1n2 Ro16p30n1n3 197513.233835279
Ro16p30n1t4 Ro16p30n1n3 o16p 197196.374178097
* o16 input 31 w=-0.332324220948992 w-  bank=n alpha=1 R=100303.652975236 G_phys=9.96972662846976e-06 G_eff=9.96972662846976e-06
* tiled Ro16n31n1 series x4  each=25075.913243809
Ro16n31n1t1 h31buf Ro16n31n1n1 25123.5942252225
Ro16n31n1t2 Ro16n31n1n1 Ro16n31n1n2 25110.4287138017
Ro16n31n1t3 Ro16n31n1n2 Ro16n31n1n3 25062.5535506112
Ro16n31n1t4 Ro16n31n1n3 o16n 25100.8346104838
* o16 input 32 w=+0.137132637809711 w+  bank=n alpha=1 R=243073.668425948 G_phys=4.11397913429134e-06 G_eff=4.11397913429134e-06
* tiled Ro16p32n1 series x4  each=60768.4171064869
Ro16p32n1t1 h32buf Ro16p32n1n1 60517.2962120712
Ro16p32n1t2 Ro16p32n1n1 Ro16p32n1n2 60579.7922592957
Ro16p32n1t3 Ro16p32n1n2 Ro16p32n1n3 60930.7815124402
Ro16p32n1t4 Ro16p32n1n3 o16p 60757.7476680759
* o16 bias=+0.0410780079484629 b+  bank=n alpha=1 R=811464.21158382 G_phys=1.23234023845389e-06 G_eff=1.23234023845389e-06
* tiled Ro16bpn1 series x4  each=202866.052895955
Ro16bpn1t1 vref Ro16bpn1n1 203026.223072886
Ro16bpn1t2 Ro16bpn1n1 Ro16bpn1n2 202684.995387044
Ro16bpn1t3 Ro16bpn1n2 Ro16bpn1n3 203680.448941263
Ro16bpn1t4 Ro16bpn1n3 o16p 203401.118575222
Vo16p o16p 0 DC 0
Vo16n o16n 0 DC 0
Fo16p 0 o16d Vo16p 1.001
Fo16n o16d 0 Vo16n 1.001
* ratiometric I-to-V: V = I * R_IV,  R_IV=33333.3333333333 (weight ~ R_IV / R_w)
* tiled Ro16iv series x4  each=8333.33333333333
Ro16ivt1 o16d Ro16ivn1 8301.55534945258
Ro16ivt2 Ro16ivn1 Ro16ivn2 8294.99214722122
Ro16ivt3 Ro16ivn2 Ro16ivn3 8363.58663815888
Ro16ivt4 Ro16ivn3 0 8306.17082034566
Bo16leak 0 o16d I = 1e-08
Eo16sc o16raw 0 o16d 0 1
Eo16lin o16lin 0 o16raw 0 1
.control
set numdgt=15
alter Vin1 DC 0.632806662832958
alter Vin2 DC 0.12910344039598
alter Vin3 DC 0.49834978033831
alter Vin4 DC 0.50907595064656
alter Vin5 DC 0.74349818979303
alter Vin6 DC -0.176647517025355
alter Vin7 DC -0.709872190396221
alter Vin8 DC -0.991897574307239
alter Vin9 DC 0.125692875531774
alter Vin10 DC 0.928123327453064
alter Vin11 DC 0.758248410073987
alter Vin12 DC -0.349051319927262
alter Vin13 DC 0.771795110161728
alter Vin14 DC 0.809051479331938
alter Vin15 DC 0.311432059393185
alter Vin16 DC 0.381501299071895
op
print v(o1lin)
print v(o2lin)
print v(o3lin)
print v(o4lin)
print v(o5lin)
print v(o6lin)
print v(o7lin)
print v(o8lin)
print v(o9lin)
print v(o10lin)
print v(o11lin)
print v(o12lin)
print v(o13lin)
print v(o14lin)
print v(o15lin)
print v(o16lin)
alter Vin1 DC -0.97362126165688
alter Vin2 DC -0.20248077872752
alter Vin3 DC 0.82165123084035
alter Vin4 DC 0.925838127958239
alter Vin5 DC -0.235641852811929
alter Vin6 DC -0.140283013864133
alter Vin7 DC -0.887120046748515
alter Vin8 DC 0.40459178430786
alter Vin9 DC -0.906079117735519
alter Vin10 DC -0.716258501199918
alter Vin11 DC 0.506684484344625
alter Vin12 DC -0.423527159234815
alter Vin13 DC -0.188113431918994
alter Vin14 DC -0.729994091818428
alter Vin15 DC -0.820814370580543
alter Vin16 DC 0.729291775339703
op
print v(o1lin)
print v(o2lin)
print v(o3lin)
print v(o4lin)
print v(o5lin)
print v(o6lin)
print v(o7lin)
print v(o8lin)
print v(o9lin)
print v(o10lin)
print v(o11lin)
print v(o12lin)
print v(o13lin)
print v(o14lin)
print v(o15lin)
print v(o16lin)
alter Vin1 DC 0.846445146733499
alter Vin2 DC -0.79598459783341
alter Vin3 DC -0.57712161478075
alter Vin4 DC 0.807803076139763
alter Vin5 DC -0.272284522985911
alter Vin6 DC 0.984395445957763
alter Vin7 DC 0.87358346571158
alter Vin8 DC -0.39723994124089
alter Vin9 DC -0.914758949716048
alter Vin10 DC -0.81593603132693
alter Vin11 DC 0.384188530472354
alter Vin12 DC 0.976158452213748
alter Vin13 DC 0.860032161578109
alter Vin14 DC -0.484754921691684
alter Vin15 DC -0.389237968061337
alter Vin16 DC -0.0775290314946673
op
print v(o1lin)
print v(o2lin)
print v(o3lin)
print v(o4lin)
print v(o5lin)
print v(o6lin)
print v(o7lin)
print v(o8lin)
print v(o9lin)
print v(o10lin)
print v(o11lin)
print v(o12lin)
print v(o13lin)
print v(o14lin)
print v(o15lin)
print v(o16lin)
alter Vin1 DC -0.633978942338751
alter Vin2 DC 0.661884789978104
alter Vin3 DC -0.0594737352959514
alter Vin4 DC 0.722044297958502
alter Vin5 DC 0.259408770512595
alter Vin6 DC 0.575419341544806
alter Vin7 DC 0.856728443393506
alter Vin8 DC -0.0996943208232113
alter Vin9 DC -0.298855737224273
alter Vin10 DC 0.530802246065167
alter Vin11 DC 0.0985819207905231
alter Vin12 DC -0.229034000990453
alter Vin13 DC -0.425032575484324
alter Vin14 DC -0.322526026748994
alter Vin15 DC 0.964313575560369
alter Vin16 DC 0.888249683253812
op
print v(o1lin)
print v(o2lin)
print v(o3lin)
print v(o4lin)
print v(o5lin)
print v(o6lin)
print v(o7lin)
print v(o8lin)
print v(o9lin)
print v(o10lin)
print v(o11lin)
print v(o12lin)
print v(o13lin)
print v(o14lin)
print v(o15lin)
print v(o16lin)
alter Vin1 DC 0.399697487979084
alter Vin2 DC 0.822040723862099
alter Vin3 DC -0.21796471591394
alter Vin4 DC -0.522274848520139
alter Vin5 DC -0.344077855245197
alter Vin6 DC 0.598378315182593
alter Vin7 DC 0.746245450024059
alter Vin8 DC -0.310118869408844
alter Vin9 DC -0.551168306020734
alter Vin10 DC 0.508539366184392
alter Vin11 DC 0.968383160505887
alter Vin12 DC 0.435980043708068
alter Vin13 DC -0.637606352060199
alter Vin14 DC -0.610311157816348
alter Vin15 DC -0.0259385918835956
alter Vin16 DC 0.865645264317594
op
print v(o1lin)
print v(o2lin)
print v(o3lin)
print v(o4lin)
print v(o5lin)
print v(o6lin)
print v(o7lin)
print v(o8lin)
print v(o9lin)
print v(o10lin)
print v(o11lin)
print v(o12lin)
print v(o13lin)
print v(o14lin)
print v(o15lin)
print v(o16lin)
alter Vin1 DC -0.399268465451532
alter Vin2 DC 0.845019210326623
alter Vin3 DC -0.292458640932421
alter Vin4 DC -0.935999575855453
alter Vin5 DC -0.0802329680860277
alter Vin6 DC -0.899313674820603
alter Vin7 DC -0.554373834033999
alter Vin8 DC 0.759696630012423
alter Vin9 DC 0.761675284131055
alter Vin10 DC -0.948332079947448
alter Vin11 DC 0.031947883404111
alter Vin12 DC -0.0277751119779371
alter Vin13 DC -0.580425900813694
alter Vin14 DC 0.907369791876862
alter Vin15 DC -0.0726108119089597
alter Vin16 DC 0.0683134332031523
op
print v(o1lin)
print v(o2lin)
print v(o3lin)
print v(o4lin)
print v(o5lin)
print v(o6lin)
print v(o7lin)
print v(o8lin)
print v(o9lin)
print v(o10lin)
print v(o11lin)
print v(o12lin)
print v(o13lin)
print v(o14lin)
print v(o15lin)
print v(o16lin)
alter Vin1 DC -0.270106770373158
alter Vin2 DC -0.0593501081153218
alter Vin3 DC -0.938361622768156
alter Vin4 DC 0.373875466305193
alter Vin5 DC -0.641578795395846
alter Vin6 DC 0.285383888822187
alter Vin7 DC 0.495538058171767
alter Vin8 DC 0.485433858149023
alter Vin9 DC 0.865739610534779
alter Vin10 DC -0.63839783970223
alter Vin11 DC 0.140854361675759
alter Vin12 DC -0.79290537659306
alter Vin13 DC 0.802793263596096
alter Vin14 DC 0.646133043860875
alter Vin15 DC 0.802984846928791
alter Vin16 DC 0.00133321425662828
op
print v(o1lin)
print v(o2lin)
print v(o3lin)
print v(o4lin)
print v(o5lin)
print v(o6lin)
print v(o7lin)
print v(o8lin)
print v(o9lin)
print v(o10lin)
print v(o11lin)
print v(o12lin)
print v(o13lin)
print v(o14lin)
print v(o15lin)
print v(o16lin)
alter Vin1 DC -0.67831148797028
alter Vin2 DC 0.970634730086014
alter Vin3 DC 0.023061904780391
alter Vin4 DC -0.680978836444958
alter Vin5 DC 0.936729898964734
alter Vin6 DC 0.408194555027121
alter Vin7 DC 0.0487210799419546
alter Vin8 DC 0.829193515238021
alter Vin9 DC 0.782956200940303
alter Vin10 DC 0.206749046668065
alter Vin11 DC 0.218538319202768
alter Vin12 DC -0.647241206726223
alter Vin13 DC -0.449882036341183
alter Vin14 DC -0.166000010655126
alter Vin15 DC 0.57047241867899
alter Vin16 DC -0.894103971179292
op
print v(o1lin)
print v(o2lin)
print v(o3lin)
print v(o4lin)
print v(o5lin)
print v(o6lin)
print v(o7lin)
print v(o8lin)
print v(o9lin)
print v(o10lin)
print v(o11lin)
print v(o12lin)
print v(o13lin)
print v(o14lin)
print v(o15lin)
print v(o16lin)
.endc

.end
