* Physical AI - Experiment 14 architecture D: ratiometric fabric (physical R_IV, weight ~ R_IV/R_w)
* Frozen Experiment 9 weights. No Python output correction.
* Behavioral variation study. Not transistor-level or PCB power.
* divider Ra=999000 Rb=1000 beta=0.001 Ileak=0 rail=15 linear=False k1=1 k2=1 physical_iv=True
* shape: 2 -> 4 -> 1

Vin1 in1 0 DC 0
* tiled Rdiv1a series x2  each=499500
Rdiv1at1 in1 Rdiv1an1 500553.199256495
Rdiv1at2 Rdiv1an1 tap1 503907.859669039
* tiled Rdiv1b parallel x2  each=2000
Rdiv1bt1 tap1 0 2009.61817852954
Rdiv1bt2 tap1 0 2017.2133961468
Ediv1 inf1 0 tap1 0 1
Vin2 in2 0 DC 0
* tiled Rdiv2a series x2  each=499500
Rdiv2at1 in2 Rdiv2an1 497982.841259579
Rdiv2at2 Rdiv2an1 tap2 497421.306624392
* tiled Rdiv2b parallel x2  each=2000
Rdiv2bt1 tap2 0 1994.75384903962
Rdiv2bt2 tap2 0 2012.56416186054
Ediv2 inf2 0 tap2 0 1
Vref vref 0 DC 1
* tiled Rdivrefa series x2  each=499500
Rdivrefat1 vref Rdivrefan1 499468.746231072
Rdivrefat2 Rdivrefan1 tapref 500416.364672947
* tiled Rdivrefb parallel x2  each=2000
Rdivrefbt1 tapref 0 1980.20647450317
Rdivrefbt2 tapref 0 1980.95658161375
Edivref vreff 0 tapref 0 1

* h1 input 1 w=+0.683760795348816 w+  bank=n alpha=1 R=48749.9920441162 G_phys=2.05128238604645e-05 G_eff=2.05128238604645e-05
* tiled Rh1p1n1 series x2  each=24374.9960220581
Rh1p1n1t1 in1 Rh1p1n1n1 24575.4468801121
Rh1p1n1t2 Rh1p1n1n1 h1p 24205.9301331505
* h1 input 2 w=+0.309366783045794 w+  bank=n alpha=1 R=107746.969487669 G_phys=9.28100349137382e-06 G_eff=9.28100349137382e-06
* tiled Rh1p2n1 series x2  each=53873.4847438343
Rh1p2n1t1 in2 Rh1p2n1n1 54301.1815393358
Rh1p2n1t2 Rh1p2n1n1 h1p 54294.3730170915
* h1 bias=-0.0265987962576462 b-  bank=f alpha=0.001 R=1253.18954325804 G_phys=0.000797963887729386 G_eff=7.97963887729385e-07
* tiled Rh1bnf1 parallel x2  each=2506.37908651608
Rh1bnf1t1 vreff h1n 2530.45178164839
Rh1bnf1t2 vreff h1n 2494.26075382796
Vh1p h1p 0 DC 0
Vh1n h1n 0 DC 0
Fh1p 0 h1d Vh1p 1
Fh1n h1d 0 Vh1n 1
* ratiometric I-to-V: V = I * R_IV,  R_IV=33333.3333333333 (weight ~ R_IV / R_w)
* tiled Rh1iv series x2  each=16666.6666666667
Rh1ivt1 h1d Rh1ivn1 16543.2261990756
Rh1ivt2 Rh1ivn1 0 16771.9249167054
Eh1sc h1raw 0 h1d 0 1
Eh1lin h1lin 0 h1raw 0 1
* direct bounded ReLU: y=max(0, min(15, v(h1lin))) no high-gain op-amp loop
Bh1relu h1y 0 V = max(0, min(15, v(h1lin)))
Eh1 h1buf 0 h1y 0 1

* h2 input 1 w=-0.884821731731664 w-  bank=n alpha=1 R=37672.3718890781 G_phys=2.65446519519499e-05 G_eff=2.65446519519499e-05
* tiled Rh2n1n1 series x2  each=18836.1859445391
Rh2n1n1t1 in1 Rh2n1n1n1 18967.9414633497
Rh2n1n1t2 Rh2n1n1n1 h2n 18819.9124398636
* h2 input 2 w=+0.782653240240456 w+  bank=n alpha=1 R=42590.1684417639 G_phys=2.34795972072137e-05 G_eff=2.34795972072137e-05
* tiled Rh2p2n1 series x2  each=21295.084220882
Rh2p2n1t1 in2 Rh2p2n1n1 21231.2639358907
Rh2p2n1t2 Rh2p2n1n1 h2p 21462.1555383893
* h2 bias=+5.94215208512688e-05 b+  bank=f alpha=0.001 R=560963.988396833 G_phys=1.78264562553806e-06 G_eff=1.78264562553806e-09
* tiled Rh2bpf1 series x2  each=280481.994198416
Rh2bpf1t1 vreff Rh2bpf1n1 281694.134642024
Rh2bpf1t2 Rh2bpf1n1 h2p 280113.369458523
Vh2p h2p 0 DC 0
Vh2n h2n 0 DC 0
Fh2p 0 h2d Vh2p 1
Fh2n h2d 0 Vh2n 1
* ratiometric I-to-V: V = I * R_IV,  R_IV=33333.3333333333 (weight ~ R_IV / R_w)
* tiled Rh2iv series x2  each=16666.6666666667
Rh2ivt1 h2d Rh2ivn1 16640.6125172522
Rh2ivt2 Rh2ivn1 0 16651.9772694352
Eh2sc h2raw 0 h2d 0 1
Eh2lin h2lin 0 h2raw 0 1
* direct bounded ReLU: y=max(0, min(15, v(h2lin))) no high-gain op-amp loop
Bh2relu h2y 0 V = max(0, min(15, v(h2lin)))
Eh2 h2buf 0 h2y 0 1

* h3 input 1 w=+0.80723931339229 w+  bank=n alpha=1 R=41293.0004526854 G_phys=2.42171794017687e-05 G_eff=2.42171794017687e-05
* tiled Rh3p1n1 series x2  each=20646.5002263427
Rh3p1n1t1 in1 Rh3p1n1n1 20683.7211104966
Rh3p1n1t2 Rh3p1n1n1 h3p 20536.4985802342
* h3 input 2 w=+1.71882311343666 w+  bank=n alpha=1 R=19393.1144355429 G_phys=5.15646934030999e-05 G_eff=5.15646934030999e-05
* tiled Rh3p2n1 series x2  each=9696.55721777144
Rh3p2n1t1 in2 Rh3p2n1n1 9619.13441011316
Rh3p2n1t2 Rh3p2n1n1 h3p 9711.83281880345
* h3 bias=+0.0173783581286745 b+  bank=f alpha=0.001 R=1918.09451080035 G_phys=0.000521350743860236 G_eff=5.21350743860236e-07
* tiled Rh3bpf1 parallel x2  each=3836.18902160071
Rh3bpf1t1 vreff h3p 3846.34845179306
Rh3bpf1t2 vreff h3p 3848.15047909403
Vh3p h3p 0 DC 0
Vh3n h3n 0 DC 0
Fh3p 0 h3d Vh3p 1
Fh3n h3d 0 Vh3n 1
* ratiometric I-to-V: V = I * R_IV,  R_IV=33333.3333333333 (weight ~ R_IV / R_w)
* tiled Rh3iv series x2  each=16666.6666666667
Rh3ivt1 h3d Rh3ivn1 16508.2371802064
Rh3ivt2 Rh3ivn1 0 16527.8474708423
Eh3sc h3raw 0 h3d 0 1
Eh3lin h3lin 0 h3raw 0 1
* direct bounded ReLU: y=max(0, min(15, v(h3lin))) no high-gain op-amp loop
Bh3relu h3y 0 V = max(0, min(15, v(h3lin)))
Eh3 h3buf 0 h3y 0 1

* h4 input 1 w=-2.16286246457598 w-  bank=n alpha=1 R=15411.6749813161 G_phys=6.48858739372794e-05 G_eff=6.48858739372794e-05
* tiled Rh4n1n1 series x2  each=7705.83749065806
Rh4n1n1t1 in1 Rh4n1n1n1 7731.89881445401
Rh4n1n1t2 Rh4n1n1n1 h4n 7681.95656169753
* h4 input 2 w=+0.726967919426763 w+  bank=n alpha=1 R=45852.5506319697 G_phys=2.18090375828029e-05 G_eff=2.18090375828029e-05
* tiled Rh4p2n1 series x2  each=22926.2753159849
Rh4p2n1t1 in2 Rh4p2n1n1 22974.5644018307
Rh4p2n1t2 Rh4p2n1n1 h4p 22759.3797259442
* h4 bias=-0.0184151286231249 b-  bank=f alpha=0.001 R=1810.10591973139 G_phys=0.000552453858693748 G_eff=5.52453858693748e-07
* tiled Rh4bnf1 parallel x2  each=3620.21183946277
Rh4bnf1t1 vreff h4n 3614.67679327749
Rh4bnf1t2 vreff h4n 3589.62460873291
Vh4p h4p 0 DC 0
Vh4n h4n 0 DC 0
Fh4p 0 h4d Vh4p 1
Fh4n h4d 0 Vh4n 1
* ratiometric I-to-V: V = I * R_IV,  R_IV=33333.3333333333 (weight ~ R_IV / R_w)
* tiled Rh4iv series x2  each=16666.6666666667
Rh4ivt1 h4d Rh4ivn1 16626.6634283307
Rh4ivt2 Rh4ivn1 0 16630.7462425901
Eh4sc h4raw 0 h4d 0 1
Eh4lin h4lin 0 h4raw 0 1
* direct bounded ReLU: y=max(0, min(15, v(h4lin))) no high-gain op-amp loop
Bh4relu h4y 0 V = max(0, min(15, v(h4lin)))
Eh4 h4buf 0 h4y 0 1

* tiled Rdivh1a series x2  each=499500
Rdivh1at1 h1buf Rdivh1an1 503246.052174987
Rdivh1at2 Rdivh1an1 htap1 500519.190992769
* tiled Rdivh1b parallel x2  each=2000
Rdivh1bt1 htap1 0 2014.93701717349
Rdivh1bt2 htap1 0 1985.42655826418
Edivh1 h1f 0 htap1 0 1
* tiled Rdivh2a series x2  each=499500
Rdivh2at1 h2buf Rdivh2an1 503257.171141589
Rdivh2at2 Rdivh2an1 htap2 496136.322519126
* tiled Rdivh2b parallel x2  each=2000
Rdivh2bt1 htap2 0 1981.62263906538
Rdivh2bt2 htap2 0 2005.53522251181
Edivh2 h2f 0 htap2 0 1
* tiled Rdivh3a series x2  each=499500
Rdivh3at1 h3buf Rdivh3an1 495290.622236062
Rdivh3at2 Rdivh3an1 htap3 497746.425040697
* tiled Rdivh3b parallel x2  each=2000
Rdivh3bt1 htap3 0 1980.14052934937
Rdivh3bt2 htap3 0 1980.95602323561
Edivh3 h3f 0 htap3 0 1
* tiled Rdivh4a series x2  each=499500
Rdivh4at1 h4buf Rdivh4an1 497990.778383476
Rdivh4at2 Rdivh4an1 htap4 503959.522950419
* tiled Rdivh4b parallel x2  each=2000
Rdivh4bt1 htap4 0 2002.80782661844
Rdivh4bt2 htap4 0 2018.77346849927
Edivh4 h4f 0 htap4 0 1
* o1 input 1 w=+0.601889648539537 w+  bank=n alpha=1 R=55381.137413171 G_phys=1.80566894561861e-05 G_eff=1.80566894561861e-05
* tiled Ro1p1n1 series x2  each=27690.5687065855
Ro1p1n1t1 h1buf Ro1p1n1n1 27675.5677005638
Ro1p1n1t2 Ro1p1n1n1 o1p 27743.1746848414
* o1 input 2 w=+0.347315954504283 w+  bank=n alpha=1 R=95974.0918925228 G_phys=1.04194786351285e-05 G_eff=1.04194786351285e-05
* tiled Ro1p2n1 series x2  each=47987.0459462614
Ro1p2n1t1 h2buf Ro1p2n1n1 48138.0187789882
Ro1p2n1t2 Ro1p2n1n1 o1p 48422.611483075
* o1 input 3 w=+0.876922607606196 w+  bank=n alpha=1 R=38011.716249768 G_phys=2.63076782281859e-05 G_eff=2.63076782281859e-05
* tiled Ro1p3n1 series x2  each=19005.858124884
Ro1p3n1t1 h3buf Ro1p3n1n1 19050.9544927039
Ro1p3n1t2 Ro1p3n1n1 o1p 19129.5321470173
* o1 input 4 w=+0.929527796434486 w+  bank=n alpha=1 R=35860.5019249499 G_phys=2.78858338930346e-05 G_eff=2.78858338930346e-05
* tiled Ro1p4n1 series x2  each=17930.250962475
Ro1p4n1t1 h4buf Ro1p4n1n1 17810.6455065969
Ro1p4n1t2 Ro1p4n1n1 o1p 17873.5532342854
* o1 bias=+0.0103504514823374 b+  bank=f alpha=0.001 R=3220.47143452777 G_phys=0.000310513544470123 G_eff=3.10513544470123e-07
* tiled Ro1bpf1 series x2  each=1610.23571726388
Ro1bpf1t1 vreff Ro1bpf1n1 1598.7195688089
Ro1bpf1t2 Ro1bpf1n1 o1p 1599.69381023785
Vo1p o1p 0 DC 0
Vo1n o1n 0 DC 0
Fo1p 0 o1d Vo1p 1
Fo1n o1d 0 Vo1n 1
* ratiometric I-to-V: V = I * R_IV,  R_IV=33333.3333333333 (weight ~ R_IV / R_w)
* tiled Ro1iv series x2  each=16666.6666666667
Ro1ivt1 o1d Ro1ivn1 16616.050669342
Ro1ivt2 Ro1ivn1 0 16622.5633719827
Eo1sc o1raw 0 o1d 0 1
Eo1lin o1lin 0 o1raw 0 1
.control
set numdgt=15
alter Vin1 DC 0.494125531810799
alter Vin2 DC -0.229451673774848
op
print v(o1lin)
alter Vin1 DC 0.756925898000261
alter Vin2 DC -0.494115472466579
op
print v(o1lin)
alter Vin1 DC 0.0208787503964407
alter Vin2 DC -0.496416458868835
op
print v(o1lin)
alter Vin1 DC 0.718610447200065
alter Vin2 DC 0.919157890410241
op
print v(o1lin)
alter Vin1 DC 0.853272914872112
alter Vin2 DC 0.475051693668985
op
print v(o1lin)
alter Vin1 DC -0.990532770398839
alter Vin2 DC 0.373831316331627
op
print v(o1lin)
alter Vin1 DC -0.493372271299048
alter Vin2 DC -0.61799069167069
op
print v(o1lin)
alter Vin1 DC 0.476619483972029
alter Vin2 DC 0.37665129561251
op
print v(o1lin)
.endc

.end
