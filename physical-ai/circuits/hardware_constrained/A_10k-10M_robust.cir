* Physical AI - Experiment 10: hardware-constrained A
* Frozen Experiment 9 weights. Mapping: 10k-10M per_layer Gw1=3.23e-07 Gb1=0.00168 Gw2=2.88e-07 Gb2=9.66e-06
* Weights were not edited. Resistors are not clipped.
* Hidden: precision ReLU. Output: linear.
* Signed weights: G+/G- paths, I_diff = I+ - I- by KCL in SPICE.
* Bias: separate ammeter path + CCCS gain k=G_WEIGHT/G_BIAS so V_b = b. Vref remains 1 V.
* G_WEIGHT_1=3.23240908786247e-07 G_BIAS_1=0.00168289196687339 k1=0.000192074663822176
* G_WEIGHT_2=2.87922275965491e-07 G_BIAS_2=9.66141431324472e-06 k2=0.0298012554508486
* R_IV_1=3093667.82736427 R_IV_2=3473159.54156967
* Layer voltages stay in neural units (no inter-layer Python rescale).
* shape: 2 -> 4 -> 1

Vin1 in1 0 DC 0
Vin2 in2 0 DC 0
Vref vref 0 DC 1

* --- neuron h1 ---
* separate bias path: I_b_injected = k * Vref * G_B * |b|, k=G_W/G_B=0.000192074663822176
* so V_b = I_b_injected / G_W = |b|  (math bias unchanged)
* h1 input 1 w=+0.683760795348816 w+  G = 2.21019460880958e-07 S  R = 4524488.45913439 Ohm
Rh1p1 in1 h1p 4564013.24501417
* h1 input 2 w=+0.309366783045794 w+  G = 1.000000001e-07 S  R = 9999999.99 Ohm
Rh1p2 in2 h1p 10137229.7028547
* h1 bias=-0.0265987962576462 b-  G = 4.47629005504948e-05 S  R = 22339.92855025 Ohm
Rh1bn vref h1biasn 22631.6911456774
Vh1bbn h1biasn 0 DC 0
Fh1bbn h1d 0 Vh1bbn 0.000192074663822176
Vh1p h1p 0 DC 0
Vh1n h1n 0 DC 0
Fh1p 0 h1d Vh1p 1
Fh1n h1d 0 Vh1n 1
Vh1d h1d 0 DC 0
Hh1 h1lin 0 Vh1d 3093667.82736427
Bh1 h1amp 0 V = max(-15, min(15, 100000 * v(h1lin, h1y)))
Dh1 h1amp h1y Dsi
RLh1 h1y 0 10000
Eh1 h1buf 0 h1y 0 1

* --- neuron h2 ---
* separate bias path: I_b_injected = k * Vref * G_B * |b|, k=G_W/G_B=0.000192074663822176
* so V_b = I_b_injected / G_W = |b|  (math bias unchanged)
* h2 input 1 w=-0.884821731731664 w-  G = 2.86010580678764e-07 S  R = 3496374.14681229 Ohm
Rh2n1 in1 h2n 3604620.65879006
* h2 input 2 w=+0.782653240240456 w+  G = 2.52985544639826e-07 S  R = 3952795.0161093 Ohm
Rh2p2 in2 h2p 4130856.42584893
* h2 bias=+5.94215208512688e-05 b+  G = 1.000000001e-07 S  R = 9999999.99 Ohm
Rh2bp vref h2biasp 10163239.2875141
Vh2bbp h2biasp 0 DC 0
Fh2bbp 0 h2d Vh2bbp 0.000192074663822176
Vh2p h2p 0 DC 0
Vh2n h2n 0 DC 0
Fh2p 0 h2d Vh2p 1
Fh2n h2d 0 Vh2n 1
Vh2d h2d 0 DC 0
Hh2 h2lin 0 Vh2d 3093667.82736427
Bh2 h2amp 0 V = max(-15, min(15, 100000 * v(h2lin, h2y)))
Dh2 h2amp h2y Dsi
RLh2 h2y 0 10000
Eh2 h2buf 0 h2y 0 1

* --- neuron h3 ---
* separate bias path: I_b_injected = k * Vref * G_B * |b|, k=G_W/G_B=0.000192074663822176
* so V_b = I_b_injected / G_W = |b|  (math bias unchanged)
* h3 input 1 w=+0.80723931339229 w+  G = 2.6093276926891e-07 S  R = 3832404.80987434 Ohm
Rh3p1 in1 h3p 3908456.80677882
* h3 input 2 w=+1.71882311343666 w+  G = 5.55593945230073e-07 S  R = 1799875.62604898 Ohm
Rh3p2 in2 h3p 1764009.41714937
* h3 bias=+0.0173783581286745 b+  G = 2.92458992921953e-05 S  R = 34192.8278562754 Ohm
Rh3bp vref h3biasp 35674.3590496731
Vh3bbp h3biasp 0 DC 0
Fh3bbp 0 h3d Vh3bbp 0.000192074663822176
Vh3p h3p 0 DC 0
Vh3n h3n 0 DC 0
Fh3p 0 h3d Vh3p 1
Fh3n h3d 0 Vh3n 1
Vh3d h3d 0 DC 0
Hh3 h3lin 0 Vh3d 3093667.82736427
Bh3 h3amp 0 V = max(-15, min(15, 100000 * v(h3lin, h3y)))
Dh3 h3amp h3y Dsi
RLh3 h3y 0 10000
Eh3 h3buf 0 h3y 0 1

* --- neuron h4 ---
* separate bias path: I_b_injected = k * Vref * G_B * |b|, k=G_W/G_B=0.000192074663822176
* so V_b = I_b_injected / G_W = |b|  (math bias unchanged)
* h4 input 1 w=-2.16286246457598 w-  G = 6.99125628629201e-07 S  R = 1430358.09166478 Ohm
Rh4n1 in1 h4n 1437411.4490532
* h4 input 2 w=+0.726967919426763 w+  G = 2.34985770933954e-07 S  R = 4255576.82078148 Ohm
Rh4p2 in2 h4p 4217584.35401466
* h4 bias=-0.0184151286231249 b-  G = 3.09906720287972e-05 S  R = 32267.7739634293 Ohm
Rh4bn vref h4biasn 31041.5460422413
Vh4bbn h4biasn 0 DC 0
Fh4bbn h4d 0 Vh4bbn 0.000192074663822176
Vh4p h4p 0 DC 0
Vh4n h4n 0 DC 0
Fh4p 0 h4d Vh4p 1
Fh4n h4d 0 Vh4n 1
Vh4d h4d 0 DC 0
Hh4 h4lin 0 Vh4d 3093667.82736427
Bh4 h4amp 0 V = max(-15, min(15, 100000 * v(h4lin, h4y)))
Dh4 h4amp h4y Dsi
RLh4 h4y 0 10000
Eh4 h4buf 0 h4y 0 1

* --- neuron o1 ---
* separate bias path: I_b_injected = k * Vref * G_B * |b|, k=G_W/G_B=0.0298012554508486
* so V_b = I_b_injected / G_W = |b|  (math bias unchanged)
* o1 input 1 w=+0.601889648539537 w+  G = 1.73297437487573e-07 S  R = 5770425.77488608 Ohm
Ro1p1 h1buf o1p 5510821.76212022
* o1 input 2 w=+0.347315954504283 w+  G = 1.000000001e-07 S  R = 9999999.99 Ohm
Ro1p2 h2buf o1p 10069358.5663611
* o1 input 3 w=+0.876922607606196 w+  G = 2.52485553027569e-07 S  R = 3960622.64952961 Ohm
Ro1p3 h3buf o1p 4038893.2639984
* o1 input 4 w=+0.929527796434486 w+  G = 2.67631758722605e-07 S  R = 3736477.33278352 Ohm
Ro1p4 h4buf o1p 3659287.80765133
* o1 bias=+0.0103504514823374 b+  G = 1.000000001e-07 S  R = 9999999.99 Ohm
Ro1bp vref o1biasp 9935893.26328573
Vo1bbp o1biasp 0 DC 0
Fo1bbp 0 o1d Vo1bbp 0.0298012554508486
Vo1p o1p 0 DC 0
Vo1n o1n 0 DC 0
Fo1p 0 o1d Vo1p 1
Fo1n o1d 0 Vo1n 1
Vo1d o1d 0 DC 0
Ho1 o1lin 0 Vo1d 3473159.54156967

.model Dsi D(Is=1e-14 N=1 Rs=1)
.control
set numdgt=15
alter Vin1 DC 0.494125531810799
alter Vin2 DC -0.229451673774848
op
print v(o1lin)
alter Vin1 DC 0.756925898000261
alter Vin2 DC -0.494115472466579
op
print v(o1lin)
alter Vin1 DC 0.0208787503964407
alter Vin2 DC -0.496416458868835
op
print v(o1lin)
alter Vin1 DC 0.718610447200065
alter Vin2 DC 0.919157890410241
op
print v(o1lin)
alter Vin1 DC 0.853272914872112
alter Vin2 DC 0.475051693668985
op
print v(o1lin)
alter Vin1 DC -0.990532770398839
alter Vin2 DC 0.373831316331627
op
print v(o1lin)
alter Vin1 DC -0.493372271299048
alter Vin2 DC -0.61799069167069
op
print v(o1lin)
alter Vin1 DC 0.476619483972029
alter Vin2 DC 0.37665129561251
op
print v(o1lin)
.endc

.end
