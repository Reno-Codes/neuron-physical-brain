* Physical AI - Experiment 10 baseline (Exp 9 mapping) F
* Unified G_SCALE=1e-05. No resistor-range constraint.
* Hidden: precision ReLU. Output: linear.
* Signed weights: G+/G- paths, I_diff = I+ - I- by KCL in SPICE.
* Bias: 1 V reference through G_WEIGHT*|b| onto the + or - path.
* G_WEIGHT_1=1e-05 G_BIAS_1=1e-05 k1=1
* G_WEIGHT_2=1e-05 G_BIAS_2=1e-05 k2=1
* R_IV_1=100000 R_IV_2=100000
* Layer voltages stay in neural units (no inter-layer Python rescale).
* shape: 16 -> 32 -> 16

Vin1 in1 0 DC 0
Vin2 in2 0 DC 0
Vin3 in3 0 DC 0
Vin4 in4 0 DC 0
Vin5 in5 0 DC 0
Vin6 in6 0 DC 0
Vin7 in7 0 DC 0
Vin8 in8 0 DC 0
Vin9 in9 0 DC 0
Vin10 in10 0 DC 0
Vin11 in11 0 DC 0
Vin12 in12 0 DC 0
Vin13 in13 0 DC 0
Vin14 in14 0 DC 0
Vin15 in15 0 DC 0
Vin16 in16 0 DC 0
Vref vref 0 DC 1

* --- neuron h1 ---
* h1 input 1 w=-0.0168555731920106 w-  G = 1.68555731920106e-07 S  R = 5932755.82270909 Ohm
Rh1n1 in1 h1n 5932755.82270909
* h1 input 2 w=+0.167421682129858 w+  G = 1.67421682129858e-06 S  R = 597294.201849176 Ohm
Rh1p2 in2 h1p 597294.201849176
* h1 input 3 w=-0.175338604042315 w-  G = 1.75338604042315e-06 S  R = 570325.060737147 Ohm
Rh1n3 in3 h1n 570325.060737147
* h1 input 4 w=-0.3026243730549 w-  G = 3.026243730549e-06 S  R = 330442.650704339 Ohm
Rh1n4 in4 h1n 330442.650704339
* h1 input 5 w=-0.0731653551060092 w-  G = 7.31653551060092e-07 S  R = 1366767.09701074 Ohm
Rh1n5 in5 h1n 1366767.09701074
* h1 input 6 w=+0.135452999280782 w+  G = 1.35452999280782e-06 S  R = 738263.460617132 Ohm
Rh1p6 in6 h1p 738263.460617132
* h1 input 7 w=+0.21541693193391 w+  G = 2.1541693193391e-06 S  R = 464216.06278693 Ohm
Rh1p7 in7 h1p 464216.06278693
* h1 input 8 w=-0.0225117532106789 w-  G = 2.25117532106789e-07 S  R = 4442124.03468261 Ohm
Rh1n8 in8 h1n 4442124.03468261
* h1 input 9 w=-0.120865686071453 w-  G = 1.20865686071453e-06 S  R = 827364.682651802 Ohm
Rh1n9 in9 h1n 827364.682651802
* h1 input 10 w=+0.732018397911567 w+  G = 7.32018397911567e-06 S  R = 136608.58837059 Ohm
Rh1p10 in10 h1p 136608.58837059
* h1 input 11 w=+0.435334885703784 w+  G = 4.35334885703784e-06 S  R = 229708.216097442 Ohm
Rh1p11 in11 h1p 229708.216097442
* h1 input 12 w=+0.385479984810207 w+  G = 3.85479984810207e-06 S  R = 259416.841186282 Ohm
Rh1p12 in12 h1p 259416.841186282
* h1 input 13 w=-0.42800728852471 w-  G = 4.2800728852471e-06 S  R = 233640.881080993 Ohm
Rh1n13 in13 h1n 233640.881080993
* h1 input 14 w=+0.104452911276431 w+  G = 1.04452911276431e-06 S  R = 957369.198981477 Ohm
Rh1p14 in14 h1p 957369.198981477
* h1 input 15 w=-0.361295245628978 w-  G = 3.61295245628978e-06 S  R = 276781.942773452 Ohm
Rh1n15 in15 h1n 276781.942773452
* h1 input 16 w=+0.0759383856082483 w+  G = 7.59383856082483e-07 S  R = 1316857.07036071 Ohm
Rh1p16 in16 h1p 1316857.07036071
* h1 bias=-0.0910888061470142 b-  G = 9.10888061470142e-07 S  R = 1097829.73594586 Ohm
Rh1bn vref h1n 1097829.73594586
Vh1p h1p 0 DC 0
Vh1n h1n 0 DC 0
Fh1p 0 h1d Vh1p 1
Fh1n h1d 0 Vh1n 1
Vh1d h1d 0 DC 0
Hh1 h1lin 0 Vh1d 100000
Bh1 h1amp 0 V = max(-15, min(15, 100000 * v(h1lin, h1y)))
Dh1 h1amp h1y Dsi
RLh1 h1y 0 10000
Eh1 h1buf 0 h1y 0 1

* --- neuron h2 ---
* h2 input 1 w=+0.0248542194622879 w+  G = 2.48542194622879e-07 S  R = 4023461.69638251 Ohm
Rh2p1 in1 h2p 4023461.69638251
* h2 input 2 w=+0.400223191665755 w+  G = 4.00223191665755e-06 S  R = 249860.583000684 Ohm
Rh2p2 in2 h2p 249860.583000684
* h2 input 3 w=+0.358260577298724 w+  G = 3.58260577298724e-06 S  R = 279126.441301462 Ohm
Rh2p3 in3 h2p 279126.441301462
* h2 input 4 w=+0.348073132477087 w+  G = 3.48073132477087e-06 S  R = 287295.946367199 Ohm
Rh2p4 in4 h2p 287295.946367199
* h2 input 5 w=-0.489776715185261 w-  G = 4.89776715185261e-06 S  R = 204174.671640269 Ohm
Rh2n5 in5 h2n 204174.671640269
* h2 input 6 w=-0.262585224656684 w-  G = 2.62585224656684e-06 S  R = 380828.739053177 Ohm
Rh2n6 in6 h2n 380828.739053177
* h2 input 7 w=+0.634452480443638 w+  G = 6.34452480443638e-06 S  R = 157616.21726197 Ohm
Rh2p7 in7 h2p 157616.21726197
* h2 input 8 w=-0.0150494358056585 w-  G = 1.50494358056585e-07 S  R = 6644767.37143863 Ohm
Rh2n8 in8 h2n 6644767.37143863
* h2 input 9 w=+0.317089980091076 w+  G = 3.17089980091076e-06 S  R = 315367.896428886 Ohm
Rh2p9 in9 h2p 315367.896428886
* h2 input 10 w=-0.171694565495531 w-  G = 1.71694565495531e-06 S  R = 582429.616868699 Ohm
Rh2n10 in10 h2n 582429.616868699
* h2 input 11 w=+0.113535277026032 w+  G = 1.13535277026032e-06 S  R = 880783.511692767 Ohm
Rh2p11 in11 h2p 880783.511692767
* h2 input 12 w=+0.342235951147447 w+  G = 3.42235951147447e-06 S  R = 292196.070181174 Ohm
Rh2p12 in12 h2p 292196.070181174
* h2 input 13 w=-0.268945400148547 w-  G = 2.68945400148547e-06 S  R = 371822.68201935 Ohm
Rh2n13 in13 h2n 371822.68201935
* h2 input 14 w=+0.239258603190851 w+  G = 2.39258603190851e-06 S  R = 417957.802421141 Ohm
Rh2p14 in14 h2p 417957.802421141
* h2 input 15 w=+0.347826837541335 w+  G = 3.47826837541335e-06 S  R = 287499.379596079 Ohm
Rh2p15 in15 h2p 287499.379596079
* h2 input 16 w=+0.00438097035906581 w+  G = 4.38097035906581e-08 S  R = 22825993.2854975 Ohm
Rh2p16 in16 h2p 22825993.2854975
* h2 bias=-0.0501304580317642 b-  G = 5.01304580317642e-07 S  R = 1994795.25873546 Ohm
Rh2bn vref h2n 1994795.25873546
Vh2p h2p 0 DC 0
Vh2n h2n 0 DC 0
Fh2p 0 h2d Vh2p 1
Fh2n h2d 0 Vh2n 1
Vh2d h2d 0 DC 0
Hh2 h2lin 0 Vh2d 100000
Bh2 h2amp 0 V = max(-15, min(15, 100000 * v(h2lin, h2y)))
Dh2 h2amp h2y Dsi
RLh2 h2y 0 10000
Eh2 h2buf 0 h2y 0 1

* --- neuron h3 ---
* h3 input 1 w=-0.916033562434709 w-  G = 9.16033562434709e-06 S  R = 109166.305800207 Ohm
Rh3n1 in1 h3n 109166.305800207
* h3 input 2 w=+0.507521982744407 w+  G = 5.07521982744407e-06 S  R = 197035.800221408 Ohm
Rh3p2 in2 h3p 197035.800221408
* h3 input 3 w=+0.0871477019742823 w+  G = 8.71477019742823e-07 S  R = 1147477.18797577 Ohm
Rh3p3 in3 h3p 1147477.18797577
* h3 input 4 w=-0.0658557100969535 w-  G = 6.58557100969535e-07 S  R = 1518471.21309267 Ohm
Rh3n4 in4 h3n 1518471.21309267
* h3 input 5 w=-0.179053685151098 w-  G = 1.79053685151098e-06 S  R = 558491.716691634 Ohm
Rh3n5 in5 h3n 558491.716691634
* h3 input 6 w=+0.315007728496672 w+  G = 3.15007728496672e-06 S  R = 317452.528791072 Ohm
Rh3p6 in6 h3p 317452.528791072
* h3 input 7 w=+0.677608935484657 w+  G = 6.77608935484657e-06 S  R = 147577.746932271 Ohm
Rh3p7 in7 h3p 147577.746932271
* h3 input 8 w=+0.295351776524173 w+  G = 2.95351776524173e-06 S  R = 338579.307620367 Ohm
Rh3p8 in8 h3p 338579.307620367
* h3 input 9 w=+0.00172302579693755 w+  G = 1.72302579693755e-08 S  R = 58037436.3388735 Ohm
Rh3p9 in9 h3p 58037436.3388735
* h3 input 10 w=+0.317835264102281 w+  G = 3.17835264102281e-06 S  R = 314628.398086813 Ohm
Rh3p10 in10 h3p 314628.398086813
* h3 input 11 w=-0.530129158700576 w-  G = 5.30129158700576e-06 S  R = 188633.276172008 Ohm
Rh3n11 in11 h3n 188633.276172008
* h3 input 12 w=-0.291249394999097 w-  G = 2.91249394999097e-06 S  R = 343348.352707514 Ohm
Rh3n12 in12 h3n 343348.352707514
* h3 input 13 w=-0.395820894073244 w-  G = 3.95820894073244e-06 S  R = 252639.518270341 Ohm
Rh3n13 in13 h3n 252639.518270341
* h3 input 14 w=-0.0451489915790311 w-  G = 4.51489915790311e-07 S  R = 2214888.89347517 Ohm
Rh3n14 in14 h3n 2214888.89347517
* h3 input 15 w=+0.0633187763010491 w+  G = 6.33187763010491e-07 S  R = 1579310.36955847 Ohm
Rh3p15 in15 h3p 1579310.36955847
* h3 input 16 w=-0.149745176344707 w-  G = 1.49745176344707e-06 S  R = 667801.143522674 Ohm
Rh3n16 in16 h3n 667801.143522674
* h3 bias=-0.0553554658432052 b-  G = 5.53554658432052e-07 S  R = 1806506.34001077 Ohm
Rh3bn vref h3n 1806506.34001077
Vh3p h3p 0 DC 0
Vh3n h3n 0 DC 0
Fh3p 0 h3d Vh3p 1
Fh3n h3d 0 Vh3n 1
Vh3d h3d 0 DC 0
Hh3 h3lin 0 Vh3d 100000
Bh3 h3amp 0 V = max(-15, min(15, 100000 * v(h3lin, h3y)))
Dh3 h3amp h3y Dsi
RLh3 h3y 0 10000
Eh3 h3buf 0 h3y 0 1

* --- neuron h4 ---
* h4 input 1 w=+0.0673940677866904 w+  G = 6.73940677866904e-07 S  R = 1483810.12282136 Ohm
Rh4p1 in1 h4p 1483810.12282136
* h4 input 2 w=-0.087995350925692 w-  G = 8.7995350925692e-07 S  R = 1136423.67406939 Ohm
Rh4n2 in2 h4n 1136423.67406939
* h4 input 3 w=-0.354237391786533 w-  G = 3.54237391786533e-06 S  R = 282296.568116843 Ohm
Rh4n3 in3 h4n 282296.568116843
* h4 input 4 w=-0.0201421700797575 w-  G = 2.01421700797575e-07 S  R = 4964708.35088907 Ohm
Rh4n4 in4 h4n 4964708.35088907
* h4 input 5 w=-0.808084436849872 w-  G = 8.08084436849872e-06 S  R = 123749.444290533 Ohm
Rh4n5 in5 h4n 123749.444290533
* h4 input 6 w=-0.290030636557288 w-  G = 2.90030636557288e-06 S  R = 344791.16133046 Ohm
Rh4n6 in6 h4n 344791.16133046
* h4 input 7 w=+0.344262354214072 w+  G = 3.44262354214072e-06 S  R = 290476.140582647 Ohm
Rh4p7 in7 h4p 290476.140582647
* h4 input 8 w=-0.872472737770673 w-  G = 8.72472737770673e-06 S  R = 114616.761843491 Ohm
Rh4n8 in8 h4n 114616.761843491
* h4 input 9 w=+0.163024654235771 w+  G = 1.63024654235771e-06 S  R = 613404.153309088 Ohm
Rh4p9 in9 h4p 613404.153309088
* h4 input 10 w=-0.143734302026109 w-  G = 1.43734302026109e-06 S  R = 695728.149720554 Ohm
Rh4n10 in10 h4n 695728.149720554
* h4 input 11 w=-0.110414936368951 w-  G = 1.10414936368951e-06 S  R = 905674.569841262 Ohm
Rh4n11 in11 h4n 905674.569841262
* h4 input 12 w=+0.321561566587255 w+  G = 3.21561566587255e-06 S  R = 310982.438172894 Ohm
Rh4p12 in12 h4p 310982.438172894
* h4 input 13 w=-0.501486514423905 w-  G = 5.01486514423906e-06 S  R = 199407.156770461 Ohm
Rh4n13 in13 h4n 199407.156770461
* h4 input 14 w=-0.0233644803539605 w-  G = 2.33644803539605e-07 S  R = 4280001.03084035 Ohm
Rh4n14 in14 h4n 4280001.03084035
* h4 input 15 w=-0.211065663454959 w-  G = 2.11065663454959e-06 S  R = 473786.206449159 Ohm
Rh4n15 in15 h4n 473786.206449159
* h4 input 16 w=+0.18002446765288 w+  G = 1.8002446765288e-06 S  R = 555480.048372191 Ohm
Rh4p16 in16 h4p 555480.048372191
* h4 bias=+0.0472838049870426 b+  G = 4.72838049870426e-07 S  R = 2114889.02019208 Ohm
Rh4bp vref h4p 2114889.02019208
Vh4p h4p 0 DC 0
Vh4n h4n 0 DC 0
Fh4p 0 h4d Vh4p 1
Fh4n h4d 0 Vh4n 1
Vh4d h4d 0 DC 0
Hh4 h4lin 0 Vh4d 100000
Bh4 h4amp 0 V = max(-15, min(15, 100000 * v(h4lin, h4y)))
Dh4 h4amp h4y Dsi
RLh4 h4y 0 10000
Eh4 h4buf 0 h4y 0 1

* --- neuron h5 ---
* h5 input 1 w=-0.122756848133934 w-  G = 1.22756848133934e-06 S  R = 814618.504141576 Ohm
Rh5n1 in1 h5n 814618.504141576
* h5 input 2 w=+0.794704720471975 w+  G = 7.94704720471975e-06 S  R = 125832.900477312 Ohm
Rh5p2 in2 h5p 125832.900477312
* h5 input 3 w=-0.26372184795707 w-  G = 2.6372184795707e-06 S  R = 379187.392984894 Ohm
Rh5n3 in3 h5n 379187.392984894
* h5 input 4 w=+0.65217090039031 w+  G = 6.5217090039031e-06 S  R = 153334.041644839 Ohm
Rh5p4 in4 h5p 153334.041644839
* h5 input 5 w=-0.272670344884174 w-  G = 2.72670344884174e-06 S  R = 366743.218968232 Ohm
Rh5n5 in5 h5n 366743.218968232
* h5 input 6 w=+0.0607101548077554 w+  G = 6.07101548077554e-07 S  R = 1647170.89450125 Ohm
Rh5p6 in6 h5p 1647170.89450125
* h5 input 7 w=+0.629980287413506 w+  G = 6.29980287413506e-06 S  R = 158735.125523637 Ohm
Rh5p7 in7 h5p 158735.125523637
* h5 input 8 w=-0.369402487956774 w-  G = 3.69402487956774e-06 S  R = 270707.435007047 Ohm
Rh5n8 in8 h5n 270707.435007047
* h5 input 9 w=-0.0924511829208223 w-  G = 9.24511829208223e-07 S  R = 1081651.9252722 Ohm
Rh5n9 in9 h5n 1081651.9252722
* h5 input 10 w=-0.00426485730080124 w-  G = 4.26485730080124e-08 S  R = 23447443.3602299 Ohm
Rh5n10 in10 h5n 23447443.3602299
* h5 input 11 w=+0.540478898079688 w+  G = 5.40478898079688e-06 S  R = 185021.099538388 Ohm
Rh5p11 in11 h5p 185021.099538388
* h5 input 12 w=+0.161688921548601 w+  G = 1.61688921548601e-06 S  R = 618471.562814783 Ohm
Rh5p12 in12 h5p 618471.562814783
* h5 input 13 w=+0.0259557799028364 w+  G = 2.59557799028364e-07 S  R = 3852706.42509463 Ohm
Rh5p13 in13 h5p 3852706.42509463
* h5 input 14 w=+0.470073429319239 w+  G = 4.70073429319239e-06 S  R = 212732.721661848 Ohm
Rh5p14 in14 h5p 212732.721661848
* h5 input 15 w=+0.188749264833093 w+  G = 1.88749264833093e-06 S  R = 529803.388047248 Ohm
Rh5p15 in15 h5p 529803.388047248
* h5 input 16 w=+0.031866913791992 w+  G = 3.1866913791992e-07 S  R = 3138050.97828863 Ohm
Rh5p16 in16 h5p 3138050.97828863
* h5 bias=+0.0181393489298792 b+  G = 1.81393489298792e-07 S  R = 5512877.02698523 Ohm
Rh5bp vref h5p 5512877.02698523
Vh5p h5p 0 DC 0
Vh5n h5n 0 DC 0
Fh5p 0 h5d Vh5p 1
Fh5n h5d 0 Vh5n 1
Vh5d h5d 0 DC 0
Hh5 h5lin 0 Vh5d 100000
Bh5 h5amp 0 V = max(-15, min(15, 100000 * v(h5lin, h5y)))
Dh5 h5amp h5y Dsi
RLh5 h5y 0 10000
Eh5 h5buf 0 h5y 0 1

* --- neuron h6 ---
* h6 input 1 w=-0.340583473625464 w-  G = 3.40583473625464e-06 S  R = 293613.776779929 Ohm
Rh6n1 in1 h6n 293613.776779929
* h6 input 2 w=-0.593797589144587 w-  G = 5.93797589144587e-06 S  R = 168407.554742784 Ohm
Rh6n2 in2 h6n 168407.554742784
* h6 input 3 w=-0.388639564922933 w-  G = 3.88639564922933e-06 S  R = 257307.822017118 Ohm
Rh6n3 in3 h6n 257307.822017118
* h6 input 4 w=+0.284617429170421 w+  G = 2.84617429170421e-06 S  R = 351348.82741184 Ohm
Rh6p4 in4 h6p 351348.82741184
* h6 input 5 w=-0.270576674342045 w-  G = 2.70576674342045e-06 S  R = 369581.007835091 Ohm
Rh6n5 in5 h6n 369581.007835091
* h6 input 6 w=+0.0593082278184784 w+  G = 5.93082278184784e-07 S  R = 1686106.6951126 Ohm
Rh6p6 in6 h6p 1686106.6951126
* h6 input 7 w=+0.460681196235491 w+  G = 4.60681196235491e-06 S  R = 217069.853983973 Ohm
Rh6p7 in7 h6p 217069.853983973
* h6 input 8 w=+0.530418434730864 w+  G = 5.30418434730864e-06 S  R = 188530.40062746 Ohm
Rh6p8 in8 h6p 188530.40062746
* h6 input 9 w=+0.069052799324409 w+  G = 6.9052799324409e-07 S  R = 1448167.21376061 Ohm
Rh6p9 in9 h6p 1448167.21376061
* h6 input 10 w=+0.150678240315211 w+  G = 1.50678240315211e-06 S  R = 663665.833837755 Ohm
Rh6p10 in10 h6p 663665.833837755
* h6 input 11 w=+0.0896190095447204 w+  G = 8.96190095447204e-07 S  R = 1115834.69297437 Ohm
Rh6p11 in11 h6p 1115834.69297437
* h6 input 12 w=-0.177342454994274 w-  G = 1.77342454994274e-06 S  R = 563880.769572231 Ohm
Rh6n12 in12 h6n 563880.769572231
* h6 input 13 w=+0.643544080066549 w+  G = 6.43544080066549e-06 S  R = 155389.511142203 Ohm
Rh6p13 in13 h6p 155389.511142203
* h6 input 14 w=+0.0993069474158396 w+  G = 9.93069474158396e-07 S  R = 1006978.89324156 Ohm
Rh6p14 in14 h6p 1006978.89324156
* h6 input 15 w=-0.324176483950696 w-  G = 3.24176483950696e-06 S  R = 308473.948453364 Ohm
Rh6n15 in15 h6n 308473.948453364
* h6 input 16 w=+0.0932186969347454 w+  G = 9.32186969347454e-07 S  R = 1072746.16882922 Ohm
Rh6p16 in16 h6p 1072746.16882922
* h6 bias=-0.0198556852101353 b-  G = 1.98556852101353e-07 S  R = 5036340.92410749 Ohm
Rh6bn vref h6n 5036340.92410749
Vh6p h6p 0 DC 0
Vh6n h6n 0 DC 0
Fh6p 0 h6d Vh6p 1
Fh6n h6d 0 Vh6n 1
Vh6d h6d 0 DC 0
Hh6 h6lin 0 Vh6d 100000
Bh6 h6amp 0 V = max(-15, min(15, 100000 * v(h6lin, h6y)))
Dh6 h6amp h6y Dsi
RLh6 h6y 0 10000
Eh6 h6buf 0 h6y 0 1

* --- neuron h7 ---
* h7 input 1 w=+0.32217720874051 w+  G = 3.2217720874051e-06 S  R = 310388.18788868 Ohm
Rh7p1 in1 h7p 310388.18788868
* h7 input 2 w=-0.146738476402048 w-  G = 1.46738476402048e-06 S  R = 681484.518934289 Ohm
Rh7n2 in2 h7n 681484.518934289
* h7 input 3 w=+0.524171111363509 w+  G = 5.2417111136351e-06 S  R = 190777.396602177 Ohm
Rh7p3 in3 h7p 190777.396602177
* h7 input 4 w=-0.439531494343149 w-  G = 4.3953149434315e-06 S  R = 227514.98194559 Ohm
Rh7n4 in4 h7n 227514.98194559
* h7 input 5 w=+0.367500929015048 w+  G = 3.67500929015048e-06 S  R = 272108.155666473 Ohm
Rh7p5 in5 h7p 272108.155666473
* h7 input 6 w=-1.05409273633464 w-  G = 1.05409273633464e-05 S  R = 94868.3133399883 Ohm
Rh7n6 in6 h7n 94868.3133399883
* h7 input 7 w=-0.045065971974084 w-  G = 4.5065971974084e-07 S  R = 2218969.11615502 Ohm
Rh7n7 in7 h7n 2218969.11615502
* h7 input 8 w=-0.167915862386558 w-  G = 1.67915862386558e-06 S  R = 595536.351233994 Ohm
Rh7n8 in8 h7n 595536.351233994
* h7 input 9 w=+0.0197430594045346 w+  G = 1.97430594045346e-07 S  R = 5065071.11947564 Ohm
Rh7p9 in9 h7p 5065071.11947564
* h7 input 10 w=-0.287534460104587 w-  G = 2.87534460104587e-06 S  R = 347784.401089269 Ohm
Rh7n10 in10 h7n 347784.401089269
* h7 input 11 w=-0.517871662481308 w-  G = 5.17871662481308e-06 S  R = 193098.034213466 Ohm
Rh7n11 in11 h7n 193098.034213466
* h7 input 12 w=+0.348150035983652 w+  G = 3.48150035983652e-06 S  R = 287232.485033251 Ohm
Rh7p12 in12 h7p 287232.485033251
* h7 input 13 w=-0.408247593362815 w-  G = 4.08247593362815e-06 S  R = 244949.392539661 Ohm
Rh7n13 in13 h7n 244949.392539661
* h7 input 14 w=-0.41711419269885 w-  G = 4.1711419269885e-06 S  R = 239742.501574859 Ohm
Rh7n14 in14 h7n 239742.501574859
* h7 input 15 w=-0.341449872918214 w-  G = 3.41449872918214e-06 S  R = 292868.757411875 Ohm
Rh7n15 in15 h7n 292868.757411875
* h7 input 16 w=-0.0335582003371702 w-  G = 3.35582003371702e-07 S  R = 2979897.58077809 Ohm
Rh7n16 in16 h7n 2979897.58077809
* h7 bias=-0.0212324287895191 b-  G = 2.12324287895191e-07 S  R = 4709776.77548424 Ohm
Rh7bn vref h7n 4709776.77548424
Vh7p h7p 0 DC 0
Vh7n h7n 0 DC 0
Fh7p 0 h7d Vh7p 1
Fh7n h7d 0 Vh7n 1
Vh7d h7d 0 DC 0
Hh7 h7lin 0 Vh7d 100000
Bh7 h7amp 0 V = max(-15, min(15, 100000 * v(h7lin, h7y)))
Dh7 h7amp h7y Dsi
RLh7 h7y 0 10000
Eh7 h7buf 0 h7y 0 1

* --- neuron h8 ---
* h8 input 1 w=+0.185544590700454 w+  G = 1.85544590700454e-06 S  R = 538954.003576646 Ohm
Rh8p1 in1 h8p 538954.003576646
* h8 input 2 w=-0.385658106289114 w-  G = 3.85658106289114e-06 S  R = 259297.025964841 Ohm
Rh8n2 in2 h8n 259297.025964841
* h8 input 3 w=+0.230915543832556 w+  G = 2.30915543832556e-06 S  R = 433058.763997771 Ohm
Rh8p3 in3 h8p 433058.763997771
* h8 input 4 w=+0.205353187615931 w+  G = 2.05353187615931e-06 S  R = 486965.900850921 Ohm
Rh8p4 in4 h8p 486965.900850921
* h8 input 5 w=+0.00415238713767869 w+  G = 4.15238713767869e-08 S  R = 24082532.9345141 Ohm
Rh8p5 in5 h8p 24082532.9345141
* h8 input 6 w=-0.514726379917983 w-  G = 5.14726379917983e-06 S  R = 194277.977390501 Ohm
Rh8n6 in6 h8n 194277.977390501
* h8 input 7 w=+0.210716479044664 w+  G = 2.10716479044664e-06 S  R = 474571.33136134 Ohm
Rh8p7 in7 h8p 474571.33136134
* h8 input 8 w=+0.375574589425665 w+  G = 3.75574589425665e-06 S  R = 266258.694851858 Ohm
Rh8p8 in8 h8p 266258.694851858
* h8 input 9 w=+0.00572491873576676 w+  G = 5.72491873576676e-08 S  R = 17467496.85288 Ohm
Rh8p9 in9 h8p 17467496.85288
* h8 input 10 w=-0.367556769900021 w-  G = 3.67556769900021e-06 S  R = 272066.815766177 Ohm
Rh8n10 in10 h8n 272066.815766177
* h8 input 11 w=+0.41225604099869 w+  G = 4.1225604099869e-06 S  R = 242567.700785536 Ohm
Rh8p11 in11 h8p 242567.700785536
* h8 input 12 w=+0.21126612483399 w+  G = 2.1126612483399e-06 S  R = 473336.651006302 Ohm
Rh8p12 in12 h8p 473336.651006302
* h8 input 13 w=+0.318427374873886 w+  G = 3.18427374873886e-06 S  R = 314043.351453704 Ohm
Rh8p13 in13 h8p 314043.351453704
* h8 input 14 w=-0.262828471961964 w-  G = 2.62828471961964e-06 S  R = 380476.282700726 Ohm
Rh8n14 in14 h8n 380476.282700726
* h8 input 15 w=+0.319620775512722 w+  G = 3.19620775512722e-06 S  R = 312870.775811066 Ohm
Rh8p15 in15 h8p 312870.775811066
* h8 input 16 w=+0.15331491024055 w+  G = 1.5331491024055e-06 S  R = 652252.281549789 Ohm
Rh8p16 in16 h8p 652252.281549789
* h8 bias=-0.030517345445392 b-  G = 3.0517345445392e-07 S  R = 3276824.98397316 Ohm
Rh8bn vref h8n 3276824.98397316
Vh8p h8p 0 DC 0
Vh8n h8n 0 DC 0
Fh8p 0 h8d Vh8p 1
Fh8n h8d 0 Vh8n 1
Vh8d h8d 0 DC 0
Hh8 h8lin 0 Vh8d 100000
Bh8 h8amp 0 V = max(-15, min(15, 100000 * v(h8lin, h8y)))
Dh8 h8amp h8y Dsi
RLh8 h8y 0 10000
Eh8 h8buf 0 h8y 0 1

* --- neuron h9 ---
* h9 input 1 w=-0.192368051906404 w-  G = 1.92368051906404e-06 S  R = 519836.838856459 Ohm
Rh9n1 in1 h9n 519836.838856459
* h9 input 2 w=-0.0188071151742732 w-  G = 1.88071151742732e-07 S  R = 5317136.57694789 Ohm
Rh9n2 in2 h9n 5317136.57694789
* h9 input 3 w=+0.675590388456855 w+  G = 6.75590388456855e-06 S  R = 148018.683670758 Ohm
Rh9p3 in3 h9p 148018.683670758
* h9 input 4 w=-0.777819910920126 w-  G = 7.77819910920126e-06 S  R = 128564.464082315 Ohm
Rh9n4 in4 h9n 128564.464082315
* h9 input 5 w=-0.0591658911038067 w-  G = 5.91658911038067e-07 S  R = 1690162.99990394 Ohm
Rh9n5 in5 h9n 1690162.99990394
* h9 input 6 w=-0.373077376819092 w-  G = 3.73077376819092e-06 S  R = 268040.911117724 Ohm
Rh9n6 in6 h9n 268040.911117724
* h9 input 7 w=+0.173600484730372 w+  G = 1.73600484730372e-06 S  R = 576035.257939026 Ohm
Rh9p7 in7 h9p 576035.257939026
* h9 input 8 w=+0.21285190098274 w+  G = 2.1285190098274e-06 S  R = 469810.227384857 Ohm
Rh9p8 in8 h9p 469810.227384857
* h9 input 9 w=+0.47939396555815 w+  G = 4.7939396555815e-06 S  R = 208596.701636767 Ohm
Rh9p9 in9 h9p 208596.701636767
* h9 input 10 w=-0.695860852133009 w-  G = 6.95860852133009e-06 S  R = 143706.891533662 Ohm
Rh9n10 in10 h9n 143706.891533662
* h9 input 11 w=+0.426719797848979 w+  G = 4.26719797848979e-06 S  R = 234345.817803821 Ohm
Rh9p11 in11 h9p 234345.817803821
* h9 input 12 w=+0.190883817865507 w+  G = 1.90883817865507e-06 S  R = 523878.876262095 Ohm
Rh9p12 in12 h9p 523878.876262095
* h9 input 13 w=-0.203891646942192 w-  G = 2.03891646942192e-06 S  R = 490456.580736494 Ohm
Rh9n13 in13 h9n 490456.580736494
* h9 input 14 w=-0.0564974778722501 w-  G = 5.64974778722501e-07 S  R = 1769990.5157911 Ohm
Rh9n14 in14 h9n 1769990.5157911
* h9 input 15 w=-0.251891815788561 w-  G = 2.51891815788561e-06 S  R = 396995.828097648 Ohm
Rh9n15 in15 h9n 396995.828097648
* h9 input 16 w=-0.340248378281639 w-  G = 3.40248378281639e-06 S  R = 293902.94379956 Ohm
Rh9n16 in16 h9n 293902.94379956
* h9 bias=-0.0264599072666679 b-  G = 2.64599072666679e-07 S  R = 3779302.73875041 Ohm
Rh9bn vref h9n 3779302.73875041
Vh9p h9p 0 DC 0
Vh9n h9n 0 DC 0
Fh9p 0 h9d Vh9p 1
Fh9n h9d 0 Vh9n 1
Vh9d h9d 0 DC 0
Hh9 h9lin 0 Vh9d 100000
Bh9 h9amp 0 V = max(-15, min(15, 100000 * v(h9lin, h9y)))
Dh9 h9amp h9y Dsi
RLh9 h9y 0 10000
Eh9 h9buf 0 h9y 0 1

* --- neuron h10 ---
* h10 input 1 w=+0.0856004623316453 w+  G = 8.56004623316453e-07 S  R = 1168217.98943756 Ohm
Rh10p1 in1 h10p 1168217.98943756
* h10 input 2 w=+0.717707405140542 w+  G = 7.17707405140542e-06 S  R = 139332.545942476 Ohm
Rh10p2 in2 h10p 139332.545942476
* h10 input 3 w=+0.367326370670395 w+  G = 3.67326370670395e-06 S  R = 272237.465057282 Ohm
Rh10p3 in3 h10p 272237.465057282
* h10 input 4 w=+0.5220921972442 w+  G = 5.220921972442e-06 S  R = 191537.051363414 Ohm
Rh10p4 in4 h10p 191537.051363414
* h10 input 5 w=+0.0909071116243784 w+  G = 9.09071116243784e-07 S  R = 1100023.94986646 Ohm
Rh10p5 in5 h10p 1100023.94986646
* h10 input 6 w=-0.0568053629833511 w-  G = 5.68053629833511e-07 S  R = 1760397.16583289 Ohm
Rh10n6 in6 h10n 1760397.16583289
* h10 input 7 w=+0.372078007523385 w+  G = 3.72078007523385e-06 S  R = 268760.845785047 Ohm
Rh10p7 in7 h10p 268760.845785047
* h10 input 8 w=+0.384900055079612 w+  G = 3.84900055079612e-06 S  R = 259807.705091952 Ohm
Rh10p8 in8 h10p 259807.705091952
* h10 input 9 w=+0.617655459577812 w+  G = 6.17655459577813e-06 S  R = 161902.55983223 Ohm
Rh10p9 in9 h10p 161902.55983223
* h10 input 10 w=+0.306521845436409 w+  G = 3.06521845436409e-06 S  R = 326241.021606879 Ohm
Rh10p10 in10 h10p 326241.021606879
* h10 input 11 w=-0.0307901580575706 w-  G = 3.07901580575706e-07 S  R = 3247791.05755231 Ohm
Rh10n11 in11 h10n 3247791.05755231
* h10 input 12 w=+0.163538031424557 w+  G = 1.63538031424557e-06 S  R = 611478.560240173 Ohm
Rh10p12 in12 h10p 611478.560240173
* h10 input 13 w=-0.0170713095619708 w-  G = 1.70713095619708e-07 S  R = 5857781.42192248 Ohm
Rh10n13 in13 h10n 5857781.42192248
* h10 input 14 w=-0.123347220224403 w-  G = 1.23347220224403e-06 S  R = 810719.526699279 Ohm
Rh10n14 in14 h10n 810719.526699279
* h10 input 15 w=-0.136765368652097 w-  G = 1.36765368652097e-06 S  R = 731179.252361608 Ohm
Rh10n15 in15 h10n 731179.252361608
* h10 input 16 w=+0.269183781267177 w+  G = 2.69183781267177e-06 S  R = 371493.4069551 Ohm
Rh10p16 in16 h10p 371493.4069551
* h10 bias=-0.0641449868406755 b-  G = 6.41449868406755e-07 S  R = 1558968.28303016 Ohm
Rh10bn vref h10n 1558968.28303016
Vh10p h10p 0 DC 0
Vh10n h10n 0 DC 0
Fh10p 0 h10d Vh10p 1
Fh10n h10d 0 Vh10n 1
Vh10d h10d 0 DC 0
Hh10 h10lin 0 Vh10d 100000
Bh10 h10amp 0 V = max(-15, min(15, 100000 * v(h10lin, h10y)))
Dh10 h10amp h10y Dsi
RLh10 h10y 0 10000
Eh10 h10buf 0 h10y 0 1

* --- neuron h11 ---
* h11 input 1 w=+0.100174494534941 w+  G = 1.00174494534941e-06 S  R = 998258.09418105 Ohm
Rh11p1 in1 h11p 998258.09418105
* h11 input 2 w=-0.350357054027393 w-  G = 3.50357054027393e-06 S  R = 285423.110082953 Ohm
Rh11n2 in2 h11n 285423.110082953
* h11 input 3 w=-0.364058373495884 w-  G = 3.64058373495884e-06 S  R = 274681.224990779 Ohm
Rh11n3 in3 h11n 274681.224990779
* h11 input 4 w=+0.201551043415431 w+  G = 2.01551043415431e-06 S  R = 496152.231739544 Ohm
Rh11p4 in4 h11p 496152.231739544
* h11 input 5 w=+0.30370864041576 w+  G = 3.0370864041576e-06 S  R = 329262.940504773 Ohm
Rh11p5 in5 h11p 329262.940504773
* h11 input 6 w=+0.221531530750713 w+  G = 2.21531530750713e-06 S  R = 451403.010944428 Ohm
Rh11p6 in6 h11p 451403.010944428
* h11 input 7 w=-0.554388667333083 w-  G = 5.54388667333083e-06 S  R = 180378.867557044 Ohm
Rh11n7 in7 h11n 180378.867557044
* h11 input 8 w=+0.382929077760783 w+  G = 3.82929077760783e-06 S  R = 261144.963408786 Ohm
Rh11p8 in8 h11p 261144.963408786
* h11 input 9 w=-0.415059943002996 w-  G = 4.15059943002996e-06 S  R = 240929.055394965 Ohm
Rh11n9 in9 h11n 240929.055394965
* h11 input 10 w=-0.579957638432045 w-  G = 5.79957638432045e-06 S  R = 172426.386641543 Ohm
Rh11n10 in10 h11n 172426.386641543
* h11 input 11 w=+0.208304459025755 w+  G = 2.08304459025755e-06 S  R = 480066.535626277 Ohm
Rh11p11 in11 h11p 480066.535626277
* h11 input 12 w=+0.150185585205542 w+  G = 1.50185585205542e-06 S  R = 665842.862769696 Ohm
Rh11p12 in12 h11p 665842.862769696
* h11 input 13 w=-0.130595100347527 w-  G = 1.30595100347527e-06 S  R = 765725.511400428 Ohm
Rh11n13 in13 h11n 765725.511400428
* h11 input 14 w=+0.223944918125423 w+  G = 2.23944918125423e-06 S  R = 446538.375762534 Ohm
Rh11p14 in14 h11p 446538.375762534
* h11 input 15 w=+0.219816736012751 w+  G = 2.19816736012751e-06 S  R = 454924.414827992 Ohm
Rh11p15 in15 h11p 454924.414827992
* h11 input 16 w=-0.0825561420887272 w-  G = 8.25561420887272e-07 S  R = 1211296.9122579 Ohm
Rh11n16 in16 h11n 1211296.9122579
* h11 bias=-0.0111908465565794 b-  G = 1.11908465565794e-07 S  R = 8935874.46619108 Ohm
Rh11bn vref h11n 8935874.46619108
Vh11p h11p 0 DC 0
Vh11n h11n 0 DC 0
Fh11p 0 h11d Vh11p 1
Fh11n h11d 0 Vh11n 1
Vh11d h11d 0 DC 0
Hh11 h11lin 0 Vh11d 100000
Bh11 h11amp 0 V = max(-15, min(15, 100000 * v(h11lin, h11y)))
Dh11 h11amp h11y Dsi
RLh11 h11y 0 10000
Eh11 h11buf 0 h11y 0 1

* --- neuron h12 ---
* h12 input 1 w=-0.0647804813106503 w-  G = 6.47804813106503e-07 S  R = 1543674.8535482 Ohm
Rh12n1 in1 h12n 1543674.8535482
* h12 input 2 w=-0.668825239918342 w-  G = 6.68825239918342e-06 S  R = 149515.888503564 Ohm
Rh12n2 in2 h12n 149515.888503564
* h12 input 3 w=+0.43152134817872 w+  G = 4.3152134817872e-06 S  R = 231738.245215585 Ohm
Rh12p3 in3 h12p 231738.245215585
* h12 input 4 w=+0.0766102486579458 w+  G = 7.66102486579458e-07 S  R = 1305308.38565067 Ohm
Rh12p4 in4 h12p 1305308.38565067
* h12 input 5 w=+0.112143595115044 w+  G = 1.12143595115044e-06 S  R = 891713.877171619 Ohm
Rh12p5 in5 h12p 891713.877171619
* h12 input 6 w=-0.214387519256146 w-  G = 2.14387519256146e-06 S  R = 466445.063345884 Ohm
Rh12n6 in6 h12n 466445.063345884
* h12 input 7 w=+0.0362945018752433 w+  G = 3.62945018752433e-07 S  R = 2755238.25464624 Ohm
Rh12p7 in7 h12p 2755238.25464624
* h12 input 8 w=-0.654320698371061 w-  G = 6.54320698371061e-06 S  R = 152830.256247359 Ohm
Rh12n8 in8 h12n 152830.256247359
* h12 input 9 w=-0.424313635659581 w-  G = 4.24313635659581e-06 S  R = 235674.726419182 Ohm
Rh12n9 in9 h12n 235674.726419182
* h12 input 10 w=-0.147731830075345 w-  G = 1.47731830075345e-06 S  R = 676902.194665826 Ohm
Rh12n10 in10 h12n 676902.194665826
* h12 input 11 w=+0.422841356490785 w+  G = 4.22841356490785e-06 S  R = 236495.315476974 Ohm
Rh12p11 in11 h12p 236495.315476974
* h12 input 12 w=+0.250573650346706 w+  G = 2.50573650346706e-06 S  R = 399084.260701933 Ohm
Rh12p12 in12 h12p 399084.260701933
* h12 input 13 w=+0.0601122436783251 w+  G = 6.01122436783251e-07 S  R = 1663554.6085274 Ohm
Rh12p13 in13 h12p 1663554.6085274
* h12 input 14 w=-0.651755086554606 w-  G = 6.51755086554607e-06 S  R = 153431.867373116 Ohm
Rh12n14 in14 h12n 153431.867373116
* h12 input 15 w=+0.130109285988943 w+  G = 1.30109285988943e-06 S  R = 768584.64974205 Ohm
Rh12p15 in15 h12p 768584.64974205
* h12 input 16 w=-0.0778767908450736 w-  G = 7.78767908450736e-07 S  R = 1284079.62006213 Ohm
Rh12n16 in16 h12n 1284079.62006213
* h12 bias=+0.0176157808963936 b+  G = 1.76157808963936e-07 S  R = 5676728.18980579 Ohm
Rh12bp vref h12p 5676728.18980579
Vh12p h12p 0 DC 0
Vh12n h12n 0 DC 0
Fh12p 0 h12d Vh12p 1
Fh12n h12d 0 Vh12n 1
Vh12d h12d 0 DC 0
Hh12 h12lin 0 Vh12d 100000
Bh12 h12amp 0 V = max(-15, min(15, 100000 * v(h12lin, h12y)))
Dh12 h12amp h12y Dsi
RLh12 h12y 0 10000
Eh12 h12buf 0 h12y 0 1

* --- neuron h13 ---
* h13 input 1 w=+0.034343742118514 w+  G = 3.4343742118514e-07 S  R = 2911738.61179479 Ohm
Rh13p1 in1 h13p 2911738.61179479
* h13 input 2 w=-0.102232912320493 w-  G = 1.02232912320493e-06 S  R = 978158.576628506 Ohm
Rh13n2 in2 h13n 978158.576628506
* h13 input 3 w=+1.31993068300228 w+  G = 1.31993068300228e-05 S  R = 75761.5542147583 Ohm
Rh13p3 in3 h13p 75761.5542147583
* h13 input 4 w=-0.233319639483811 w-  G = 2.33319639483811e-06 S  R = 428596.582016142 Ohm
Rh13n4 in4 h13n 428596.582016142
* h13 input 5 w=-0.375430599339701 w-  G = 3.75430599339701e-06 S  R = 266360.813891776 Ohm
Rh13n5 in5 h13n 266360.813891776
* h13 input 6 w=+0.442115486842334 w+  G = 4.42115486842334e-06 S  R = 226185.245656553 Ohm
Rh13p6 in6 h13p 226185.245656553
* h13 input 7 w=-0.102130412545238 w-  G = 1.02130412545238e-06 S  R = 979140.272792937 Ohm
Rh13n7 in7 h13n 979140.272792937
* h13 input 8 w=-0.136235661297007 w-  G = 1.36235661297007e-06 S  R = 734022.201294199 Ohm
Rh13n8 in8 h13n 734022.201294199
* h13 input 9 w=+0.0915800560074952 w+  G = 9.15800560074952e-07 S  R = 1091940.80413989 Ohm
Rh13p9 in9 h13p 1091940.80413989
* h13 input 10 w=-0.194905587913072 w-  G = 1.94905587913072e-06 S  R = 513068.922603696 Ohm
Rh13n10 in10 h13n 513068.922603696
* h13 input 11 w=-0.611958537828416 w-  G = 6.11958537828416e-06 S  R = 163409.763600747 Ohm
Rh13n11 in11 h13n 163409.763600747
* h13 input 12 w=+0.19411196838682 w+  G = 1.9411196838682e-06 S  R = 515166.585713681 Ohm
Rh13p12 in12 h13p 515166.585713681
* h13 input 13 w=+0.146421986160596 w+  G = 1.46421986160596e-06 S  R = 682957.543618617 Ohm
Rh13p13 in13 h13p 682957.543618617
* h13 input 14 w=+0.246088955287688 w+  G = 2.46088955287688e-06 S  R = 406357.123516965 Ohm
Rh13p14 in14 h13p 406357.123516965
* h13 input 15 w=-0.101801651380703 w-  G = 1.01801651380703e-06 S  R = 982302.336393684 Ohm
Rh13n15 in15 h13n 982302.336393684
* h13 input 16 w=-0.212672591801914 w-  G = 2.12672591801914e-06 S  R = 470206.335253306 Ohm
Rh13n16 in16 h13n 470206.335253306
* h13 bias=+0.0212362032828689 b+  G = 2.12362032828689e-07 S  R = 4708939.66628532 Ohm
Rh13bp vref h13p 4708939.66628532
Vh13p h13p 0 DC 0
Vh13n h13n 0 DC 0
Fh13p 0 h13d Vh13p 1
Fh13n h13d 0 Vh13n 1
Vh13d h13d 0 DC 0
Hh13 h13lin 0 Vh13d 100000
Bh13 h13amp 0 V = max(-15, min(15, 100000 * v(h13lin, h13y)))
Dh13 h13amp h13y Dsi
RLh13 h13y 0 10000
Eh13 h13buf 0 h13y 0 1

* --- neuron h14 ---
* h14 input 1 w=-0.089975491938664 w-  G = 8.9975491938664e-07 S  R = 1111413.76218504 Ohm
Rh14n1 in1 h14n 1111413.76218504
* h14 input 2 w=-0.0792638889786837 w-  G = 7.92638889786837e-07 S  R = 1261608.54947318 Ohm
Rh14n2 in2 h14n 1261608.54947318
* h14 input 3 w=-0.392380373690676 w-  G = 3.92380373690676e-06 S  R = 254854.744796264 Ohm
Rh14n3 in3 h14n 254854.744796264
* h14 input 4 w=+0.471386854681532 w+  G = 4.71386854681533e-06 S  R = 212139.984403171 Ohm
Rh14p4 in4 h14p 212139.984403171
* h14 input 5 w=-0.118903138220599 w-  G = 1.18903138220599e-06 S  R = 841020.695471233 Ohm
Rh14n5 in5 h14n 841020.695471233
* h14 input 6 w=+0.618408634475196 w+  G = 6.18408634475196e-06 S  R = 161705.374771915 Ohm
Rh14p6 in6 h14p 161705.374771915
* h14 input 7 w=-0.0462466843022721 w-  G = 4.62466843022721e-07 S  R = 2162317.18032782 Ohm
Rh14n7 in7 h14n 2162317.18032782
* h14 input 8 w=-0.0297824475583231 w-  G = 2.97824475583231e-07 S  R = 3357682.40015095 Ohm
Rh14n8 in8 h14n 3357682.40015095
* h14 input 9 w=+0.0766531636417715 w+  G = 7.66531636417715e-07 S  R = 1304577.59665781 Ohm
Rh14p9 in9 h14p 1304577.59665781
* h14 input 10 w=-0.0192124865162136 w-  G = 1.92124865162136e-07 S  R = 5204948.35041832 Ohm
Rh14n10 in10 h14n 5204948.35041832
* h14 input 11 w=-0.118584174544602 w-  G = 1.18584174544602e-06 S  R = 843282.844308939 Ohm
Rh14n11 in11 h14n 843282.844308939
* h14 input 12 w=+0.498792575097448 w+  G = 4.98792575097448e-06 S  R = 200484.139084194 Ohm
Rh14p12 in12 h14p 200484.139084194
* h14 input 13 w=+0.131240430694277 w+  G = 1.31240430694277e-06 S  R = 761960.315666356 Ohm
Rh14p13 in13 h14p 761960.315666356
* h14 input 14 w=-0.699789872634837 w-  G = 6.99789872634837e-06 S  R = 142900.038869499 Ohm
Rh14n14 in14 h14n 142900.038869499
* h14 input 15 w=+0.0882030102342884 w+  G = 8.82030102342884e-07 S  R = 1133748.15365571 Ohm
Rh14p15 in15 h14p 1133748.15365571
* h14 input 16 w=-0.409062788225599 w-  G = 4.09062788225599e-06 S  R = 244461.248684517 Ohm
Rh14n16 in16 h14n 244461.248684517
* h14 bias=+0.0824693880781811 b+  G = 8.24693880781811e-07 S  R = 1212571.14100568 Ohm
Rh14bp vref h14p 1212571.14100568
Vh14p h14p 0 DC 0
Vh14n h14n 0 DC 0
Fh14p 0 h14d Vh14p 1
Fh14n h14d 0 Vh14n 1
Vh14d h14d 0 DC 0
Hh14 h14lin 0 Vh14d 100000
Bh14 h14amp 0 V = max(-15, min(15, 100000 * v(h14lin, h14y)))
Dh14 h14amp h14y Dsi
RLh14 h14y 0 10000
Eh14 h14buf 0 h14y 0 1

* --- neuron h15 ---
* h15 input 1 w=-0.104362920527351 w-  G = 1.04362920527351e-06 S  R = 958194.725623765 Ohm
Rh15n1 in1 h15n 958194.725623765
* h15 input 2 w=+0.0920701784982539 w+  G = 9.20701784982539e-07 S  R = 1086128.0126865 Ohm
Rh15p2 in2 h15p 1086128.0126865
* h15 input 3 w=+0.710914651543076 w+  G = 7.10914651543076e-06 S  R = 140663.861383283 Ohm
Rh15p3 in3 h15p 140663.861383283
* h15 input 4 w=+0.0431405504557543 w+  G = 4.31405504557543e-07 S  R = 2318004.72973941 Ohm
Rh15p4 in4 h15p 2318004.72973941
* h15 input 5 w=-0.544653793286569 w-  G = 5.44653793286569e-06 S  R = 183602.870727433 Ohm
Rh15n5 in5 h15n 183602.870727433
* h15 input 6 w=+0.236607896967987 w+  G = 2.36607896967987e-06 S  R = 422640.162401385 Ohm
Rh15p6 in6 h15p 422640.162401385
* h15 input 7 w=+0.205722108048513 w+  G = 2.05722108048513e-06 S  R = 486092.627324324 Ohm
Rh15p7 in7 h15p 486092.627324324
* h15 input 8 w=+0.119910326826568 w+  G = 1.19910326826569e-06 S  R = 833956.52940413 Ohm
Rh15p8 in8 h15p 833956.52940413
* h15 input 9 w=-0.0351999996705356 w-  G = 3.51999996705356e-07 S  R = 2840909.11749939 Ohm
Rh15n9 in9 h15n 2840909.11749939
* h15 input 10 w=-0.0279846802936883 w-  G = 2.79846802936883e-07 S  R = 3573383.68530707 Ohm
Rh15n10 in10 h15n 3573383.68530707
* h15 input 11 w=-0.155672537202176 w-  G = 1.55672537202176e-06 S  R = 642374.06158626 Ohm
Rh15n11 in11 h15n 642374.06158626
* h15 input 12 w=-0.248740189524738 w-  G = 2.48740189524738e-06 S  R = 402025.905789762 Ohm
Rh15n12 in12 h15n 402025.905789762
* h15 input 13 w=+0.142944744841187 w+  G = 1.42944744841187e-06 S  R = 699571.013338762 Ohm
Rh15p13 in13 h15p 699571.013338762
* h15 input 14 w=-0.364164748984914 w-  G = 3.64164748984914e-06 S  R = 274600.988367885 Ohm
Rh15n14 in14 h15n 274600.988367885
* h15 input 15 w=-0.240848341925517 w-  G = 2.40848341925517e-06 S  R = 415199.038534071 Ohm
Rh15n15 in15 h15n 415199.038534071
* h15 input 16 w=-0.736896288827917 w-  G = 7.36896288827917e-06 S  R = 135704.30672009 Ohm
Rh15n16 in16 h15n 135704.30672009
* h15 bias=+0.00140769830063221 b+  G = 1.40769830063221e-08 S  R = 71037948.9377014 Ohm
Rh15bp vref h15p 71037948.9377014
Vh15p h15p 0 DC 0
Vh15n h15n 0 DC 0
Fh15p 0 h15d Vh15p 1
Fh15n h15d 0 Vh15n 1
Vh15d h15d 0 DC 0
Hh15 h15lin 0 Vh15d 100000
Bh15 h15amp 0 V = max(-15, min(15, 100000 * v(h15lin, h15y)))
Dh15 h15amp h15y Dsi
RLh15 h15y 0 10000
Eh15 h15buf 0 h15y 0 1

* --- neuron h16 ---
* h16 input 1 w=-0.211528252190937 w-  G = 2.11528252190937e-06 S  R = 472750.08876703 Ohm
Rh16n1 in1 h16n 472750.08876703
* h16 input 2 w=-0.194947045242045 w-  G = 1.94947045242045e-06 S  R = 512959.813655245 Ohm
Rh16n2 in2 h16n 512959.813655245
* h16 input 3 w=-0.281660896127353 w-  G = 2.81660896127353e-06 S  R = 355036.859482209 Ohm
Rh16n3 in3 h16n 355036.859482209
* h16 input 4 w=-0.246854224570453 w-  G = 2.46854224570453e-06 S  R = 405097.381557914 Ohm
Rh16n4 in4 h16n 405097.381557914
* h16 input 5 w=+0.785179968580328 w+  G = 7.85179968580328e-06 S  R = 127359.336714624 Ohm
Rh16p5 in5 h16p 127359.336714624
* h16 input 6 w=-0.342055263707418 w-  G = 3.42055263707418e-06 S  R = 292350.419976394 Ohm
Rh16n6 in6 h16n 292350.419976394
* h16 input 7 w=-0.213390213186068 w-  G = 2.13390213186068e-06 S  R = 468625.053168694 Ohm
Rh16n7 in7 h16n 468625.053168694
* h16 input 8 w=-0.06183287092446 w-  G = 6.183287092446e-07 S  R = 1617262.76824778 Ohm
Rh16n8 in8 h16n 1617262.76824778
* h16 input 9 w=+0.114369297885863 w+  G = 1.14369297885863e-06 S  R = 874360.530741364 Ohm
Rh16p9 in9 h16p 874360.530741364
* h16 input 10 w=+0.418702574206734 w+  G = 4.18702574206734e-06 S  R = 238833.019332298 Ohm
Rh16p10 in10 h16p 238833.019332298
* h16 input 11 w=-0.38263995973155 w-  G = 3.8263995973155e-06 S  R = 261342.28131886 Ohm
Rh16n11 in11 h16n 261342.28131886
* h16 input 12 w=-0.447982918675276 w-  G = 4.47982918675276e-06 S  R = 223222.796743475 Ohm
Rh16n12 in12 h16n 223222.796743475
* h16 input 13 w=-0.354860709093241 w-  G = 3.54860709093241e-06 S  R = 281800.710638057 Ohm
Rh16n13 in13 h16n 281800.710638057
* h16 input 14 w=-0.245379266072843 w-  G = 2.45379266072843e-06 S  R = 407532.395057023 Ohm
Rh16n14 in14 h16n 407532.395057023
* h16 input 15 w=-0.0999148922371372 w-  G = 9.99148922371373e-07 S  R = 1000851.80257875 Ohm
Rh16n15 in15 h16n 1000851.80257875
* h16 input 16 w=-0.428765175056332 w-  G = 4.28765175056332e-06 S  R = 233227.896801231 Ohm
Rh16n16 in16 h16n 233227.896801231
* h16 bias=+0.0857431075924666 b+  G = 8.57431075924666e-07 S  R = 1166274.50074816 Ohm
Rh16bp vref h16p 1166274.50074816
Vh16p h16p 0 DC 0
Vh16n h16n 0 DC 0
Fh16p 0 h16d Vh16p 1
Fh16n h16d 0 Vh16n 1
Vh16d h16d 0 DC 0
Hh16 h16lin 0 Vh16d 100000
Bh16 h16amp 0 V = max(-15, min(15, 100000 * v(h16lin, h16y)))
Dh16 h16amp h16y Dsi
RLh16 h16y 0 10000
Eh16 h16buf 0 h16y 0 1

* --- neuron h17 ---
* h17 input 1 w=+0.690050155404084 w+  G = 6.90050155404084e-06 S  R = 144917.002361142 Ohm
Rh17p1 in1 h17p 144917.002361142
* h17 input 2 w=-0.128803090681736 w-  G = 1.28803090681736e-06 S  R = 776378.885558683 Ohm
Rh17n2 in2 h17n 776378.885558683
* h17 input 3 w=-0.49836012605351 w-  G = 4.9836012605351e-06 S  R = 200658.108006945 Ohm
Rh17n3 in3 h17n 200658.108006945
* h17 input 4 w=-0.0597081457071854 w-  G = 5.97081457071854e-07 S  R = 1674813.3578023 Ohm
Rh17n4 in4 h17n 1674813.3578023
* h17 input 5 w=+0.0531710366485299 w+  G = 5.317103664853e-07 S  R = 1880723.15875686 Ohm
Rh17p5 in5 h17p 1880723.15875686
* h17 input 6 w=+0.325686197829899 w+  G = 3.25686197829899e-06 S  R = 307044.021718809 Ohm
Rh17p6 in6 h17p 307044.021718809
* h17 input 7 w=-0.138446110206034 w-  G = 1.38446110206034e-06 S  R = 722302.705732803 Ohm
Rh17n7 in7 h17n 722302.705732803
* h17 input 8 w=-0.354640771144099 w-  G = 3.54640771144099e-06 S  R = 281975.475288395 Ohm
Rh17n8 in8 h17n 281975.475288395
* h17 input 9 w=+0.283153126675736 w+  G = 2.83153126675736e-06 S  R = 353165.798216733 Ohm
Rh17p9 in9 h17p 353165.798216733
* h17 input 10 w=+0.187509087652136 w+  G = 1.87509087652136e-06 S  R = 533307.485264493 Ohm
Rh17p10 in10 h17p 533307.485264493
* h17 input 11 w=+0.286891884918939 w+  G = 2.86891884918939e-06 S  R = 348563.362216589 Ohm
Rh17p11 in11 h17p 348563.362216589
* h17 input 12 w=-0.663420236101193 w-  G = 6.63420236101193e-06 S  R = 150734.021301012 Ohm
Rh17n12 in12 h17n 150734.021301012
* h17 input 13 w=-0.00672050178940724 w-  G = 6.72050178940724e-08 S  R = 14879841.2876876 Ohm
Rh17n13 in13 h17n 14879841.2876876
* h17 input 14 w=+0.213870810385993 w+  G = 2.13870810385993e-06 S  R = 467571.988059149 Ohm
Rh17p14 in14 h17p 467571.988059149
* h17 input 15 w=+0.856655380645102 w+  G = 8.56655380645102e-06 S  R = 116733.055391183 Ohm
Rh17p15 in15 h17p 116733.055391183
* h17 input 16 w=-0.153994690926048 w-  G = 1.53994690926048e-06 S  R = 649373.0361654 Ohm
Rh17n16 in16 h17n 649373.0361654
* h17 bias=+0.0931053836114148 b+  G = 9.31053836114148e-07 S  R = 1074051.74782761 Ohm
Rh17bp vref h17p 1074051.74782761
Vh17p h17p 0 DC 0
Vh17n h17n 0 DC 0
Fh17p 0 h17d Vh17p 1
Fh17n h17d 0 Vh17n 1
Vh17d h17d 0 DC 0
Hh17 h17lin 0 Vh17d 100000
Bh17 h17amp 0 V = max(-15, min(15, 100000 * v(h17lin, h17y)))
Dh17 h17amp h17y Dsi
RLh17 h17y 0 10000
Eh17 h17buf 0 h17y 0 1

* --- neuron h18 ---
* h18 input 1 w=+0.00309692999044255 w+  G = 3.09692999044255e-08 S  R = 32290042.1735752 Ohm
Rh18p1 in1 h18p 32290042.1735752
* h18 input 2 w=-0.290006429631547 w-  G = 2.90006429631547e-06 S  R = 344819.94115458 Ohm
Rh18n2 in2 h18n 344819.94115458
* h18 input 3 w=+0.161902441115013 w+  G = 1.61902441115013e-06 S  R = 617655.912482266 Ohm
Rh18p3 in3 h18p 617655.912482266
* h18 input 4 w=-0.201165440039706 w-  G = 2.01165440039706e-06 S  R = 497103.279670017 Ohm
Rh18n4 in4 h18n 497103.279670017
* h18 input 5 w=+0.167521926893116 w+  G = 1.67521926893116e-06 S  R = 596936.782274494 Ohm
Rh18p5 in5 h18p 596936.782274494
* h18 input 6 w=+0.306365656745506 w+  G = 3.06365656745506e-06 S  R = 326407.342984494 Ohm
Rh18p6 in6 h18p 326407.342984494
* h18 input 7 w=+0.567135277617062 w+  G = 5.67135277617062e-06 S  R = 176324.774611396 Ohm
Rh18p7 in7 h18p 176324.774611396
* h18 input 8 w=+0.27754647202065 w+  G = 2.7754647202065e-06 S  R = 360300.022089849 Ohm
Rh18p8 in8 h18p 360300.022089849
* h18 input 9 w=-0.295299170614896 w-  G = 2.95299170614896e-06 S  R = 338639.623645986 Ohm
Rh18n9 in9 h18n 338639.623645986
* h18 input 10 w=+0.627786354607437 w+  G = 6.27786354607437e-06 S  R = 159289.859147275 Ohm
Rh18p10 in10 h18p 159289.859147275
* h18 input 11 w=+0.158870042328046 w+  G = 1.58870042328046e-06 S  R = 629445.290846671 Ohm
Rh18p11 in11 h18p 629445.290846671
* h18 input 12 w=+0.503831351799562 w+  G = 5.03831351799562e-06 S  R = 198479.113383525 Ohm
Rh18p12 in12 h18p 198479.113383525
* h18 input 13 w=+0.0259448474340262 w+  G = 2.59448474340262e-07 S  R = 3854329.85313499 Ohm
Rh18p13 in13 h18p 3854329.85313499
* h18 input 14 w=-0.0445667146819355 w-  G = 4.45667146819355e-07 S  R = 2243827.05150428 Ohm
Rh18n14 in14 h18n 2243827.05150428
* h18 input 15 w=-0.425048584977393 w-  G = 4.25048584977393e-06 S  R = 235267.222464271 Ohm
Rh18n15 in15 h18n 235267.222464271
* h18 input 16 w=-0.290071708244206 w-  G = 2.90071708244206e-06 S  R = 344742.341834358 Ohm
Rh18n16 in16 h18n 344742.341834358
* h18 bias=+0.103219643590821 b+  G = 1.03219643590821e-06 S  R = 968807.840457345 Ohm
Rh18bp vref h18p 968807.840457345
Vh18p h18p 0 DC 0
Vh18n h18n 0 DC 0
Fh18p 0 h18d Vh18p 1
Fh18n h18d 0 Vh18n 1
Vh18d h18d 0 DC 0
Hh18 h18lin 0 Vh18d 100000
Bh18 h18amp 0 V = max(-15, min(15, 100000 * v(h18lin, h18y)))
Dh18 h18amp h18y Dsi
RLh18 h18y 0 10000
Eh18 h18buf 0 h18y 0 1

* --- neuron h19 ---
* h19 input 1 w=+0.361917529899694 w+  G = 3.61917529899694e-06 S  R = 276306.041400413 Ohm
Rh19p1 in1 h19p 276306.041400413
* h19 input 2 w=+0.460196491117441 w+  G = 4.60196491117441e-06 S  R = 217298.484300004 Ohm
Rh19p2 in2 h19p 217298.484300004
* h19 input 3 w=+0.284766719035728 w+  G = 2.84766719035728e-06 S  R = 351164.63166278 Ohm
Rh19p3 in3 h19p 351164.63166278
* h19 input 4 w=-0.664899666016021 w-  G = 6.64899666016021e-06 S  R = 150398.631720159 Ohm
Rh19n4 in4 h19n 150398.631720159
* h19 input 5 w=+0.507213486118456 w+  G = 5.07213486118456e-06 S  R = 197155.64104036 Ohm
Rh19p5 in5 h19p 197155.64104036
* h19 input 6 w=+0.130688397719858 w+  G = 1.30688397719858e-06 S  R = 765178.866255282 Ohm
Rh19p6 in6 h19p 765178.866255282
* h19 input 7 w=+0.0897047942241856 w+  G = 8.97047942241856e-07 S  R = 1114767.62044719 Ohm
Rh19p7 in7 h19p 1114767.62044719
* h19 input 8 w=+0.0897866911799249 w+  G = 8.97866911799249e-07 S  R = 1113750.80967856 Ohm
Rh19p8 in8 h19p 1113750.80967856
* h19 input 9 w=-0.272382660879323 w-  G = 2.72382660879323e-06 S  R = 367130.564321435 Ohm
Rh19n9 in9 h19n 367130.564321435
* h19 input 10 w=+0.0908546616405757 w+  G = 9.08546616405757e-07 S  R = 1100658.98870004 Ohm
Rh19p10 in10 h19p 1100658.98870004
* h19 input 11 w=-0.0411180740799587 w-  G = 4.11180740799587e-07 S  R = 2432020.52230216 Ohm
Rh19n11 in11 h19n 2432020.52230216
* h19 input 12 w=-0.14910928160707 w-  G = 1.4910928160707e-06 S  R = 670649.063037657 Ohm
Rh19n12 in12 h19n 670649.063037657
* h19 input 13 w=-0.0351824330179761 w-  G = 3.51824330179761e-07 S  R = 2842327.58856973 Ohm
Rh19n13 in13 h19n 2842327.58856973
* h19 input 14 w=+0.491588757414346 w+  G = 4.91588757414346e-06 S  R = 203422.064666367 Ohm
Rh19p14 in14 h19p 203422.064666367
* h19 input 15 w=-0.0385925197286318 w-  G = 3.85925197286318e-07 S  R = 2591175.71755259 Ohm
Rh19n15 in15 h19n 2591175.71755259
* h19 input 16 w=-0.690622583753164 w-  G = 6.90622583753164e-06 S  R = 144796.886682381 Ohm
Rh19n16 in16 h19n 144796.886682381
* h19 bias=+0.0200863362195416 b+  G = 2.00863362195416e-07 S  R = 4978508.71891271 Ohm
Rh19bp vref h19p 4978508.71891271
Vh19p h19p 0 DC 0
Vh19n h19n 0 DC 0
Fh19p 0 h19d Vh19p 1
Fh19n h19d 0 Vh19n 1
Vh19d h19d 0 DC 0
Hh19 h19lin 0 Vh19d 100000
Bh19 h19amp 0 V = max(-15, min(15, 100000 * v(h19lin, h19y)))
Dh19 h19amp h19y Dsi
RLh19 h19y 0 10000
Eh19 h19buf 0 h19y 0 1

* --- neuron h20 ---
* h20 input 1 w=-0.0810043123301717 w-  G = 8.10043123301717e-07 S  R = 1234502.17801248 Ohm
Rh20n1 in1 h20n 1234502.17801248
* h20 input 2 w=+0.646296718361532 w+  G = 6.46296718361532e-06 S  R = 154727.692651011 Ohm
Rh20p2 in2 h20p 154727.692651011
* h20 input 3 w=-0.000929252010170944 w-  G = 9.29252010170944e-09 S  R = 107613434.144312 Ohm
Rh20n3 in3 h20n 107613434.144312
* h20 input 4 w=+0.269987692172837 w+  G = 2.69987692172837e-06 S  R = 370387.25430485 Ohm
Rh20p4 in4 h20p 370387.25430485
* h20 input 5 w=+0.140155013181344 w+  G = 1.40155013181344e-06 S  R = 713495.705434468 Ohm
Rh20p5 in5 h20p 713495.705434468
* h20 input 6 w=+0.15481044132605 w+  G = 1.5481044132605e-06 S  R = 645951.262353084 Ohm
Rh20p6 in6 h20p 645951.262353084
* h20 input 7 w=-0.803119096824844 w-  G = 8.03119096824844e-06 S  R = 124514.533890868 Ohm
Rh20n7 in7 h20n 124514.533890868
* h20 input 8 w=+0.12095822380885 w+  G = 1.2095822380885e-06 S  R = 826731.716547277 Ohm
Rh20p8 in8 h20p 826731.716547277
* h20 input 9 w=+0.307944073046154 w+  G = 3.07944073046154e-06 S  R = 324734.290258648 Ohm
Rh20p9 in9 h20p 324734.290258648
* h20 input 10 w=+0.100067069291622 w+  G = 1.00067069291622e-06 S  R = 999329.756611276 Ohm
Rh20p10 in10 h20p 999329.756611276
* h20 input 11 w=+0.376050768766317 w+  G = 3.76050768766317e-06 S  R = 265921.541200575 Ohm
Rh20p11 in11 h20p 265921.541200575
* h20 input 12 w=-0.859853426992325 w-  G = 8.59853426992325e-06 S  R = 116298.891021217 Ohm
Rh20n12 in12 h20n 116298.891021217
* h20 input 13 w=+0.0677970111280841 w+  G = 6.77970111280841e-07 S  R = 1474991.27669621 Ohm
Rh20p13 in13 h20p 1474991.27669621
* h20 input 14 w=-0.43012675419833 w-  G = 4.3012675419833e-06 S  R = 232489.606898273 Ohm
Rh20n14 in14 h20n 232489.606898273
* h20 input 15 w=-0.0800571778528839 w-  G = 8.00571778528839e-07 S  R = 1249107.23412913 Ohm
Rh20n15 in15 h20n 1249107.23412913
* h20 input 16 w=-0.127529601563162 w-  G = 1.27529601563162e-06 S  R = 784131.674327179 Ohm
Rh20n16 in16 h20n 784131.674327179
* h20 bias=+0.0269672795638665 b+  G = 2.69672795638665e-07 S  R = 3708197.54967016 Ohm
Rh20bp vref h20p 3708197.54967016
Vh20p h20p 0 DC 0
Vh20n h20n 0 DC 0
Fh20p 0 h20d Vh20p 1
Fh20n h20d 0 Vh20n 1
Vh20d h20d 0 DC 0
Hh20 h20lin 0 Vh20d 100000
Bh20 h20amp 0 V = max(-15, min(15, 100000 * v(h20lin, h20y)))
Dh20 h20amp h20y Dsi
RLh20 h20y 0 10000
Eh20 h20buf 0 h20y 0 1

* --- neuron h21 ---
* h21 input 1 w=-0.00681344895090886 w-  G = 6.81344895090886e-08 S  R = 14676854.6620813 Ohm
Rh21n1 in1 h21n 14676854.6620813
* h21 input 2 w=+0.17215275761211 w+  G = 1.7215275761211e-06 S  R = 580879.454892714 Ohm
Rh21p2 in2 h21p 580879.454892714
* h21 input 3 w=-0.241244992284912 w-  G = 2.41244992284912e-06 S  R = 414516.37628979 Ohm
Rh21n3 in3 h21n 414516.37628979
* h21 input 4 w=-0.253516997925259 w-  G = 2.53516997925259e-06 S  R = 394450.868456094 Ohm
Rh21n4 in4 h21n 394450.868456094
* h21 input 5 w=+0.732528033504134 w+  G = 7.32528033504134e-06 S  R = 136513.546821735 Ohm
Rh21p5 in5 h21p 136513.546821735
* h21 input 6 w=-0.335745026911547 w-  G = 3.35745026911547e-06 S  R = 297845.066894603 Ohm
Rh21n6 in6 h21n 297845.066894603
* h21 input 7 w=-0.133397447206163 w-  G = 1.33397447206163e-06 S  R = 749639.532797445 Ohm
Rh21n7 in7 h21n 749639.532797445
* h21 input 8 w=-0.602502751086194 w-  G = 6.02502751086194e-06 S  R = 165974.345875964 Ohm
Rh21n8 in8 h21n 165974.345875964
* h21 input 9 w=-0.464313715662176 w-  G = 4.64313715662176e-06 S  R = 215371.626180343 Ohm
Rh21n9 in9 h21n 215371.626180343
* h21 input 10 w=+0.0220606443883595 w+  G = 2.20606443883595e-07 S  R = 4532959.15747437 Ohm
Rh21p10 in10 h21p 4532959.15747437
* h21 input 11 w=+0.293613135845564 w+  G = 2.93613135845564e-06 S  R = 340584.21709238 Ohm
Rh21p11 in11 h21p 340584.21709238
* h21 input 12 w=+0.585788543436 w+  G = 5.85788543436e-06 S  R = 170710.064443118 Ohm
Rh21p12 in12 h21p 170710.064443118
* h21 input 13 w=-0.255400978522459 w-  G = 2.55400978522459e-06 S  R = 391541.178027266 Ohm
Rh21n13 in13 h21n 391541.178027266
* h21 input 14 w=+0.15251581562556 w+  G = 1.5251581562556e-06 S  R = 655669.706055332 Ohm
Rh21p14 in14 h21p 655669.706055332
* h21 input 15 w=-0.610279514665944 w-  G = 6.10279514665944e-06 S  R = 163859.342476436 Ohm
Rh21n15 in15 h21n 163859.342476436
* h21 input 16 w=+0.0580238118020399 w+  G = 5.80238118020399e-07 S  R = 1723430.37960295 Ohm
Rh21p16 in16 h21p 1723430.37960295
* h21 bias=-0.00602264402556266 b-  G = 6.02264402556266e-08 S  R = 16604003.0882711 Ohm
Rh21bn vref h21n 16604003.0882711
Vh21p h21p 0 DC 0
Vh21n h21n 0 DC 0
Fh21p 0 h21d Vh21p 1
Fh21n h21d 0 Vh21n 1
Vh21d h21d 0 DC 0
Hh21 h21lin 0 Vh21d 100000
Bh21 h21amp 0 V = max(-15, min(15, 100000 * v(h21lin, h21y)))
Dh21 h21amp h21y Dsi
RLh21 h21y 0 10000
Eh21 h21buf 0 h21y 0 1

* --- neuron h22 ---
* h22 input 1 w=+0.733134048211177 w+  G = 7.33134048211177e-06 S  R = 136400.703587559 Ohm
Rh22p1 in1 h22p 136400.703587559
* h22 input 2 w=-0.468945077984231 w-  G = 4.68945077984231e-06 S  R = 213244.588107955 Ohm
Rh22n2 in2 h22n 213244.588107955
* h22 input 3 w=+0.0425168801269381 w+  G = 4.25168801269381e-07 S  R = 2352007.00760358 Ohm
Rh22p3 in3 h22p 2352007.00760358
* h22 input 4 w=-0.440513463519883 w-  G = 4.40513463519883e-06 S  R = 227007.817652062 Ohm
Rh22n4 in4 h22n 227007.817652062
* h22 input 5 w=+0.139436850403416 w+  G = 1.39436850403416e-06 S  R = 717170.530678812 Ohm
Rh22p5 in5 h22p 717170.530678812
* h22 input 6 w=-0.216633688080034 w-  G = 2.16633688080034e-06 S  R = 461608.722476514 Ohm
Rh22n6 in6 h22n 461608.722476514
* h22 input 7 w=+0.3413541130964 w+  G = 3.413541130964e-06 S  R = 292950.915672018 Ohm
Rh22p7 in7 h22p 292950.915672018
* h22 input 8 w=+0.375494249585175 w+  G = 3.75494249585175e-06 S  R = 266315.66291754 Ohm
Rh22p8 in8 h22p 266315.66291754
* h22 input 9 w=-0.0598723775607 w-  G = 5.98723775607e-07 S  R = 1670219.29100139 Ohm
Rh22n9 in9 h22n 1670219.29100139
* h22 input 10 w=-0.886177024526985 w-  G = 8.86177024526985e-06 S  R = 112844.270650525 Ohm
Rh22n10 in10 h22n 112844.270650525
* h22 input 11 w=-0.158397755226926 w-  G = 1.58397755226926e-06 S  R = 631322.078123751 Ohm
Rh22n11 in11 h22n 631322.078123751
* h22 input 12 w=+0.00642379373490928 w+  G = 6.42379373490928e-08 S  R = 15567124.9929092 Ohm
Rh22p12 in12 h22p 15567124.9929092
* h22 input 13 w=+0.483338726494796 w+  G = 4.83338726494796e-06 S  R = 206894.243143326 Ohm
Rh22p13 in13 h22p 206894.243143326
* h22 input 14 w=+0.995892890290009 w+  G = 9.95892890290009e-06 S  R = 100412.404762604 Ohm
Rh22p14 in14 h22p 100412.404762604
* h22 input 15 w=-0.0635579626600016 w-  G = 6.35579626600016e-07 S  R = 1573366.98369239 Ohm
Rh22n15 in15 h22n 1573366.98369239
* h22 input 16 w=+0.143429643183018 w+  G = 1.43429643183018e-06 S  R = 697205.945582662 Ohm
Rh22p16 in16 h22p 697205.945582662
* h22 bias=+0.00381018335041017 b+  G = 3.81018335041017e-08 S  R = 26245456.1377565 Ohm
Rh22bp vref h22p 26245456.1377565
Vh22p h22p 0 DC 0
Vh22n h22n 0 DC 0
Fh22p 0 h22d Vh22p 1
Fh22n h22d 0 Vh22n 1
Vh22d h22d 0 DC 0
Hh22 h22lin 0 Vh22d 100000
Bh22 h22amp 0 V = max(-15, min(15, 100000 * v(h22lin, h22y)))
Dh22 h22amp h22y Dsi
RLh22 h22y 0 10000
Eh22 h22buf 0 h22y 0 1

* --- neuron h23 ---
* h23 input 1 w=-0.311855168471888 w-  G = 3.11855168471888e-06 S  R = 320661.672820775 Ohm
Rh23n1 in1 h23n 320661.672820775
* h23 input 2 w=-0.519305850985266 w-  G = 5.19305850985267e-06 S  R = 192564.747364722 Ohm
Rh23n2 in2 h23n 192564.747364722
* h23 input 3 w=+0.0590711076347425 w+  G = 5.90711076347425e-07 S  R = 1692874.97736347 Ohm
Rh23p3 in3 h23p 1692874.97736347
* h23 input 4 w=-0.153433475387477 w-  G = 1.53433475387477e-06 S  R = 651748.256027328 Ohm
Rh23n4 in4 h23n 651748.256027328
* h23 input 5 w=+0.565735693190981 w+  G = 5.65735693190981e-06 S  R = 176760.987866894 Ohm
Rh23p5 in5 h23p 176760.987866894
* h23 input 6 w=-0.371646754353268 w-  G = 3.71646754353268e-06 S  R = 269072.71173138 Ohm
Rh23n6 in6 h23n 269072.71173138
* h23 input 7 w=-0.111660278324499 w-  G = 1.11660278324499e-06 S  R = 895573.622961848 Ohm
Rh23n7 in7 h23n 895573.622961848
* h23 input 8 w=+0.496809212320021 w+  G = 4.96809212320021e-06 S  R = 201284.512283932 Ohm
Rh23p8 in8 h23p 201284.512283932
* h23 input 9 w=-0.177241184436762 w-  G = 1.77241184436762e-06 S  R = 564202.954960951 Ohm
Rh23n9 in9 h23n 564202.954960951
* h23 input 10 w=-0.405292848695184 w-  G = 4.05292848695184e-06 S  R = 246735.170190997 Ohm
Rh23n10 in10 h23n 246735.170190997
* h23 input 11 w=-0.16052467280172 w-  G = 1.6052467280172e-06 S  R = 622957.195642567 Ohm
Rh23n11 in11 h23n 622957.195642567
* h23 input 12 w=+0.846508036935069 w+  G = 8.46508036935069e-06 S  R = 118132.369259089 Ohm
Rh23p12 in12 h23p 118132.369259089
* h23 input 13 w=-0.0538311215013525 w-  G = 5.38311215013525e-07 S  R = 1857661.46442792 Ohm
Rh23n13 in13 h23n 1857661.46442792
* h23 input 14 w=+0.31071243911676 w+  G = 3.1071243911676e-06 S  R = 321840.993184125 Ohm
Rh23p14 in14 h23p 321840.993184125
* h23 input 15 w=+0.331311012578656 w+  G = 3.31311012578656e-06 S  R = 301831.198491355 Ohm
Rh23p15 in15 h23p 301831.198491355
* h23 input 16 w=-0.486368816876819 w-  G = 4.86368816876819e-06 S  R = 205605.286626191 Ohm
Rh23n16 in16 h23n 205605.286626191
* h23 bias=-0.0518579015055903 b-  G = 5.18579015055903e-07 S  R = 1928346.44474034 Ohm
Rh23bn vref h23n 1928346.44474034
Vh23p h23p 0 DC 0
Vh23n h23n 0 DC 0
Fh23p 0 h23d Vh23p 1
Fh23n h23d 0 Vh23n 1
Vh23d h23d 0 DC 0
Hh23 h23lin 0 Vh23d 100000
Bh23 h23amp 0 V = max(-15, min(15, 100000 * v(h23lin, h23y)))
Dh23 h23amp h23y Dsi
RLh23 h23y 0 10000
Eh23 h23buf 0 h23y 0 1

* --- neuron h24 ---
* h24 input 1 w=+0.61389120350986 w+  G = 6.1389120350986e-06 S  R = 162895.313417524 Ohm
Rh24p1 in1 h24p 162895.313417524
* h24 input 2 w=-0.0429199313830527 w-  G = 4.29199313830527e-07 S  R = 2329919.84790278 Ohm
Rh24n2 in2 h24n 2329919.84790278
* h24 input 3 w=-0.014915873427812 w-  G = 1.4915873427812e-07 S  R = 6704267.1342022 Ohm
Rh24n3 in3 h24n 6704267.1342022
* h24 input 4 w=-0.169036355792668 w-  G = 1.69036355792668e-06 S  R = 591588.711973035 Ohm
Rh24n4 in4 h24n 591588.711973035
* h24 input 5 w=-0.510336523880732 w-  G = 5.10336523880733e-06 S  R = 195949.134190071 Ohm
Rh24n5 in5 h24n 195949.134190071
* h24 input 6 w=-0.303361656916169 w-  G = 3.03361656916169e-06 S  R = 329639.549759033 Ohm
Rh24n6 in6 h24n 329639.549759033
* h24 input 7 w=-0.0292327970624363 w-  G = 2.92327970624363e-07 S  R = 3420815.31871265 Ohm
Rh24n7 in7 h24n 3420815.31871265
* h24 input 8 w=-0.329334996951297 w-  G = 3.29334996951297e-06 S  R = 303642.190856468 Ohm
Rh24n8 in8 h24n 303642.190856468
* h24 input 9 w=+0.0109599477370603 w+  G = 1.09599477370603e-07 S  R = 9124131.09980962 Ohm
Rh24p9 in9 h24p 9124131.09980962
* h24 input 10 w=+0.0571459019805778 w+  G = 5.71459019805778e-07 S  R = 1749906.75681324 Ohm
Rh24p10 in10 h24p 1749906.75681324
* h24 input 11 w=+0.243568584743939 w+  G = 2.43568584743939e-06 S  R = 410561.978282746 Ohm
Rh24p11 in11 h24p 410561.978282746
* h24 input 12 w=-0.323004255102081 w-  G = 3.23004255102081e-06 S  R = 309593.444731545 Ohm
Rh24n12 in12 h24n 309593.444731545
* h24 input 13 w=+0.243938800887145 w+  G = 2.43938800887145e-06 S  R = 409938.884819983 Ohm
Rh24p13 in13 h24p 409938.884819983
* h24 input 14 w=+0.0840399613598874 w+  G = 8.40399613598874e-07 S  R = 1189910.11397264 Ohm
Rh24p14 in14 h24p 1189910.11397264
* h24 input 15 w=-0.352451854106752 w-  G = 3.52451854106752e-06 S  R = 283726.695816194 Ohm
Rh24n15 in15 h24n 283726.695816194
* h24 input 16 w=+0.406056698737055 w+  G = 4.06056698737055e-06 S  R = 246271.026462627 Ohm
Rh24p16 in16 h24p 246271.026462627
* h24 bias=+0.0185909259510049 b+  G = 1.85909259510049e-07 S  R = 5378968.22694809 Ohm
Rh24bp vref h24p 5378968.22694809
Vh24p h24p 0 DC 0
Vh24n h24n 0 DC 0
Fh24p 0 h24d Vh24p 1
Fh24n h24d 0 Vh24n 1
Vh24d h24d 0 DC 0
Hh24 h24lin 0 Vh24d 100000
Bh24 h24amp 0 V = max(-15, min(15, 100000 * v(h24lin, h24y)))
Dh24 h24amp h24y Dsi
RLh24 h24y 0 10000
Eh24 h24buf 0 h24y 0 1

* --- neuron h25 ---
* h25 input 1 w=-0.507226781565224 w-  G = 5.07226781565224e-06 S  R = 197150.473189557 Ohm
Rh25n1 in1 h25n 197150.473189557
* h25 input 2 w=-0.323616844242374 w-  G = 3.23616844242374e-06 S  R = 309007.401126205 Ohm
Rh25n2 in2 h25n 309007.401126205
* h25 input 3 w=+0.251581142719107 w+  G = 2.51581142719107e-06 S  R = 397486.07117049 Ohm
Rh25p3 in3 h25p 397486.07117049
* h25 input 4 w=+0.0279414599016099 w+  G = 2.79414599016099e-07 S  R = 3578911.06449446 Ohm
Rh25p4 in4 h25p 3578911.06449446
* h25 input 5 w=+0.310516223746861 w+  G = 3.10516223746861e-06 S  R = 322044.364681963 Ohm
Rh25p5 in5 h25p 322044.364681963
* h25 input 6 w=-0.583310440311788 w-  G = 5.83310440311788e-06 S  R = 171435.299437721 Ohm
Rh25n6 in6 h25n 171435.299437721
* h25 input 7 w=-0.128366308561082 w-  G = 1.28366308561082e-06 S  R = 779020.61001011 Ohm
Rh25n7 in7 h25n 779020.61001011
* h25 input 8 w=-0.237966635841971 w-  G = 2.37966635841971e-06 S  R = 420226.976971714 Ohm
Rh25n8 in8 h25n 420226.976971714
* h25 input 9 w=+0.869293927250567 w+  G = 8.69293927250567e-06 S  R = 115035.889317993 Ohm
Rh25p9 in9 h25p 115035.889317993
* h25 input 10 w=-0.700407093798758 w-  G = 7.00407093798758e-06 S  R = 142774.110778399 Ohm
Rh25n10 in10 h25n 142774.110778399
* h25 input 11 w=+0.176416664646434 w+  G = 1.76416664646434e-06 S  R = 566839.874228523 Ohm
Rh25p11 in11 h25p 566839.874228523
* h25 input 12 w=+0.165054591787149 w+  G = 1.65054591787149e-06 S  R = 605860.151585228 Ohm
Rh25p12 in12 h25p 605860.151585228
* h25 input 13 w=+0.414882742059982 w+  G = 4.14882742059982e-06 S  R = 241031.958821614 Ohm
Rh25p13 in13 h25p 241031.958821614
* h25 input 14 w=-0.441614461314228 w-  G = 4.41614461314228e-06 S  R = 226441.859948163 Ohm
Rh25n14 in14 h25n 226441.859948163
* h25 input 15 w=+0.152726206779301 w+  G = 1.52726206779301e-06 S  R = 654766.474652949 Ohm
Rh25p15 in15 h25p 654766.474652949
* h25 input 16 w=-0.0538945970745783 w-  G = 5.38945970745783e-07 S  R = 1855473.56187898 Ohm
Rh25n16 in16 h25n 1855473.56187898
* h25 bias=+0.0841612656537764 b+  G = 8.41612656537765e-07 S  R = 1188195.05889302 Ohm
Rh25bp vref h25p 1188195.05889302
Vh25p h25p 0 DC 0
Vh25n h25n 0 DC 0
Fh25p 0 h25d Vh25p 1
Fh25n h25d 0 Vh25n 1
Vh25d h25d 0 DC 0
Hh25 h25lin 0 Vh25d 100000
Bh25 h25amp 0 V = max(-15, min(15, 100000 * v(h25lin, h25y)))
Dh25 h25amp h25y Dsi
RLh25 h25y 0 10000
Eh25 h25buf 0 h25y 0 1

* --- neuron h26 ---
* h26 input 1 w=-0.733410608571861 w-  G = 7.33410608571861e-06 S  R = 136349.268515117 Ohm
Rh26n1 in1 h26n 136349.268515117
* h26 input 2 w=+0.207000343516658 w+  G = 2.07000343516658e-06 S  R = 483090.985749753 Ohm
Rh26p2 in2 h26p 483090.985749753
* h26 input 3 w=-0.0671817515718929 w-  G = 6.71817515718929e-07 S  R = 1488499.44605847 Ohm
Rh26n3 in3 h26n 1488499.44605847
* h26 input 4 w=+0.312724326896377 w+  G = 3.12724326896377e-06 S  R = 319770.454036777 Ohm
Rh26p4 in4 h26p 319770.454036777
* h26 input 5 w=+0.0982363551813243 w+  G = 9.82363551813243e-07 S  R = 1017953.07669366 Ohm
Rh26p5 in5 h26p 1017953.07669366
* h26 input 6 w=+0.0433697195878843 w+  G = 4.33697195878843e-07 S  R = 2305756.20387308 Ohm
Rh26p6 in6 h26p 2305756.20387308
* h26 input 7 w=-0.253243820471769 w-  G = 2.53243820471769e-06 S  R = 394876.36781703 Ohm
Rh26n7 in7 h26n 394876.36781703
* h26 input 8 w=+0.388367135047654 w+  G = 3.88367135047654e-06 S  R = 257488.317047552 Ohm
Rh26p8 in8 h26p 257488.317047552
* h26 input 9 w=+0.190562655499984 w+  G = 1.90562655499984e-06 S  R = 524761.788912038 Ohm
Rh26p9 in9 h26p 524761.788912038
* h26 input 10 w=-0.282938574156096 w-  G = 2.82938574156096e-06 S  R = 353433.604089736 Ohm
Rh26n10 in10 h26n 353433.604089736
* h26 input 11 w=+0.123317846030254 w+  G = 1.23317846030254e-06 S  R = 810912.639322831 Ohm
Rh26p11 in11 h26p 810912.639322831
* h26 input 12 w=-0.494646699470857 w-  G = 4.94646699470857e-06 S  R = 202164.494591744 Ohm
Rh26n12 in12 h26n 202164.494591744
* h26 input 13 w=-0.136127092468903 w-  G = 1.36127092468903e-06 S  R = 734607.624289371 Ohm
Rh26n13 in13 h26n 734607.624289371
* h26 input 14 w=+0.481522107274068 w+  G = 4.81522107274068e-06 S  R = 207674.784790479 Ohm
Rh26p14 in14 h26p 207674.784790479
* h26 input 15 w=+0.0644124429905188 w+  G = 6.44124429905188e-07 S  R = 1552495.06705901 Ohm
Rh26p15 in15 h26p 1552495.06705901
* h26 input 16 w=+0.0297993400818282 w+  G = 2.97993400818282e-07 S  R = 3355779.01139431 Ohm
Rh26p16 in16 h26p 3355779.01139431
* h26 bias=-0.0154994859917217 b-  G = 1.54994859917217e-07 S  R = 6451826.85757514 Ohm
Rh26bn vref h26n 6451826.85757514
Vh26p h26p 0 DC 0
Vh26n h26n 0 DC 0
Fh26p 0 h26d Vh26p 1
Fh26n h26d 0 Vh26n 1
Vh26d h26d 0 DC 0
Hh26 h26lin 0 Vh26d 100000
Bh26 h26amp 0 V = max(-15, min(15, 100000 * v(h26lin, h26y)))
Dh26 h26amp h26y Dsi
RLh26 h26y 0 10000
Eh26 h26buf 0 h26y 0 1

* --- neuron h27 ---
* h27 input 1 w=-0.473232380174693 w-  G = 4.73232380174693e-06 S  R = 211312.674680218 Ohm
Rh27n1 in1 h27n 211312.674680218
* h27 input 2 w=+0.0192680774504759 w+  G = 1.92680774504759e-07 S  R = 5189931.39076934 Ohm
Rh27p2 in2 h27p 5189931.39076934
* h27 input 3 w=-0.33925202928177 w-  G = 3.3925202928177e-06 S  R = 294766.107108363 Ohm
Rh27n3 in3 h27n 294766.107108363
* h27 input 4 w=+0.300608725256371 w+  G = 3.00608725256371e-06 S  R = 332658.341552515 Ohm
Rh27p4 in4 h27p 332658.341552515
* h27 input 5 w=-0.265937781386581 w-  G = 2.65937781386581e-06 S  R = 376027.804242809 Ohm
Rh27n5 in5 h27n 376027.804242809
* h27 input 6 w=-0.0714924370091341 w-  G = 7.14924370091341e-07 S  R = 1398749.35284726 Ohm
Rh27n6 in6 h27n 1398749.35284726
* h27 input 7 w=+0.32365049129675 w+  G = 3.2365049129675e-06 S  R = 308975.276383287 Ohm
Rh27p7 in7 h27p 308975.276383287
* h27 input 8 w=+0.264468500812474 w+  G = 2.64468500812474e-06 S  R = 378116.863417722 Ohm
Rh27p8 in8 h27p 378116.863417722
* h27 input 9 w=-0.251852607935664 w-  G = 2.51852607935664e-06 S  R = 397057.631523693 Ohm
Rh27n9 in9 h27n 397057.631523693
* h27 input 10 w=-0.0922567674902895 w-  G = 9.22567674902895e-07 S  R = 1083931.32255068 Ohm
Rh27n10 in10 h27n 1083931.32255068
* h27 input 11 w=-0.519972660308657 w-  G = 5.19972660308657e-06 S  R = 192317.803671908 Ohm
Rh27n11 in11 h27n 192317.803671908
* h27 input 12 w=+0.109096005067641 w+  G = 1.09096005067641e-06 S  R = 916623.848306804 Ohm
Rh27p12 in12 h27p 916623.848306804
* h27 input 13 w=+0.0733868764952063 w+  G = 7.33868764952063e-07 S  R = 1362641.4527471 Ohm
Rh27p13 in13 h27p 1362641.4527471
* h27 input 14 w=-0.779894486957924 w-  G = 7.79894486957924e-06 S  R = 128222.473260534 Ohm
Rh27n14 in14 h27n 128222.473260534
* h27 input 15 w=+0.520337169546291 w+  G = 5.20337169546291e-06 S  R = 192183.08022699 Ohm
Rh27p15 in15 h27p 192183.08022699
* h27 input 16 w=+0.00922691889455085 w+  G = 9.22691889455085e-08 S  R = 10837854.0163669 Ohm
Rh27p16 in16 h27p 10837854.0163669
* h27 bias=+0.0122793649099004 b+  G = 1.22793649099004e-07 S  R = 8143743.64910143 Ohm
Rh27bp vref h27p 8143743.64910143
Vh27p h27p 0 DC 0
Vh27n h27n 0 DC 0
Fh27p 0 h27d Vh27p 1
Fh27n h27d 0 Vh27n 1
Vh27d h27d 0 DC 0
Hh27 h27lin 0 Vh27d 100000
Bh27 h27amp 0 V = max(-15, min(15, 100000 * v(h27lin, h27y)))
Dh27 h27amp h27y Dsi
RLh27 h27y 0 10000
Eh27 h27buf 0 h27y 0 1

* --- neuron h28 ---
* h28 input 1 w=+0.0928477001370985 w+  G = 9.28477001370985e-07 S  R = 1077032.60126358 Ohm
Rh28p1 in1 h28p 1077032.60126358
* h28 input 2 w=+0.628866123797832 w+  G = 6.28866123797832e-06 S  R = 159016.356925195 Ohm
Rh28p2 in2 h28p 159016.356925195
* h28 input 3 w=-0.429442295580587 w-  G = 4.29442295580587e-06 S  R = 232860.156135306 Ohm
Rh28n3 in3 h28n 232860.156135306
* h28 input 4 w=+0.0390774584408687 w+  G = 3.90774584408687e-07 S  R = 2559020.05887405 Ohm
Rh28p4 in4 h28p 2559020.05887405
* h28 input 5 w=-0.500231352741198 w-  G = 5.00231352741198e-06 S  R = 199907.50170299 Ohm
Rh28n5 in5 h28n 199907.50170299
* h28 input 6 w=-0.374880121408735 w-  G = 3.74880121408735e-06 S  R = 266751.940925054 Ohm
Rh28n6 in6 h28n 266751.940925054
* h28 input 7 w=-0.575469641796179 w-  G = 5.75469641796179e-06 S  R = 173771.112734767 Ohm
Rh28n7 in7 h28n 173771.112734767
* h28 input 8 w=+0.475130253886277 w+  G = 4.75130253886277e-06 S  R = 210468.601361544 Ohm
Rh28p8 in8 h28p 210468.601361544
* h28 input 9 w=-0.381841652824232 w-  G = 3.81841652824232e-06 S  R = 261888.663168006 Ohm
Rh28n9 in9 h28n 261888.663168006
* h28 input 10 w=+0.758567082707225 w+  G = 7.58567082707225e-06 S  R = 131827.497237441 Ohm
Rh28p10 in10 h28p 131827.497237441
* h28 input 11 w=-0.0530277840915393 w-  G = 5.30277840915393e-07 S  R = 1885803.86137529 Ohm
Rh28n11 in11 h28n 1885803.86137529
* h28 input 12 w=+0.0401492881024246 w+  G = 4.01492881024246e-07 S  R = 2490704.18745385 Ohm
Rh28p12 in12 h28p 2490704.18745385
* h28 input 13 w=-0.344979802042177 w-  G = 3.44979802042177e-06 S  R = 289872.042966081 Ohm
Rh28n13 in13 h28n 289872.042966081
* h28 input 14 w=+0.139059200435423 w+  G = 1.39059200435423e-06 S  R = 719118.18626081 Ohm
Rh28p14 in14 h28p 719118.18626081
* h28 input 15 w=-0.317012120275182 w-  G = 3.17012120275182e-06 S  R = 315445.352414902 Ohm
Rh28n15 in15 h28n 315445.352414902
* h28 input 16 w=-0.398313118116402 w-  G = 3.98313118116402e-06 S  R = 251058.7662111 Ohm
Rh28n16 in16 h28n 251058.7662111
* h28 bias=-0.0847668662328426 b-  G = 8.47668662328427e-07 S  R = 1179706.22772952 Ohm
Rh28bn vref h28n 1179706.22772952
Vh28p h28p 0 DC 0
Vh28n h28n 0 DC 0
Fh28p 0 h28d Vh28p 1
Fh28n h28d 0 Vh28n 1
Vh28d h28d 0 DC 0
Hh28 h28lin 0 Vh28d 100000
Bh28 h28amp 0 V = max(-15, min(15, 100000 * v(h28lin, h28y)))
Dh28 h28amp h28y Dsi
RLh28 h28y 0 10000
Eh28 h28buf 0 h28y 0 1

* --- neuron h29 ---
* h29 input 1 w=+0.125932002984804 w+  G = 1.25932002984804e-06 S  R = 794079.325587055 Ohm
Rh29p1 in1 h29p 794079.325587055
* h29 input 2 w=-0.650061827874195 w-  G = 6.50061827874195e-06 S  R = 153831.52142161 Ohm
Rh29n2 in2 h29n 153831.52142161
* h29 input 3 w=-0.0394473233812264 w-  G = 3.94473233812264e-07 S  R = 2535026.24331646 Ohm
Rh29n3 in3 h29n 2535026.24331646
* h29 input 4 w=-0.231823015010513 w-  G = 2.31823015010513e-06 S  R = 431363.555492818 Ohm
Rh29n4 in4 h29n 431363.555492818
* h29 input 5 w=+0.19053303604273 w+  G = 1.9053303604273e-06 S  R = 524843.366152911 Ohm
Rh29p5 in5 h29p 524843.366152911
* h29 input 6 w=+0.447719174196915 w+  G = 4.47719174196915e-06 S  R = 223354.293859253 Ohm
Rh29p6 in6 h29p 223354.293859253
* h29 input 7 w=+0.0126486175371352 w+  G = 1.26486175371352e-07 S  R = 7906002.35214712 Ohm
Rh29p7 in7 h29p 7906002.35214712
* h29 input 8 w=+0.108364236263017 w+  G = 1.08364236263017e-06 S  R = 922813.68326432 Ohm
Rh29p8 in8 h29p 922813.68326432
* h29 input 9 w=+0.430118110319429 w+  G = 4.30118110319429e-06 S  R = 232494.279131224 Ohm
Rh29p9 in9 h29p 232494.279131224
* h29 input 10 w=+0.849664650654267 w+  G = 8.49664650654267e-06 S  R = 117693.492277214 Ohm
Rh29p10 in10 h29p 117693.492277214
* h29 input 11 w=+0.430581993177771 w+  G = 4.30581993177771e-06 S  R = 232243.803931471 Ohm
Rh29p11 in11 h29p 232243.803931471
* h29 input 12 w=-0.974573192285427 w-  G = 9.74573192285427e-06 S  R = 102609.019816659 Ohm
Rh29n12 in12 h29n 102609.019816659
* h29 input 13 w=+0.16029064712382 w+  G = 1.6029064712382e-06 S  R = 623866.718329189 Ohm
Rh29p13 in13 h29p 623866.718329189
* h29 input 14 w=+0.466636118473806 w+  G = 4.66636118473807e-06 S  R = 214299.742435418 Ohm
Rh29p14 in14 h29p 214299.742435418
* h29 input 15 w=-0.0331745755104183 w-  G = 3.31745755104183e-07 S  R = 3014356.580647 Ohm
Rh29n15 in15 h29n 3014356.580647
* h29 input 16 w=-0.589046477086867 w-  G = 5.89046477086867e-06 S  R = 169765.890960847 Ohm
Rh29n16 in16 h29n 169765.890960847
* h29 bias=-0.0665836653392507 b-  G = 6.65836653392507e-07 S  R = 1501869.85787715 Ohm
Rh29bn vref h29n 1501869.85787715
Vh29p h29p 0 DC 0
Vh29n h29n 0 DC 0
Fh29p 0 h29d Vh29p 1
Fh29n h29d 0 Vh29n 1
Vh29d h29d 0 DC 0
Hh29 h29lin 0 Vh29d 100000
Bh29 h29amp 0 V = max(-15, min(15, 100000 * v(h29lin, h29y)))
Dh29 h29amp h29y Dsi
RLh29 h29y 0 10000
Eh29 h29buf 0 h29y 0 1

* --- neuron h30 ---
* h30 input 1 w=-0.507901838841989 w-  G = 5.07901838841989e-06 S  R = 196888.438577027 Ohm
Rh30n1 in1 h30n 196888.438577027
* h30 input 2 w=-0.0392944483392576 w-  G = 3.92944483392577e-07 S  R = 2544888.76231642 Ohm
Rh30n2 in2 h30n 2544888.76231642
* h30 input 3 w=+0.205776196534446 w+  G = 2.05776196534446e-06 S  R = 485964.857374845 Ohm
Rh30p3 in3 h30p 485964.857374845
* h30 input 4 w=+0.172383143604269 w+  G = 1.72383143604269e-06 S  R = 580103.123247161 Ohm
Rh30p4 in4 h30p 580103.123247161
* h30 input 5 w=-0.0737740397875715 w-  G = 7.37740397875715e-07 S  R = 1355490.36338453 Ohm
Rh30n5 in5 h30n 1355490.36338453
* h30 input 6 w=-0.113337981854853 w-  G = 1.13337981854853e-06 S  R = 882316.751749345 Ohm
Rh30n6 in6 h30n 882316.751749345
* h30 input 7 w=-0.199472534274412 w-  G = 1.99472534274412e-06 S  R = 501322.151261343 Ohm
Rh30n7 in7 h30n 501322.151261343
* h30 input 8 w=+0.667476408484971 w+  G = 6.67476408484971e-06 S  R = 149818.029115034 Ohm
Rh30p8 in8 h30p 149818.029115034
* h30 input 9 w=+0.0327305955718174 w+  G = 3.27305955718174e-07 S  R = 3055245.35233647 Ohm
Rh30p9 in9 h30p 3055245.35233647
* h30 input 10 w=-0.112124407230259 w-  G = 1.12124407230259e-06 S  R = 891866.476445578 Ohm
Rh30n10 in10 h30n 891866.476445578
* h30 input 11 w=+0.283868618501327 w+  G = 2.83868618501327e-06 S  R = 352275.642612227 Ohm
Rh30p11 in11 h30p 352275.642612227
* h30 input 12 w=-0.058671072800694 w-  G = 5.8671072800694e-07 S  R = 1704417.44502782 Ohm
Rh30n12 in12 h30n 1704417.44502782
* h30 input 13 w=-0.679698898194489 w-  G = 6.79698898194489e-06 S  R = 147123.969548331 Ohm
Rh30n13 in13 h30n 147123.969548331
* h30 input 14 w=+0.213421552049108 w+  G = 2.13421552049108e-06 S  R = 468556.240172924 Ohm
Rh30p14 in14 h30p 468556.240172924
* h30 input 15 w=+0.353043376484901 w+  G = 3.53043376484901e-06 S  R = 283251.313183259 Ohm
Rh30p15 in15 h30p 283251.313183259
* h30 input 16 w=-0.0402310971621178 w-  G = 4.02310971621178e-07 S  R = 2485639.39474565 Ohm
Rh30n16 in16 h30n 2485639.39474565
* h30 bias=+0.0283807691184238 b+  G = 2.83807691184238e-07 S  R = 3523512.68504149 Ohm
Rh30bp vref h30p 3523512.68504149
Vh30p h30p 0 DC 0
Vh30n h30n 0 DC 0
Fh30p 0 h30d Vh30p 1
Fh30n h30d 0 Vh30n 1
Vh30d h30d 0 DC 0
Hh30 h30lin 0 Vh30d 100000
Bh30 h30amp 0 V = max(-15, min(15, 100000 * v(h30lin, h30y)))
Dh30 h30amp h30y Dsi
RLh30 h30y 0 10000
Eh30 h30buf 0 h30y 0 1

* --- neuron h31 ---
* h31 input 1 w=+0.786523739677983 w+  G = 7.86523739677983e-06 S  R = 127141.744050779 Ohm
Rh31p1 in1 h31p 127141.744050779
* h31 input 2 w=+0.575951127580127 w+  G = 5.75951127580127e-06 S  R = 173625.842908152 Ohm
Rh31p2 in2 h31p 173625.842908152
* h31 input 3 w=+0.131568206508636 w+  G = 1.31568206508636e-06 S  R = 760062.044270825 Ohm
Rh31p3 in3 h31p 760062.044270825
* h31 input 4 w=+0.217046331869883 w+  G = 2.17046331869883e-06 S  R = 460731.121961319 Ohm
Rh31p4 in4 h31p 460731.121961319
* h31 input 5 w=+0.0670548023806797 w+  G = 6.70548023806798e-07 S  R = 1491317.49628141 Ohm
Rh31p5 in5 h31p 1491317.49628141
* h31 input 6 w=-0.0924541633789126 w-  G = 9.24541633789126e-07 S  R = 1081617.05590436 Ohm
Rh31n6 in6 h31n 1081617.05590436
* h31 input 7 w=+0.532768880755568 w+  G = 5.32768880755569e-06 S  R = 187698.650600953 Ohm
Rh31p7 in7 h31p 187698.650600953
* h31 input 8 w=-0.213038536483163 w-  G = 2.13038536483163e-06 S  R = 469398.643319648 Ohm
Rh31n8 in8 h31n 469398.643319648
* h31 input 9 w=+0.217996086164886 w+  G = 2.17996086164886e-06 S  R = 458723.831969914 Ohm
Rh31p9 in9 h31p 458723.831969914
* h31 input 10 w=-0.173189336412784 w-  G = 1.73189336412784e-06 S  R = 577402.75510761 Ohm
Rh31n10 in10 h31n 577402.75510761
* h31 input 11 w=+0.227561810267943 w+  G = 2.27561810267943e-06 S  R = 439441.046290917 Ohm
Rh31p11 in11 h31p 439441.046290917
* h31 input 12 w=+0.400647928830177 w+  G = 4.00647928830177e-06 S  R = 249595.699376215 Ohm
Rh31p12 in12 h31p 249595.699376215
* h31 input 13 w=+0.0924404555732517 w+  G = 9.24404555732517e-07 S  R = 1081777.44668034 Ohm
Rh31p13 in13 h31p 1081777.44668034
* h31 input 14 w=+0.340918137300815 w+  G = 3.40918137300815e-06 S  R = 293325.549622381 Ohm
Rh31p14 in14 h31p 293325.549622381
* h31 input 15 w=+0.631456773568415 w+  G = 6.31456773568415e-06 S  R = 158363.967552191 Ohm
Rh31p15 in15 h31p 158363.967552191
* h31 input 16 w=+0.19173700817347 w+  G = 1.9173700817347e-06 S  R = 521547.722855503 Ohm
Rh31p16 in16 h31p 521547.722855503
* h31 bias=-0.0537174074345555 b-  G = 5.37174074345555e-07 S  R = 1861593.93715773 Ohm
Rh31bn vref h31n 1861593.93715773
Vh31p h31p 0 DC 0
Vh31n h31n 0 DC 0
Fh31p 0 h31d Vh31p 1
Fh31n h31d 0 Vh31n 1
Vh31d h31d 0 DC 0
Hh31 h31lin 0 Vh31d 100000
Bh31 h31amp 0 V = max(-15, min(15, 100000 * v(h31lin, h31y)))
Dh31 h31amp h31y Dsi
RLh31 h31y 0 10000
Eh31 h31buf 0 h31y 0 1

* --- neuron h32 ---
* h32 input 1 w=+0.018363806586789 w+  G = 1.8363806586789e-07 S  R = 5445494.07702543 Ohm
Rh32p1 in1 h32p 5445494.07702543
* h32 input 2 w=+0.274234487929714 w+  G = 2.74234487929714e-06 S  R = 364651.436640711 Ohm
Rh32p2 in2 h32p 364651.436640711
* h32 input 3 w=+0.286642259390481 w+  G = 2.86642259390481e-06 S  R = 348866.912410755 Ohm
Rh32p3 in3 h32p 348866.912410755
* h32 input 4 w=-0.106012181190002 w-  G = 1.06012181190002e-06 S  R = 943287.826714677 Ohm
Rh32n4 in4 h32n 943287.826714677
* h32 input 5 w=-0.539184466126997 w-  G = 5.39184466126997e-06 S  R = 185465.283742886 Ohm
Rh32n5 in5 h32n 185465.283742886
* h32 input 6 w=-0.141969883388357 w-  G = 1.41969883388357e-06 S  R = 704374.742116617 Ohm
Rh32n6 in6 h32n 704374.742116617
* h32 input 7 w=-0.343812430494534 w-  G = 3.43812430494534e-06 S  R = 290856.266761971 Ohm
Rh32n7 in7 h32n 290856.266761971
* h32 input 8 w=-0.197072814561277 w-  G = 1.97072814561277e-06 S  R = 507426.659646687 Ohm
Rh32n8 in8 h32n 507426.659646687
* h32 input 9 w=-0.180430465047897 w-  G = 1.80430465047897e-06 S  R = 554230.129448782 Ohm
Rh32n9 in9 h32n 554230.129448782
* h32 input 10 w=+0.113268490856906 w+  G = 1.13268490856906e-06 S  R = 882858.059143135 Ohm
Rh32p10 in10 h32p 882858.059143135
* h32 input 11 w=+0.0737822862098911 w+  G = 7.37822862098911e-07 S  R = 1355338.86433834 Ohm
Rh32p11 in11 h32p 1355338.86433834
* h32 input 12 w=+0.131260687318804 w+  G = 1.31260687318805e-06 S  R = 761842.727191586 Ohm
Rh32p12 in12 h32p 761842.727191586
* h32 input 13 w=-0.105796213840622 w-  G = 1.05796213840622e-06 S  R = 945213.409533223 Ohm
Rh32n13 in13 h32n 945213.409533223
* h32 input 14 w=-0.365435123738796 w-  G = 3.65435123738796e-06 S  R = 273646.383458963 Ohm
Rh32n14 in14 h32n 273646.383458963
* h32 input 15 w=-0.0205558893905 w-  G = 2.05558893905e-07 S  R = 4864785.85773163 Ohm
Rh32n15 in15 h32n 4864785.85773163
* h32 input 16 w=-0.212152037098157 w-  G = 2.12152037098157e-06 S  R = 471360.074443842 Ohm
Rh32n16 in16 h32n 471360.074443842
* h32 bias=+0.00806132622522946 b+  G = 8.06132622522946e-08 S  R = 12404906.7369375 Ohm
Rh32bp vref h32p 12404906.7369375
Vh32p h32p 0 DC 0
Vh32n h32n 0 DC 0
Fh32p 0 h32d Vh32p 1
Fh32n h32d 0 Vh32n 1
Vh32d h32d 0 DC 0
Hh32 h32lin 0 Vh32d 100000
Bh32 h32amp 0 V = max(-15, min(15, 100000 * v(h32lin, h32y)))
Dh32 h32amp h32y Dsi
RLh32 h32y 0 10000
Eh32 h32buf 0 h32y 0 1

* --- neuron o1 ---
* o1 input 1 w=+0.115109951768787 w+  G = 1.15109951768787e-06 S  R = 868734.618192379 Ohm
Ro1p1 h1buf o1p 868734.618192379
* o1 input 2 w=+0.416557305918275 w+  G = 4.16557305918275e-06 S  R = 240063.008328605 Ohm
Ro1p2 h2buf o1p 240063.008328605
* o1 input 3 w=+0.460762298204741 w+  G = 4.60762298204741e-06 S  R = 217031.646012766 Ohm
Ro1p3 h3buf o1p 217031.646012766
* o1 input 4 w=+0.128235529120638 w+  G = 1.28235529120638e-06 S  R = 779815.08467848 Ohm
Ro1p4 h4buf o1p 779815.08467848
* o1 input 5 w=+0.25946188501651 w+  G = 2.59461885016511e-06 S  R = 385413.063632204 Ohm
Ro1p5 h5buf o1p 385413.063632204
* o1 input 6 w=+0.0121141451968155 w+  G = 1.21141451968155e-07 S  R = 8254812.73134218 Ohm
Ro1p6 h6buf o1p 8254812.73134218
* o1 input 7 w=-0.240253536162518 w-  G = 2.40253536162518e-06 S  R = 416226.964219813 Ohm
Ro1n7 h7buf o1n 416226.964219813
* o1 input 8 w=+0.187475674056081 w+  G = 1.87475674056081e-06 S  R = 533402.536107624 Ohm
Ro1p8 h8buf o1p 533402.536107624
* o1 input 9 w=-0.249792136720497 w-  G = 2.49792136720497e-06 S  R = 400332.85800303 Ohm
Ro1n9 h9buf o1n 400332.85800303
* o1 input 10 w=-0.0478130377197742 w-  G = 4.78130377197742e-07 S  R = 2091479.7463003 Ohm
Ro1n10 h10buf o1n 2091479.7463003
* o1 input 11 w=+0.103135444855694 w+  G = 1.03135444855694e-06 S  R = 969598.765389713 Ohm
Ro1p11 h11buf o1p 969598.765389713
* o1 input 12 w=-0.0209153710838255 w-  G = 2.09153710838255e-07 S  R = 4781172.64088769 Ohm
Ro1n12 h12buf o1n 4781172.64088769
* o1 input 13 w=-0.0177641479719743 w-  G = 1.77641479719743e-07 S  R = 5629315.86461481 Ohm
Ro1n13 h13buf o1n 5629315.86461481
* o1 input 14 w=-0.162077236015947 w-  G = 1.62077236015947e-06 S  R = 616989.791152168 Ohm
Ro1n14 h14buf o1n 616989.791152168
* o1 input 15 w=+0.156787201998635 w+  G = 1.56787201998635e-06 S  R = 637807.159801668 Ohm
Ro1p15 h15buf o1p 637807.159801668
* o1 input 16 w=-0.00694237968883333 w-  G = 6.94237968883333e-08 S  R = 14404282.7506032 Ohm
Ro1n16 h16buf o1n 14404282.7506032
* o1 input 17 w=+0.263424706628807 w+  G = 2.63424706628807e-06 S  R = 379615.113858361 Ohm
Ro1p17 h17buf o1p 379615.113858361
* o1 input 18 w=+0.403807796552332 w+  G = 4.03807796552332e-06 S  R = 247642.568701717 Ohm
Ro1p18 h18buf o1p 247642.568701717
* o1 input 19 w=+0.415931315874452 w+  G = 4.15931315874452e-06 S  R = 240424.310897967 Ohm
Ro1p19 h19buf o1p 240424.310897967
* o1 input 20 w=+0.0719298844689274 w+  G = 7.19298844689274e-07 S  R = 1390242.74456048 Ohm
Ro1p20 h20buf o1p 1390242.74456048
* o1 input 21 w=-0.387164693396724 w-  G = 3.87164693396724e-06 S  R = 258288.014649959 Ohm
Ro1n21 h21buf o1n 258288.014649959
* o1 input 22 w=+0.13881898843949 w+  G = 1.3881898843949e-06 S  R = 720362.546393206 Ohm
Ro1p22 h22buf o1p 720362.546393206
* o1 input 23 w=-0.118143194098524 w-  G = 1.18143194098524e-06 S  R = 846430.475856325 Ohm
Ro1n23 h23buf o1n 846430.475856325
* o1 input 24 w=-0.494956544406075 w-  G = 4.94956544406075e-06 S  R = 202037.938744694 Ohm
Ro1n24 h24buf o1n 202037.938744694
* o1 input 25 w=-0.0137314432186455 w-  G = 1.37314432186455e-07 S  R = 7282555.6940885 Ohm
Ro1n25 h25buf o1n 7282555.6940885
* o1 input 26 w=+0.00762307525297978 w+  G = 7.62307525297978e-08 S  R = 13118065.4370309 Ohm
Ro1p26 h26buf o1p 13118065.4370309
* o1 input 27 w=+0.187160704798257 w+  G = 1.87160704798257e-06 S  R = 534300.189282742 Ohm
Ro1p27 h27buf o1p 534300.189282742
* o1 input 28 w=+0.0939442280900053 w+  G = 9.39442280900053e-07 S  R = 1064461.35151798 Ohm
Ro1p28 h28buf o1p 1064461.35151798
* o1 input 29 w=+0.0315398664392492 w+  G = 3.15398664392492e-07 S  R = 3170590.47135206 Ohm
Ro1p29 h29buf o1p 3170590.47135206
* o1 input 30 w=+0.183835448783735 w+  G = 1.83835448783735e-06 S  R = 543964.728574414 Ohm
Ro1p30 h30buf o1p 543964.728574414
* o1 input 31 w=-0.236627512253244 w-  G = 2.36627512253244e-06 S  R = 422605.127560052 Ohm
Ro1n31 h31buf o1n 422605.127560052
* o1 input 32 w=-0.230869865069063 w-  G = 2.30869865069063e-06 S  R = 433144.446851415 Ohm
Ro1n32 h32buf o1n 433144.446851415
* o1 bias=-0.0809652357124875 b-  G = 8.09652357124875e-07 S  R = 1235097.99137875 Ohm
Ro1bn vref o1n 1235097.99137875
Vo1p o1p 0 DC 0
Vo1n o1n 0 DC 0
Fo1p 0 o1d Vo1p 1
Fo1n o1d 0 Vo1n 1
Vo1d o1d 0 DC 0
Ho1 o1lin 0 Vo1d 100000

* --- neuron o2 ---
* o2 input 1 w=-0.195521390350609 w-  G = 1.95521390350609e-06 S  R = 511452.991515046 Ohm
Ro2n1 h1buf o2n 511452.991515046
* o2 input 2 w=+0.386445174905558 w+  G = 3.86445174905559e-06 S  R = 258768.918578007 Ohm
Ro2p2 h2buf o2p 258768.918578007
* o2 input 3 w=+0.296294588630229 w+  G = 2.96294588630229e-06 S  R = 337501.94514959 Ohm
Ro2p3 h3buf o2p 337501.94514959
* o2 input 4 w=-0.299308681857295 w-  G = 2.99308681857295e-06 S  R = 334103.238768323 Ohm
Ro2n4 h4buf o2n 334103.238768323
* o2 input 5 w=+0.732671792857329 w+  G = 7.32671792857329e-06 S  R = 136486.761159471 Ohm
Ro2p5 h5buf o2p 136486.761159471
* o2 input 6 w=+0.124925987288217 w+  G = 1.24925987288217e-06 S  R = 800473.96198911 Ohm
Ro2p6 h6buf o2p 800473.96198911
* o2 input 7 w=-0.0857938493267301 w-  G = 8.57938493267301e-07 S  R = 1165584.7218041 Ohm
Ro2n7 h7buf o2n 1165584.7218041
* o2 input 8 w=-0.0609936542707342 w-  G = 6.09936542707342e-07 S  R = 1639514.81831417 Ohm
Ro2n8 h8buf o2n 1639514.81831417
* o2 input 9 w=+0.256981204903229 w+  G = 2.56981204903229e-06 S  R = 389133.516739704 Ohm
Ro2p9 h9buf o2p 389133.516739704
* o2 input 10 w=+0.073638013162671 w+  G = 7.3638013162671e-07 S  R = 1357994.27096293 Ohm
Ro2p10 h10buf o2p 1357994.27096293
* o2 input 11 w=-0.149208279345328 w-  G = 1.49208279345328e-06 S  R = 670204.096171902 Ohm
Ro2n11 h11buf o2n 670204.096171902
* o2 input 12 w=-0.475362564845884 w-  G = 4.75362564845884e-06 S  R = 210365.744791916 Ohm
Ro2n12 h12buf o2n 210365.744791916
* o2 input 13 w=-0.0533811781970356 w-  G = 5.33811781970356e-07 S  R = 1873319.46160666 Ohm
Ro2n13 h13buf o2n 1873319.46160666
* o2 input 14 w=+0.279456004632752 w+  G = 2.79456004632752e-06 S  R = 357838.079490957 Ohm
Ro2p14 h14buf o2p 357838.079490957
* o2 input 15 w=-0.0744870090943736 w-  G = 7.44870090943736e-07 S  R = 1342515.97984424 Ohm
Ro2n15 h15buf o2n 1342515.97984424
* o2 input 16 w=-0.0222148593491043 w-  G = 2.22148593491043e-07 S  R = 4501491.47597606 Ohm
Ro2n16 h16buf o2n 4501491.47597606
* o2 input 17 w=+0.0088751960388594 w+  G = 8.8751960388594e-08 S  R = 11267356.7504489 Ohm
Ro2p17 h17buf o2p 11267356.7504489
* o2 input 18 w=-0.194172060066752 w-  G = 1.94172060066752e-06 S  R = 515007.153787328 Ohm
Ro2n18 h18buf o2n 515007.153787328
* o2 input 19 w=+0.341327626188232 w+  G = 3.41327626188232e-06 S  R = 292973.648563838 Ohm
Ro2p19 h19buf o2p 292973.648563838
* o2 input 20 w=-0.0323870183321868 w-  G = 3.23870183321868e-07 S  R = 3087656.8807391 Ohm
Ro2n20 h20buf o2n 3087656.8807391
* o2 input 21 w=-0.0999542141187652 w-  G = 9.99542141187652e-07 S  R = 1000458.06854307 Ohm
Ro2n21 h21buf o2n 1000458.06854307
* o2 input 22 w=+0.693789300406694 w+  G = 6.93789300406694e-06 S  R = 144135.978951219 Ohm
Ro2p22 h22buf o2p 144135.978951219
* o2 input 23 w=+0.0972685864670828 w+  G = 9.72685864670828e-07 S  R = 1028081.14759477 Ohm
Ro2p23 h23buf o2p 1028081.14759477
* o2 input 24 w=-0.0293783170287994 w-  G = 2.93783170287994e-07 S  R = 3403870.9536006 Ohm
Ro2n24 h24buf o2n 3403870.9536006
* o2 input 25 w=+0.0497492024826392 w+  G = 4.97492024826392e-07 S  R = 2010082.47388281 Ohm
Ro2p25 h25buf o2p 2010082.47388281
* o2 input 26 w=-0.466063512962686 w-  G = 4.66063512962686e-06 S  R = 214563.031043381 Ohm
Ro2n26 h26buf o2n 214563.031043381
* o2 input 27 w=+0.194887582685885 w+  G = 1.94887582685885e-06 S  R = 513116.323892105 Ohm
Ro2p27 h27buf o2p 513116.323892105
* o2 input 28 w=+0.209047565197081 w+  G = 2.09047565197081e-06 S  R = 478360.032109078 Ohm
Ro2p28 h28buf o2p 478360.032109078
* o2 input 29 w=+0.00919963467526149 w+  G = 9.19963467526149e-08 S  R = 10869996.8563869 Ohm
Ro2p29 h29buf o2p 10869996.8563869
* o2 input 30 w=-0.379437042796868 w-  G = 3.79437042796868e-06 S  R = 263548.332716516 Ohm
Ro2n30 h30buf o2n 263548.332716516
* o2 input 31 w=-0.216631724491884 w-  G = 2.16631724491884e-06 S  R = 461612.90657937 Ohm
Ro2n31 h31buf o2n 461612.90657937
* o2 input 32 w=+0.139103822260271 w+  G = 1.39103822260271e-06 S  R = 718887.507008213 Ohm
Ro2p32 h32buf o2p 718887.507008213
* o2 bias=+0.0322130531942455 b+  G = 3.22130531942455e-07 S  R = 3104331.63218021 Ohm
Ro2bp vref o2p 3104331.63218021
Vo2p o2p 0 DC 0
Vo2n o2n 0 DC 0
Fo2p 0 o2d Vo2p 1
Fo2n o2d 0 Vo2n 1
Vo2d o2d 0 DC 0
Ho2 o2lin 0 Vo2d 100000

* --- neuron o3 ---
* o3 input 1 w=-0.100595944434035 w-  G = 1.00595944434035e-06 S  R = 994075.860240814 Ohm
Ro3n1 h1buf o3n 994075.860240814
* o3 input 2 w=-0.265315115107159 w-  G = 2.65315115107159e-06 S  R = 376910.301396175 Ohm
Ro3n2 h2buf o3n 376910.301396175
* o3 input 3 w=-0.0591677372187977 w-  G = 5.91677372187977e-07 S  R = 1690110.26448769 Ohm
Ro3n3 h3buf o3n 1690110.26448769
* o3 input 4 w=-0.0695954531730398 w-  G = 6.95954531730398e-07 S  R = 1436875.4773586 Ohm
Ro3n4 h4buf o3n 1436875.4773586
* o3 input 5 w=-0.284313347850547 w-  G = 2.84313347850547e-06 S  R = 351724.605109171 Ohm
Ro3n5 h5buf o3n 351724.605109171
* o3 input 6 w=+0.314440272159438 w+  G = 3.14440272159438e-06 S  R = 318025.421213523 Ohm
Ro3p6 h6buf o3p 318025.421213523
* o3 input 7 w=-0.349535009995164 w-  G = 3.49535009995164e-06 S  R = 286094.374355758 Ohm
Ro3n7 h7buf o3n 286094.374355758
* o3 input 8 w=-0.295696300813859 w-  G = 2.95696300813859e-06 S  R = 338184.819102455 Ohm
Ro3n8 h8buf o3n 338184.819102455
* o3 input 9 w=-0.735854867565559 w-  G = 7.35854867565559e-06 S  R = 135896.362730917 Ohm
Ro3n9 h9buf o3n 135896.362730917
* o3 input 10 w=-0.0859238760568894 w-  G = 8.59238760568894e-07 S  R = 1163820.86783179 Ohm
Ro3n10 h10buf o3n 1163820.86783179
* o3 input 11 w=-0.105996934570411 w-  G = 1.05996934570411e-06 S  R = 943423.509418309 Ohm
Ro3n11 h11buf o3n 943423.509418309
* o3 input 12 w=-0.193541479603888 w-  G = 1.93541479603888e-06 S  R = 516685.106493271 Ohm
Ro3n12 h12buf o3n 516685.106493271
* o3 input 13 w=-0.351950930756974 w-  G = 3.51950930756974e-06 S  R = 284130.517242618 Ohm
Ro3n13 h13buf o3n 284130.517242618
* o3 input 14 w=+0.0402342325324318 w+  G = 4.02342325324318e-07 S  R = 2485445.69402169 Ohm
Ro3p14 h14buf o3p 2485445.69402169
* o3 input 15 w=+0.188158881095559 w+  G = 1.88158881095559e-06 S  R = 531465.745426142 Ohm
Ro3p15 h15buf o3p 531465.745426142
* o3 input 16 w=+0.204693314484602 w+  G = 2.04693314484602e-06 S  R = 488535.74066056 Ohm
Ro3p16 h16buf o3p 488535.74066056
* o3 input 17 w=+0.153640089266272 w+  G = 1.53640089266272e-06 S  R = 650871.790543489 Ohm
Ro3p17 h17buf o3p 650871.790543489
* o3 input 18 w=+0.463153650429953 w+  G = 4.63153650429953e-06 S  R = 215911.06948454 Ohm
Ro3p18 h18buf o3p 215911.06948454
* o3 input 19 w=-0.0426705918571366 w-  G = 4.26705918571366e-07 S  R = 2343534.40268195 Ohm
Ro3n19 h19buf o3n 2343534.40268195
* o3 input 20 w=+0.210331327799834 w+  G = 2.10331327799834e-06 S  R = 475440.349500228 Ohm
Ro3p20 h20buf o3p 475440.349500228
* o3 input 21 w=-0.0625815721904128 w-  G = 6.25815721904128e-07 S  R = 1597914.4738604 Ohm
Ro3n21 h21buf o3n 1597914.4738604
* o3 input 22 w=+0.238697201684848 w+  G = 2.38697201684848e-06 S  R = 418940.814111554 Ohm
Ro3p22 h22buf o3p 418940.814111554
* o3 input 23 w=-0.0558624260671465 w-  G = 5.58624260671465e-07 S  R = 1790112.01339162 Ohm
Ro3n23 h23buf o3n 1790112.01339162
* o3 input 24 w=+0.439236044835332 w+  G = 4.39236044835332e-06 S  R = 227668.018542262 Ohm
Ro3p24 h24buf o3p 227668.018542262
* o3 input 25 w=+0.113742741787302 w+  G = 1.13742741787302e-06 S  R = 879176.978052796 Ohm
Ro3p25 h25buf o3p 879176.978052796
* o3 input 26 w=-0.433617266896606 w-  G = 4.33617266896606e-06 S  R = 230618.122557017 Ohm
Ro3n26 h26buf o3n 230618.122557017
* o3 input 27 w=+0.230315174630548 w+  G = 2.30315174630548e-06 S  R = 434187.630756035 Ohm
Ro3p27 h27buf o3p 434187.630756035
* o3 input 28 w=-0.12398109066818 w-  G = 1.2398109066818e-06 S  R = 806574.611185163 Ohm
Ro3n28 h28buf o3n 806574.611185163
* o3 input 29 w=-0.26178305647614 w-  G = 2.6178305647614e-06 S  R = 381995.692716325 Ohm
Ro3n29 h29buf o3n 381995.692716325
* o3 input 30 w=-0.44647126763401 w-  G = 4.4647126763401e-06 S  R = 223978.578800672 Ohm
Ro3n30 h30buf o3n 223978.578800672
* o3 input 31 w=-0.53039390006668 w-  G = 5.3039390006668e-06 S  R = 188539.121561218 Ohm
Ro3n31 h31buf o3n 188539.121561218
* o3 input 32 w=+0.288818654520262 w+  G = 2.88818654520262e-06 S  R = 346238.023184838 Ohm
Ro3p32 h32buf o3p 346238.023184838
* o3 bias=+0.0635007025703613 b+  G = 6.35007025703613e-07 S  R = 1574785.72601927 Ohm
Ro3bp vref o3p 1574785.72601927
Vo3p o3p 0 DC 0
Vo3n o3n 0 DC 0
Fo3p 0 o3d Vo3p 1
Fo3n o3d 0 Vo3n 1
Vo3d o3d 0 DC 0
Ho3 o3lin 0 Vo3d 100000

* --- neuron o4 ---
* o4 input 1 w=+0.274757256178841 w+  G = 2.74757256178841e-06 S  R = 363957.630785589 Ohm
Ro4p1 h1buf o4p 363957.630785589
* o4 input 2 w=-0.133159767354893 w-  G = 1.33159767354893e-06 S  R = 750977.581189997 Ohm
Ro4n2 h2buf o4n 750977.581189997
* o4 input 3 w=-0.106623598682841 w-  G = 1.06623598682841e-06 S  R = 937878.68009836 Ohm
Ro4n3 h3buf o4n 937878.68009836
* o4 input 4 w=+0.10049322803724 w+  G = 1.0049322803724e-06 S  R = 995091.927616687 Ohm
Ro4p4 h4buf o4p 995091.927616687
* o4 input 5 w=-0.195742340683107 w-  G = 1.95742340683107e-06 S  R = 510875.672841233 Ohm
Ro4n5 h5buf o4n 510875.672841233
* o4 input 6 w=-0.202179592890339 w-  G = 2.02179592890339e-06 S  R = 494609.760413552 Ohm
Ro4n6 h6buf o4n 494609.760413552
* o4 input 7 w=-0.112561544712497 w-  G = 1.12561544712497e-06 S  R = 888402.875559487 Ohm
Ro4n7 h7buf o4n 888402.875559487
* o4 input 8 w=+0.0264861793940817 w+  G = 2.64861793940817e-07 S  R = 3775553.9790063 Ohm
Ro4p8 h8buf o4p 3775553.9790063
* o4 input 9 w=-0.0974936293293829 w-  G = 9.74936293293829e-07 S  R = 1025708.04562162 Ohm
Ro4n9 h9buf o4n 1025708.04562162
* o4 input 10 w=-0.296895349286464 w-  G = 2.96895349286464e-06 S  R = 336819.01801538 Ohm
Ro4n10 h10buf o4n 336819.01801538
* o4 input 11 w=-0.580818210763829 w-  G = 5.80818210763829e-06 S  R = 172170.910186323 Ohm
Ro4n11 h11buf o4n 172170.910186323
* o4 input 12 w=-0.276549005245937 w-  G = 2.76549005245937e-06 S  R = 361599.565006821 Ohm
Ro4n12 h12buf o4n 361599.565006821
* o4 input 13 w=-0.164579538023522 w-  G = 1.64579538023522e-06 S  R = 607608.948238194 Ohm
Ro4n13 h13buf o4n 607608.948238194
* o4 input 14 w=-0.00939321676538441 w-  G = 9.39321676538441e-08 S  R = 10645980.232088 Ohm
Ro4n14 h14buf o4n 10645980.232088
* o4 input 15 w=-0.0690593814994067 w-  G = 6.90593814994067e-07 S  R = 1448029.18631496 Ohm
Ro4n15 h15buf o4n 1448029.18631496
* o4 input 16 w=-0.272869230842632 w-  G = 2.72869230842632e-06 S  R = 366475.911157868 Ohm
Ro4n16 h16buf o4n 366475.911157868
* o4 input 17 w=+0.168866320874711 w+  G = 1.68866320874711e-06 S  R = 592184.39462653 Ohm
Ro4p17 h17buf o4p 592184.39462653
* o4 input 18 w=-0.0339148293163791 w-  G = 3.39148293163791e-07 S  R = 2948562.67938536 Ohm
Ro4n18 h18buf o4n 2948562.67938536
* o4 input 19 w=-0.0805852645818897 w-  G = 8.05852645818898e-07 S  R = 1240921.65632069 Ohm
Ro4n19 h19buf o4n 1240921.65632069
* o4 input 20 w=+0.0499049155841609 w+  G = 4.99049155841609e-07 S  R = 2003810.62325128 Ohm
Ro4p20 h20buf o4p 2003810.62325128
* o4 input 21 w=+0.0630428027700635 w+  G = 6.30428027700635e-07 S  R = 1586223.89243592 Ohm
Ro4p21 h21buf o4p 1586223.89243592
* o4 input 22 w=+0.077534797791833 w+  G = 7.7534797791833e-07 S  R = 1289743.48096557 Ohm
Ro4p22 h22buf o4p 1289743.48096557
* o4 input 23 w=+0.0744829629231984 w+  G = 7.44829629231984e-07 S  R = 1342588.90993787 Ohm
Ro4p23 h23buf o4p 1342588.90993787
* o4 input 24 w=-0.00836970221956497 w-  G = 8.36970221956497e-08 S  R = 11947856.3725052 Ohm
Ro4n24 h24buf o4n 11947856.3725052
* o4 input 25 w=-0.0959555339157937 w-  G = 9.59555339157937e-07 S  R = 1042149.37814588 Ohm
Ro4n25 h25buf o4n 1042149.37814588
* o4 input 26 w=-0.27047998771669 w-  G = 2.7047998771669e-06 S  R = 369713.119422141 Ohm
Ro4n26 h26buf o4n 369713.119422141
* o4 input 27 w=-0.0478904255869687 w-  G = 4.78904255869687e-07 S  R = 2088100.04869138 Ohm
Ro4n27 h27buf o4n 2088100.04869138
* o4 input 28 w=-0.311644423649809 w-  G = 3.11644423649809e-06 S  R = 320878.515421052 Ohm
Ro4n28 h28buf o4n 320878.515421052
* o4 input 29 w=-0.0286856006407659 w-  G = 2.86856006407659e-07 S  R = 3486069.58774595 Ohm
Ro4n29 h29buf o4n 3486069.58774595
* o4 input 30 w=-0.016265879828258 w-  G = 1.6265879828258e-07 S  R = 6147838.36200943 Ohm
Ro4n30 h30buf o4n 6147838.36200943
* o4 input 31 w=-0.119685509607977 w-  G = 1.19685509607977e-06 S  R = 835523.033051738 Ohm
Ro4n31 h31buf o4n 835523.033051738
* o4 input 32 w=-0.0356690164245122 w-  G = 3.56690164245122e-07 S  R = 2803553.61666992 Ohm
Ro4n32 h32buf o4n 2803553.61666992
* o4 bias=+0.0671312079863495 b+  G = 6.71312079863495e-07 S  R = 1489620.14835684 Ohm
Ro4bp vref o4p 1489620.14835684
Vo4p o4p 0 DC 0
Vo4n o4n 0 DC 0
Fo4p 0 o4d Vo4p 1
Fo4n o4d 0 Vo4n 1
Vo4d o4d 0 DC 0
Ho4 o4lin 0 Vo4d 100000

* --- neuron o5 ---
* o5 input 1 w=+0.0860510418468527 w+  G = 8.60510418468528e-07 S  R = 1162100.97929985 Ohm
Ro5p1 h1buf o5p 1162100.97929985
* o5 input 2 w=-0.140209371980717 w-  G = 1.40209371980717e-06 S  R = 713219.085053408 Ohm
Ro5n2 h2buf o5n 713219.085053408
* o5 input 3 w=-0.298670153474102 w-  G = 2.98670153474102e-06 S  R = 334817.519718023 Ohm
Ro5n3 h3buf o5n 334817.519718023
* o5 input 4 w=+0.194023589749981 w+  G = 1.94023589749981e-06 S  R = 515401.246461114 Ohm
Ro5p4 h4buf o5p 515401.246461114
* o5 input 5 w=+0.104223096266613 w+  G = 1.04223096266613e-06 S  R = 959480.226380819 Ohm
Ro5p5 h5buf o5p 959480.226380819
* o5 input 6 w=+0.179601423642336 w+  G = 1.79601423642336e-06 S  R = 556788.459534392 Ohm
Ro5p6 h6buf o5p 556788.459534392
* o5 input 7 w=-0.15816414054373 w-  G = 1.5816414054373e-06 S  R = 632254.565770879 Ohm
Ro5n7 h7buf o5n 632254.565770879
* o5 input 8 w=-0.249576912278698 w-  G = 2.49576912278698e-06 S  R = 400678.087916769 Ohm
Ro5n8 h8buf o5n 400678.087916769
* o5 input 9 w=-0.031381439286146 w-  G = 3.1381439286146e-07 S  R = 3186596.99092091 Ohm
Ro5n9 h9buf o5n 3186596.99092091
* o5 input 10 w=+0.375618440651073 w+  G = 3.75618440651073e-06 S  R = 266227.610728234 Ohm
Ro5p10 h10buf o5p 266227.610728234
* o5 input 11 w=+0.0953608962368974 w+  G = 9.53608962368974e-07 S  R = 1048647.86244855 Ohm
Ro5p11 h11buf o5p 1048647.86244855
* o5 input 12 w=+0.235920649298708 w+  G = 2.35920649298708e-06 S  R = 423871.332574141 Ohm
Ro5p12 h12buf o5p 423871.332574141
* o5 input 13 w=-0.0940916695355706 w-  G = 9.40916695355706e-07 S  R = 1062793.3428495 Ohm
Ro5n13 h13buf o5n 1062793.3428495
* o5 input 14 w=+0.00295126144933853 w+  G = 2.95126144933853e-08 S  R = 33883816.0280287 Ohm
Ro5p14 h14buf o5p 33883816.0280287
* o5 input 15 w=+0.529616924207031 w+  G = 5.29616924207031e-06 S  R = 188815.718360445 Ohm
Ro5p15 h15buf o5p 188815.718360445
* o5 input 16 w=+0.319042125899952 w+  G = 3.19042125899952e-06 S  R = 313438.23238991 Ohm
Ro5p16 h16buf o5p 313438.23238991
* o5 input 17 w=-0.466616152697173 w-  G = 4.66616152697173e-06 S  R = 214308.911986805 Ohm
Ro5n17 h17buf o5n 214308.911986805
* o5 input 18 w=-0.243973793531226 w-  G = 2.43973793531226e-06 S  R = 409880.088154637 Ohm
Ro5n18 h18buf o5n 409880.088154637
* o5 input 19 w=-0.167620412829882 w-  G = 1.67620412829882e-06 S  R = 596586.05006235 Ohm
Ro5n19 h19buf o5n 596586.05006235
* o5 input 20 w=+0.191248887162316 w+  G = 1.91248887162316e-06 S  R = 522878.859499601 Ohm
Ro5p20 h20buf o5p 522878.859499601
* o5 input 21 w=+0.174220054558956 w+  G = 1.74220054558956e-06 S  R = 573986.733347969 Ohm
Ro5p21 h21buf o5p 573986.733347969
* o5 input 22 w=-0.14737880105185 w-  G = 1.4737880105185e-06 S  R = 678523.636278046 Ohm
Ro5n22 h22buf o5n 678523.636278046
* o5 input 23 w=-0.261133636281725 w-  G = 2.61133636281725e-06 S  R = 382945.68797761 Ohm
Ro5n23 h23buf o5n 382945.68797761
* o5 input 24 w=+0.130521837388059 w+  G = 1.30521837388059e-06 S  R = 766155.319302521 Ohm
Ro5p24 h24buf o5p 766155.319302521
* o5 input 25 w=-0.326372621774105 w-  G = 3.26372621774105e-06 S  R = 306398.249511302 Ohm
Ro5n25 h25buf o5n 306398.249511302
* o5 input 26 w=+0.16696553546102 w+  G = 1.6696553546102e-06 S  R = 598925.998253971 Ohm
Ro5p26 h26buf o5p 598925.998253971
* o5 input 27 w=-0.105618085709112 w-  G = 1.05618085709112e-06 S  R = 946807.540854458 Ohm
Ro5n27 h27buf o5n 946807.540854458
* o5 input 28 w=+0.0630335864648206 w+  G = 6.30335864648206e-07 S  R = 1586455.81837249 Ohm
Ro5p28 h28buf o5p 1586455.81837249
* o5 input 29 w=+0.231531157265063 w+  G = 2.31531157265063e-06 S  R = 431907.312956231 Ohm
Ro5p29 h29buf o5p 431907.312956231
* o5 input 30 w=-0.0894419530377066 w-  G = 8.94419530377066e-07 S  R = 1118043.56461047 Ohm
Ro5n30 h30buf o5n 1118043.56461047
* o5 input 31 w=+0.216486138811528 w+  G = 2.16486138811528e-06 S  R = 461923.338597948 Ohm
Ro5p31 h31buf o5p 461923.338597948
* o5 input 32 w=-0.32037829849107 w-  G = 3.2037829849107e-06 S  R = 312131.004100415 Ohm
Ro5n32 h32buf o5n 312131.004100415
* o5 bias=+0.0022999314168152 b+  G = 2.2999314168152e-08 S  R = 43479557.3767471 Ohm
Ro5bp vref o5p 43479557.3767471
Vo5p o5p 0 DC 0
Vo5n o5n 0 DC 0
Fo5p 0 o5d Vo5p 1
Fo5n o5d 0 Vo5n 1
Vo5d o5d 0 DC 0
Ho5 o5lin 0 Vo5d 100000

* --- neuron o6 ---
* o6 input 1 w=+0.177051530119574 w+  G = 1.77051530119574e-06 S  R = 564807.318708083 Ohm
Ro6p1 h1buf o6p 564807.318708083
* o6 input 2 w=+0.301592495922723 w+  G = 3.01592495922723e-06 S  R = 331573.236575565 Ohm
Ro6p2 h2buf o6p 331573.236575565
* o6 input 3 w=+0.171870982949934 w+  G = 1.71870982949934e-06 S  R = 581831.780348459 Ohm
Ro6p3 h3buf o6p 581831.780348459
* o6 input 4 w=-0.3405205591368 w-  G = 3.405205591368e-06 S  R = 293668.024783861 Ohm
Ro6n4 h4buf o6n 293668.024783861
* o6 input 5 w=-0.19025500833844 w-  G = 1.9025500833844e-06 S  R = 525610.342000103 Ohm
Ro6n5 h5buf o6n 525610.342000103
* o6 input 6 w=+0.141724280050197 w+  G = 1.41724280050197e-06 S  R = 705595.399493869 Ohm
Ro6p6 h6buf o6p 705595.399493869
* o6 input 7 w=-0.0326153624876146 w-  G = 3.26153624876146e-07 S  R = 3066039.81599083 Ohm
Ro6n7 h7buf o6n 3066039.81599083
* o6 input 8 w=+0.106637930601 w+  G = 1.06637930601e-06 S  R = 937752.631136136 Ohm
Ro6p8 h8buf o6p 937752.631136136
* o6 input 9 w=+0.167194950685368 w+  G = 1.67194950685368e-06 S  R = 598104.186699888 Ohm
Ro6p9 h9buf o6p 598104.186699888
* o6 input 10 w=-0.113695758135469 w-  G = 1.13695758135469e-06 S  R = 879540.289276667 Ohm
Ro6n10 h10buf o6n 879540.289276667
* o6 input 11 w=+0.174899957381211 w+  G = 1.74899957381211e-06 S  R = 571755.428059028 Ohm
Ro6p11 h11buf o6p 571755.428059028
* o6 input 12 w=-0.244360694504916 w-  G = 2.44360694504916e-06 S  R = 409231.117150832 Ohm
Ro6n12 h12buf o6n 409231.117150832
* o6 input 13 w=+0.255772583539878 w+  G = 2.55772583539878e-06 S  R = 390972.318518293 Ohm
Ro6p13 h13buf o6p 390972.318518293
* o6 input 14 w=+0.139949769298614 w+  G = 1.39949769298614e-06 S  R = 714542.08535798 Ohm
Ro6p14 h14buf o6p 714542.08535798
* o6 input 15 w=-0.401168375335584 w-  G = 4.01168375335584e-06 S  R = 249271.892173326 Ohm
Ro6n15 h15buf o6n 249271.892173326
* o6 input 16 w=+0.405832076822582 w+  G = 4.05832076822582e-06 S  R = 246407.333749809 Ohm
Ro6p16 h16buf o6p 246407.333749809
* o6 input 17 w=-0.113061682974004 w-  G = 1.13061682974004e-06 S  R = 884472.947594392 Ohm
Ro6n17 h17buf o6n 884472.947594392
* o6 input 18 w=-0.197513353657142 w-  G = 1.97513353657142e-06 S  R = 506294.881578424 Ohm
Ro6n18 h18buf o6n 506294.881578424
* o6 input 19 w=-0.228990652840289 w-  G = 2.28990652840289e-06 S  R = 436699.047579665 Ohm
Ro6n19 h19buf o6n 436699.047579665
* o6 input 20 w=-0.216778558754084 w-  G = 2.16778558754084e-06 S  R = 461300.234556136 Ohm
Ro6n20 h20buf o6n 461300.234556136
* o6 input 21 w=-0.139531541535413 w-  G = 1.39531541535413e-06 S  R = 716683.832914009 Ohm
Ro6n21 h21buf o6n 716683.832914009
* o6 input 22 w=-0.394983843934915 w-  G = 3.94983843934915e-06 S  R = 253174.912178124 Ohm
Ro6n22 h22buf o6n 253174.912178124
* o6 input 23 w=-0.193849822273603 w-  G = 1.93849822273603e-06 S  R = 515863.25345637 Ohm
Ro6n23 h23buf o6n 515863.25345637
* o6 input 24 w=-0.0741873589980665 w-  G = 7.41873589980665e-07 S  R = 1347938.53495454 Ohm
Ro6n24 h24buf o6n 1347938.53495454
* o6 input 25 w=-0.172655508406202 w-  G = 1.72655508406202e-06 S  R = 579188.008092582 Ohm
Ro6n25 h25buf o6n 579188.008092582
* o6 input 26 w=+0.0670699610875517 w+  G = 6.70699610875517e-07 S  R = 1490980.43861189 Ohm
Ro6p26 h26buf o6p 1490980.43861189
* o6 input 27 w=+0.25363855276468 w+  G = 2.5363855276468e-06 S  R = 394261.830112151 Ohm
Ro6p27 h27buf o6p 394261.830112151
* o6 input 28 w=-0.179185579156039 w-  G = 1.79185579156039e-06 S  R = 558080.624964344 Ohm
Ro6n28 h28buf o6n 558080.624964344
* o6 input 29 w=-0.129923130427228 w-  G = 1.29923130427228e-06 S  R = 769685.887887465 Ohm
Ro6n29 h29buf o6n 769685.887887465
* o6 input 30 w=-0.169171092451912 w-  G = 1.69171092451912e-06 S  R = 591117.539945104 Ohm
Ro6n30 h30buf o6n 591117.539945104
* o6 input 31 w=+0.218686712022964 w+  G = 2.18686712022964e-06 S  R = 457275.154374715 Ohm
Ro6p31 h31buf o6p 457275.154374715
* o6 input 32 w=+0.133370937368681 w+  G = 1.33370937368681e-06 S  R = 749788.536940155 Ohm
Ro6p32 h32buf o6p 749788.536940155
* o6 bias=+0.0648246120847975 b+  G = 6.48246120847975e-07 S  R = 1542623.96308966 Ohm
Ro6bp vref o6p 1542623.96308966
Vo6p o6p 0 DC 0
Vo6n o6n 0 DC 0
Fo6p 0 o6d Vo6p 1
Fo6n o6d 0 Vo6n 1
Vo6d o6d 0 DC 0
Ho6 o6lin 0 Vo6d 100000

* --- neuron o7 ---
* o7 input 1 w=+0.130193574665561 w+  G = 1.30193574665561e-06 S  R = 768087.060032558 Ohm
Ro7p1 h1buf o7p 768087.060032558
* o7 input 2 w=+0.394190134763453 w+  G = 3.94190134763453e-06 S  R = 253684.68457489 Ohm
Ro7p2 h2buf o7p 253684.68457489
* o7 input 3 w=+0.206617853142924 w+  G = 2.06617853142924e-06 S  R = 483985.282389062 Ohm
Ro7p3 h3buf o7p 483985.282389062
* o7 input 4 w=-0.378033462280536 w-  G = 3.78033462280536e-06 S  R = 264526.847429688 Ohm
Ro7n4 h4buf o7n 264526.847429688
* o7 input 5 w=-0.580108461232067 w-  G = 5.80108461232067e-06 S  R = 172381.557386035 Ohm
Ro7n5 h5buf o7n 172381.557386035
* o7 input 6 w=+0.107934080055711 w+  G = 1.07934080055711e-06 S  R = 926491.428364281 Ohm
Ro7p6 h6buf o7p 926491.428364281
* o7 input 7 w=+0.101501144533757 w+  G = 1.01501144533757e-06 S  R = 985210.565450738 Ohm
Ro7p7 h7buf o7p 985210.565450738
* o7 input 8 w=+0.0692471666647439 w+  G = 6.92471666647439e-07 S  R = 1444102.40615539 Ohm
Ro7p8 h8buf o7p 1444102.40615539
* o7 input 9 w=-0.335430638558454 w-  G = 3.35430638558454e-06 S  R = 298124.227499789 Ohm
Ro7n9 h9buf o7n 298124.227499789
* o7 input 10 w=+0.101094797691112 w+  G = 1.01094797691112e-06 S  R = 989170.583292946 Ohm
Ro7p10 h10buf o7p 989170.583292946
* o7 input 11 w=-0.148243371766924 w-  G = 1.48243371766924e-06 S  R = 674566.416077108 Ohm
Ro7n11 h11buf o7n 674566.416077108
* o7 input 12 w=-0.334713947003149 w-  G = 3.34713947003149e-06 S  R = 298762.572923378 Ohm
Ro7n12 h12buf o7n 298762.572923378
* o7 input 13 w=-0.322800486422993 w-  G = 3.22800486422993e-06 S  R = 309788.876429887 Ohm
Ro7n13 h13buf o7n 309788.876429887
* o7 input 14 w=-0.104357857187523 w-  G = 1.04357857187523e-06 S  R = 958241.216282431 Ohm
Ro7n14 h14buf o7n 958241.216282431
* o7 input 15 w=+0.182195051802482 w+  G = 1.82195051802482e-06 S  R = 548862.326450063 Ohm
Ro7p15 h15buf o7p 548862.326450063
* o7 input 16 w=+0.0146234127477982 w+  G = 1.46234127477982e-07 S  R = 6838349.00406928 Ohm
Ro7p16 h16buf o7p 6838349.00406928
* o7 input 17 w=-0.0268461940667064 w-  G = 2.68461940667064e-07 S  R = 3724922.78613214 Ohm
Ro7n17 h17buf o7n 3724922.78613214
* o7 input 18 w=+0.263886686193095 w+  G = 2.63886686193095e-06 S  R = 378950.531543022 Ohm
Ro7p18 h18buf o7p 378950.531543022
* o7 input 19 w=+0.184182739421503 w+  G = 1.84182739421503e-06 S  R = 542939.041487214 Ohm
Ro7p19 h19buf o7p 542939.041487214
* o7 input 20 w=-0.16994338127458 w-  G = 1.6994338127458e-06 S  R = 588431.271933026 Ohm
Ro7n20 h20buf o7n 588431.271933026
* o7 input 21 w=-0.17515931490212 w-  G = 1.7515931490212e-06 S  R = 570908.832658319 Ohm
Ro7n21 h21buf o7n 570908.832658319
* o7 input 22 w=+0.170460541565249 w+  G = 1.70460541565249e-06 S  R = 586646.030112031 Ohm
Ro7p22 h22buf o7p 586646.030112031
* o7 input 23 w=-0.342102206419994 w-  G = 3.42102206419994e-06 S  R = 292310.30412365 Ohm
Ro7n23 h23buf o7n 292310.30412365
* o7 input 24 w=-0.0940891241579366 w-  G = 9.40891241579366e-07 S  R = 1062822.09442338 Ohm
Ro7n24 h24buf o7n 1062822.09442338
* o7 input 25 w=-0.147263798833488 w-  G = 1.47263798833488e-06 S  R = 679053.513437273 Ohm
Ro7n25 h25buf o7n 679053.513437273
* o7 input 26 w=-0.0975787524659246 w-  G = 9.75787524659246e-07 S  R = 1024813.26593021 Ohm
Ro7n26 h26buf o7n 1024813.26593021
* o7 input 27 w=-0.201262065009158 w-  G = 2.01262065009158e-06 S  R = 496864.62272684 Ohm
Ro7n27 h27buf o7n 496864.62272684
* o7 input 28 w=-0.060609790215781 w-  G = 6.0609790215781e-07 S  R = 1649898.46762352 Ohm
Ro7n28 h28buf o7n 1649898.46762352
* o7 input 29 w=-0.355920486311588 w-  G = 3.55920486311588e-06 S  R = 280961.630043559 Ohm
Ro7n29 h29buf o7n 280961.630043559
* o7 input 30 w=+0.0702967455487947 w+  G = 7.02967455487947e-07 S  R = 1422540.96145301 Ohm
Ro7p30 h30buf o7p 1422540.96145301
* o7 input 31 w=+0.188674793501044 w+  G = 1.88674793501044e-06 S  R = 530012.505350623 Ohm
Ro7p31 h31buf o7p 530012.505350623
* o7 input 32 w=-0.221533996080022 w-  G = 2.21533996080022e-06 S  R = 451397.987529997 Ohm
Ro7n32 h32buf o7n 451397.987529997
* o7 bias=+0.0479731403374592 b+  G = 4.79731403374592e-07 S  R = 2084499.7700081 Ohm
Ro7bp vref o7p 2084499.7700081
Vo7p o7p 0 DC 0
Vo7n o7n 0 DC 0
Fo7p 0 o7d Vo7p 1
Fo7n o7d 0 Vo7n 1
Vo7d o7d 0 DC 0
Ho7 o7lin 0 Vo7d 100000

* --- neuron o8 ---
* o8 input 1 w=-0.264579445854062 w-  G = 2.64579445854062e-06 S  R = 377958.309184601 Ohm
Ro8n1 h1buf o8n 377958.309184601
* o8 input 2 w=-0.461651647659873 w-  G = 4.61651647659873e-06 S  R = 216613.545098134 Ohm
Ro8n2 h2buf o8n 216613.545098134
* o8 input 3 w=-0.248506615035073 w-  G = 2.48506615035073e-06 S  R = 402403.774989597 Ohm
Ro8n3 h3buf o8n 402403.774989597
* o8 input 4 w=-0.0596907059046396 w-  G = 5.96907059046396e-07 S  R = 1675302.68715129 Ohm
Ro8n4 h4buf o8n 1675302.68715129
* o8 input 5 w=-0.142952779428107 w-  G = 1.42952779428107e-06 S  R = 699531.694312325 Ohm
Ro8n5 h5buf o8n 699531.694312325
* o8 input 6 w=+0.230947580946818 w+  G = 2.30947580946818e-06 S  R = 432998.689962584 Ohm
Ro8p6 h6buf o8p 432998.689962584
* o8 input 7 w=+0.224542704495923 w+  G = 2.24542704495923e-06 S  R = 445349.583833019 Ohm
Ro8p7 h7buf o8p 445349.583833019
* o8 input 8 w=-0.0814289785611842 w-  G = 8.14289785611842e-07 S  R = 1228064.03527292 Ohm
Ro8n8 h8buf o8n 1228064.03527292
* o8 input 9 w=+0.151871407153412 w+  G = 1.51871407153412e-06 S  R = 658451.790724411 Ohm
Ro8p9 h9buf o8p 658451.790724411
* o8 input 10 w=-0.0439376442611886 w-  G = 4.39376442611886e-07 S  R = 2275952.69799963 Ohm
Ro8n10 h10buf o8n 2275952.69799963
* o8 input 11 w=-0.0114777570667242 w-  G = 1.14777570667242e-07 S  R = 8712503.62058245 Ohm
Ro8n11 h11buf o8n 8712503.62058245
* o8 input 12 w=-0.184091969163629 w-  G = 1.84091969163629e-06 S  R = 543206.748530759 Ohm
Ro8n12 h12buf o8n 543206.748530759
* o8 input 13 w=+0.167375709493599 w+  G = 1.67375709493599e-06 S  R = 597458.259042206 Ohm
Ro8p13 h13buf o8p 597458.259042206
* o8 input 14 w=+0.639794426458427 w+  G = 6.39794426458427e-06 S  R = 156300.204979197 Ohm
Ro8p14 h14buf o8p 156300.204979197
* o8 input 15 w=+0.00251732875304732 w+  G = 2.51732875304732e-08 S  R = 39724648.5501532 Ohm
Ro8p15 h15buf o8p 39724648.5501532
* o8 input 16 w=+0.510552134317183 w+  G = 5.10552134317183e-06 S  R = 195866.383231834 Ohm
Ro8p16 h16buf o8p 195866.383231834
* o8 input 17 w=-0.402994248540282 w-  G = 4.02994248540282e-06 S  R = 248142.499209897 Ohm
Ro8n17 h17buf o8n 248142.499209897
* o8 input 18 w=+0.141582671709231 w+  G = 1.41582671709231e-06 S  R = 706301.122819398 Ohm
Ro8p18 h18buf o8p 706301.122819398
* o8 input 19 w=+0.181760587882604 w+  G = 1.81760587882604e-06 S  R = 550174.276860219 Ohm
Ro8p19 h19buf o8p 550174.276860219
* o8 input 20 w=+0.465247625040388 w+  G = 4.65247625040388e-06 S  R = 214939.30246569 Ohm
Ro8p20 h20buf o8p 214939.30246569
* o8 input 21 w=-0.129997678502292 w-  G = 1.29997678502292e-06 S  R = 769244.506148908 Ohm
Ro8n21 h21buf o8n 769244.506148908
* o8 input 22 w=+0.727771195072513 w+  G = 7.27771195072513e-06 S  R = 137405.822979894 Ohm
Ro8p22 h22buf o8p 137405.822979894
* o8 input 23 w=+0.0590279674258587 w+  G = 5.90279674258587e-07 S  R = 1694112.20411077 Ohm
Ro8p23 h23buf o8p 1694112.20411077
* o8 input 24 w=-0.0219880792573176 w-  G = 2.19880792573176e-07 S  R = 4547918.84410369 Ohm
Ro8n24 h24buf o8n 4547918.84410369
* o8 input 25 w=-0.000673889145733125 w-  G = 6.73889145733125e-09 S  R = 148392358.94089 Ohm
Ro8n25 h25buf o8n 148392358.94089
* o8 input 26 w=-0.0895992045192751 w-  G = 8.95992045192751e-07 S  R = 1116081.33729008 Ohm
Ro8n26 h26buf o8n 1116081.33729008
* o8 input 27 w=-0.161030155307918 w-  G = 1.61030155307918e-06 S  R = 621001.698773641 Ohm
Ro8n27 h27buf o8n 621001.698773641
* o8 input 28 w=-0.0515875057732319 w-  G = 5.15875057732319e-07 S  R = 1938453.86593373 Ohm
Ro8n28 h28buf o8n 1938453.86593373
* o8 input 29 w=-0.167333727666792 w-  G = 1.67333727666792e-06 S  R = 597608.153444879 Ohm
Ro8n29 h29buf o8n 597608.153444879
* o8 input 30 w=+0.117154510339097 w+  G = 1.17154510339097e-06 S  R = 853573.624357747 Ohm
Ro8p30 h30buf o8p 853573.624357747
* o8 input 31 w=-0.114263857072683 w-  G = 1.14263857072683e-06 S  R = 875167.376298092 Ohm
Ro8n31 h31buf o8n 875167.376298092
* o8 input 32 w=+0.185068242761295 w+  G = 1.85068242761295e-06 S  R = 540341.219584508 Ohm
Ro8p32 h32buf o8p 540341.219584508
* o8 bias=+0.070334250370477 b+  G = 7.0334250370477e-07 S  R = 1421782.41003867 Ohm
Ro8bp vref o8p 1421782.41003867
Vo8p o8p 0 DC 0
Vo8n o8n 0 DC 0
Fo8p 0 o8d Vo8p 1
Fo8n o8d 0 Vo8n 1
Vo8d o8d 0 DC 0
Ho8 o8lin 0 Vo8d 100000

* --- neuron o9 ---
* o9 input 1 w=-0.342788496026982 w-  G = 3.42788496026982e-06 S  R = 291725.075838393 Ohm
Ro9n1 h1buf o9n 291725.075838393
* o9 input 2 w=+0.117901804588507 w+  G = 1.17901804588507e-06 S  R = 848163.438626013 Ohm
Ro9p2 h2buf o9p 848163.438626013
* o9 input 3 w=-0.555835720214104 w-  G = 5.55835720214104e-06 S  R = 179909.272404229 Ohm
Ro9n3 h3buf o9n 179909.272404229
* o9 input 4 w=+0.355136587925528 w+  G = 3.55136587925528e-06 S  R = 281581.800918158 Ohm
Ro9p4 h4buf o9p 281581.800918158
* o9 input 5 w=+0.236432436172994 w+  G = 2.36432436172994e-06 S  R = 422953.811324059 Ohm
Ro9p5 h5buf o9p 422953.811324059
* o9 input 6 w=-0.00589463242951189 w-  G = 5.89463242951189e-08 S  R = 16964586.2054677 Ohm
Ro9n6 h6buf o9n 16964586.2054677
* o9 input 7 w=-0.175810166557473 w-  G = 1.75810166557473e-06 S  R = 568795.320305381 Ohm
Ro9n7 h7buf o9n 568795.320305381
* o9 input 8 w=+0.162552656301944 w+  G = 1.62552656301944e-06 S  R = 615185.27149903 Ohm
Ro9p8 h8buf o9p 615185.27149903
* o9 input 9 w=-0.443497798175432 w-  G = 4.43497798175432e-06 S  R = 225480.262611007 Ohm
Ro9n9 h9buf o9n 225480.262611007
* o9 input 10 w=+0.114863161009978 w+  G = 1.14863161009978e-06 S  R = 870601.149408673 Ohm
Ro9p10 h10buf o9p 870601.149408673
* o9 input 11 w=-0.051706338551111 w-  G = 5.1706338551111e-07 S  R = 1933998.86362387 Ohm
Ro9n11 h11buf o9n 1933998.86362387
* o9 input 12 w=-0.247913853258797 w-  G = 2.47913853258797e-06 S  R = 403365.922014894 Ohm
Ro9n12 h12buf o9n 403365.922014894
* o9 input 13 w=+0.0720916431840902 w+  G = 7.20916431840902e-07 S  R = 1387123.32779881 Ohm
Ro9p13 h13buf o9p 1387123.32779881
* o9 input 14 w=+0.00473033723811417 w+  G = 4.73033723811417e-08 S  R = 21140141.8051679 Ohm
Ro9p14 h14buf o9p 21140141.8051679
* o9 input 15 w=-0.290577914446662 w-  G = 2.90577914446662e-06 S  R = 344141.777569113 Ohm
Ro9n15 h15buf o9n 344141.777569113
* o9 input 16 w=-0.0531648681945055 w-  G = 5.31648681945055e-07 S  R = 1880941.36966815 Ohm
Ro9n16 h16buf o9n 1880941.36966815
* o9 input 17 w=+0.0157425177085947 w+  G = 1.57425177085947e-07 S  R = 6352224.07565751 Ohm
Ro9p17 h17buf o9p 6352224.07565751
* o9 input 18 w=-0.104777957691913 w-  G = 1.04777957691913e-06 S  R = 954399.20955549 Ohm
Ro9n18 h18buf o9n 954399.20955549
* o9 input 19 w=-0.368259428743895 w-  G = 3.68259428743895e-06 S  R = 271547.69761386 Ohm
Ro9n19 h19buf o9n 271547.69761386
* o9 input 20 w=+0.100989358745228 w+  G = 1.00989358745228e-06 S  R = 990203.336692893 Ohm
Ro9p20 h20buf o9p 990203.336692893
* o9 input 21 w=+0.084258883556939 w+  G = 8.4258883556939e-07 S  R = 1186818.47869992 Ohm
Ro9p21 h21buf o9p 1186818.47869992
* o9 input 22 w=+0.093068688723566 w+  G = 9.3068688723566e-07 S  R = 1074475.22224173 Ohm
Ro9p22 h22buf o9p 1074475.22224173
* o9 input 23 w=+0.153137872499505 w+  G = 1.53137872499505e-06 S  R = 653006.329314933 Ohm
Ro9p23 h23buf o9p 653006.329314933
* o9 input 24 w=+0.0107021071757068 w+  G = 1.07021071757068e-07 S  R = 9343954.26603411 Ohm
Ro9p24 h24buf o9p 9343954.26603411
* o9 input 25 w=+0.151859492007221 w+  G = 1.51859492007221e-06 S  R = 658503.453937834 Ohm
Ro9p25 h25buf o9p 658503.453937834
* o9 input 26 w=-0.0745603298060184 w-  G = 7.45603298060184e-07 S  R = 1341195.78414107 Ohm
Ro9n26 h26buf o9n 1341195.78414107
* o9 input 27 w=+0.475223780202243 w+  G = 4.75223780202243e-06 S  R = 210427.180132784 Ohm
Ro9p27 h27buf o9p 210427.180132784
* o9 input 28 w=+0.715956917954612 w+  G = 7.15956917954613e-06 S  R = 139673.208669714 Ohm
Ro9p28 h28buf o9p 139673.208669714
* o9 input 29 w=-0.520384445309866 w-  G = 5.20384445309866e-06 S  R = 192165.620823763 Ohm
Ro9n29 h29buf o9n 192165.620823763
* o9 input 30 w=+0.217731604854565 w+  G = 2.17731604854565e-06 S  R = 459281.049560056 Ohm
Ro9p30 h30buf o9p 459281.049560056
* o9 input 31 w=-0.123913004875871 w-  G = 1.23913004875871e-06 S  R = 807017.795268333 Ohm
Ro9n31 h31buf o9n 807017.795268333
* o9 input 32 w=+0.0869405958454977 w+  G = 8.69405958454977e-07 S  R = 1150210.65852493 Ohm
Ro9p32 h32buf o9p 1150210.65852493
* o9 bias=-0.00785769582167887 b-  G = 7.85769582167887e-08 S  R = 12726377.0791568 Ohm
Ro9bn vref o9n 12726377.0791568
Vo9p o9p 0 DC 0
Vo9n o9n 0 DC 0
Fo9p 0 o9d Vo9p 1
Fo9n o9d 0 Vo9n 1
Vo9d o9d 0 DC 0
Ho9 o9lin 0 Vo9d 100000

* --- neuron o10 ---
* o10 input 1 w=-0.0381763956958746 w-  G = 3.81763956958746e-07 S  R = 2619419.62244503 Ohm
Ro10n1 h1buf o10n 2619419.62244503
* o10 input 2 w=+0.410781186996451 w+  G = 4.10781186996451e-06 S  R = 243438.607135784 Ohm
Ro10p2 h2buf o10p 243438.607135784
* o10 input 3 w=+0.475033421735393 w+  G = 4.75033421735393e-06 S  R = 210511.503874148 Ohm
Ro10p3 h3buf o10p 210511.503874148
* o10 input 4 w=+0.0271427582394968 w+  G = 2.71427582394968e-07 S  R = 3684223.95092054 Ohm
Ro10p4 h4buf o10p 3684223.95092054
* o10 input 5 w=+0.0212799641995083 w+  G = 2.12799641995083e-07 S  R = 4699256.0261126 Ohm
Ro10p5 h5buf o10p 4699256.0261126
* o10 input 6 w=+0.0201273268189427 w+  G = 2.01273268189427e-07 S  R = 4968369.66476273 Ohm
Ro10p6 h6buf o10p 4968369.66476273
* o10 input 7 w=-0.036291550108304 w-  G = 3.6291550108304e-07 S  R = 2755462.35147224 Ohm
Ro10n7 h7buf o10n 2755462.35147224
* o10 input 8 w=+0.0509688710938526 w+  G = 5.09688710938526e-07 S  R = 1961981.84997786 Ohm
Ro10p8 h8buf o10p 1961981.84997786
* o10 input 9 w=-0.135969386219015 w-  G = 1.35969386219015e-06 S  R = 735459.670597638 Ohm
Ro10n9 h9buf o10n 735459.670597638
* o10 input 10 w=+0.542965243347564 w+  G = 5.42965243347564e-06 S  R = 184173.851319591 Ohm
Ro10p10 h10buf o10p 184173.851319591
* o10 input 11 w=+0.200790198383509 w+  G = 2.00790198383509e-06 S  R = 498032.278492996 Ohm
Ro10p11 h11buf o10p 498032.278492996
* o10 input 12 w=-0.0602452386161185 w-  G = 6.02452386161185e-07 S  R = 1659882.21305252 Ohm
Ro10n12 h12buf o10n 1659882.21305252
* o10 input 13 w=-0.18784742953156 w-  G = 1.8784742953156e-06 S  R = 532346.917119775 Ohm
Ro10n13 h13buf o10n 532346.917119775
* o10 input 14 w=-0.0121063802780956 w-  G = 1.21063802780956e-07 S  R = 8260107.29077568 Ohm
Ro10n14 h14buf o10n 8260107.29077568
* o10 input 15 w=+0.162912924713055 w+  G = 1.62912924713055e-06 S  R = 613824.840331937 Ohm
Ro10p15 h15buf o10p 613824.840331937
* o10 input 16 w=+0.000496602144198326 w+  G = 4.96602144198326e-09 S  R = 201368441.856875 Ohm
Ro10p16 h16buf o10p 201368441.856875
* o10 input 17 w=+0.150471984074884 w+  G = 1.50471984074884e-06 S  R = 664575.539525244 Ohm
Ro10p17 h17buf o10p 664575.539525244
* o10 input 18 w=-0.0993574349593851 w-  G = 9.93574349593851e-07 S  R = 1006467.20641367 Ohm
Ro10n18 h18buf o10n 1006467.20641367
* o10 input 19 w=-0.0430450321763909 w-  G = 4.30450321763909e-07 S  R = 2323148.45509274 Ohm
Ro10n19 h19buf o10n 2323148.45509274
* o10 input 20 w=-0.498578232263262 w-  G = 4.98578232263262e-06 S  R = 200570.328844997 Ohm
Ro10n20 h20buf o10n 200570.328844997
* o10 input 21 w=-0.135185117923925 w-  G = 1.35185117923925e-06 S  R = 739726.395447423 Ohm
Ro10n21 h21buf o10n 739726.395447423
* o10 input 22 w=+0.00794231626553338 w+  G = 7.94231626553339e-08 S  R = 12590785.4405096 Ohm
Ro10p22 h22buf o10p 12590785.4405096
* o10 input 23 w=-0.411689837989046 w-  G = 4.11689837989047e-06 S  R = 242901.307665167 Ohm
Ro10n23 h23buf o10n 242901.307665167
* o10 input 24 w=+0.321047972853849 w+  G = 3.21047972853849e-06 S  R = 311479.929653763 Ohm
Ro10p24 h24buf o10p 311479.929653763
* o10 input 25 w=-0.130972309748016 w-  G = 1.30972309748016e-06 S  R = 763520.168441673 Ohm
Ro10n25 h25buf o10n 763520.168441673
* o10 input 26 w=+0.0365278526067883 w+  G = 3.65278526067883e-07 S  R = 2737636.97736275 Ohm
Ro10p26 h26buf o10p 2737636.97736275
* o10 input 27 w=-0.205674584301975 w-  G = 2.05674584301975e-06 S  R = 486204.94525069 Ohm
Ro10n27 h27buf o10n 486204.94525069
* o10 input 28 w=-0.0123163999797875 w-  G = 1.23163999797875e-07 S  R = 8119255.63996871 Ohm
Ro10n28 h28buf o10n 8119255.63996871
* o10 input 29 w=-0.120487475126756 w-  G = 1.20487475126756e-06 S  R = 829961.785611307 Ohm
Ro10n29 h29buf o10n 829961.785611307
* o10 input 30 w=-0.421650115672696 w-  G = 4.21650115672696e-06 S  R = 237163.459188102 Ohm
Ro10n30 h30buf o10n 237163.459188102
* o10 input 31 w=+0.15176529701113 w+  G = 1.5176529701113e-06 S  R = 658912.162196514 Ohm
Ro10p31 h31buf o10p 658912.162196514
* o10 input 32 w=+0.00307524765960727 w+  G = 3.07524765960727e-08 S  R = 32517706.2366322 Ohm
Ro10p32 h32buf o10p 32517706.2366322
* o10 bias=-0.031263579434271 b-  G = 3.1263579434271e-07 S  R = 3198610.0699135 Ohm
Ro10bn vref o10n 3198610.0699135
Vo10p o10p 0 DC 0
Vo10n o10n 0 DC 0
Fo10p 0 o10d Vo10p 1
Fo10n o10d 0 Vo10n 1
Vo10d o10d 0 DC 0
Ho10 o10lin 0 Vo10d 100000

* --- neuron o11 ---
* o11 input 1 w=-0.160102279955593 w-  G = 1.60102279955593e-06 S  R = 624600.724160436 Ohm
Ro11n1 h1buf o11n 624600.724160436
* o11 input 2 w=+0.011469223690656 w+  G = 1.1469223690656e-07 S  R = 8718985.93114633 Ohm
Ro11p2 h2buf o11p 8718985.93114633
* o11 input 3 w=+0.0176041755498141 w+  G = 1.76041755498141e-07 S  R = 5680470.50638823 Ohm
Ro11p3 h3buf o11p 5680470.50638823
* o11 input 4 w=-0.0193710750418404 w-  G = 1.93710750418404e-07 S  R = 5162336.1008104 Ohm
Ro11n4 h4buf o11n 5162336.1008104
* o11 input 5 w=+0.112602634979867 w+  G = 1.12602634979867e-06 S  R = 888078.684995953 Ohm
Ro11p5 h5buf o11p 888078.684995953
* o11 input 6 w=+0.00163262396170036 w+  G = 1.63262396170036e-08 S  R = 61251091.7062928 Ohm
Ro11p6 h6buf o11p 61251091.7062928
* o11 input 7 w=-0.0344149127536822 w-  G = 3.44149127536822e-07 S  R = 2905717.08595428 Ohm
Ro11n7 h7buf o11n 2905717.08595428
* o11 input 8 w=+0.0140339587694358 w+  G = 1.40339587694358e-07 S  R = 7125573.16455765 Ohm
Ro11p8 h8buf o11p 7125573.16455765
* o11 input 9 w=+0.200472625000294 w+  G = 2.00472625000294e-06 S  R = 498821.223096437 Ohm
Ro11p9 h9buf o11p 498821.223096437
* o11 input 10 w=+0.127220756971711 w+  G = 1.27220756971711e-06 S  R = 786035.253840191 Ohm
Ro11p10 h10buf o11p 786035.253840191
* o11 input 11 w=-0.215899699488286 w-  G = 2.15899699488286e-06 S  R = 463178.041641628 Ohm
Ro11n11 h11buf o11n 463178.041641628
* o11 input 12 w=-0.0276713436872213 w-  G = 2.76713436872213e-07 S  R = 3613846.91435061 Ohm
Ro11n12 h12buf o11n 3613846.91435061
* o11 input 13 w=+0.188664634231365 w+  G = 1.88664634231365e-06 S  R = 530041.045622609 Ohm
Ro11p13 h13buf o11p 530041.045622609
* o11 input 14 w=-0.119078372545684 w-  G = 1.19078372545684e-06 S  R = 839783.059359796 Ohm
Ro11n14 h14buf o11n 839783.059359796
* o11 input 15 w=+0.15422975355602 w+  G = 1.5422975355602e-06 S  R = 648383.322247076 Ohm
Ro11p15 h15buf o11p 648383.322247076
* o11 input 16 w=-0.104607206722078 w-  G = 1.04607206722078e-06 S  R = 955957.081099405 Ohm
Ro11n16 h16buf o11n 955957.081099405
* o11 input 17 w=+0.106639727219858 w+  G = 1.06639727219858e-06 S  R = 937736.832295447 Ohm
Ro11p17 h17buf o11p 937736.832295447
* o11 input 18 w=+0.310905721051453 w+  G = 3.10905721051453e-06 S  R = 321640.913077475 Ohm
Ro11p18 h18buf o11p 321640.913077475
* o11 input 19 w=+0.210141672521531 w+  G = 2.10141672521531e-06 S  R = 475869.439888246 Ohm
Ro11p19 h19buf o11p 475869.439888246
* o11 input 20 w=+0.009349861892821 w+  G = 9.349861892821e-08 S  R = 10695345.1448071 Ohm
Ro11p20 h20buf o11p 10695345.1448071
* o11 input 21 w=-0.148461029214851 w-  G = 1.48461029214851e-06 S  R = 673577.440011419 Ohm
Ro11n21 h21buf o11n 673577.440011419
* o11 input 22 w=-0.118671866129314 w-  G = 1.18671866129314e-06 S  R = 842659.707491519 Ohm
Ro11n22 h22buf o11n 842659.707491519
* o11 input 23 w=-0.109207143921327 w-  G = 1.09207143921327e-06 S  R = 915691.010764281 Ohm
Ro11n23 h23buf o11n 915691.010764281
* o11 input 24 w=-0.0902417819363344 w-  G = 9.02417819363344e-07 S  R = 1108134.14644837 Ohm
Ro11n24 h24buf o11n 1108134.14644837
* o11 input 25 w=+0.314745464583241 w+  G = 3.14745464583241e-06 S  R = 317717.04838515 Ohm
Ro11p25 h25buf o11p 317717.04838515
* o11 input 26 w=+0.0956381358816812 w+  G = 9.56381358816812e-07 S  R = 1045608.00017804 Ohm
Ro11p26 h26buf o11p 1045608.00017804
* o11 input 27 w=-0.150311342322866 w-  G = 1.50311342322866e-06 S  R = 665285.789180179 Ohm
Ro11n27 h27buf o11n 665285.789180179
* o11 input 28 w=-0.0832874521070705 w-  G = 8.32874521070705e-07 S  R = 1200661.05361759 Ohm
Ro11n28 h28buf o11n 1200661.05361759
* o11 input 29 w=+0.0404370827831914 w+  G = 4.04370827831914e-07 S  R = 2472977.60167722 Ohm
Ro11p29 h29buf o11p 2472977.60167722
* o11 input 30 w=-0.0722629324126473 w-  G = 7.22629324126473e-07 S  R = 1383835.34491742 Ohm
Ro11n30 h30buf o11n 1383835.34491742
* o11 input 31 w=-0.0830409064130833 w-  G = 8.30409064130834e-07 S  R = 1204225.77642101 Ohm
Ro11n31 h31buf o11n 1204225.77642101
* o11 input 32 w=-0.390143512242536 w-  G = 3.90143512242536e-06 S  R = 256315.937243714 Ohm
Ro11n32 h32buf o11n 256315.937243714
* o11 bias=-0.00144268984703634 b-  G = 1.44268984703634e-08 S  R = 69314967.5971077 Ohm
Ro11bn vref o11n 69314967.5971077
Vo11p o11p 0 DC 0
Vo11n o11n 0 DC 0
Fo11p 0 o11d Vo11p 1
Fo11n o11d 0 Vo11n 1
Vo11d o11d 0 DC 0
Ho11 o11lin 0 Vo11d 100000

* --- neuron o12 ---
* o12 input 1 w=-0.0568819810826339 w-  G = 5.68819810826339e-07 S  R = 1758025.97055696 Ohm
Ro12n1 h1buf o12n 1758025.97055696
* o12 input 2 w=-0.116449760348513 w-  G = 1.16449760348513e-06 S  R = 858739.42291266 Ohm
Ro12n2 h2buf o12n 858739.42291266
* o12 input 3 w=-0.394245634375715 w-  G = 3.94245634375715e-06 S  R = 253648.972317345 Ohm
Ro12n3 h3buf o12n 253648.972317345
* o12 input 4 w=-0.0304757769901363 w-  G = 3.04757769901363e-07 S  R = 3281294.51899999 Ohm
Ro12n4 h4buf o12n 3281294.51899999
* o12 input 5 w=-0.225077356892672 w-  G = 2.25077356892673e-06 S  R = 444291.693222987 Ohm
Ro12n5 h5buf o12n 444291.693222987
* o12 input 6 w=-0.48876360312342 w-  G = 4.8876360312342e-06 S  R = 204597.886096581 Ohm
Ro12n6 h6buf o12n 204597.886096581
* o12 input 7 w=+0.269859073889073 w+  G = 2.69859073889073e-06 S  R = 370563.78560428 Ohm
Ro12p7 h7buf o12p 370563.78560428
* o12 input 8 w=-0.0167144075003679 w-  G = 1.67144075003679e-07 S  R = 5982862.38969576 Ohm
Ro12n8 h8buf o12n 5982862.38969576
* o12 input 9 w=-0.271168635938693 w-  G = 2.71168635938693e-06 S  R = 368774.211862055 Ohm
Ro12n9 h9buf o12n 368774.211862055
* o12 input 10 w=-0.229866523415109 w-  G = 2.29866523415109e-06 S  R = 435035.073895527 Ohm
Ro12n10 h10buf o12n 435035.073895527
* o12 input 11 w=+0.111794037161303 w+  G = 1.11794037161303e-06 S  R = 894502.090981065 Ohm
Ro12p11 h11buf o12p 894502.090981065
* o12 input 12 w=-0.187970289472281 w-  G = 1.87970289472281e-06 S  R = 531998.967925974 Ohm
Ro12n12 h12buf o12n 531998.967925974
* o12 input 13 w=+0.219867348390274 w+  G = 2.19867348390274e-06 S  R = 454819.693474885 Ohm
Ro12p13 h13buf o12p 454819.693474885
* o12 input 14 w=-0.127058880326711 w-  G = 1.27058880326711e-06 S  R = 787036.685219217 Ohm
Ro12n14 h14buf o12n 787036.685219217
* o12 input 15 w=+0.40629100094033 w+  G = 4.0629100094033e-06 S  R = 246129.005487588 Ohm
Ro12p15 h15buf o12p 246129.005487588
* o12 input 16 w=-0.479164967789437 w-  G = 4.79164967789437e-06 S  R = 208696.392103405 Ohm
Ro12n16 h16buf o12n 208696.392103405
* o12 input 17 w=-0.142691971348636 w-  G = 1.42691971348636e-06 S  R = 700810.277234677 Ohm
Ro12n17 h17buf o12n 700810.277234677
* o12 input 18 w=+0.0750962927559542 w+  G = 7.50962927559542e-07 S  R = 1331623.65717542 Ohm
Ro12p18 h18buf o12p 1331623.65717542
* o12 input 19 w=-0.0357891000093011 w-  G = 3.57891000093011e-07 S  R = 2794146.8205127 Ohm
Ro12n19 h19buf o12n 2794146.8205127
* o12 input 20 w=-0.274882313904053 w-  G = 2.74882313904053e-06 S  R = 363792.048239614 Ohm
Ro12n20 h20buf o12n 363792.048239614
* o12 input 21 w=+0.0723735016816067 w+  G = 7.23735016816067e-07 S  R = 1381721.17800698 Ohm
Ro12p21 h21buf o12p 1381721.17800698
* o12 input 22 w=-0.42830678611073 w-  G = 4.2830678611073e-06 S  R = 233477.50547699 Ohm
Ro12n22 h22buf o12n 233477.50547699
* o12 input 23 w=-0.495732058756383 w-  G = 4.95732058756383e-06 S  R = 201721.87421339 Ohm
Ro12n23 h23buf o12n 201721.87421339
* o12 input 24 w=-0.0511653226482421 w-  G = 5.11653226482421e-07 S  R = 1954448.7325428 Ohm
Ro12n24 h24buf o12n 1954448.7325428
* o12 input 25 w=+0.0558940521557335 w+  G = 5.58940521557335e-07 S  R = 1789099.1284972 Ohm
Ro12p25 h25buf o12p 1789099.1284972
* o12 input 26 w=+0.307817092263132 w+  G = 3.07817092263132e-06 S  R = 324868.24972837 Ohm
Ro12p26 h26buf o12p 324868.24972837
* o12 input 27 w=-0.124284155438311 w-  G = 1.24284155438312e-06 S  R = 804607.792902733 Ohm
Ro12n27 h27buf o12n 804607.792902733
* o12 input 28 w=+0.511620988407946 w+  G = 5.11620988407946e-06 S  R = 195457.188555103 Ohm
Ro12p28 h28buf o12p 195457.188555103
* o12 input 29 w=-0.110998740438628 w-  G = 1.10998740438628e-06 S  R = 900911.12389956 Ohm
Ro12n29 h29buf o12n 900911.12389956
* o12 input 30 w=+0.0696620617055659 w+  G = 6.96620617055659e-07 S  R = 1435501.58510468 Ohm
Ro12p30 h30buf o12p 1435501.58510468
* o12 input 31 w=+0.219973071991933 w+  G = 2.19973071991933e-06 S  R = 454601.097736488 Ohm
Ro12p31 h31buf o12p 454601.097736488
* o12 input 32 w=+0.138023444689957 w+  G = 1.38023444689957e-06 S  R = 724514.594057773 Ohm
Ro12p32 h32buf o12p 724514.594057773
* o12 bias=+0.00625312847600372 b+  G = 6.25312847600372e-08 S  R = 15991995.1083283 Ohm
Ro12bp vref o12p 15991995.1083283
Vo12p o12p 0 DC 0
Vo12n o12n 0 DC 0
Fo12p 0 o12d Vo12p 1
Fo12n o12d 0 Vo12n 1
Vo12d o12d 0 DC 0
Ho12 o12lin 0 Vo12d 100000

* --- neuron o13 ---
* o13 input 1 w=+0.00200007413415942 w+  G = 2.00007413415942e-08 S  R = 49998146.7147105 Ohm
Ro13p1 h1buf o13p 49998146.7147105
* o13 input 2 w=-0.0237460165980216 w-  G = 2.37460165980216e-07 S  R = 4211232.63294323 Ohm
Ro13n2 h2buf o13n 4211232.63294323
* o13 input 3 w=-0.481641955158027 w-  G = 4.81641955158027e-06 S  R = 207623.108678707 Ohm
Ro13n3 h3buf o13n 207623.108678707
* o13 input 4 w=-0.401500412219866 w-  G = 4.01500412219866e-06 S  R = 249065.746774972 Ohm
Ro13n4 h4buf o13n 249065.746774972
* o13 input 5 w=-0.324731283585407 w-  G = 3.24731283585407e-06 S  R = 307946.924287322 Ohm
Ro13n5 h5buf o13n 307946.924287322
* o13 input 6 w=+0.0791891194793975 w+  G = 7.91891194793975e-07 S  R = 1262799.7464477 Ohm
Ro13p6 h6buf o13p 1262799.7464477
* o13 input 7 w=+0.286949833874567 w+  G = 2.86949833874567e-06 S  R = 348492.970529868 Ohm
Ro13p7 h7buf o13p 348492.970529868
* o13 input 8 w=-0.153846131933853 w-  G = 1.53846131933853e-06 S  R = 650000.092579485 Ohm
Ro13n8 h8buf o13n 650000.092579485
* o13 input 9 w=-0.0455077430770376 w-  G = 4.55077430770376e-07 S  R = 2197428.24491901 Ohm
Ro13n9 h9buf o13n 2197428.24491901
* o13 input 10 w=+0.122909253832841 w+  G = 1.22909253832841e-06 S  R = 813608.388966398 Ohm
Ro13p10 h10buf o13p 813608.388966398
* o13 input 11 w=+0.0797228425783465 w+  G = 7.97228425783466e-07 S  R = 1254345.64004321 Ohm
Ro13p11 h11buf o13p 1254345.64004321
* o13 input 12 w=-0.0916703213430956 w-  G = 9.16703213430956e-07 S  R = 1090865.59897318 Ohm
Ro13n12 h12buf o13n 1090865.59897318
* o13 input 13 w=-0.00253109868008519 w-  G = 2.53109868008519e-08 S  R = 39508534.6876457 Ohm
Ro13n13 h13buf o13n 39508534.6876457
* o13 input 14 w=+0.523873822520012 w+  G = 5.23873822520013e-06 S  R = 190885.659296671 Ohm
Ro13p14 h14buf o13p 190885.659296671
* o13 input 15 w=+0.0718975606852002 w+  G = 7.18975606852002e-07 S  R = 1390867.77140945 Ohm
Ro13p15 h15buf o13p 1390867.77140945
* o13 input 16 w=+0.212010526629755 w+  G = 2.12010526629755e-06 S  R = 471674.692712947 Ohm
Ro13p16 h16buf o13p 471674.692712947
* o13 input 17 w=+0.50252589011925 w+  G = 5.0252589011925e-06 S  R = 198994.722393845 Ohm
Ro13p17 h17buf o13p 198994.722393845
* o13 input 18 w=-0.0631368164337741 w-  G = 6.31368164337741e-07 S  R = 1583861.93109519 Ohm
Ro13n18 h18buf o13n 1583861.93109519
* o13 input 19 w=+0.124615759492256 w+  G = 1.24615759492256e-06 S  R = 802466.721764948 Ohm
Ro13p19 h19buf o13p 802466.721764948
* o13 input 20 w=-0.0825374863137293 w-  G = 8.25374863137293e-07 S  R = 1211570.69915959 Ohm
Ro13n20 h20buf o13n 1211570.69915959
* o13 input 21 w=-0.0332297714786912 w-  G = 3.32297714786912e-07 S  R = 3009349.61482132 Ohm
Ro13n21 h21buf o13n 3009349.61482132
* o13 input 22 w=+0.217350752944783 w+  G = 2.17350752944783e-06 S  R = 460085.822777915 Ohm
Ro13p22 h22buf o13p 460085.822777915
* o13 input 23 w=+0.00620341639632115 w+  G = 6.20341639632115e-08 S  R = 16120149.5452254 Ohm
Ro13p23 h23buf o13p 16120149.5452254
* o13 input 24 w=-0.56329887647671 w-  G = 5.6329887647671e-06 S  R = 177525.651436542 Ohm
Ro13n24 h24buf o13n 177525.651436542
* o13 input 25 w=+0.121217122487375 w+  G = 1.21217122487375e-06 S  R = 824965.961474753 Ohm
Ro13p25 h25buf o13p 824965.961474753
* o13 input 26 w=-0.0619389520134905 w-  G = 6.19389520134905e-07 S  R = 1614492.92810475 Ohm
Ro13n26 h26buf o13n 1614492.92810475
* o13 input 27 w=-0.148385692307615 w-  G = 1.48385692307615e-06 S  R = 673919.422047057 Ohm
Ro13n27 h27buf o13n 673919.422047057
* o13 input 28 w=+0.0960859107643036 w+  G = 9.60859107643036e-07 S  R = 1040735.30868951 Ohm
Ro13p28 h28buf o13p 1040735.30868951
* o13 input 29 w=-0.0967464729103534 w-  G = 9.67464729103534e-07 S  R = 1033629.41295712 Ohm
Ro13n29 h29buf o13n 1033629.41295712
* o13 input 30 w=+0.0502110731232858 w+  G = 5.02110731232858e-07 S  R = 1991592.56673254 Ohm
Ro13p30 h30buf o13p 1991592.56673254
* o13 input 31 w=+0.0717291842082243 w+  G = 7.17291842082243e-07 S  R = 1394132.68258716 Ohm
Ro13p31 h31buf o13p 1394132.68258716
* o13 input 32 w=+0.117218732023777 w+  G = 1.17218732023777e-06 S  R = 853105.969272176 Ohm
Ro13p32 h32buf o13p 853105.969272176
* o13 bias=+0.00474280842399728 b+  G = 4.74280842399728e-08 S  R = 21084553.9309638 Ohm
Ro13bp vref o13p 21084553.9309638
Vo13p o13p 0 DC 0
Vo13n o13n 0 DC 0
Fo13p 0 o13d Vo13p 1
Fo13n o13d 0 Vo13n 1
Vo13d o13d 0 DC 0
Ho13 o13lin 0 Vo13d 100000

* --- neuron o14 ---
* o14 input 1 w=-0.25477230027339 w-  G = 2.5477230027339e-06 S  R = 392507.348297645 Ohm
Ro14n1 h1buf o14n 392507.348297645
* o14 input 2 w=+0.102637632071701 w+  G = 1.02637632071701e-06 S  R = 974301.510874115 Ohm
Ro14p2 h2buf o14p 974301.510874115
* o14 input 3 w=+0.107208211835011 w+  G = 1.07208211835011e-06 S  R = 932764.368403944 Ohm
Ro14p3 h3buf o14p 932764.368403944
* o14 input 4 w=-0.361346054145307 w-  G = 3.61346054145307e-06 S  R = 276743.024734365 Ohm
Ro14n4 h4buf o14n 276743.024734365
* o14 input 5 w=+0.0565127294479513 w+  G = 5.65127294479513e-07 S  R = 1769512.83324761 Ohm
Ro14p5 h5buf o14p 1769512.83324761
* o14 input 6 w=-0.166023137794918 w-  G = 1.66023137794918e-06 S  R = 602325.683806351 Ohm
Ro14n6 h6buf o14n 602325.683806351
* o14 input 7 w=+0.0533068959488943 w+  G = 5.33068959488943e-07 S  R = 1875929.90024913 Ohm
Ro14p7 h7buf o14p 1875929.90024913
* o14 input 8 w=-0.334728977765226 w-  G = 3.34728977765227e-06 S  R = 298749.157206635 Ohm
Ro14n8 h8buf o14n 298749.157206635
* o14 input 9 w=-0.184424571200296 w-  G = 1.84424571200296e-06 S  R = 542227.097773182 Ohm
Ro14n9 h9buf o14n 542227.097773182
* o14 input 10 w=+0.263838736865495 w+  G = 2.63838736865495e-06 S  R = 379019.400972117 Ohm
Ro14p10 h10buf o14p 379019.400972117
* o14 input 11 w=+0.0215454170832462 w+  G = 2.15454170832462e-07 S  R = 4641358.28114278 Ohm
Ro14p11 h11buf o14p 4641358.28114278
* o14 input 12 w=-0.0509620245346412 w-  G = 5.09620245346412e-07 S  R = 1962245.4349714 Ohm
Ro14n12 h12buf o14n 1962245.4349714
* o14 input 13 w=-0.289718223355261 w-  G = 2.89718223355261e-06 S  R = 345162.961590363 Ohm
Ro14n13 h13buf o14n 345162.961590363
* o14 input 14 w=+0.114352462647064 w+  G = 1.14352462647064e-06 S  R = 874489.256157421 Ohm
Ro14p14 h14buf o14p 874489.256157421
* o14 input 15 w=-0.172686817087866 w-  G = 1.72686817087866e-06 S  R = 579082.999422695 Ohm
Ro14n15 h15buf o14n 579082.999422695
* o14 input 16 w=-0.0880371911025684 w-  G = 8.80371911025684e-07 S  R = 1135883.58224076 Ohm
Ro14n16 h16buf o14n 1135883.58224076
* o14 input 17 w=-0.0970577820037651 w-  G = 9.70577820037651e-07 S  R = 1030314.08646986 Ohm
Ro14n17 h17buf o14n 1030314.08646986
* o14 input 18 w=+0.279065168461303 w+  G = 2.79065168461303e-06 S  R = 358339.238649436 Ohm
Ro14p18 h18buf o14p 358339.238649436
* o14 input 19 w=+0.12574844379754 w+  G = 1.2574844379754e-06 S  R = 795238.469598909 Ohm
Ro14p19 h19buf o14p 795238.469598909
* o14 input 20 w=+0.196093228285189 w+  G = 1.96093228285189e-06 S  R = 509961.51613438 Ohm
Ro14p20 h20buf o14p 509961.51613438
* o14 input 21 w=+0.0606582432664274 w+  G = 6.06582432664274e-07 S  R = 1648580.54923835 Ohm
Ro14p21 h21buf o14p 1648580.54923835
* o14 input 22 w=+0.471542863591523 w+  G = 4.71542863591523e-06 S  R = 212069.798360103 Ohm
Ro14p22 h22buf o14p 212069.798360103
* o14 input 23 w=+0.132895212526076 w+  G = 1.32895212526076e-06 S  R = 752472.55412138 Ohm
Ro14p23 h23buf o14p 752472.55412138
* o14 input 24 w=-0.150700282102261 w-  G = 1.50700282102261e-06 S  R = 663568.764470812 Ohm
Ro14n24 h24buf o14n 663568.764470812
* o14 input 25 w=-0.172018927572569 w-  G = 1.72018927572569e-06 S  R = 581331.376791739 Ohm
Ro14n25 h25buf o14n 581331.376791739
* o14 input 26 w=-0.144277203051731 w-  G = 1.44277203051731e-06 S  R = 693110.192634834 Ohm
Ro14n26 h26buf o14n 693110.192634834
* o14 input 27 w=-0.0456897569368309 w-  G = 4.56897569368309e-07 S  R = 2188674.37045587 Ohm
Ro14n27 h27buf o14n 2188674.37045587
* o14 input 28 w=-0.269930966859316 w-  G = 2.69930966859316e-06 S  R = 370465.090254422 Ohm
Ro14n28 h28buf o14n 370465.090254422
* o14 input 29 w=-0.380176315173873 w-  G = 3.80176315173873e-06 S  R = 263035.849443344 Ohm
Ro14n29 h29buf o14n 263035.849443344
* o14 input 30 w=+0.211443520189348 w+  G = 2.11443520189348e-06 S  R = 472939.534446126 Ohm
Ro14p30 h30buf o14p 472939.534446126
* o14 input 31 w=+0.0784944631218348 w+  G = 7.84944631218348e-07 S  R = 1273975.2082231 Ohm
Ro14p31 h31buf o14p 1273975.2082231
* o14 input 32 w=+0.0843025902123393 w+  G = 8.43025902123393e-07 S  R = 1186203.17297633 Ohm
Ro14p32 h32buf o14p 1186203.17297633
* o14 bias=-0.0124822366617376 b-  G = 1.24822366617377e-07 S  R = 8011384.71493129 Ohm
Ro14bn vref o14n 8011384.71493129
Vo14p o14p 0 DC 0
Vo14n o14n 0 DC 0
Fo14p 0 o14d Vo14p 1
Fo14n o14d 0 Vo14n 1
Vo14d o14d 0 DC 0
Ho14 o14lin 0 Vo14d 100000

* --- neuron o15 ---
* o15 input 1 w=-0.113449668897813 w-  G = 1.13449668897813e-06 S  R = 881448.143229687 Ohm
Ro15n1 h1buf o15n 881448.143229687
* o15 input 2 w=-0.169978823552936 w-  G = 1.69978823552936e-06 S  R = 588308.578149781 Ohm
Ro15n2 h2buf o15n 588308.578149781
* o15 input 3 w=+0.0133598434574407 w+  G = 1.33598434574407e-07 S  R = 7485117.64517015 Ohm
Ro15p3 h3buf o15p 7485117.64517015
* o15 input 4 w=-0.169966115485037 w-  G = 1.69966115485037e-06 S  R = 588352.564948768 Ohm
Ro15n4 h4buf o15n 588352.564948768
* o15 input 5 w=-0.0418903282162887 w-  G = 4.18903282162887e-07 S  R = 2387185.87936763 Ohm
Ro15n5 h5buf o15n 2387185.87936763
* o15 input 6 w=-0.324291927905124 w-  G = 3.24291927905124e-06 S  R = 308364.135505884 Ohm
Ro15n6 h6buf o15n 308364.135505884
* o15 input 7 w=+0.558916704640692 w+  G = 5.58916704640692e-06 S  R = 178917.536673531 Ohm
Ro15p7 h7buf o15p 178917.536673531
* o15 input 8 w=-0.047599242693459 w-  G = 4.7599242693459e-07 S  R = 2100873.7606185 Ohm
Ro15n8 h8buf o15n 2100873.7606185
* o15 input 9 w=-0.103084990895521 w-  G = 1.03084990895521e-06 S  R = 970073.32620665 Ohm
Ro15n9 h9buf o15n 970073.32620665
* o15 input 10 w=-0.115049291784761 w-  G = 1.15049291784761e-06 S  R = 869192.660369298 Ohm
Ro15n10 h10buf o15n 869192.660369298
* o15 input 11 w=+0.0920546297717411 w+  G = 9.20546297717411e-07 S  R = 1086311.46796158 Ohm
Ro15p11 h11buf o15p 1086311.46796158
* o15 input 12 w=+0.0505985364133342 w+  G = 5.05985364133342e-07 S  R = 1976341.74994925 Ohm
Ro15p12 h12buf o15p 1976341.74994925
* o15 input 13 w=-0.145296396139138 w-  G = 1.45296396139138e-06 S  R = 688248.316250312 Ohm
Ro15n13 h13buf o15n 688248.316250312
* o15 input 14 w=-0.379881852318272 w-  G = 3.79881852318272e-06 S  R = 263239.739907918 Ohm
Ro15n14 h14buf o15n 263239.739907918
* o15 input 15 w=+0.223112491519187 w+  G = 2.23112491519187e-06 S  R = 448204.398234692 Ohm
Ro15p15 h15buf o15p 448204.398234692
* o15 input 16 w=-0.14757878301826 w-  G = 1.4757878301826e-06 S  R = 677604.178289143 Ohm
Ro15n16 h16buf o15n 677604.178289143
* o15 input 17 w=+0.173921977011029 w+  G = 1.73921977011029e-06 S  R = 574970.465024433 Ohm
Ro15p17 h17buf o15p 574970.465024433
* o15 input 18 w=+0.133725887369399 w+  G = 1.33725887369399e-06 S  R = 747798.365500943 Ohm
Ro15p18 h18buf o15p 747798.365500943
* o15 input 19 w=+0.209560948195519 w+  G = 2.09560948195519e-06 S  R = 477188.144361231 Ohm
Ro15p19 h19buf o15p 477188.144361231
* o15 input 20 w=-0.0239329977507233 w-  G = 2.39329977507233e-07 S  R = 4178331.56721781 Ohm
Ro15n20 h20buf o15n 4178331.56721781
* o15 input 21 w=+0.196041920231295 w+  G = 1.96041920231295e-06 S  R = 510094.983164915 Ohm
Ro15p21 h21buf o15p 510094.983164915
* o15 input 22 w=-0.0995510863910355 w-  G = 9.95510863910355e-07 S  R = 1004509.37930703 Ohm
Ro15n22 h22buf o15n 1004509.37930703
* o15 input 23 w=+0.102107365264583 w+  G = 1.02107365264583e-06 S  R = 979361.280558729 Ohm
Ro15p23 h23buf o15p 979361.280558729
* o15 input 24 w=-0.21795159550845 w-  G = 2.1795159550845e-06 S  R = 458817.471680875 Ohm
Ro15n24 h24buf o15n 458817.471680875
* o15 input 25 w=+0.202525001628457 w+  G = 2.02525001628457e-06 S  R = 493766.197733232 Ohm
Ro15p25 h25buf o15p 493766.197733232
* o15 input 26 w=-0.281017181998367 w-  G = 2.81017181998367e-06 S  R = 355850.127344104 Ohm
Ro15n26 h26buf o15n 355850.127344104
* o15 input 27 w=+0.141610254018665 w+  G = 1.41610254018665e-06 S  R = 706163.552159293 Ohm
Ro15p27 h27buf o15p 706163.552159293
* o15 input 28 w=+0.444984802739648 w+  G = 4.44984802739648e-06 S  R = 224726.775800719 Ohm
Ro15p28 h28buf o15p 224726.775800719
* o15 input 29 w=-0.120073433142323 w-  G = 1.20073433142323e-06 S  R = 832823.692826958 Ohm
Ro15n29 h29buf o15n 832823.692826958
* o15 input 30 w=-0.0538706707421541 w-  G = 5.38706707421541e-07 S  R = 1856297.65923352 Ohm
Ro15n30 h30buf o15n 1856297.65923352
* o15 input 31 w=+0.148090323839994 w+  G = 1.48090323839994e-06 S  R = 675263.564877109 Ohm
Ro15p31 h31buf o15p 675263.564877109
* o15 input 32 w=-0.347735979661958 w-  G = 3.47735979661958e-06 S  R = 287574.498610159 Ohm
Ro15n32 h32buf o15n 287574.498610159
* o15 bias=+0.0711229172621247 b+  G = 7.11229172621247e-07 S  R = 1406016.56750732 Ohm
Ro15bp vref o15p 1406016.56750732
Vo15p o15p 0 DC 0
Vo15n o15n 0 DC 0
Fo15p 0 o15d Vo15p 1
Fo15n o15d 0 Vo15n 1
Vo15d o15d 0 DC 0
Ho15 o15lin 0 Vo15d 100000

* --- neuron o16 ---
* o16 input 1 w=-0.0239168211298723 w-  G = 2.39168211298723e-07 S  R = 4181157.66543486 Ohm
Ro16n1 h1buf o16n 4181157.66543486
* o16 input 2 w=-0.455843018824687 w-  G = 4.55843018824687e-06 S  R = 219373.766560762 Ohm
Ro16n2 h2buf o16n 219373.766560762
* o16 input 3 w=-0.360558107273835 w-  G = 3.60558107273835e-06 S  R = 277347.806033529 Ohm
Ro16n3 h3buf o16n 277347.806033529
* o16 input 4 w=+0.281324980833712 w+  G = 2.81324980833712e-06 S  R = 355460.790235009 Ohm
Ro16p4 h4buf o16p 355460.790235009
* o16 input 5 w=-0.0789059543438914 w-  G = 7.89059543438914e-07 S  R = 1267331.48127422 Ohm
Ro16n5 h5buf o16n 1267331.48127422
* o16 input 6 w=+0.0459206910877794 w+  G = 4.59206910877794e-07 S  R = 2177667.5749249 Ohm
Ro16p6 h6buf o16p 2177667.5749249
* o16 input 7 w=-0.348093944852844 w-  G = 3.48093944852844e-06 S  R = 287278.769075615 Ohm
Ro16n7 h7buf o16n 287278.769075615
* o16 input 8 w=-0.0796710739452782 w-  G = 7.96710739452782e-07 S  R = 1255160.688165 Ohm
Ro16n8 h8buf o16n 1255160.688165
* o16 input 9 w=-0.173339228342165 w-  G = 1.73339228342165e-06 S  R = 576903.456629009 Ohm
Ro16n9 h9buf o16n 576903.456629009
* o16 input 10 w=+0.194262181446587 w+  G = 1.94262181446587e-06 S  R = 514768.233607503 Ohm
Ro16p10 h10buf o16p 514768.233607503
* o16 input 11 w=+0.155708231075043 w+  G = 1.55708231075043e-06 S  R = 642226.806570073 Ohm
Ro16p11 h11buf o16p 642226.806570073
* o16 input 12 w=+0.124882648574468 w+  G = 1.24882648574468e-06 S  R = 800751.75487946 Ohm
Ro16p12 h12buf o16p 800751.75487946
* o16 input 13 w=+0.270423516346849 w+  G = 2.70423516346849e-06 S  R = 369790.325009082 Ohm
Ro16p13 h13buf o16p 369790.325009082
* o16 input 14 w=-0.22936067173287 w-  G = 2.2936067173287e-06 S  R = 435994.537531122 Ohm
Ro16n14 h14buf o16n 435994.537531122
* o16 input 15 w=+0.0349795005301705 w+  G = 3.49795005301705e-07 S  R = 2858817.26395001 Ohm
Ro16p15 h15buf o16p 2858817.26395001
* o16 input 16 w=+0.104322324768401 w+  G = 1.04322324768401e-06 S  R = 958567.595402072 Ohm
Ro16p16 h16buf o16p 958567.595402072
* o16 input 17 w=-0.351176137449102 w-  G = 3.51176137449102e-06 S  R = 284757.389059482 Ohm
Ro16n17 h17buf o16n 284757.389059482
* o16 input 18 w=+0.119462358831177 w+  G = 1.19462358831177e-06 S  R = 837083.755740322 Ohm
Ro16p18 h18buf o16p 837083.755740322
* o16 input 19 w=+0.230688311648174 w+  G = 2.30688311648174e-06 S  R = 433485.334759879 Ohm
Ro16p19 h19buf o16p 433485.334759879
* o16 input 20 w=-0.0614748986253126 w-  G = 6.14748986253126e-07 S  R = 1626680.19364288 Ohm
Ro16n20 h20buf o16n 1626680.19364288
* o16 input 21 w=+0.36727529530057 w+  G = 3.6727529530057e-06 S  R = 272275.3239315 Ohm
Ro16p21 h21buf o16p 272275.3239315
* o16 input 22 w=+0.579638140801163 w+  G = 5.79638140801163e-06 S  R = 172521.428389412 Ohm
Ro16p22 h22buf o16p 172521.428389412
* o16 input 23 w=-0.0387096142803063 w-  G = 3.87096142803063e-07 S  R = 2583337.54699477 Ohm
Ro16n23 h23buf o16n 2583337.54699477
* o16 input 24 w=+0.0384174368738491 w+  G = 3.84174368738491e-07 S  R = 2602984.68969622 Ohm
Ro16p24 h24buf o16p 2602984.68969622
* o16 input 25 w=+0.201641208818347 w+  G = 2.01641208818347e-06 S  R = 495930.373488721 Ohm
Ro16p25 h25buf o16p 495930.373488721
* o16 input 26 w=-0.606109769372092 w-  G = 6.06109769372092e-06 S  R = 164986.61637412 Ohm
Ro16n26 h26buf o16n 164986.61637412
* o16 input 27 w=-0.101484914332963 w-  G = 1.01484914332963e-06 S  R = 985368.127443149 Ohm
Ro16n27 h27buf o16n 985368.127443149
* o16 input 28 w=+0.04265872854179 w+  G = 4.265872854179e-07 S  R = 2344186.13536586 Ohm
Ro16p28 h28buf o16p 2344186.13536586
* o16 input 29 w=+0.0889131834636398 w+  G = 8.89131834636398e-07 S  R = 1124692.60580344 Ohm
Ro16p29 h29buf o16p 1124692.60580344
* o16 input 30 w=+0.0420485970959956 w+  G = 4.20485970959956e-07 S  R = 2378200.62751923 Ohm
Ro16p30 h30buf o16p 2378200.62751923
* o16 input 31 w=-0.332324220948992 w-  G = 3.32324220948992e-06 S  R = 300910.958925708 Ohm
Ro16n31 h31buf o16n 300910.958925708
* o16 input 32 w=+0.137132637809711 w+  G = 1.37132637809711e-06 S  R = 729221.005277843 Ohm
Ro16p32 h32buf o16p 729221.005277843
* o16 bias=+0.0410780079484629 b+  G = 4.10780079484629e-07 S  R = 2434392.63475146 Ohm
Ro16bp vref o16p 2434392.63475146
Vo16p o16p 0 DC 0
Vo16n o16n 0 DC 0
Fo16p 0 o16d Vo16p 1
Fo16n o16d 0 Vo16n 1
Vo16d o16d 0 DC 0
Ho16 o16lin 0 Vo16d 100000

.model Dsi D(Is=1e-14 N=1 Rs=1)
.control
set numdgt=15
alter Vin1 DC 0.632568504068692
alter Vin2 DC 0.130751912471634
alter Vin3 DC 0.498395519129232
alter Vin4 DC 0.508991138596361
alter Vin5 DC 0.741696432510955
alter Vin6 DC -0.174816274310903
alter Vin7 DC -0.711636899513491
alter Vin8 DC -0.992297390491566
alter Vin9 DC 0.124859661764151
alter Vin10 DC 0.927115220977617
alter Vin11 DC 0.757625693253616
alter Vin12 DC -0.349962125380286
alter Vin13 DC 0.772046924490164
alter Vin14 DC 0.809792344935797
alter Vin15 DC 0.311400434804866
alter Vin16 DC 0.38369938347353
op
print v(o1lin)
print v(o2lin)
print v(o3lin)
print v(o4lin)
print v(o5lin)
print v(o6lin)
print v(o7lin)
print v(o8lin)
print v(o9lin)
print v(o10lin)
print v(o11lin)
print v(o12lin)
print v(o13lin)
print v(o14lin)
print v(o15lin)
print v(o16lin)
alter Vin1 DC -0.974788209071848
alter Vin2 DC -0.200637826852555
alter Vin3 DC 0.823173051424639
alter Vin4 DC 0.925543502570132
alter Vin5 DC -0.235735032734585
alter Vin6 DC -0.141680228154392
alter Vin7 DC -0.886626844533918
alter Vin8 DC 0.40575230866322
alter Vin9 DC -0.9068934262577
alter Vin10 DC -0.71518146061856
alter Vin11 DC 0.507768822660382
alter Vin12 DC -0.423033389400712
alter Vin13 DC -0.189634986503447
alter Vin14 DC -0.729894999162038
alter Vin15 DC -0.822420852539174
alter Vin16 DC 0.729238013944139
op
print v(o1lin)
print v(o2lin)
print v(o3lin)
print v(o4lin)
print v(o5lin)
print v(o6lin)
print v(o7lin)
print v(o8lin)
print v(o9lin)
print v(o10lin)
print v(o11lin)
print v(o12lin)
print v(o13lin)
print v(o14lin)
print v(o15lin)
print v(o16lin)
alter Vin1 DC 0.847734806115268
alter Vin2 DC -0.795676825133873
alter Vin3 DC -0.576906573311323
alter Vin4 DC 0.808070915111557
alter Vin5 DC -0.272832325997157
alter Vin6 DC 0.984764551383679
alter Vin7 DC 0.873557149180198
alter Vin8 DC -0.395997821263188
alter Vin9 DC -0.91476403063532
alter Vin10 DC -0.814982443313317
alter Vin11 DC 0.386244963375333
alter Vin12 DC 0.97673536509706
alter Vin13 DC 0.859516677956838
alter Vin14 DC -0.48344879964576
alter Vin15 DC -0.389119391902879
alter Vin16 DC -0.0777429346880354
op
print v(o1lin)
print v(o2lin)
print v(o3lin)
print v(o4lin)
print v(o5lin)
print v(o6lin)
print v(o7lin)
print v(o8lin)
print v(o9lin)
print v(o10lin)
print v(o11lin)
print v(o12lin)
print v(o13lin)
print v(o14lin)
print v(o15lin)
print v(o16lin)
alter Vin1 DC -0.634763869503377
alter Vin2 DC 0.66136408923338
alter Vin3 DC -0.0583013778475243
alter Vin4 DC 0.720990552465887
alter Vin5 DC 0.260016013717853
alter Vin6 DC 0.577414589397466
alter Vin7 DC 0.854892175873237
alter Vin8 DC -0.100267864923785
alter Vin9 DC -0.2976521369567
alter Vin10 DC 0.530570623968421
alter Vin11 DC 0.0982353459122769
alter Vin12 DC -0.228498741708201
alter Vin13 DC -0.423704441504684
alter Vin14 DC -0.324453707550555
alter Vin15 DC 0.963733756086886
alter Vin16 DC 0.888564654599973
op
print v(o1lin)
print v(o2lin)
print v(o3lin)
print v(o4lin)
print v(o5lin)
print v(o6lin)
print v(o7lin)
print v(o8lin)
print v(o9lin)
print v(o10lin)
print v(o11lin)
print v(o12lin)
print v(o13lin)
print v(o14lin)
print v(o15lin)
print v(o16lin)
alter Vin1 DC 0.399419993562847
alter Vin2 DC 0.822754861286246
alter Vin3 DC -0.217979993499255
alter Vin4 DC -0.524840716208239
alter Vin5 DC -0.343585224682448
alter Vin6 DC 0.597298680392867
alter Vin7 DC 0.745769924406716
alter Vin8 DC -0.31122778594332
alter Vin9 DC -0.551408564506993
alter Vin10 DC 0.508813890470598
alter Vin11 DC 0.967095039058534
alter Vin12 DC 0.436711939252078
alter Vin13 DC -0.637944426107168
alter Vin14 DC -0.610126039852947
alter Vin15 DC -0.0266004623343832
alter Vin16 DC 0.865503835859949
op
print v(o1lin)
print v(o2lin)
print v(o3lin)
print v(o4lin)
print v(o5lin)
print v(o6lin)
print v(o7lin)
print v(o8lin)
print v(o9lin)
print v(o10lin)
print v(o11lin)
print v(o12lin)
print v(o13lin)
print v(o14lin)
print v(o15lin)
print v(o16lin)
alter Vin1 DC -0.39950651162754
alter Vin2 DC 0.845146280157393
alter Vin3 DC -0.293453062060104
alter Vin4 DC -0.935486140839395
alter Vin5 DC -0.0810356399901349
alter Vin6 DC -0.902253265490345
alter Vin7 DC -0.555846545167458
alter Vin8 DC 0.760951343886015
alter Vin9 DC 0.759556104325771
alter Vin10 DC -0.949711300869059
alter Vin11 DC 0.0303569257790743
alter Vin12 DC -0.0286488050711204
alter Vin13 DC -0.578375740619194
alter Vin14 DC 0.906957053187536
alter Vin15 DC -0.073548295446664
alter Vin16 DC 0.0683418880828401
op
print v(o1lin)
print v(o2lin)
print v(o3lin)
print v(o4lin)
print v(o5lin)
print v(o6lin)
print v(o7lin)
print v(o8lin)
print v(o9lin)
print v(o10lin)
print v(o11lin)
print v(o12lin)
print v(o13lin)
print v(o14lin)
print v(o15lin)
print v(o16lin)
alter Vin1 DC -0.269700131318679
alter Vin2 DC -0.0587851098186172
alter Vin3 DC -0.93859148153159
alter Vin4 DC 0.37397748574996
alter Vin5 DC -0.640198473614279
alter Vin6 DC 0.28300439655269
alter Vin7 DC 0.495573806278234
alter Vin8 DC 0.4844036398211
alter Vin9 DC 0.865719664227782
alter Vin10 DC -0.637807257193159
alter Vin11 DC 0.140608503083495
alter Vin12 DC -0.793259398029265
alter Vin13 DC 0.803362583110163
alter Vin14 DC 0.644880503300019
alter Vin15 DC 0.80511980776248
alter Vin16 DC 0.00183769605351314
op
print v(o1lin)
print v(o2lin)
print v(o3lin)
print v(o4lin)
print v(o5lin)
print v(o6lin)
print v(o7lin)
print v(o8lin)
print v(o9lin)
print v(o10lin)
print v(o11lin)
print v(o12lin)
print v(o13lin)
print v(o14lin)
print v(o15lin)
print v(o16lin)
alter Vin1 DC -0.681053369759573
alter Vin2 DC 0.971345998932643
alter Vin3 DC 0.0228486000093842
alter Vin4 DC -0.68100585488642
alter Vin5 DC 0.935892877213541
alter Vin6 DC 0.408157507560112
alter Vin7 DC 0.0488412507809939
alter Vin8 DC 0.828266383636528
alter Vin9 DC 0.784246855742534
alter Vin10 DC 0.207324880526272
alter Vin11 DC 0.218839873002423
alter Vin12 DC -0.64711694724826
alter Vin13 DC -0.45152559776989
alter Vin14 DC -0.16638824613438
alter Vin15 DC 0.56955443939986
alter Vin16 DC -0.894236938055073
op
print v(o1lin)
print v(o2lin)
print v(o3lin)
print v(o4lin)
print v(o5lin)
print v(o6lin)
print v(o7lin)
print v(o8lin)
print v(o9lin)
print v(o10lin)
print v(o11lin)
print v(o12lin)
print v(o13lin)
print v(o14lin)
print v(o15lin)
print v(o16lin)
alter Vin1 DC -0.924906884178613
alter Vin2 DC 0.267791334016869
alter Vin3 DC 0.386698050737095
alter Vin4 DC -0.375678093248884
alter Vin5 DC -0.481472424709471
alter Vin6 DC -0.590426934613701
alter Vin7 DC 0.274930056654101
alter Vin8 DC -0.495416670165966
alter Vin9 DC 0.662447960935986
alter Vin10 DC -0.39828366695253
alter Vin11 DC -0.435305893543825
alter Vin12 DC -0.673137852956615
alter Vin13 DC 0.399291241842683
alter Vin14 DC -0.135245929167714
alter Vin15 DC 0.191750308509824
alter Vin16 DC -0.317239774769057
op
print v(o1lin)
print v(o2lin)
print v(o3lin)
print v(o4lin)
print v(o5lin)
print v(o6lin)
print v(o7lin)
print v(o8lin)
print v(o9lin)
print v(o10lin)
print v(o11lin)
print v(o12lin)
print v(o13lin)
print v(o14lin)
print v(o15lin)
print v(o16lin)
alter Vin1 DC 0.691315307576891
alter Vin2 DC -0.966597973272848
alter Vin3 DC 0.337819856228323
alter Vin4 DC 0.445958641593821
alter Vin5 DC 0.28794565803369
alter Vin6 DC -0.437558044466196
alter Vin7 DC 0.335767271835964
alter Vin8 DC 0.741106323711654
alter Vin9 DC -0.498474688285342
alter Vin10 DC -0.937258343994007
alter Vin11 DC 0.628549591207388
alter Vin12 DC 0.0809865794436
alter Vin13 DC -0.792347081447127
alter Vin14 DC 0.290895831462678
alter Vin15 DC 0.917514644221665
alter Vin16 DC -0.636405891470935
op
print v(o1lin)
print v(o2lin)
print v(o3lin)
print v(o4lin)
print v(o5lin)
print v(o6lin)
print v(o7lin)
print v(o8lin)
print v(o9lin)
print v(o10lin)
print v(o11lin)
print v(o12lin)
print v(o13lin)
print v(o14lin)
print v(o15lin)
print v(o16lin)
alter Vin1 DC -0.436056235334991
alter Vin2 DC 0.359995773967924
alter Vin3 DC -0.862040082296962
alter Vin4 DC -0.613020281079166
alter Vin5 DC -0.682661118108276
alter Vin6 DC 0.0327240219234706
alter Vin7 DC -0.254762451719826
alter Vin8 DC -0.628386977446209
alter Vin9 DC -0.435404154442101
alter Vin10 DC -0.560268250029906
alter Vin11 DC -0.34004922102946
alter Vin12 DC 0.828462300998657
alter Vin13 DC -0.258762364783062
alter Vin14 DC 0.0615557520793739
alter Vin15 DC -0.749003484831865
alter Vin16 DC -0.461728905661948
op
print v(o1lin)
print v(o2lin)
print v(o3lin)
print v(o4lin)
print v(o5lin)
print v(o6lin)
print v(o7lin)
print v(o8lin)
print v(o9lin)
print v(o10lin)
print v(o11lin)
print v(o12lin)
print v(o13lin)
print v(o14lin)
print v(o15lin)
print v(o16lin)
alter Vin1 DC 0.402941317710264
alter Vin2 DC 0.676235321348749
alter Vin3 DC 0.422742637816617
alter Vin4 DC 0.294030371745866
alter Vin5 DC -0.638561187867718
alter Vin6 DC -0.0501402124484349
alter Vin7 DC -0.126876472940439
alter Vin8 DC 0.249620810954959
alter Vin9 DC 0.800022887685632
alter Vin10 DC -0.267525733933315
alter Vin11 DC -0.0493799961815793
alter Vin12 DC 0.412930540027973
alter Vin13 DC 0.168971578589697
alter Vin14 DC 0.402529908662486
alter Vin15 DC 0.590508734712441
alter Vin16 DC -0.809797572982249
op
print v(o1lin)
print v(o2lin)
print v(o3lin)
print v(o4lin)
print v(o5lin)
print v(o6lin)
print v(o7lin)
print v(o8lin)
print v(o9lin)
print v(o10lin)
print v(o11lin)
print v(o12lin)
print v(o13lin)
print v(o14lin)
print v(o15lin)
print v(o16lin)
alter Vin1 DC -0.720940644465072
alter Vin2 DC 0.811090286911281
alter Vin3 DC 0.0887704649024641
alter Vin4 DC -0.703881870777446
alter Vin5 DC 0.792271352370679
alter Vin6 DC -0.611577475657032
alter Vin7 DC 0.630598962593579
alter Vin8 DC -0.909175170042211
alter Vin9 DC 0.45028681887581
alter Vin10 DC -0.610646509410917
alter Vin11 DC 0.942769230832138
alter Vin12 DC 0.253399891858326
alter Vin13 DC 0.239806152599995
alter Vin14 DC -0.424323687911083
alter Vin15 DC -0.132402036224528
alter Vin16 DC 0.499567887714755
op
print v(o1lin)
print v(o2lin)
print v(o3lin)
print v(o4lin)
print v(o5lin)
print v(o6lin)
print v(o7lin)
print v(o8lin)
print v(o9lin)
print v(o10lin)
print v(o11lin)
print v(o12lin)
print v(o13lin)
print v(o14lin)
print v(o15lin)
print v(o16lin)
alter Vin1 DC -0.553601012740836
alter Vin2 DC -0.0853827874775894
alter Vin3 DC 0.472526855220367
alter Vin4 DC 0.983320104826496
alter Vin5 DC -0.32589641106305
alter Vin6 DC 0.620602426134993
alter Vin7 DC -0.529649272081957
alter Vin8 DC -0.400401658684954
alter Vin9 DC 0.506127142109278
alter Vin10 DC -0.0613843649963521
alter Vin11 DC 0.194508563247131
alter Vin12 DC -0.0888973979013215
alter Vin13 DC 0.304485213029303
alter Vin14 DC 0.571192626328441
alter Vin15 DC 0.39987631868635
alter Vin16 DC 0.458594801121468
op
print v(o1lin)
print v(o2lin)
print v(o3lin)
print v(o4lin)
print v(o5lin)
print v(o6lin)
print v(o7lin)
print v(o8lin)
print v(o9lin)
print v(o10lin)
print v(o11lin)
print v(o12lin)
print v(o13lin)
print v(o14lin)
print v(o15lin)
print v(o16lin)
alter Vin1 DC 0.941921702845139
alter Vin2 DC -0.797590224953611
alter Vin3 DC -0.353544884625478
alter Vin4 DC -0.223679714692619
alter Vin5 DC 0.934853237163932
alter Vin6 DC 0.813220120283511
alter Vin7 DC 0.620477689684263
alter Vin8 DC -0.971969304466214
alter Vin9 DC -0.591538023713506
alter Vin10 DC 0.157162778762541
alter Vin11 DC -0.00954942079742005
alter Vin12 DC -0.766378178791702
alter Vin13 DC 0.781165514171662
alter Vin14 DC -0.870653903905813
alter Vin15 DC -0.855576259711061
alter Vin16 DC 0.576744547964966
op
print v(o1lin)
print v(o2lin)
print v(o3lin)
print v(o4lin)
print v(o5lin)
print v(o6lin)
print v(o7lin)
print v(o8lin)
print v(o9lin)
print v(o10lin)
print v(o11lin)
print v(o12lin)
print v(o13lin)
print v(o14lin)
print v(o15lin)
print v(o16lin)
alter Vin1 DC 0.0847980140064368
alter Vin2 DC -0.546436186199117
alter Vin3 DC 0.157551439199196
alter Vin4 DC -0.675094911660673
alter Vin5 DC 0.251984062858915
alter Vin6 DC 0.533034777990185
alter Vin7 DC -0.636309229712619
alter Vin8 DC 0.205266715162125
alter Vin9 DC 0.355151588504783
alter Vin10 DC -0.763079400779309
alter Vin11 DC 0.279208117784239
alter Vin12 DC -0.046053502725351
alter Vin13 DC -0.0674199792200116
alter Vin14 DC -0.0988424326224195
alter Vin15 DC 0.341224431366531
alter Vin16 DC -0.128234288046615
op
print v(o1lin)
print v(o2lin)
print v(o3lin)
print v(o4lin)
print v(o5lin)
print v(o6lin)
print v(o7lin)
print v(o8lin)
print v(o9lin)
print v(o10lin)
print v(o11lin)
print v(o12lin)
print v(o13lin)
print v(o14lin)
print v(o15lin)
print v(o16lin)
alter Vin1 DC -0.595380417251091
alter Vin2 DC -0.170465926726426
alter Vin3 DC -0.165712373937593
alter Vin4 DC 0.484522499674577
alter Vin5 DC 0.78085882899596
alter Vin6 DC -0.00693757328167033
alter Vin7 DC -0.498016397952294
alter Vin8 DC -0.76057897931883
alter Vin9 DC -0.343082475402419
alter Vin10 DC 0.0125577265451373
alter Vin11 DC 0.60192661275731
alter Vin12 DC -0.0810399461010238
alter Vin13 DC 0.308396489131115
alter Vin14 DC -0.555444513107257
alter Vin15 DC -0.388314730894595
alter Vin16 DC 0.923801824090698
op
print v(o1lin)
print v(o2lin)
print v(o3lin)
print v(o4lin)
print v(o5lin)
print v(o6lin)
print v(o7lin)
print v(o8lin)
print v(o9lin)
print v(o10lin)
print v(o11lin)
print v(o12lin)
print v(o13lin)
print v(o14lin)
print v(o15lin)
print v(o16lin)
alter Vin1 DC -0.344075298305219
alter Vin2 DC -0.299983052907286
alter Vin3 DC -0.203058505077156
alter Vin4 DC 0.435239788418766
alter Vin5 DC 0.363815756954568
alter Vin6 DC 0.837980352083505
alter Vin7 DC -0.538527300440037
alter Vin8 DC -0.938627722316779
alter Vin9 DC 0.4922043173456
alter Vin10 DC 0.207737109101553
alter Vin11 DC 0.020741026962491
alter Vin12 DC 0.25637018547913
alter Vin13 DC -0.83211091299048
alter Vin14 DC 0.766421841791898
alter Vin15 DC -0.927411256783522
alter Vin16 DC 0.369430588094565
op
print v(o1lin)
print v(o2lin)
print v(o3lin)
print v(o4lin)
print v(o5lin)
print v(o6lin)
print v(o7lin)
print v(o8lin)
print v(o9lin)
print v(o10lin)
print v(o11lin)
print v(o12lin)
print v(o13lin)
print v(o14lin)
print v(o15lin)
print v(o16lin)
alter Vin1 DC 0.627063489212866
alter Vin2 DC -0.582648694346974
alter Vin3 DC -0.765786006835309
alter Vin4 DC 0.102836606226475
alter Vin5 DC -0.66611661718385
alter Vin6 DC 0.412069103904774
alter Vin7 DC -0.320626602803983
alter Vin8 DC 0.664935939224919
alter Vin9 DC -0.907582410736682
alter Vin10 DC 0.138301736499832
alter Vin11 DC -0.124043342050667
alter Vin12 DC -0.444462469724564
alter Vin13 DC 0.993018090945098
alter Vin14 DC 0.384970115288437
alter Vin15 DC 0.988144749211259
alter Vin16 DC 0.83719280846034
op
print v(o1lin)
print v(o2lin)
print v(o3lin)
print v(o4lin)
print v(o5lin)
print v(o6lin)
print v(o7lin)
print v(o8lin)
print v(o9lin)
print v(o10lin)
print v(o11lin)
print v(o12lin)
print v(o13lin)
print v(o14lin)
print v(o15lin)
print v(o16lin)
alter Vin1 DC -0.45182957480955
alter Vin2 DC -0.662024952982424
alter Vin3 DC -0.229489946519203
alter Vin4 DC 0.68091685978688
alter Vin5 DC -0.524794188274996
alter Vin6 DC -0.775298122631856
alter Vin7 DC 0.477695002661498
alter Vin8 DC 0.318249373784927
alter Vin9 DC 0.0674353216224022
alter Vin10 DC -0.757574746285693
alter Vin11 DC 0.194480016220294
alter Vin12 DC -0.986058532734065
alter Vin13 DC -0.858099129281211
alter Vin14 DC 0.875413943263164
alter Vin15 DC -0.355937045022594
alter Vin16 DC -0.909269999495478
op
print v(o1lin)
print v(o2lin)
print v(o3lin)
print v(o4lin)
print v(o5lin)
print v(o6lin)
print v(o7lin)
print v(o8lin)
print v(o9lin)
print v(o10lin)
print v(o11lin)
print v(o12lin)
print v(o13lin)
print v(o14lin)
print v(o15lin)
print v(o16lin)
alter Vin1 DC -0.166134124041978
alter Vin2 DC 0.326271636139386
alter Vin3 DC 0.0377865575229868
alter Vin4 DC 0.642967168503026
alter Vin5 DC -0.0313452796975957
alter Vin6 DC -0.898196834887308
alter Vin7 DC -0.0223210703281855
alter Vin8 DC 0.0240743286141054
alter Vin9 DC -0.32939698929494
alter Vin10 DC 0.156138339259947
alter Vin11 DC 0.998037514156259
alter Vin12 DC 0.996329734012833
alter Vin13 DC -0.792547573290175
alter Vin14 DC 0.272037484511549
alter Vin15 DC 0.144597423090336
alter Vin16 DC 0.648759180262861
op
print v(o1lin)
print v(o2lin)
print v(o3lin)
print v(o4lin)
print v(o5lin)
print v(o6lin)
print v(o7lin)
print v(o8lin)
print v(o9lin)
print v(o10lin)
print v(o11lin)
print v(o12lin)
print v(o13lin)
print v(o14lin)
print v(o15lin)
print v(o16lin)
alter Vin1 DC 0.513767503102245
alter Vin2 DC -0.993130673228192
alter Vin3 DC -0.741368455463561
alter Vin4 DC -0.673172294979255
alter Vin5 DC 0.53329038934038
alter Vin6 DC 0.273011112722964
alter Vin7 DC -0.22429483417346
alter Vin8 DC -0.904486174889755
alter Vin9 DC -0.0476389722976311
alter Vin10 DC 0.0830713748633647
alter Vin11 DC -0.0631237690576123
alter Vin12 DC -0.387190151349574
alter Vin13 DC 0.490599598157352
alter Vin14 DC -0.431150162403273
alter Vin15 DC -0.494227353798093
alter Vin16 DC 0.199587837072336
op
print v(o1lin)
print v(o2lin)
print v(o3lin)
print v(o4lin)
print v(o5lin)
print v(o6lin)
print v(o7lin)
print v(o8lin)
print v(o9lin)
print v(o10lin)
print v(o11lin)
print v(o12lin)
print v(o13lin)
print v(o14lin)
print v(o15lin)
print v(o16lin)
alter Vin1 DC -0.527641643915313
alter Vin2 DC -0.760469900825891
alter Vin3 DC -0.971812928614647
alter Vin4 DC -0.462029484155251
alter Vin5 DC -0.0990347067926469
alter Vin6 DC -0.431709782876269
alter Vin7 DC 0.582115295594787
alter Vin8 DC 0.490760521778589
alter Vin9 DC -0.597773697850127
alter Vin10 DC -0.146377118439857
alter Vin11 DC 0.77673031103089
alter Vin12 DC -0.958686104499727
alter Vin13 DC -0.651792165711311
alter Vin14 DC -0.771428363238295
alter Vin15 DC -0.274616062196005
alter Vin16 DC 0.797804290304925
op
print v(o1lin)
print v(o2lin)
print v(o3lin)
print v(o4lin)
print v(o5lin)
print v(o6lin)
print v(o7lin)
print v(o8lin)
print v(o9lin)
print v(o10lin)
print v(o11lin)
print v(o12lin)
print v(o13lin)
print v(o14lin)
print v(o15lin)
print v(o16lin)
alter Vin1 DC -0.0660406839746723
alter Vin2 DC -0.199767810717373
alter Vin3 DC 0.433496899757818
alter Vin4 DC 0.179118988466795
alter Vin5 DC -0.213841522026575
alter Vin6 DC 0.556646137550105
alter Vin7 DC -0.700676048926627
alter Vin8 DC -0.447891404812417
alter Vin9 DC -0.03646969314408
alter Vin10 DC 0.356038664374622
alter Vin11 DC -0.898261479878571
alter Vin12 DC -0.522238075094493
alter Vin13 DC 0.470385125738646
alter Vin14 DC -0.934570154871633
alter Vin15 DC -0.215637621907727
alter Vin16 DC -0.839313330640211
op
print v(o1lin)
print v(o2lin)
print v(o3lin)
print v(o4lin)
print v(o5lin)
print v(o6lin)
print v(o7lin)
print v(o8lin)
print v(o9lin)
print v(o10lin)
print v(o11lin)
print v(o12lin)
print v(o13lin)
print v(o14lin)
print v(o15lin)
print v(o16lin)
alter Vin1 DC 0.944694975466901
alter Vin2 DC 0.557429746816729
alter Vin3 DC 0.0879434025868335
alter Vin4 DC -0.971277715280804
alter Vin5 DC 0.469272183979264
alter Vin6 DC 0.0553351732696565
alter Vin7 DC 0.319789179040026
alter Vin8 DC 0.105605881218313
alter Vin9 DC -0.808751474487991
alter Vin10 DC 0.345207050357025
alter Vin11 DC 0.887488099386043
alter Vin12 DC -0.946434379958131
alter Vin13 DC -0.756800857731664
alter Vin14 DC 0.584597058025779
alter Vin15 DC -0.172504938226507
alter Vin16 DC 0.057467887193803
op
print v(o1lin)
print v(o2lin)
print v(o3lin)
print v(o4lin)
print v(o5lin)
print v(o6lin)
print v(o7lin)
print v(o8lin)
print v(o9lin)
print v(o10lin)
print v(o11lin)
print v(o12lin)
print v(o13lin)
print v(o14lin)
print v(o15lin)
print v(o16lin)
alter Vin1 DC 0.268139611364692
alter Vin2 DC -0.0761352932592003
alter Vin3 DC 0.257679787771012
alter Vin4 DC 0.647151913043588
alter Vin5 DC 0.688559040420576
alter Vin6 DC 0.195725091292368
alter Vin7 DC -0.650874124907297
alter Vin8 DC 0.757864910663943
alter Vin9 DC -0.801870229804984
alter Vin10 DC 0.0650107507341318
alter Vin11 DC 0.76839506437409
alter Vin12 DC 0.626485114847845
alter Vin13 DC -0.916744432608743
alter Vin14 DC -0.0381884442222795
alter Vin15 DC -0.39538459366548
alter Vin16 DC -0.53577973836249
op
print v(o1lin)
print v(o2lin)
print v(o3lin)
print v(o4lin)
print v(o5lin)
print v(o6lin)
print v(o7lin)
print v(o8lin)
print v(o9lin)
print v(o10lin)
print v(o11lin)
print v(o12lin)
print v(o13lin)
print v(o14lin)
print v(o15lin)
print v(o16lin)
alter Vin1 DC -0.399980891864974
alter Vin2 DC -0.311058824105357
alter Vin3 DC -0.121767102063513
alter Vin4 DC -0.1825017503415
alter Vin5 DC -0.384605419902336
alter Vin6 DC 0.330631581125283
alter Vin7 DC -0.386290416681561
alter Vin8 DC -0.384489741601594
alter Vin9 DC 0.461619066894131
alter Vin10 DC 0.340745152205258
alter Vin11 DC 0.0704341709189509
alter Vin12 DC -0.729253158394329
alter Vin13 DC -0.938300926484224
alter Vin14 DC -0.138387864413021
alter Vin15 DC -0.774754191520238
alter Vin16 DC -0.06472577537549
op
print v(o1lin)
print v(o2lin)
print v(o3lin)
print v(o4lin)
print v(o5lin)
print v(o6lin)
print v(o7lin)
print v(o8lin)
print v(o9lin)
print v(o10lin)
print v(o11lin)
print v(o12lin)
print v(o13lin)
print v(o14lin)
print v(o15lin)
print v(o16lin)
alter Vin1 DC 0.829033111352976
alter Vin2 DC 0.280583414286498
alter Vin3 DC -0.120742403743087
alter Vin4 DC 0.0243484731867412
alter Vin5 DC 0.814584378326768
alter Vin6 DC 0.126953925080522
alter Vin7 DC -0.480745642214154
alter Vin8 DC 0.58301448926957
alter Vin9 DC -0.81340983633115
alter Vin10 DC -0.0371270227098195
alter Vin11 DC 0.20534777858118
alter Vin12 DC 0.195891870031178
alter Vin13 DC 0.970242611575792
alter Vin14 DC -0.260742875944806
alter Vin15 DC -0.707389032009879
alter Vin16 DC -0.834880031964718
op
print v(o1lin)
print v(o2lin)
print v(o3lin)
print v(o4lin)
print v(o5lin)
print v(o6lin)
print v(o7lin)
print v(o8lin)
print v(o9lin)
print v(o10lin)
print v(o11lin)
print v(o12lin)
print v(o13lin)
print v(o14lin)
print v(o15lin)
print v(o16lin)
alter Vin1 DC 0.857714478615315
alter Vin2 DC -0.977990911511488
alter Vin3 DC 0.522120406530206
alter Vin4 DC -0.818687889680604
alter Vin5 DC -0.375725178244296
alter Vin6 DC 0.0646773078474716
alter Vin7 DC -0.0696743243817957
alter Vin8 DC -0.260504274511249
alter Vin9 DC 0.991412947690472
alter Vin10 DC -0.736994622705201
alter Vin11 DC -0.989748939020532
alter Vin12 DC 0.745774856471066
alter Vin13 DC 0.801402815326226
alter Vin14 DC -0.709499539722716
alter Vin15 DC 0.652792790844334
alter Vin16 DC 0.832995677945966
op
print v(o1lin)
print v(o2lin)
print v(o3lin)
print v(o4lin)
print v(o5lin)
print v(o6lin)
print v(o7lin)
print v(o8lin)
print v(o9lin)
print v(o10lin)
print v(o11lin)
print v(o12lin)
print v(o13lin)
print v(o14lin)
print v(o15lin)
print v(o16lin)
alter Vin1 DC 0.578295068169871
alter Vin2 DC -0.645738590777075
alter Vin3 DC -0.438695216585002
alter Vin4 DC 0.354791332621486
alter Vin5 DC 0.572376875240838
alter Vin6 DC 0.283557785900749
alter Vin7 DC 0.801480336715229
alter Vin8 DC 0.837498240545797
alter Vin9 DC -0.162628392977149
alter Vin10 DC 0.0188708173241798
alter Vin11 DC 0.732770034383577
alter Vin12 DC 0.829886941830955
alter Vin13 DC -0.215883555562326
alter Vin14 DC 0.778511642633058
alter Vin15 DC 0.726117246545339
alter Vin16 DC -0.836770051577228
op
print v(o1lin)
print v(o2lin)
print v(o3lin)
print v(o4lin)
print v(o5lin)
print v(o6lin)
print v(o7lin)
print v(o8lin)
print v(o9lin)
print v(o10lin)
print v(o11lin)
print v(o12lin)
print v(o13lin)
print v(o14lin)
print v(o15lin)
print v(o16lin)
alter Vin1 DC 0.512666764012534
alter Vin2 DC -0.91042789183315
alter Vin3 DC -0.674618340260172
alter Vin4 DC 0.77595275679209
alter Vin5 DC 0.541729157541262
alter Vin6 DC 0.434965717552227
alter Vin7 DC 0.812555641142557
alter Vin8 DC -0.696450119180847
alter Vin9 DC 0.349416262802516
alter Vin10 DC 0.238837808121401
alter Vin11 DC -0.606665588660031
alter Vin12 DC 0.394312915601357
alter Vin13 DC -0.299226531600345
alter Vin14 DC -0.590822138784816
alter Vin15 DC -0.900583331081588
alter Vin16 DC 0.969002954577666
op
print v(o1lin)
print v(o2lin)
print v(o3lin)
print v(o4lin)
print v(o5lin)
print v(o6lin)
print v(o7lin)
print v(o8lin)
print v(o9lin)
print v(o10lin)
print v(o11lin)
print v(o12lin)
print v(o13lin)
print v(o14lin)
print v(o15lin)
print v(o16lin)
alter Vin1 DC 0.996964849631111
alter Vin2 DC -0.382670628895657
alter Vin3 DC -0.589629194051136
alter Vin4 DC -0.257488018342011
alter Vin5 DC -0.0225875667849409
alter Vin6 DC 0.316086952435916
alter Vin7 DC 0.923082372784055
alter Vin8 DC 0.0720344794803358
alter Vin9 DC -0.570888117083981
alter Vin10 DC 0.636196022229113
alter Vin11 DC -0.59824376349448
alter Vin12 DC 0.724608074730714
alter Vin13 DC -0.224915642937104
alter Vin14 DC 0.262010847512565
alter Vin15 DC -0.401587833404117
alter Vin16 DC 0.438103800930035
op
print v(o1lin)
print v(o2lin)
print v(o3lin)
print v(o4lin)
print v(o5lin)
print v(o6lin)
print v(o7lin)
print v(o8lin)
print v(o9lin)
print v(o10lin)
print v(o11lin)
print v(o12lin)
print v(o13lin)
print v(o14lin)
print v(o15lin)
print v(o16lin)
alter Vin1 DC 0.146388210996796
alter Vin2 DC 0.851378176855976
alter Vin3 DC -0.545296719530172
alter Vin4 DC 0.936320371011729
alter Vin5 DC -0.659971945152452
alter Vin6 DC 0.637939687045485
alter Vin7 DC 0.775987953987478
alter Vin8 DC -0.7151329644111
alter Vin9 DC -0.403349246529835
alter Vin10 DC -0.818560699155668
alter Vin11 DC 0.66658468821056
alter Vin12 DC 0.229852048443837
alter Vin13 DC 0.152309271507268
alter Vin14 DC -0.0441514852931166
alter Vin15 DC 0.0779565043300003
alter Vin16 DC -0.122549087436726
op
print v(o1lin)
print v(o2lin)
print v(o3lin)
print v(o4lin)
print v(o5lin)
print v(o6lin)
print v(o7lin)
print v(o8lin)
print v(o9lin)
print v(o10lin)
print v(o11lin)
print v(o12lin)
print v(o13lin)
print v(o14lin)
print v(o15lin)
print v(o16lin)
alter Vin1 DC -0.926439381972823
alter Vin2 DC -0.615234894251263
alter Vin3 DC -0.0340238055806736
alter Vin4 DC 0.109946635985621
alter Vin5 DC -0.227895739326049
alter Vin6 DC 0.455407156960182
alter Vin7 DC 0.400984605846592
alter Vin8 DC -0.461739950266764
alter Vin9 DC 0.962599087089418
alter Vin10 DC 0.712808562717367
alter Vin11 DC 0.514105913709235
alter Vin12 DC 0.33339311864586
alter Vin13 DC 0.983543769948446
alter Vin14 DC 0.536587909150327
alter Vin15 DC 0.0318213121438755
alter Vin16 DC 0.666927443816752
op
print v(o1lin)
print v(o2lin)
print v(o3lin)
print v(o4lin)
print v(o5lin)
print v(o6lin)
print v(o7lin)
print v(o8lin)
print v(o9lin)
print v(o10lin)
print v(o11lin)
print v(o12lin)
print v(o13lin)
print v(o14lin)
print v(o15lin)
print v(o16lin)
alter Vin1 DC -0.322834862686127
alter Vin2 DC -0.584062888919473
alter Vin3 DC -0.720596149709497
alter Vin4 DC -0.678155702025423
alter Vin5 DC -0.50355911783956
alter Vin6 DC 0.493391744831513
alter Vin7 DC 0.77110097674651
alter Vin8 DC 0.35657120941032
alter Vin9 DC -0.299379898988419
alter Vin10 DC 0.913130383361827
alter Vin11 DC 0.047342951298037
alter Vin12 DC -0.309370616770426
alter Vin13 DC 0.192831131458793
alter Vin14 DC 0.116497038265849
alter Vin15 DC 0.128520413216278
alter Vin16 DC 0.177999850779134
op
print v(o1lin)
print v(o2lin)
print v(o3lin)
print v(o4lin)
print v(o5lin)
print v(o6lin)
print v(o7lin)
print v(o8lin)
print v(o9lin)
print v(o10lin)
print v(o11lin)
print v(o12lin)
print v(o13lin)
print v(o14lin)
print v(o15lin)
print v(o16lin)
alter Vin1 DC -0.727341455542907
alter Vin2 DC 0.529599033013268
alter Vin3 DC 0.521024787135614
alter Vin4 DC -0.866776027386548
alter Vin5 DC 0.776840732388895
alter Vin6 DC -0.717793598737009
alter Vin7 DC -0.591867360923596
alter Vin8 DC -0.0815920521485731
alter Vin9 DC -0.0328119134751146
alter Vin10 DC 0.509073071940425
alter Vin11 DC -0.546284331957509
alter Vin12 DC 0.481384262792588
alter Vin13 DC -0.859595413394354
alter Vin14 DC -0.291234569240053
alter Vin15 DC -0.870152250182007
alter Vin16 DC -0.435785443442337
op
print v(o1lin)
print v(o2lin)
print v(o3lin)
print v(o4lin)
print v(o5lin)
print v(o6lin)
print v(o7lin)
print v(o8lin)
print v(o9lin)
print v(o10lin)
print v(o11lin)
print v(o12lin)
print v(o13lin)
print v(o14lin)
print v(o15lin)
print v(o16lin)
alter Vin1 DC 0.308674565966459
alter Vin2 DC 0.476522030460678
alter Vin3 DC 0.176116940403099
alter Vin4 DC -0.269696616647023
alter Vin5 DC -0.835425825203222
alter Vin6 DC -0.257374488996112
alter Vin7 DC 0.861825960245245
alter Vin8 DC -0.757200981805819
alter Vin9 DC 0.219570221593069
alter Vin10 DC -0.737313772662746
alter Vin11 DC 0.916532670163939
alter Vin12 DC -0.326724749976099
alter Vin13 DC -0.258958621423432
alter Vin14 DC 0.110523904762884
alter Vin15 DC -0.262524879020353
alter Vin16 DC 0.595305764490593
op
print v(o1lin)
print v(o2lin)
print v(o3lin)
print v(o4lin)
print v(o5lin)
print v(o6lin)
print v(o7lin)
print v(o8lin)
print v(o9lin)
print v(o10lin)
print v(o11lin)
print v(o12lin)
print v(o13lin)
print v(o14lin)
print v(o15lin)
print v(o16lin)
alter Vin1 DC -0.121565718815817
alter Vin2 DC 0.85026137362778
alter Vin3 DC -0.725882120507907
alter Vin4 DC 0.0407127903627837
alter Vin5 DC 0.486714139870312
alter Vin6 DC -0.174725929659921
alter Vin7 DC 0.197358954375944
alter Vin8 DC 0.807395499014515
alter Vin9 DC 0.843354973338086
alter Vin10 DC 0.282953221647761
alter Vin11 DC -0.999304235886526
alter Vin12 DC -0.950389802844308
alter Vin13 DC 0.771638055757985
alter Vin14 DC -0.140350408284357
alter Vin15 DC 0.438700172314504
alter Vin16 DC 0.766208145137089
op
print v(o1lin)
print v(o2lin)
print v(o3lin)
print v(o4lin)
print v(o5lin)
print v(o6lin)
print v(o7lin)
print v(o8lin)
print v(o9lin)
print v(o10lin)
print v(o11lin)
print v(o12lin)
print v(o13lin)
print v(o14lin)
print v(o15lin)
print v(o16lin)
alter Vin1 DC 0.524565147427742
alter Vin2 DC -0.228728707561463
alter Vin3 DC 0.622966092889961
alter Vin4 DC 0.442099278822348
alter Vin5 DC -0.68185971324033
alter Vin6 DC -0.657022993439861
alter Vin7 DC 0.606146642396182
alter Vin8 DC -0.234310724429887
alter Vin9 DC 0.330684414271566
alter Vin10 DC 0.118943468091141
alter Vin11 DC -0.905603957323895
alter Vin12 DC -0.647082133976604
alter Vin13 DC -0.988277487148225
alter Vin14 DC -0.0351159487862691
alter Vin15 DC 0.0357885445778272
alter Vin16 DC -0.573737602016074
op
print v(o1lin)
print v(o2lin)
print v(o3lin)
print v(o4lin)
print v(o5lin)
print v(o6lin)
print v(o7lin)
print v(o8lin)
print v(o9lin)
print v(o10lin)
print v(o11lin)
print v(o12lin)
print v(o13lin)
print v(o14lin)
print v(o15lin)
print v(o16lin)
alter Vin1 DC 0.420805696758339
alter Vin2 DC -0.616530557983683
alter Vin3 DC 0.364821943112122
alter Vin4 DC -0.395523393484615
alter Vin5 DC -0.679355100506025
alter Vin6 DC -0.65784113684798
alter Vin7 DC 0.438381846487236
alter Vin8 DC -0.85021400464495
alter Vin9 DC -0.420415477822893
alter Vin10 DC 0.0361561564656332
alter Vin11 DC -0.815551896898906
alter Vin12 DC -0.241219421510256
alter Vin13 DC -0.0373494349822094
alter Vin14 DC -0.135841212962577
alter Vin15 DC 0.57727959838417
alter Vin16 DC -0.210802787968692
op
print v(o1lin)
print v(o2lin)
print v(o3lin)
print v(o4lin)
print v(o5lin)
print v(o6lin)
print v(o7lin)
print v(o8lin)
print v(o9lin)
print v(o10lin)
print v(o11lin)
print v(o12lin)
print v(o13lin)
print v(o14lin)
print v(o15lin)
print v(o16lin)
alter Vin1 DC 0.629943578679728
alter Vin2 DC -0.630269214707563
alter Vin3 DC -0.535415717482891
alter Vin4 DC -0.48530144792653
alter Vin5 DC 0.876443527101505
alter Vin6 DC 0.956831608196373
alter Vin7 DC 0.62296091785086
alter Vin8 DC -0.371158011771501
alter Vin9 DC -0.426667771368826
alter Vin10 DC -0.123590564539462
alter Vin11 DC 0.672310760463096
alter Vin12 DC -0.616138587739159
alter Vin13 DC -0.762917650415718
alter Vin14 DC 0.966351017630807
alter Vin15 DC -0.733199412609241
alter Vin16 DC 0.716651575923025
op
print v(o1lin)
print v(o2lin)
print v(o3lin)
print v(o4lin)
print v(o5lin)
print v(o6lin)
print v(o7lin)
print v(o8lin)
print v(o9lin)
print v(o10lin)
print v(o11lin)
print v(o12lin)
print v(o13lin)
print v(o14lin)
print v(o15lin)
print v(o16lin)
alter Vin1 DC 0.871749943944607
alter Vin2 DC 0.800566991487011
alter Vin3 DC 0.148517405813394
alter Vin4 DC 0.16411092224549
alter Vin5 DC 0.15095057678523
alter Vin6 DC 0.665540825522831
alter Vin7 DC -0.328809795820072
alter Vin8 DC -0.101089727549368
alter Vin9 DC 0.412539036523303
alter Vin10 DC -0.923741521545875
alter Vin11 DC 0.841822758518547
alter Vin12 DC -0.320625674375062
alter Vin13 DC 0.98527699831693
alter Vin14 DC 0.698574088472181
alter Vin15 DC 0.201542535103489
alter Vin16 DC -0.251875350325209
op
print v(o1lin)
print v(o2lin)
print v(o3lin)
print v(o4lin)
print v(o5lin)
print v(o6lin)
print v(o7lin)
print v(o8lin)
print v(o9lin)
print v(o10lin)
print v(o11lin)
print v(o12lin)
print v(o13lin)
print v(o14lin)
print v(o15lin)
print v(o16lin)
alter Vin1 DC -0.435790593033425
alter Vin2 DC 0.509010632089743
alter Vin3 DC -0.736236410676319
alter Vin4 DC -0.282429435826858
alter Vin5 DC -0.35739314238874
alter Vin6 DC -0.0994848388126692
alter Vin7 DC 0.34808330040118
alter Vin8 DC 0.129827556796683
alter Vin9 DC 0.929576139225079
alter Vin10 DC 0.0147729948880049
alter Vin11 DC 0.712078809311182
alter Vin12 DC -0.453779086309546
alter Vin13 DC -0.739264697377888
alter Vin14 DC -0.873302038896945
alter Vin15 DC -0.656907648788633
alter Vin16 DC 0.193540209230586
op
print v(o1lin)
print v(o2lin)
print v(o3lin)
print v(o4lin)
print v(o5lin)
print v(o6lin)
print v(o7lin)
print v(o8lin)
print v(o9lin)
print v(o10lin)
print v(o11lin)
print v(o12lin)
print v(o13lin)
print v(o14lin)
print v(o15lin)
print v(o16lin)
alter Vin1 DC -0.444985010439622
alter Vin2 DC 0.262105737972402
alter Vin3 DC -0.134639715320711
alter Vin4 DC 0.00871492112369121
alter Vin5 DC -0.164802178150099
alter Vin6 DC -0.0360065886251681
alter Vin7 DC 0.582785467335486
alter Vin8 DC 0.325086095337421
alter Vin9 DC -0.382644437592201
alter Vin10 DC 0.63941316648002
alter Vin11 DC 0.81311392949342
alter Vin12 DC 0.284714979923845
alter Vin13 DC 0.14466457580675
alter Vin14 DC -0.0423617027702567
alter Vin15 DC 0.0315935197234194
alter Vin16 DC -0.794915100614559
op
print v(o1lin)
print v(o2lin)
print v(o3lin)
print v(o4lin)
print v(o5lin)
print v(o6lin)
print v(o7lin)
print v(o8lin)
print v(o9lin)
print v(o10lin)
print v(o11lin)
print v(o12lin)
print v(o13lin)
print v(o14lin)
print v(o15lin)
print v(o16lin)
alter Vin1 DC 0.473959618535904
alter Vin2 DC -0.674919507705084
alter Vin3 DC -0.090541423246211
alter Vin4 DC 0.0328552965976765
alter Vin5 DC 0.491720749572774
alter Vin6 DC 0.174490536774184
alter Vin7 DC 0.523607134618408
alter Vin8 DC -0.589568013375201
alter Vin9 DC 0.214150190485903
alter Vin10 DC -0.331800505532196
alter Vin11 DC 0.00911138311969562
alter Vin12 DC -0.127929443927684
alter Vin13 DC 0.382569507742663
alter Vin14 DC 0.848857557230351
alter Vin15 DC -0.160914258094886
alter Vin16 DC 0.84313484847354
op
print v(o1lin)
print v(o2lin)
print v(o3lin)
print v(o4lin)
print v(o5lin)
print v(o6lin)
print v(o7lin)
print v(o8lin)
print v(o9lin)
print v(o10lin)
print v(o11lin)
print v(o12lin)
print v(o13lin)
print v(o14lin)
print v(o15lin)
print v(o16lin)
alter Vin1 DC 0.854121267648881
alter Vin2 DC -0.863104920259956
alter Vin3 DC 0.699118531725876
alter Vin4 DC -0.44028455805589
alter Vin5 DC 0.723564266889591
alter Vin6 DC -0.923328667795676
alter Vin7 DC -0.517612280697899
alter Vin8 DC 0.923043749130722
alter Vin9 DC -0.106379997970902
alter Vin10 DC 0.0530858948433515
alter Vin11 DC -0.726512896509584
alter Vin12 DC 0.815408190373248
alter Vin13 DC -0.513508836420983
alter Vin14 DC -0.0541394505593924
alter Vin15 DC -0.38530517537534
alter Vin16 DC 0.958996250521952
op
print v(o1lin)
print v(o2lin)
print v(o3lin)
print v(o4lin)
print v(o5lin)
print v(o6lin)
print v(o7lin)
print v(o8lin)
print v(o9lin)
print v(o10lin)
print v(o11lin)
print v(o12lin)
print v(o13lin)
print v(o14lin)
print v(o15lin)
print v(o16lin)
alter Vin1 DC -0.182410546979668
alter Vin2 DC 0.835243093179319
alter Vin3 DC -0.242977882583611
alter Vin4 DC -0.115668704459711
alter Vin5 DC 0.265493830424646
alter Vin6 DC 0.561733159477189
alter Vin7 DC 0.720426533508478
alter Vin8 DC -0.428997435422247
alter Vin9 DC 0.984837014581437
alter Vin10 DC -0.367744059540572
alter Vin11 DC 0.685842058608806
alter Vin12 DC -0.504080364451237
alter Vin13 DC 0.827196242512833
alter Vin14 DC -0.499935904265155
alter Vin15 DC 0.293558200495249
alter Vin16 DC 0.154385433292093
op
print v(o1lin)
print v(o2lin)
print v(o3lin)
print v(o4lin)
print v(o5lin)
print v(o6lin)
print v(o7lin)
print v(o8lin)
print v(o9lin)
print v(o10lin)
print v(o11lin)
print v(o12lin)
print v(o13lin)
print v(o14lin)
print v(o15lin)
print v(o16lin)
alter Vin1 DC -0.0424199175493747
alter Vin2 DC 0.838664061223018
alter Vin3 DC -0.824229098325945
alter Vin4 DC -0.0776565316448008
alter Vin5 DC -0.33628537155322
alter Vin6 DC 0.470674543102509
alter Vin7 DC 0.1193827012023
alter Vin8 DC -0.0773252185154991
alter Vin9 DC 0.565532983466461
alter Vin10 DC -0.521398283374638
alter Vin11 DC -0.732414208324432
alter Vin12 DC -0.540649956671461
alter Vin13 DC -0.362176019358767
alter Vin14 DC -0.316870800752612
alter Vin15 DC 0.519193177263088
alter Vin16 DC 0.32991981793343
op
print v(o1lin)
print v(o2lin)
print v(o3lin)
print v(o4lin)
print v(o5lin)
print v(o6lin)
print v(o7lin)
print v(o8lin)
print v(o9lin)
print v(o10lin)
print v(o11lin)
print v(o12lin)
print v(o13lin)
print v(o14lin)
print v(o15lin)
print v(o16lin)
alter Vin1 DC 0.648944715161894
alter Vin2 DC 0.89444347606232
alter Vin3 DC 0.933554156660556
alter Vin4 DC -0.352808984745151
alter Vin5 DC -0.693379467863867
alter Vin6 DC 0.534913180875795
alter Vin7 DC -0.127206907376035
alter Vin8 DC -0.261728410062389
alter Vin9 DC 0.0846384567007528
alter Vin10 DC 0.244806740171615
alter Vin11 DC 0.871994572429132
alter Vin12 DC -0.990311897901168
alter Vin13 DC 0.224341882683374
alter Vin14 DC -0.614489544655322
alter Vin15 DC -0.919716028840953
alter Vin16 DC -0.959890141914985
op
print v(o1lin)
print v(o2lin)
print v(o3lin)
print v(o4lin)
print v(o5lin)
print v(o6lin)
print v(o7lin)
print v(o8lin)
print v(o9lin)
print v(o10lin)
print v(o11lin)
print v(o12lin)
print v(o13lin)
print v(o14lin)
print v(o15lin)
print v(o16lin)
alter Vin1 DC 0.638665199401574
alter Vin2 DC 0.211397114558356
alter Vin3 DC -0.266232655579499
alter Vin4 DC 0.597100765753113
alter Vin5 DC 0.415698441491614
alter Vin6 DC 0.368787974568283
alter Vin7 DC 0.316802795864751
alter Vin8 DC 0.901506717038802
alter Vin9 DC 0.277532205112194
alter Vin10 DC 0.587310888203781
alter Vin11 DC 0.930805247475178
alter Vin12 DC -0.0202701542085035
alter Vin13 DC 0.630123261270705
alter Vin14 DC -0.0491258306588274
alter Vin15 DC -0.496890624777446
alter Vin16 DC 0.549915670553419
op
print v(o1lin)
print v(o2lin)
print v(o3lin)
print v(o4lin)
print v(o5lin)
print v(o6lin)
print v(o7lin)
print v(o8lin)
print v(o9lin)
print v(o10lin)
print v(o11lin)
print v(o12lin)
print v(o13lin)
print v(o14lin)
print v(o15lin)
print v(o16lin)
alter Vin1 DC -0.776646806339778
alter Vin2 DC 0.0270042358561953
alter Vin3 DC -0.422748185746588
alter Vin4 DC -0.957562222478306
alter Vin5 DC -0.588583448036055
alter Vin6 DC -0.503375050858121
alter Vin7 DC -0.173557277611215
alter Vin8 DC -0.752484542171101
alter Vin9 DC 0.710529218810553
alter Vin10 DC -0.439100138375982
alter Vin11 DC -0.0193668471030695
alter Vin12 DC 0.702223282020261
alter Vin13 DC -0.798560621482278
alter Vin14 DC -0.0621944011452502
alter Vin15 DC -0.337922095172016
alter Vin16 DC 0.633402950094418
op
print v(o1lin)
print v(o2lin)
print v(o3lin)
print v(o4lin)
print v(o5lin)
print v(o6lin)
print v(o7lin)
print v(o8lin)
print v(o9lin)
print v(o10lin)
print v(o11lin)
print v(o12lin)
print v(o13lin)
print v(o14lin)
print v(o15lin)
print v(o16lin)
alter Vin1 DC -0.0156640774286299
alter Vin2 DC 0.982939007622261
alter Vin3 DC 0.295273198465372
alter Vin4 DC -0.00773761927777894
alter Vin5 DC -0.731637156921157
alter Vin6 DC 0.0633775235529461
alter Vin7 DC -0.909096294008988
alter Vin8 DC 0.43948661944112
alter Vin9 DC 0.068542910085142
alter Vin10 DC 0.423308360793934
alter Vin11 DC 0.24030192452525
alter Vin12 DC 0.932579672696048
alter Vin13 DC 0.168210885531479
alter Vin14 DC 0.232979678985918
alter Vin15 DC -0.592880765844443
alter Vin16 DC -0.00383615105463186
op
print v(o1lin)
print v(o2lin)
print v(o3lin)
print v(o4lin)
print v(o5lin)
print v(o6lin)
print v(o7lin)
print v(o8lin)
print v(o9lin)
print v(o10lin)
print v(o11lin)
print v(o12lin)
print v(o13lin)
print v(o14lin)
print v(o15lin)
print v(o16lin)
alter Vin1 DC 0.224564627243125
alter Vin2 DC 0.610288675427606
alter Vin3 DC 0.580393382529235
alter Vin4 DC -0.144263157730481
alter Vin5 DC 0.837779402785377
alter Vin6 DC -0.967521386243169
alter Vin7 DC 0.134890958525509
alter Vin8 DC -0.304619338448763
alter Vin9 DC -0.90703329649748
alter Vin10 DC 0.264191221026108
alter Vin11 DC -0.317220749012029
alter Vin12 DC -0.412043168254245
alter Vin13 DC -0.357406899713616
alter Vin14 DC -0.240186282218046
alter Vin15 DC 0.669781409204899
alter Vin16 DC 0.434406486561547
op
print v(o1lin)
print v(o2lin)
print v(o3lin)
print v(o4lin)
print v(o5lin)
print v(o6lin)
print v(o7lin)
print v(o8lin)
print v(o9lin)
print v(o10lin)
print v(o11lin)
print v(o12lin)
print v(o13lin)
print v(o14lin)
print v(o15lin)
print v(o16lin)
alter Vin1 DC 0.525516325865444
alter Vin2 DC -0.472026525993039
alter Vin3 DC 0.00878573704683516
alter Vin4 DC 0.484555174397423
alter Vin5 DC 0.716942514121287
alter Vin6 DC 0.692804898507213
alter Vin7 DC 0.332216042398138
alter Vin8 DC -0.690345574529332
alter Vin9 DC -0.859210080855616
alter Vin10 DC 0.0915004368134058
alter Vin11 DC 0.0793722741029574
alter Vin12 DC 0.589068982026526
alter Vin13 DC 0.572666309377992
alter Vin14 DC -0.578207843265613
alter Vin15 DC -0.659972708657091
alter Vin16 DC 0.0486242423499932
op
print v(o1lin)
print v(o2lin)
print v(o3lin)
print v(o4lin)
print v(o5lin)
print v(o6lin)
print v(o7lin)
print v(o8lin)
print v(o9lin)
print v(o10lin)
print v(o11lin)
print v(o12lin)
print v(o13lin)
print v(o14lin)
print v(o15lin)
print v(o16lin)
alter Vin1 DC -0.622221839389324
alter Vin2 DC -0.662295312134024
alter Vin3 DC 0.260215664888797
alter Vin4 DC -0.121089732531255
alter Vin5 DC 0.974384557116512
alter Vin6 DC -0.617339160843703
alter Vin7 DC 0.0342451436437881
alter Vin8 DC -0.262105851727904
alter Vin9 DC -0.747866052536473
alter Vin10 DC -0.704798481274105
alter Vin11 DC 0.434286233094723
alter Vin12 DC -0.129657062766771
alter Vin13 DC -0.213276455255674
alter Vin14 DC -0.111912580608682
alter Vin15 DC 0.782870249253859
alter Vin16 DC 0.0754548868047169
op
print v(o1lin)
print v(o2lin)
print v(o3lin)
print v(o4lin)
print v(o5lin)
print v(o6lin)
print v(o7lin)
print v(o8lin)
print v(o9lin)
print v(o10lin)
print v(o11lin)
print v(o12lin)
print v(o13lin)
print v(o14lin)
print v(o15lin)
print v(o16lin)
alter Vin1 DC -0.876136938032233
alter Vin2 DC -0.368404602581621
alter Vin3 DC -0.12870675386055
alter Vin4 DC -0.605276332057781
alter Vin5 DC -0.60327389446703
alter Vin6 DC 0.612852797412629
alter Vin7 DC -0.285795693486291
alter Vin8 DC 0.478726389253242
alter Vin9 DC -0.566211187511154
alter Vin10 DC 0.628976017698857
alter Vin11 DC -0.830279674229913
alter Vin12 DC 0.363527391280215
alter Vin13 DC 0.644465793786057
alter Vin14 DC 0.741348767216022
alter Vin15 DC -0.960302467727177
alter Vin16 DC 0.190194840071317
op
print v(o1lin)
print v(o2lin)
print v(o3lin)
print v(o4lin)
print v(o5lin)
print v(o6lin)
print v(o7lin)
print v(o8lin)
print v(o9lin)
print v(o10lin)
print v(o11lin)
print v(o12lin)
print v(o13lin)
print v(o14lin)
print v(o15lin)
print v(o16lin)
alter Vin1 DC 0.242818245034849
alter Vin2 DC 0.560008840382686
alter Vin3 DC -0.135366557688265
alter Vin4 DC -0.712172378843545
alter Vin5 DC 0.642009664105753
alter Vin6 DC 0.858678551839878
alter Vin7 DC -0.936262310919088
alter Vin8 DC -0.721109434855769
alter Vin9 DC 0.946911609907694
alter Vin10 DC -0.501538640024414
alter Vin11 DC -0.320253202230799
alter Vin12 DC 0.34433434676464
alter Vin13 DC -0.239510478153063
alter Vin14 DC 0.797739837032284
alter Vin15 DC -0.820072583471885
alter Vin16 DC -0.634940172842468
op
print v(o1lin)
print v(o2lin)
print v(o3lin)
print v(o4lin)
print v(o5lin)
print v(o6lin)
print v(o7lin)
print v(o8lin)
print v(o9lin)
print v(o10lin)
print v(o11lin)
print v(o12lin)
print v(o13lin)
print v(o14lin)
print v(o15lin)
print v(o16lin)
alter Vin1 DC -0.226957369108368
alter Vin2 DC -0.486040529973842
alter Vin3 DC 0.795505146463134
alter Vin4 DC -0.797029481086641
alter Vin5 DC 0.0691838391920991
alter Vin6 DC -0.495282232152387
alter Vin7 DC 0.253091024196157
alter Vin8 DC -0.30294336122378
alter Vin9 DC -0.272198693696353
alter Vin10 DC 0.958970948285373
alter Vin11 DC -0.00384427292140122
alter Vin12 DC 0.113963051669706
alter Vin13 DC -0.0463791918020768
alter Vin14 DC -0.937220348279607
alter Vin15 DC 0.534862413689226
alter Vin16 DC -0.0510061348900046
op
print v(o1lin)
print v(o2lin)
print v(o3lin)
print v(o4lin)
print v(o5lin)
print v(o6lin)
print v(o7lin)
print v(o8lin)
print v(o9lin)
print v(o10lin)
print v(o11lin)
print v(o12lin)
print v(o13lin)
print v(o14lin)
print v(o15lin)
print v(o16lin)
alter Vin1 DC -0.815492786474637
alter Vin2 DC 0.898974779006224
alter Vin3 DC -0.246466587322885
alter Vin4 DC -0.576666276194137
alter Vin5 DC 0.564139491246543
alter Vin6 DC 0.259059245701549
alter Vin7 DC 0.0121425319785879
alter Vin8 DC -0.896416483281655
alter Vin9 DC 0.0390104989881048
alter Vin10 DC 0.20516612213072
alter Vin11 DC 0.562403202391762
alter Vin12 DC 0.0667578854880457
alter Vin13 DC -0.319917394261815
alter Vin14 DC -0.586842218123976
alter Vin15 DC -0.338724018126737
alter Vin16 DC -0.0515969130710348
op
print v(o1lin)
print v(o2lin)
print v(o3lin)
print v(o4lin)
print v(o5lin)
print v(o6lin)
print v(o7lin)
print v(o8lin)
print v(o9lin)
print v(o10lin)
print v(o11lin)
print v(o12lin)
print v(o13lin)
print v(o14lin)
print v(o15lin)
print v(o16lin)
alter Vin1 DC 0.695146863475247
alter Vin2 DC -0.590850372933995
alter Vin3 DC -0.754671137444595
alter Vin4 DC -0.802395711938365
alter Vin5 DC -0.488235021194964
alter Vin6 DC 0.106795768837743
alter Vin7 DC -0.354856798723143
alter Vin8 DC -0.456997485924752
alter Vin9 DC 0.284314473635527
alter Vin10 DC -0.0761392852316809
alter Vin11 DC -0.378298747354088
alter Vin12 DC -0.977272221658282
alter Vin13 DC 0.305524695323935
alter Vin14 DC 0.373394545537216
alter Vin15 DC 0.595590302677602
alter Vin16 DC 0.615582304354054
op
print v(o1lin)
print v(o2lin)
print v(o3lin)
print v(o4lin)
print v(o5lin)
print v(o6lin)
print v(o7lin)
print v(o8lin)
print v(o9lin)
print v(o10lin)
print v(o11lin)
print v(o12lin)
print v(o13lin)
print v(o14lin)
print v(o15lin)
print v(o16lin)
alter Vin1 DC -0.705042861758872
alter Vin2 DC -0.917809824169352
alter Vin3 DC -0.617444840483489
alter Vin4 DC -0.743528395819646
alter Vin5 DC 0.0363569450703602
alter Vin6 DC 0.718345871629722
alter Vin7 DC -0.918295742000921
alter Vin8 DC -0.403604388712328
alter Vin9 DC 0.91909912110896
alter Vin10 DC 0.658577399827512
alter Vin11 DC -0.617133543792804
alter Vin12 DC 0.26300458909155
alter Vin13 DC 0.306295434917204
alter Vin14 DC 0.0511249346027192
alter Vin15 DC -0.635553059206769
alter Vin16 DC -0.335426736743261
op
print v(o1lin)
print v(o2lin)
print v(o3lin)
print v(o4lin)
print v(o5lin)
print v(o6lin)
print v(o7lin)
print v(o8lin)
print v(o9lin)
print v(o10lin)
print v(o11lin)
print v(o12lin)
print v(o13lin)
print v(o14lin)
print v(o15lin)
print v(o16lin)
alter Vin1 DC -0.887097680577035
alter Vin2 DC -0.137874232610651
alter Vin3 DC 0.392261448514225
alter Vin4 DC -0.669837240112028
alter Vin5 DC 0.937054408596362
alter Vin6 DC 0.532497785895781
alter Vin7 DC 0.0743920329483156
alter Vin8 DC -0.929020865983353
alter Vin9 DC 0.375784262210059
alter Vin10 DC -0.812631275478867
alter Vin11 DC 0.390938742093426
alter Vin12 DC 0.252260478797552
alter Vin13 DC -0.879420770781863
alter Vin14 DC 0.107480463606217
alter Vin15 DC 0.183090002339345
alter Vin16 DC 0.938620526010063
op
print v(o1lin)
print v(o2lin)
print v(o3lin)
print v(o4lin)
print v(o5lin)
print v(o6lin)
print v(o7lin)
print v(o8lin)
print v(o9lin)
print v(o10lin)
print v(o11lin)
print v(o12lin)
print v(o13lin)
print v(o14lin)
print v(o15lin)
print v(o16lin)
alter Vin1 DC 0.441874005011241
alter Vin2 DC 0.820330118728777
alter Vin3 DC -0.528349659979035
alter Vin4 DC 0.63832901799845
alter Vin5 DC 0.447825508372061
alter Vin6 DC 0.0103318788620494
alter Vin7 DC 0.565247873837889
alter Vin8 DC 0.189458574542664
alter Vin9 DC -0.985798858787869
alter Vin10 DC 0.740352357890542
alter Vin11 DC 0.917691393028369
alter Vin12 DC -0.412443952371496
alter Vin13 DC -0.525379420448268
alter Vin14 DC -0.498063479502502
alter Vin15 DC 0.0619363871468119
alter Vin16 DC -0.824915930675084
op
print v(o1lin)
print v(o2lin)
print v(o3lin)
print v(o4lin)
print v(o5lin)
print v(o6lin)
print v(o7lin)
print v(o8lin)
print v(o9lin)
print v(o10lin)
print v(o11lin)
print v(o12lin)
print v(o13lin)
print v(o14lin)
print v(o15lin)
print v(o16lin)
alter Vin1 DC -0.209946057226828
alter Vin2 DC 0.938358698480211
alter Vin3 DC 0.844522381767788
alter Vin4 DC -0.914717237198387
alter Vin5 DC -0.826167252736566
alter Vin6 DC 0.412012459136602
alter Vin7 DC -0.0919991894610943
alter Vin8 DC 0.246586178463741
alter Vin9 DC -0.695482496539151
alter Vin10 DC -0.212274284126689
alter Vin11 DC 0.714675203458971
alter Vin12 DC 0.00777602352554307
alter Vin13 DC -0.711002400316846
alter Vin14 DC 0.617353975867579
alter Vin15 DC 0.622661293671702
alter Vin16 DC 0.606399190335689
op
print v(o1lin)
print v(o2lin)
print v(o3lin)
print v(o4lin)
print v(o5lin)
print v(o6lin)
print v(o7lin)
print v(o8lin)
print v(o9lin)
print v(o10lin)
print v(o11lin)
print v(o12lin)
print v(o13lin)
print v(o14lin)
print v(o15lin)
print v(o16lin)
alter Vin1 DC 0.0498502903955802
alter Vin2 DC -0.677314933653201
alter Vin3 DC 0.27997518646347
alter Vin4 DC 0.479517928033712
alter Vin5 DC 0.0171504298922649
alter Vin6 DC 0.532530733287977
alter Vin7 DC -0.69325644325773
alter Vin8 DC 0.0472833299463045
alter Vin9 DC 0.166146653023768
alter Vin10 DC -0.228158989287587
alter Vin11 DC 0.618073892836404
alter Vin12 DC -0.522880331874539
alter Vin13 DC -0.180054515105621
alter Vin14 DC -0.627517424625704
alter Vin15 DC -0.0631174152542417
alter Vin16 DC 0.531232484855429
op
print v(o1lin)
print v(o2lin)
print v(o3lin)
print v(o4lin)
print v(o5lin)
print v(o6lin)
print v(o7lin)
print v(o8lin)
print v(o9lin)
print v(o10lin)
print v(o11lin)
print v(o12lin)
print v(o13lin)
print v(o14lin)
print v(o15lin)
print v(o16lin)
alter Vin1 DC 0.0485766359943614
alter Vin2 DC 0.511540897498797
alter Vin3 DC 0.203785966504559
alter Vin4 DC -0.962215812282735
alter Vin5 DC 0.659329549233748
alter Vin6 DC -0.0876846705267378
alter Vin7 DC 0.0553243711996942
alter Vin8 DC 0.109943837949864
alter Vin9 DC 0.887634400399363
alter Vin10 DC 0.442053774183632
alter Vin11 DC -0.980971297292902
alter Vin12 DC -0.780068949581031
alter Vin13 DC 0.378893707174163
alter Vin14 DC 0.683329275930105
alter Vin15 DC 0.0949733781079198
alter Vin16 DC -0.442793522922775
op
print v(o1lin)
print v(o2lin)
print v(o3lin)
print v(o4lin)
print v(o5lin)
print v(o6lin)
print v(o7lin)
print v(o8lin)
print v(o9lin)
print v(o10lin)
print v(o11lin)
print v(o12lin)
print v(o13lin)
print v(o14lin)
print v(o15lin)
print v(o16lin)
alter Vin1 DC -0.0799512722320355
alter Vin2 DC -0.924589866919053
alter Vin3 DC 0.705664810193632
alter Vin4 DC 0.547664708077549
alter Vin5 DC 0.565349869657294
alter Vin6 DC 0.626254280591989
alter Vin7 DC -0.804948741147138
alter Vin8 DC 0.469391367096575
alter Vin9 DC 0.249795984372565
alter Vin10 DC 0.498344638093884
alter Vin11 DC 0.244649170389585
alter Vin12 DC 0.710742873523942
alter Vin13 DC -0.748290949896328
alter Vin14 DC -0.0197622677824538
alter Vin15 DC -0.2593742670946
alter Vin16 DC 0.288057489564645
op
print v(o1lin)
print v(o2lin)
print v(o3lin)
print v(o4lin)
print v(o5lin)
print v(o6lin)
print v(o7lin)
print v(o8lin)
print v(o9lin)
print v(o10lin)
print v(o11lin)
print v(o12lin)
print v(o13lin)
print v(o14lin)
print v(o15lin)
print v(o16lin)
alter Vin1 DC -0.492792468805358
alter Vin2 DC 0.370797733613262
alter Vin3 DC -0.48624664167606
alter Vin4 DC 0.526335705026254
alter Vin5 DC 0.0579877683955743
alter Vin6 DC 0.678488296469331
alter Vin7 DC 0.53749909181621
alter Vin8 DC -0.553856162875301
alter Vin9 DC 0.601945927054395
alter Vin10 DC -0.409549813109874
alter Vin11 DC 0.650259693594131
alter Vin12 DC 0.0218978418622007
alter Vin13 DC 0.129967451543016
alter Vin14 DC 0.917902172163158
alter Vin15 DC 0.813004278322354
alter Vin16 DC -0.224803247925623
op
print v(o1lin)
print v(o2lin)
print v(o3lin)
print v(o4lin)
print v(o5lin)
print v(o6lin)
print v(o7lin)
print v(o8lin)
print v(o9lin)
print v(o10lin)
print v(o11lin)
print v(o12lin)
print v(o13lin)
print v(o14lin)
print v(o15lin)
print v(o16lin)
alter Vin1 DC 0.600443664364203
alter Vin2 DC 0.728641531451005
alter Vin3 DC -0.271435291660514
alter Vin4 DC 0.666328892342692
alter Vin5 DC -0.848986302085329
alter Vin6 DC -0.629400345888944
alter Vin7 DC 0.878489399317293
alter Vin8 DC -0.606849193575
alter Vin9 DC -0.486747239464091
alter Vin10 DC 0.611086497639423
alter Vin11 DC 0.0823939796241802
alter Vin12 DC 0.634303637870709
alter Vin13 DC 0.67460872597927
alter Vin14 DC -0.927790028925394
alter Vin15 DC -0.929009732746119
alter Vin16 DC 0.0735433324936505
op
print v(o1lin)
print v(o2lin)
print v(o3lin)
print v(o4lin)
print v(o5lin)
print v(o6lin)
print v(o7lin)
print v(o8lin)
print v(o9lin)
print v(o10lin)
print v(o11lin)
print v(o12lin)
print v(o13lin)
print v(o14lin)
print v(o15lin)
print v(o16lin)
alter Vin1 DC 0.945950737536584
alter Vin2 DC 0.358846137573675
alter Vin3 DC -0.813768600589099
alter Vin4 DC 0.089299260688279
alter Vin5 DC 0.68465018478882
alter Vin6 DC -0.648692011356278
alter Vin7 DC -0.735434551805334
alter Vin8 DC -0.593070151993877
alter Vin9 DC -0.209166393084939
alter Vin10 DC -0.184996618275574
alter Vin11 DC 0.929970438545642
alter Vin12 DC 0.47479867415402
alter Vin13 DC -0.669204879149613
alter Vin14 DC -0.302127877689915
alter Vin15 DC -0.196804452963316
alter Vin16 DC -0.0824110898032884
op
print v(o1lin)
print v(o2lin)
print v(o3lin)
print v(o4lin)
print v(o5lin)
print v(o6lin)
print v(o7lin)
print v(o8lin)
print v(o9lin)
print v(o10lin)
print v(o11lin)
print v(o12lin)
print v(o13lin)
print v(o14lin)
print v(o15lin)
print v(o16lin)
alter Vin1 DC 0.827256307031516
alter Vin2 DC 0.987407237737572
alter Vin3 DC -0.841338617516153
alter Vin4 DC 0.210538087341858
alter Vin5 DC -0.310498331443039
alter Vin6 DC 0.763728785520983
alter Vin7 DC 0.547367342552173
alter Vin8 DC -0.23904814067003
alter Vin9 DC -0.484165658524584
alter Vin10 DC -0.0642727923102222
alter Vin11 DC 0.445035241181168
alter Vin12 DC -0.0538577241076315
alter Vin13 DC -0.525813848241217
alter Vin14 DC -0.503075968194904
alter Vin15 DC -0.371428712384779
alter Vin16 DC 0.839667374221899
op
print v(o1lin)
print v(o2lin)
print v(o3lin)
print v(o4lin)
print v(o5lin)
print v(o6lin)
print v(o7lin)
print v(o8lin)
print v(o9lin)
print v(o10lin)
print v(o11lin)
print v(o12lin)
print v(o13lin)
print v(o14lin)
print v(o15lin)
print v(o16lin)
alter Vin1 DC 0.697582099246848
alter Vin2 DC 0.703506888206538
alter Vin3 DC 0.0626677721407845
alter Vin4 DC 0.721636554631369
alter Vin5 DC -0.58096525958454
alter Vin6 DC 0.47296954048449
alter Vin7 DC 0.314957329421309
alter Vin8 DC -0.258700594589067
alter Vin9 DC -0.956806069036936
alter Vin10 DC -0.261477460132429
alter Vin11 DC -0.274528273726773
alter Vin12 DC 0.00519733383760834
alter Vin13 DC -0.320023063452715
alter Vin14 DC 0.0226789400838276
alter Vin15 DC -0.150551170175648
alter Vin16 DC -0.522298464335814
op
print v(o1lin)
print v(o2lin)
print v(o3lin)
print v(o4lin)
print v(o5lin)
print v(o6lin)
print v(o7lin)
print v(o8lin)
print v(o9lin)
print v(o10lin)
print v(o11lin)
print v(o12lin)
print v(o13lin)
print v(o14lin)
print v(o15lin)
print v(o16lin)
alter Vin1 DC 0.969720117767562
alter Vin2 DC -0.0688558679463769
alter Vin3 DC 0.361158893713795
alter Vin4 DC 0.148957003272323
alter Vin5 DC 0.874309558706625
alter Vin6 DC 0.88243724177356
alter Vin7 DC 0.470404627768669
alter Vin8 DC 0.648649369018818
alter Vin9 DC -0.368889012433012
alter Vin10 DC 0.973408567332465
alter Vin11 DC 0.719689053242747
alter Vin12 DC -0.126479340620669
alter Vin13 DC 0.844109827979641
alter Vin14 DC 0.646353743480673
alter Vin15 DC -0.789890614200543
alter Vin16 DC -0.441159876378689
op
print v(o1lin)
print v(o2lin)
print v(o3lin)
print v(o4lin)
print v(o5lin)
print v(o6lin)
print v(o7lin)
print v(o8lin)
print v(o9lin)
print v(o10lin)
print v(o11lin)
print v(o12lin)
print v(o13lin)
print v(o14lin)
print v(o15lin)
print v(o16lin)
alter Vin1 DC -0.178176682192213
alter Vin2 DC 0.606834471441963
alter Vin3 DC 0.24651814662987
alter Vin4 DC 0.151160645359747
alter Vin5 DC 0.544881433824854
alter Vin6 DC -0.640431460314758
alter Vin7 DC 0.87818288692739
alter Vin8 DC -0.821279467963386
alter Vin9 DC 0.0265327326567903
alter Vin10 DC 0.206062938138194
alter Vin11 DC -0.781078279904025
alter Vin12 DC -0.992968876498198
alter Vin13 DC 0.501328410248888
alter Vin14 DC -0.194975474991937
alter Vin15 DC -0.646524578541201
alter Vin16 DC -0.702600942548315
op
print v(o1lin)
print v(o2lin)
print v(o3lin)
print v(o4lin)
print v(o5lin)
print v(o6lin)
print v(o7lin)
print v(o8lin)
print v(o9lin)
print v(o10lin)
print v(o11lin)
print v(o12lin)
print v(o13lin)
print v(o14lin)
print v(o15lin)
print v(o16lin)
alter Vin1 DC -0.454612166990748
alter Vin2 DC -0.957772823172446
alter Vin3 DC 0.215198077647149
alter Vin4 DC 0.515045742321581
alter Vin5 DC 0.842227195127188
alter Vin6 DC 0.18537180534857
alter Vin7 DC 0.603012125133378
alter Vin8 DC -0.329889240521066
alter Vin9 DC -0.0581146376236437
alter Vin10 DC 0.226450445795289
alter Vin11 DC 0.337429634983277
alter Vin12 DC 0.14996577315978
alter Vin13 DC -0.200199015489032
alter Vin14 DC -0.283004789264095
alter Vin15 DC 0.313061198774298
alter Vin16 DC 0.140841707180674
op
print v(o1lin)
print v(o2lin)
print v(o3lin)
print v(o4lin)
print v(o5lin)
print v(o6lin)
print v(o7lin)
print v(o8lin)
print v(o9lin)
print v(o10lin)
print v(o11lin)
print v(o12lin)
print v(o13lin)
print v(o14lin)
print v(o15lin)
print v(o16lin)
alter Vin1 DC 0.0448551309495191
alter Vin2 DC -0.524426997580122
alter Vin3 DC -0.605802052103143
alter Vin4 DC -0.210240773970239
alter Vin5 DC 0.831770840638942
alter Vin6 DC -0.850245197957977
alter Vin7 DC 0.563402975441066
alter Vin8 DC 0.617475592629917
alter Vin9 DC -0.300432710093494
alter Vin10 DC 0.466427605383626
alter Vin11 DC 0.355486418232088
alter Vin12 DC 0.346578755342608
alter Vin13 DC 0.603985190445687
alter Vin14 DC 0.682528783548757
alter Vin15 DC 0.280626017145419
alter Vin16 DC 0.754261083769534
op
print v(o1lin)
print v(o2lin)
print v(o3lin)
print v(o4lin)
print v(o5lin)
print v(o6lin)
print v(o7lin)
print v(o8lin)
print v(o9lin)
print v(o10lin)
print v(o11lin)
print v(o12lin)
print v(o13lin)
print v(o14lin)
print v(o15lin)
print v(o16lin)
alter Vin1 DC 0.811109440766841
alter Vin2 DC -0.369721942388224
alter Vin3 DC 0.232390718275878
alter Vin4 DC -0.035375940424196
alter Vin5 DC 0.573430596542918
alter Vin6 DC -0.978945547198472
alter Vin7 DC -0.173969191368985
alter Vin8 DC -0.854132040789167
alter Vin9 DC 0.906467911552255
alter Vin10 DC -0.56479349997363
alter Vin11 DC -0.121313918019413
alter Vin12 DC 0.433905388499429
alter Vin13 DC -0.883435226411189
alter Vin14 DC -0.40205808009512
alter Vin15 DC -0.821980447608816
alter Vin16 DC 0.318373758403904
op
print v(o1lin)
print v(o2lin)
print v(o3lin)
print v(o4lin)
print v(o5lin)
print v(o6lin)
print v(o7lin)
print v(o8lin)
print v(o9lin)
print v(o10lin)
print v(o11lin)
print v(o12lin)
print v(o13lin)
print v(o14lin)
print v(o15lin)
print v(o16lin)
alter Vin1 DC 0.989101531384208
alter Vin2 DC -0.223727450540307
alter Vin3 DC 0.314131419687807
alter Vin4 DC 0.627048741497774
alter Vin5 DC -0.708691291502564
alter Vin6 DC -0.914879042488359
alter Vin7 DC -0.486629932816746
alter Vin8 DC -0.854782713193951
alter Vin9 DC -0.0676626206337283
alter Vin10 DC 0.907163574334391
alter Vin11 DC 0.872916689641299
alter Vin12 DC 0.757754880573969
alter Vin13 DC -0.905410481000973
alter Vin14 DC -0.476681581988137
alter Vin15 DC 0.703470972653305
alter Vin16 DC -0.407724824174907
op
print v(o1lin)
print v(o2lin)
print v(o3lin)
print v(o4lin)
print v(o5lin)
print v(o6lin)
print v(o7lin)
print v(o8lin)
print v(o9lin)
print v(o10lin)
print v(o11lin)
print v(o12lin)
print v(o13lin)
print v(o14lin)
print v(o15lin)
print v(o16lin)
alter Vin1 DC 0.525229625017788
alter Vin2 DC 0.644791292664811
alter Vin3 DC 0.146413294256124
alter Vin4 DC 0.322379289780606
alter Vin5 DC -0.165349647558841
alter Vin6 DC -0.761282325299101
alter Vin7 DC -0.95368199643579
alter Vin8 DC -0.99806228730102
alter Vin9 DC 0.803080250734483
alter Vin10 DC 0.0311467035235893
alter Vin11 DC -0.996493525965273
alter Vin12 DC 0.572764809728096
alter Vin13 DC -0.0302315153271957
alter Vin14 DC -0.941091994943199
alter Vin15 DC 0.66668782349295
alter Vin16 DC -0.630867969889361
op
print v(o1lin)
print v(o2lin)
print v(o3lin)
print v(o4lin)
print v(o5lin)
print v(o6lin)
print v(o7lin)
print v(o8lin)
print v(o9lin)
print v(o10lin)
print v(o11lin)
print v(o12lin)
print v(o13lin)
print v(o14lin)
print v(o15lin)
print v(o16lin)
alter Vin1 DC 0.241126571892773
alter Vin2 DC 0.351922732650552
alter Vin3 DC 0.618641572938716
alter Vin4 DC -0.0432145068757026
alter Vin5 DC -0.543377263785828
alter Vin6 DC 0.193774255250767
alter Vin7 DC 0.0524553140012638
alter Vin8 DC 0.93784555936526
alter Vin9 DC 0.166624073027691
alter Vin10 DC 0.492421608313141
alter Vin11 DC 0.207182081705857
alter Vin12 DC 0.0860837882865844
alter Vin13 DC 0.449588201446202
alter Vin14 DC 0.791414286231209
alter Vin15 DC 0.270157461608006
alter Vin16 DC 0.0522954354499074
op
print v(o1lin)
print v(o2lin)
print v(o3lin)
print v(o4lin)
print v(o5lin)
print v(o6lin)
print v(o7lin)
print v(o8lin)
print v(o9lin)
print v(o10lin)
print v(o11lin)
print v(o12lin)
print v(o13lin)
print v(o14lin)
print v(o15lin)
print v(o16lin)
alter Vin1 DC 0.207638918826526
alter Vin2 DC 0.247746173861467
alter Vin3 DC -0.0708820681079936
alter Vin4 DC -0.672323886273823
alter Vin5 DC 0.560118222284554
alter Vin6 DC -0.447239504400762
alter Vin7 DC -0.364283544850807
alter Vin8 DC -0.222674628049924
alter Vin9 DC 0.686021843895396
alter Vin10 DC -0.274491212295516
alter Vin11 DC 0.367541091324131
alter Vin12 DC 0.318000744238493
alter Vin13 DC 0.295555782638408
alter Vin14 DC 0.365621823847745
alter Vin15 DC -0.262759993307509
alter Vin16 DC -0.616316064029572
op
print v(o1lin)
print v(o2lin)
print v(o3lin)
print v(o4lin)
print v(o5lin)
print v(o6lin)
print v(o7lin)
print v(o8lin)
print v(o9lin)
print v(o10lin)
print v(o11lin)
print v(o12lin)
print v(o13lin)
print v(o14lin)
print v(o15lin)
print v(o16lin)
alter Vin1 DC 0.93756232758382
alter Vin2 DC -0.0249976007851191
alter Vin3 DC -0.415339958617733
alter Vin4 DC 0.754343080307631
alter Vin5 DC 0.724719691008024
alter Vin6 DC -0.478991204329938
alter Vin7 DC -0.680503764725437
alter Vin8 DC -0.409393444842378
alter Vin9 DC -0.178082545870394
alter Vin10 DC -0.573208263375447
alter Vin11 DC 0.312597960369496
alter Vin12 DC -0.0433498706968471
alter Vin13 DC -0.397009314673435
alter Vin14 DC 0.0224518668150915
alter Vin15 DC -0.208397724154374
alter Vin16 DC 0.367932294172906
op
print v(o1lin)
print v(o2lin)
print v(o3lin)
print v(o4lin)
print v(o5lin)
print v(o6lin)
print v(o7lin)
print v(o8lin)
print v(o9lin)
print v(o10lin)
print v(o11lin)
print v(o12lin)
print v(o13lin)
print v(o14lin)
print v(o15lin)
print v(o16lin)
alter Vin1 DC -0.298713615045025
alter Vin2 DC 0.634484181256362
alter Vin3 DC 0.291892028177446
alter Vin4 DC -0.192194698690675
alter Vin5 DC -0.713482845448225
alter Vin6 DC 0.72233996490941
alter Vin7 DC -0.427435863408891
alter Vin8 DC -0.698225332357444
alter Vin9 DC 0.967190930169392
alter Vin10 DC 0.143881497477357
alter Vin11 DC -0.311626381743331
alter Vin12 DC 0.958750954233563
alter Vin13 DC 0.131862631701446
alter Vin14 DC -0.441053743774667
alter Vin15 DC -0.318996832050447
alter Vin16 DC 0.793181999396358
op
print v(o1lin)
print v(o2lin)
print v(o3lin)
print v(o4lin)
print v(o5lin)
print v(o6lin)
print v(o7lin)
print v(o8lin)
print v(o9lin)
print v(o10lin)
print v(o11lin)
print v(o12lin)
print v(o13lin)
print v(o14lin)
print v(o15lin)
print v(o16lin)
alter Vin1 DC -0.509514724761263
alter Vin2 DC 0.768427625522596
alter Vin3 DC -0.472694156765724
alter Vin4 DC 0.509426014771566
alter Vin5 DC -0.139920302419472
alter Vin6 DC -0.108479512378281
alter Vin7 DC 0.883768677600612
alter Vin8 DC 0.0179432453625292
alter Vin9 DC 0.756959162380701
alter Vin10 DC 0.0799648053489626
alter Vin11 DC -0.711876780097821
alter Vin12 DC -0.244058473367452
alter Vin13 DC 0.471552348975999
alter Vin14 DC 0.39107335468043
alter Vin15 DC 0.400923173656082
alter Vin16 DC -0.488653333851872
op
print v(o1lin)
print v(o2lin)
print v(o3lin)
print v(o4lin)
print v(o5lin)
print v(o6lin)
print v(o7lin)
print v(o8lin)
print v(o9lin)
print v(o10lin)
print v(o11lin)
print v(o12lin)
print v(o13lin)
print v(o14lin)
print v(o15lin)
print v(o16lin)
alter Vin1 DC 0.202742147076658
alter Vin2 DC 0.50028231959791
alter Vin3 DC 0.162692459719469
alter Vin4 DC 0.485788423153896
alter Vin5 DC -0.348233698427949
alter Vin6 DC 0.271914808290799
alter Vin7 DC -0.0376412674347857
alter Vin8 DC 0.558555559918488
alter Vin9 DC 0.905406149489045
alter Vin10 DC -0.3901698171679
alter Vin11 DC 0.813465652635289
alter Vin12 DC -0.395829962259306
alter Vin13 DC -0.648497389929514
alter Vin14 DC 0.225078105321613
alter Vin15 DC 0.432778820633166
alter Vin16 DC -0.714477085514031
op
print v(o1lin)
print v(o2lin)
print v(o3lin)
print v(o4lin)
print v(o5lin)
print v(o6lin)
print v(o7lin)
print v(o8lin)
print v(o9lin)
print v(o10lin)
print v(o11lin)
print v(o12lin)
print v(o13lin)
print v(o14lin)
print v(o15lin)
print v(o16lin)
alter Vin1 DC 0.0220305633963669
alter Vin2 DC 0.101501179134314
alter Vin3 DC 0.938277938410768
alter Vin4 DC 0.725447234580585
alter Vin5 DC -0.751447077527289
alter Vin6 DC -0.330988245114584
alter Vin7 DC 0.752931774207321
alter Vin8 DC -0.755597545715247
alter Vin9 DC -0.160981369945104
alter Vin10 DC -0.586193541575244
alter Vin11 DC 0.983916957472405
alter Vin12 DC -0.865293323300439
alter Vin13 DC -0.784091227476907
alter Vin14 DC -0.141032648795711
alter Vin15 DC 0.551956298194616
alter Vin16 DC -0.260569901142077
op
print v(o1lin)
print v(o2lin)
print v(o3lin)
print v(o4lin)
print v(o5lin)
print v(o6lin)
print v(o7lin)
print v(o8lin)
print v(o9lin)
print v(o10lin)
print v(o11lin)
print v(o12lin)
print v(o13lin)
print v(o14lin)
print v(o15lin)
print v(o16lin)
alter Vin1 DC 0.106175764745221
alter Vin2 DC -0.606978509649468
alter Vin3 DC -0.662077289741862
alter Vin4 DC 0.0372788414165643
alter Vin5 DC -0.334657664130343
alter Vin6 DC -0.527383266482695
alter Vin7 DC 0.651655467036549
alter Vin8 DC -0.496486940000237
alter Vin9 DC -0.414228211848161
alter Vin10 DC 0.84152208438024
alter Vin11 DC -0.222651790435098
alter Vin12 DC -0.664401389486084
alter Vin13 DC -0.943019109412111
alter Vin14 DC -0.000523519647687154
alter Vin15 DC 0.860751938063858
alter Vin16 DC 0.742188998589844
op
print v(o1lin)
print v(o2lin)
print v(o3lin)
print v(o4lin)
print v(o5lin)
print v(o6lin)
print v(o7lin)
print v(o8lin)
print v(o9lin)
print v(o10lin)
print v(o11lin)
print v(o12lin)
print v(o13lin)
print v(o14lin)
print v(o15lin)
print v(o16lin)
alter Vin1 DC -0.304819394079119
alter Vin2 DC -0.841382742150991
alter Vin3 DC 0.34615341802189
alter Vin4 DC -0.11624792247663
alter Vin5 DC 0.0996682289115558
alter Vin6 DC -0.982865968507694
alter Vin7 DC -0.765528440508616
alter Vin8 DC 0.83592803896873
alter Vin9 DC -0.0125442322059521
alter Vin10 DC -0.515590020403758
alter Vin11 DC 0.288320952890698
alter Vin12 DC 0.456595088382586
alter Vin13 DC 0.965082105530804
alter Vin14 DC -0.61965532794512
alter Vin15 DC -0.392264454892612
alter Vin16 DC -0.878382026043063
op
print v(o1lin)
print v(o2lin)
print v(o3lin)
print v(o4lin)
print v(o5lin)
print v(o6lin)
print v(o7lin)
print v(o8lin)
print v(o9lin)
print v(o10lin)
print v(o11lin)
print v(o12lin)
print v(o13lin)
print v(o14lin)
print v(o15lin)
print v(o16lin)
alter Vin1 DC -0.519397928235501
alter Vin2 DC -0.00454991855061504
alter Vin3 DC -0.769813128211644
alter Vin4 DC 0.528434204068419
alter Vin5 DC -0.775155694243881
alter Vin6 DC 0.0299576529346495
alter Vin7 DC -0.241116686824036
alter Vin8 DC -0.424738547592608
alter Vin9 DC -0.707859838607783
alter Vin10 DC 0.499394582683201
alter Vin11 DC -0.702448054055822
alter Vin12 DC -0.679540912897949
alter Vin13 DC -0.211699437260038
alter Vin14 DC 0.344979879479219
alter Vin15 DC -0.746858806278094
alter Vin16 DC 0.484091334990617
op
print v(o1lin)
print v(o2lin)
print v(o3lin)
print v(o4lin)
print v(o5lin)
print v(o6lin)
print v(o7lin)
print v(o8lin)
print v(o9lin)
print v(o10lin)
print v(o11lin)
print v(o12lin)
print v(o13lin)
print v(o14lin)
print v(o15lin)
print v(o16lin)
alter Vin1 DC 0.465818423761792
alter Vin2 DC -0.355120784491731
alter Vin3 DC 0.53111755683896
alter Vin4 DC 0.119079518038387
alter Vin5 DC 0.398286355739045
alter Vin6 DC -0.304745619759036
alter Vin7 DC 0.600649940780647
alter Vin8 DC 0.977576911710975
alter Vin9 DC 0.385179508950295
alter Vin10 DC -0.371032637340386
alter Vin11 DC 0.171121775846077
alter Vin12 DC 0.558255055290421
alter Vin13 DC -0.960323061977769
alter Vin14 DC 0.269050366409341
alter Vin15 DC 0.286833886303788
alter Vin16 DC -0.743360917111528
op
print v(o1lin)
print v(o2lin)
print v(o3lin)
print v(o4lin)
print v(o5lin)
print v(o6lin)
print v(o7lin)
print v(o8lin)
print v(o9lin)
print v(o10lin)
print v(o11lin)
print v(o12lin)
print v(o13lin)
print v(o14lin)
print v(o15lin)
print v(o16lin)
alter Vin1 DC 0.628539626430782
alter Vin2 DC 0.742638152639209
alter Vin3 DC -0.0450727336204513
alter Vin4 DC 0.314512946044637
alter Vin5 DC 0.176482959875566
alter Vin6 DC 0.28847707214137
alter Vin7 DC -0.715079895456147
alter Vin8 DC 0.205224503555972
alter Vin9 DC 0.685498630749846
alter Vin10 DC 0.741397448809869
alter Vin11 DC -0.157338250218745
alter Vin12 DC -0.78828061782925
alter Vin13 DC -0.730589065985733
alter Vin14 DC -0.739323467344887
alter Vin15 DC 0.274510450625638
alter Vin16 DC 0.299281933452443
op
print v(o1lin)
print v(o2lin)
print v(o3lin)
print v(o4lin)
print v(o5lin)
print v(o6lin)
print v(o7lin)
print v(o8lin)
print v(o9lin)
print v(o10lin)
print v(o11lin)
print v(o12lin)
print v(o13lin)
print v(o14lin)
print v(o15lin)
print v(o16lin)
alter Vin1 DC -0.746936274543551
alter Vin2 DC -0.815314078924804
alter Vin3 DC -0.585111352274115
alter Vin4 DC 0.521554725029419
alter Vin5 DC -0.776860636989009
alter Vin6 DC 0.785560343022689
alter Vin7 DC 0.449806447083261
alter Vin8 DC -0.283312878389276
alter Vin9 DC 0.981221917932191
alter Vin10 DC 0.933496467695242
alter Vin11 DC -0.0263306864066226
alter Vin12 DC 0.44941930798886
alter Vin13 DC 0.669868394442397
alter Vin14 DC -0.498597000349495
alter Vin15 DC -0.554269003769571
alter Vin16 DC 0.583326082506922
op
print v(o1lin)
print v(o2lin)
print v(o3lin)
print v(o4lin)
print v(o5lin)
print v(o6lin)
print v(o7lin)
print v(o8lin)
print v(o9lin)
print v(o10lin)
print v(o11lin)
print v(o12lin)
print v(o13lin)
print v(o14lin)
print v(o15lin)
print v(o16lin)
alter Vin1 DC -0.0960987157602182
alter Vin2 DC -0.142046819643391
alter Vin3 DC 0.199447640266098
alter Vin4 DC -0.408134578990929
alter Vin5 DC -0.45897120894642
alter Vin6 DC 0.708207973138302
alter Vin7 DC 0.980010434144708
alter Vin8 DC -0.319655955474761
alter Vin9 DC 0.151453838512594
alter Vin10 DC -0.556866021990551
alter Vin11 DC -0.362939969467471
alter Vin12 DC 0.0783436342883661
alter Vin13 DC -0.367735717901507
alter Vin14 DC 0.220201359425539
alter Vin15 DC 0.886917897912617
alter Vin16 DC -0.89364130954225
op
print v(o1lin)
print v(o2lin)
print v(o3lin)
print v(o4lin)
print v(o5lin)
print v(o6lin)
print v(o7lin)
print v(o8lin)
print v(o9lin)
print v(o10lin)
print v(o11lin)
print v(o12lin)
print v(o13lin)
print v(o14lin)
print v(o15lin)
print v(o16lin)
alter Vin1 DC -0.37427789781944
alter Vin2 DC 0.0779153347735002
alter Vin3 DC 0.497052142382582
alter Vin4 DC -0.0868619163913968
alter Vin5 DC -0.735964036442503
alter Vin6 DC 0.617173822657697
alter Vin7 DC 0.670676108956427
alter Vin8 DC 0.098277887324101
alter Vin9 DC -0.795197657792907
alter Vin10 DC 0.552821801624367
alter Vin11 DC -0.439114996082939
alter Vin12 DC -0.309542910552894
alter Vin13 DC 0.430951668499667
alter Vin14 DC -0.122656949818681
alter Vin15 DC 0.00280420797061232
alter Vin16 DC 0.733998073975531
op
print v(o1lin)
print v(o2lin)
print v(o3lin)
print v(o4lin)
print v(o5lin)
print v(o6lin)
print v(o7lin)
print v(o8lin)
print v(o9lin)
print v(o10lin)
print v(o11lin)
print v(o12lin)
print v(o13lin)
print v(o14lin)
print v(o15lin)
print v(o16lin)
alter Vin1 DC -0.456180728848085
alter Vin2 DC 0.825594922760391
alter Vin3 DC -0.881707150876417
alter Vin4 DC -0.212706488584025
alter Vin5 DC -0.629526199895362
alter Vin6 DC -0.252992473542526
alter Vin7 DC 0.47987806884808
alter Vin8 DC -0.677182043960485
alter Vin9 DC 0.290584241002003
alter Vin10 DC 0.271014971015881
alter Vin11 DC -0.441358635394155
alter Vin12 DC -0.0297693636541956
alter Vin13 DC 0.18278300120729
alter Vin14 DC -0.251337248742715
alter Vin15 DC -0.796276024007498
alter Vin16 DC 0.63887836176303
op
print v(o1lin)
print v(o2lin)
print v(o3lin)
print v(o4lin)
print v(o5lin)
print v(o6lin)
print v(o7lin)
print v(o8lin)
print v(o9lin)
print v(o10lin)
print v(o11lin)
print v(o12lin)
print v(o13lin)
print v(o14lin)
print v(o15lin)
print v(o16lin)
alter Vin1 DC 0.152875655458815
alter Vin2 DC -0.162064729263905
alter Vin3 DC 0.764596904296594
alter Vin4 DC -0.626502139472495
alter Vin5 DC 0.450065213548301
alter Vin6 DC -0.0485838747304337
alter Vin7 DC -0.526125499380451
alter Vin8 DC -0.931994385728434
alter Vin9 DC 0.0931924650820906
alter Vin10 DC -0.181025685332339
alter Vin11 DC 0.172736214171088
alter Vin12 DC 0.399036356621722
alter Vin13 DC -0.902041465173391
alter Vin14 DC -0.156854076561682
alter Vin15 DC 0.205048054745725
alter Vin16 DC 0.195833634537256
op
print v(o1lin)
print v(o2lin)
print v(o3lin)
print v(o4lin)
print v(o5lin)
print v(o6lin)
print v(o7lin)
print v(o8lin)
print v(o9lin)
print v(o10lin)
print v(o11lin)
print v(o12lin)
print v(o13lin)
print v(o14lin)
print v(o15lin)
print v(o16lin)
alter Vin1 DC 0.548107882807999
alter Vin2 DC -0.359099765699305
alter Vin3 DC -0.0814436334122941
alter Vin4 DC 0.389509234053137
alter Vin5 DC 0.404744733312565
alter Vin6 DC -0.866604637081141
alter Vin7 DC -0.0094342903587874
alter Vin8 DC -0.368513865167459
alter Vin9 DC 0.0612003377865014
alter Vin10 DC -0.362188016964488
alter Vin11 DC 0.85004409112971
alter Vin12 DC 0.849180365992721
alter Vin13 DC -0.407731936448977
alter Vin14 DC -0.904713737073052
alter Vin15 DC 0.199027416621327
alter Vin16 DC -0.0321276074523107
op
print v(o1lin)
print v(o2lin)
print v(o3lin)
print v(o4lin)
print v(o5lin)
print v(o6lin)
print v(o7lin)
print v(o8lin)
print v(o9lin)
print v(o10lin)
print v(o11lin)
print v(o12lin)
print v(o13lin)
print v(o14lin)
print v(o15lin)
print v(o16lin)
alter Vin1 DC -0.872625945947281
alter Vin2 DC -0.292916514876445
alter Vin3 DC -0.258320749648818
alter Vin4 DC -0.957529809044733
alter Vin5 DC -0.805784663688048
alter Vin6 DC -0.100333638346312
alter Vin7 DC 0.989669914443136
alter Vin8 DC 0.675762437931675
alter Vin9 DC 0.228150497862181
alter Vin10 DC 0.824043468575066
alter Vin11 DC 0.207950149117681
alter Vin12 DC 0.611393256464383
alter Vin13 DC -0.0466233963688369
alter Vin14 DC -0.585731908120707
alter Vin15 DC -0.893048487140536
alter Vin16 DC -0.411236963029905
op
print v(o1lin)
print v(o2lin)
print v(o3lin)
print v(o4lin)
print v(o5lin)
print v(o6lin)
print v(o7lin)
print v(o8lin)
print v(o9lin)
print v(o10lin)
print v(o11lin)
print v(o12lin)
print v(o13lin)
print v(o14lin)
print v(o15lin)
print v(o16lin)
alter Vin1 DC -0.776387976849552
alter Vin2 DC -0.121844321792997
alter Vin3 DC 0.94809212597166
alter Vin4 DC -0.109902197754286
alter Vin5 DC 0.567240347497347
alter Vin6 DC 0.422111354130629
alter Vin7 DC 0.04842404937567
alter Vin8 DC -0.851259350416096
alter Vin9 DC 0.377152224948503
alter Vin10 DC 0.730827361904131
alter Vin11 DC -0.921414792003353
alter Vin12 DC -0.657578649190621
alter Vin13 DC -0.308858905131998
alter Vin14 DC -0.684063317475975
alter Vin15 DC 0.45841459103231
alter Vin16 DC -0.585382864971662
op
print v(o1lin)
print v(o2lin)
print v(o3lin)
print v(o4lin)
print v(o5lin)
print v(o6lin)
print v(o7lin)
print v(o8lin)
print v(o9lin)
print v(o10lin)
print v(o11lin)
print v(o12lin)
print v(o13lin)
print v(o14lin)
print v(o15lin)
print v(o16lin)
alter Vin1 DC -0.356965586596369
alter Vin2 DC -0.247138675313609
alter Vin3 DC 0.301916567714139
alter Vin4 DC 0.28240025280647
alter Vin5 DC -0.711629303289659
alter Vin6 DC -0.68082277842392
alter Vin7 DC 0.245053855545164
alter Vin8 DC -0.693381937587164
alter Vin9 DC -0.011227490733668
alter Vin10 DC 0.844237750607192
alter Vin11 DC 0.0468995276105275
alter Vin12 DC 0.257122567605428
alter Vin13 DC 0.363071145517366
alter Vin14 DC -0.907712404492938
alter Vin15 DC 0.38060515288418
alter Vin16 DC -0.842232322499995
op
print v(o1lin)
print v(o2lin)
print v(o3lin)
print v(o4lin)
print v(o5lin)
print v(o6lin)
print v(o7lin)
print v(o8lin)
print v(o9lin)
print v(o10lin)
print v(o11lin)
print v(o12lin)
print v(o13lin)
print v(o14lin)
print v(o15lin)
print v(o16lin)
.endc

.end
