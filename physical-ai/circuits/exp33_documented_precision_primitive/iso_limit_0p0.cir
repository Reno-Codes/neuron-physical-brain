* Experiment 33 isolated invert kind=limit Vin=0 Rload=4914.01
Vin in 0 DC 0
R1 in mid 10000
R2 out mid 10000
Rload out 0 4914.01304862554
.model limiso limit(gain=1e5 in_offset=0 out_lower_limit=-15 out_upper_limit=15 fraction=false limit_range=0.05)
Ainv %vd(0 mid) out limiso
.control
set numdgt=15
op
print i(Rload)
print v(out)
print v(mid)
print v(in)
.endc
.end
