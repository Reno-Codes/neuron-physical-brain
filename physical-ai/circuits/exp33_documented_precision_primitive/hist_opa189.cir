* Experiment 33 isolated invert kind=opa189 Vin=0 Rload=4914.01
Vin in 0 PWL(0 0 0.0002 0 0.000201 2.60817586522917 0.0004 2.60817586522917 0.000401 1 0.0006 1 0.000601 0 0.0008 0)
R1 in mid 10000
R2 out mid 10000
Rload out 0 4914.01304862554
.include "C:/dev/neuron-physical-brain/physical-ai/models/vendor/ti/opa189/OPAx189.LIB"
Vdd vdd 0 DC 15
Vss vss 0 DC -15
Xinv 0 mid vdd vss out OPAx189
Ccl out 0 1p
.control
set numdgt=15
tran 2e-06 0.0008
meas tran vs0 find v(out) at=0.0002
print vs0
meas tran vs1 find v(out) at=0.0004
print vs1
meas tran vs2 find v(out) at=0.0006
print vs2
meas tran vs3 find v(out) at=0.0008
print vs3
.endc
.end
