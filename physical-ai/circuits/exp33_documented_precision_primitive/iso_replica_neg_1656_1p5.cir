* Experiment 33 isolated invert kind=replica_neg_1656 Vin=1.5 Rload=4914.01
Vin in 0 DC 1.5
R1 in mid 10000
R2 out mid 10000
Rload out 0 4914.01304862554
.include "C:/ngspice/examples/optran/models/opa1656.lib"
Vdd vdd 0 DC 15
Vss vss 0 DC -15
Rra 0 rmid 10000
Rrb rout rmid 10000
Xrep 0 rmid vdd vss rout OPA1656
Crc rout 0 1p
Rrl rout 0 4914.01304862554
Eref inp 0 rmid 0 -1
Xinv inp mid vdd vss out OPA1656
Ccl out 0 1p
.control
set numdgt=15
op
print i(Rload)
print v(rmid)
print v(inp)
print i(Vdd)
print v(out)
print v(mid)
print v(in)
.endc
.end
