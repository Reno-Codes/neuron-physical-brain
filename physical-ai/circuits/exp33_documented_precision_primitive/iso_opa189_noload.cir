* Experiment 33 isolated invert kind=opa189 Vin=2.60818 Rload=1e+09
Vin in 0 DC 2.60817586522917
R1 in mid 10000
R2 out mid 10000
Rload out 0 1000000000
.include "C:/dev/neuron-physical-brain/physical-ai/models/vendor/ti/opa189/OPAx189.LIB"
Vdd vdd 0 DC 15
Vss vss 0 DC -15
Xinv 0 mid vdd vss out OPAx189
Ccl out 0 1p
.control
set numdgt=15
op
print i(Rload)
print i(Vdd)
print v(out)
print v(mid)
print v(in)
.endc
.end
