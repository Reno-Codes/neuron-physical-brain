* Experiment 22 isolated TIA neuron n1
* frozen n=32 L1=6.7601697 b=0.0322130531942455
* A=100000 vos=0 Ileak=0 Rout=0 fp=0 invertA=1e+07
* Behavioral TIA. Not transistor-level. Weights were not edited.
* shape: 32 -> 1 (linear Vlin vs z unless ReLU requested)

* Experiment 26 MOS primitive. Models included, not copied.
.include "C:/ngspice/examples/xspice/see/CMOSOpAmp/modelcard.nmos"
.include "C:/ngspice/examples/xspice/see/CMOSOpAmp/modelcard.pmos"

.subckt NCH D G S B W=1u L=1.4u m=1
MN1 D G S B N1 W={W} L={L} M={m} AS={3*L*W} AD={3*L*W} PS={6*L+W} PD={6*L+W}
.ends NCH

.subckt PCH D G S B W=1u L=1.4u m=1
MP1 D G S B P1 W={W} L={L} M={m} AS={3*L*W} AD={3*L*W} PS={6*L+W} PD={6*L+W}
.ends PCH

* Two-stage Miller CMOS OTA. Topology from ngspice CMOS-OP1, dual supply.
* Bodies to rails. Analog ground is node 0.
.subckt miller_tia inp inn out vdd vss
.param L=1.4u WD=2.8u WT=5.0u WL=2.8u
+ WOP=14.5u WON=17.4u WDI=5.0u
+ MD=2 MT=2 MO=4 CC=2p IBIAS=40u DW=0 L1=1.4u
Ibias vdd vb {IBIAS}
Xdiode vb vb vss vss NCH W={WDI} L={L} m={MT}
Xtail vs vb vss vss NCH W={WT} L={L} m={MT}
* Diode load on IN- drain (CMOS-OP1 polarity). DW unbalances the pair.
Xdp dplus inp vs vss NCH W={WD*(1+DW)} L={L1} m={MD}
Xdn dmin inn vs vss NCH W={WD*(1-DW)} L={L1} m={MD}
Xln dmin dmin vdd vdd PCH W={WL} L={L1} m={MD}
Xlp dplus dmin vdd vdd PCH W={WL} L={L1} m={MD}
Xop out dplus vdd vdd PCH W={WOP} L={L} m={MO}
Xon out vb vss vss NCH W={WON} L={L} m={MO}
Cc dplus out {CC}
.ends miller_tia

* Telescopic-cascode first stage + Miller CS. Higher DC gain for o2 load.
.subckt miller_cascode inp inn out vdd vss
.param L=1.4u WD=2.8u WT=5.0u WL=2.8u
+ WOP=14.5u WON=17.4u WDI=5.0u WC=2.8u
+ MD=2 MT=2 MO=4 CC=2p IBIAS=40u DW=0
Ibias vdd vb {IBIAS}
Xdiode vb vb vss vss NCH W={WDI} L={L} m={MT}
Xstack vcn vcn vb vss NCH W={WDI} L={L} m={MT}
Xtail vs vb vss vss NCH W={WT} L={L} m={MT}
Xdp splus inp vs vss NCH W={WD*(1+DW)} L={L} m={MD}
Xdn smin inn vs vss NCH W={WD*(1-DW)} L={L} m={MD}
Xcn dplus vcn splus vss NCH W={WC} L={L} m={MD}
Xcm dmin vcn smin vss NCH W={WC} L={L} m={MD}
Xln dmin dmin vdd vdd PCH W={WL} L={L} m={MD}
Xlp dplus dmin vdd vdd PCH W={WL} L={L} m={MD}
Xop out dplus vdd vdd PCH W={WOP} L={L} m={MO}
Xon out vb vss vss NCH W={WON} L={L} m={MO}
Cc dplus out {CC}
.ends miller_cascode

* 5-transistor OTA used as a slow integrator (capacitive load).
.subckt servo_ota inp inn out vdd vss
.param L=1.4u WD=2.8u WT=5.0u WL=2.8u
+ MD=1 MT=1 IBIAS=2u DW=0
Ibias vdd vb {IBIAS}
Xdiode vb vb vss vss NCH W={WT} L={L} m={MT}
Xtail vs vb vss vss NCH W={WT} L={L} m={MT}
Xdp dplus inp vs vss NCH W={WD*(1+DW)} L={L} m={MD}
Xdn dmin inn vs vss NCH W={WD*(1-DW)} L={L} m={MD}
Xlp dplus dplus vdd vdd PCH W={WL} L={L} m={MD}
Xln out dplus vdd vdd PCH W={WL} L={L} m={MD}
.ends servo_ota

* Experiment 26 device TIA  VDD=2.5 VSS=-2.5
* Ibias=4e-05 m_diff=2 m_out=4 Cc=2e-12
* servo=True vos_inject=0.000214 dw_frac=0.00185
* Weights were not edited. SPICE is not Python-corrected.
Vdd vdd 0 DC 2.5
Vss vss 0 DC -2.5
.temp 85
.options reltol=1e-6 abstol=1e-12 vntol=1e-8

Vin1 in1 0 PULSE(0 0.336281146288125 0.000202 10n 10n 1 2)
Vin2 in2 0 PULSE(0 0 0.000202 10n 10n 1 2)
* passive invert in2 -> in2n: R2/R1=1.0000002 closed-loop -1 at A=1e+07
Rinv2ia in2 inv2m 10012.4671654417
Rinv2ib in2n inv2m 10006.5778447357
Einv2amp in2n 0 0 inv2m 10000000
Vin3 in3 0 PULSE(0 0 0.000202 10n 10n 1 2)
* passive invert in3 -> in3n: R2/R1=1.0000002 closed-loop -1 at A=1e+07
Rinv3ia in3 inv3m 9990.68427557588
Rinv3ib in3n inv3m 10002.5684764174
Einv3amp in3n 0 0 inv3m 10000000
Vin4 in4 0 PULSE(0 0 0.000202 10n 10n 1 2)
Vin5 in5 0 PULSE(0 0 0.000202 10n 10n 1 2)
* passive invert in5 -> in5n: R2/R1=1.0000002 closed-loop -1 at A=1e+07
Rinv5ia in5 inv5m 9998.49503723459
Rinv5ib in5n inv5m 9994.74738273202
Einv5amp in5n 0 0 inv5m 10000000
Vin6 in6 0 PULSE(0 0.777243957364389 0.000202 10n 10n 1 2)
* passive invert in6 -> in6n: R2/R1=1.0000002 closed-loop -1 at A=1e+07
Rinv6ia in6 inv6m 9999.97775568407
Rinv6ib in6n inv6m 10011.6821568382
Einv6amp in6n 0 0 inv6m 10000000
Vin7 in7 0 PULSE(0 0 0.000202 10n 10n 1 2)
Vin8 in8 0 PULSE(0 0.0705982519785909 0.000202 10n 10n 1 2)
Vin9 in9 0 PULSE(0 0.361068022357012 0.000202 10n 10n 1 2)
* passive invert in9 -> in9n: R2/R1=1.0000002 closed-loop -1 at A=1e+07
Rinv9ia in9 inv9m 9989.24235070006
Rinv9ib in9n inv9m 10001.0006645974
Einv9amp in9n 0 0 inv9m 10000000
Vin10 in10 0 PULSE(0 0 0.000202 10n 10n 1 2)
* passive invert in10 -> in10n: R2/R1=1.0000002 closed-loop -1 at A=1e+07
Rinv10ia in10 inv10m 9991.1084155008
Rinv10ib in10n inv10m 9993.49201819003
Einv10amp in10n 0 0 inv10m 10000000
Vin11 in11 0 PULSE(0 1.1565823149901 0.000202 10n 10n 1 2)
Vin12 in12 0 PULSE(0 0 0.000202 10n 10n 1 2)
Vin13 in13 0 PULSE(0 0 0.000202 10n 10n 1 2)
Vin14 in14 0 PULSE(0 0 0.000202 10n 10n 1 2)
* passive invert in14 -> in14n: R2/R1=1.0000002 closed-loop -1 at A=1e+07
Rinv14ia in14 inv14m 9993.3509689748
Rinv14ib in14n inv14m 9991.49493378913
Einv14amp in14n 0 0 inv14m 10000000
Vin15 in15 0 PULSE(0 0.0416289190497384 0.000202 10n 10n 1 2)
Vin16 in16 0 PULSE(0 0.436458566192918 0.000202 10n 10n 1 2)
* load-compensated divider in16->tap16: G_load=0.000666445780473128 Ra=599479.450040294 Rb=1000 target beta=0.001 (no tap buffer)
Rdiv16a in16 tap16 600040.543443203
Rdiv16b tap16 0 999.508850828198
Vin17 in17 0 PULSE(0 0.366244026736095 0.000202 10n 10n 1 2)
* passive invert in17 -> in17n: R2/R1=1.0000002 closed-loop -1 at A=1e+07
Rinv17ia in17 inv17m 10007.141308621
Rinv17ib in17n inv17m 10007.4260006233
Einv17amp in17n 0 0 inv17m 10000000
* load-compensated divider in17n->tap17n: G_load=0.000266255881165782 Ra=788940.067216326 Rb=1000 target beta=0.001 (no tap buffer)
Rdiv17na in17n tap17n 788036.408318495
Rdiv17nb tap17n 0 999.840743914289
Vin18 in18 0 PULSE(0 1.52626596704316 0.000202 10n 10n 1 2)
Vin19 in19 0 PULSE(0 1.7315038027247 0.000202 10n 10n 1 2)
* passive invert in19 -> in19n: R2/R1=1.0000002 closed-loop -1 at A=1e+07
Rinv19ia in19 inv19m 10007.9711288825
Rinv19ib in19n inv19m 9996.9997130583
Einv19amp in19n 0 0 inv19m 10000000
Vin20 in20 0 PULSE(0 0 0.000202 10n 10n 1 2)
* load-compensated divider in20->tap20: G_load=0.000971610549965604 Ra=506692.358700063 Rb=1000 target beta=0.001 (no tap buffer)
Rdiv20a in20 tap20 507175.738915063
Rdiv20b tap20 0 999.624410755895
Vin21 in21 0 PULSE(0 0.518920693033615 0.000202 10n 10n 1 2)
Vin22 in22 0 PULSE(0 2.14599413442392 0.000202 10n 10n 1 2)
* passive invert in22 -> in22n: R2/R1=1.0000002 closed-loop -1 at A=1e+07
Rinv22ia in22 inv22m 10012.0178836122
Rinv22ib in22n inv22m 9993.24869098754
Einv22amp in22n 0 0 inv22m 10000000
Vin23 in23 0 PULSE(0 1.20942836359533 0.000202 10n 10n 1 2)
* passive invert in23 -> in23n: R2/R1=1.0000002 closed-loop -1 at A=1e+07
Rinv23ia in23 inv23m 10011.0559129701
Rinv23ib in23n inv23m 9987.77690826746
Einv23amp in23n 0 0 inv23m 10000000
Vin24 in24 0 PULSE(0 0 0.000202 10n 10n 1 2)
* load-compensated divider in24->tap24: G_load=0.000881349510863982 Ra=531001.812385847 Rb=1000 target beta=0.001 (no tap buffer)
Rdiv24a in24 tap24 530404.722128959
Rdiv24b tap24 0 1000.00724933674
Vin25 in25 0 PULSE(0 0 0.000202 10n 10n 1 2)
* passive invert in25 -> in25n: R2/R1=1.0000002 closed-loop -1 at A=1e+07
Rinv25ia in25 inv25m 10007.4162259322
Rinv25ib in25n inv25m 9996.35164402534
Einv25amp in25n 0 0 inv25m 10000000
Vin26 in26 0 PULSE(0 0.119125138158868 0.000202 10n 10n 1 2)
Vin27 in27 0 PULSE(0 0 0.000202 10n 10n 1 2)
* passive invert in27 -> in27n: R2/R1=1.0000002 closed-loop -1 at A=1e+07
Rinv27ia in27 inv27m 9999.92962576295
Rinv27ib in27n inv27m 9988.61357618505
Einv27amp in27n 0 0 inv27m 10000000
Vin28 in28 0 PULSE(0 0.1550269134803 0.000202 10n 10n 1 2)
* passive invert in28 -> in28n: R2/R1=1.0000002 closed-loop -1 at A=1e+07
Rinv28ia in28 inv28m 9990.41127412254
Rinv28ib in28n inv28m 10002.029986463
Einv28amp in28n 0 0 inv28m 10000000
Vin29 in29 0 PULSE(0 1.87754084678094 0.000202 10n 10n 1 2)
* passive invert in29 -> in29n: R2/R1=1.0000002 closed-loop -1 at A=1e+07
Rinv29ia in29 inv29m 10006.2382874741
Rinv29ib in29n inv29m 9993.13503978492
Einv29amp in29n 0 0 inv29m 10000000
* load-compensated divider in29n->tap29n: G_load=0.000275989040257845 Ra=782922.085128668 Rb=1000 target beta=0.001 (no tap buffer)
Rdiv29na in29n tap29n 783632.92414571
Rdiv29nb tap29n 0 1001.12280098593
Vin30 in30 0 PULSE(0 0.223511482191497 0.000202 10n 10n 1 2)
Vin31 in31 0 PULSE(0 0 0.000202 10n 10n 1 2)
Vin32 in32 0 PULSE(0 0 0.000202 10n 10n 1 2)
* passive invert in32 -> in32n: R2/R1=1.0000002 closed-loop -1 at A=1e+07
Rinv32ia in32 inv32m 10006.6898767879
Rinv32ib in32n inv32m 9999.37537101656
Einv32amp in32n 0 0 inv32m 10000000
Vref vref 0 PULSE(0 1 0.000202 10n 10n 1 2)
* passive invert vref -> vrefn: R2/R1=1.0000002 closed-loop -1 at A=1e+07
Rinvrefia vref invrefm 9989.89239905512
Rinvrefib vrefn invrefm 10012.4330401764
Einvrefamp vrefn 0 0 invrefm 10000000
* load-compensated divider vrefn->taprefn: G_load=0.000966391595827364 Ra=508037.159088685 Rb=1000 target beta=0.001 (no tap buffer)
Rdivrefna vrefn taprefn 507830.659089838
Rdivrefnb taprefn 0 999.312363878831

* n1 input 1 w=-0.195521390350609 w-  bank=n alpha=1 R=170484.330505015 G_phys=5.86564171051827e-06 G_eff=5.86564171051827e-06
Rn1n1n1 in1 n1p 170669.508657437
* n1 input 2 w=+0.386445174905558 w+  bank=n alpha=1 R=86256.3061926689 G_phys=1.15933552471668e-05 G_eff=1.15933552471668e-05
Rn1p2n1 in2n n1p 86334.8537705059
* n1 input 3 w=+0.296294588630229 w+  bank=n alpha=1 R=112500.648383197 G_phys=8.88883765890688e-06 G_eff=8.88883765890688e-06
Rn1p3n1 in3n n1p 112615.674310949
* n1 input 4 w=-0.299308681857295 w-  bank=n alpha=1 R=111367.746256108 G_phys=8.97926045571886e-06 G_eff=8.97926045571886e-06
Rn1n4n1 in4 n1p 111340.122620623
* n1 input 5 w=+0.732671792857329 w+  bank=n alpha=1 R=45495.5870531571 G_phys=2.19801537857199e-05 G_eff=2.19801537857199e-05
Rn1p5n1 in5n n1p 45514.2773198785
* n1 input 6 w=+0.124925987288217 w+  bank=n alpha=1 R=266824.65399637 G_phys=3.7477796186465e-06 G_eff=3.7477796186465e-06
Rn1p6n1 in6n n1p 266550.424427709
* n1 input 7 w=-0.0857938493267301 w-  bank=n alpha=1 R=388528.240601368 G_phys=2.5738154798019e-06 G_eff=2.5738154798019e-06
Rn1n7n1 in7 n1p 388268.874774066
* n1 input 8 w=-0.0609936542707342 w-  bank=n alpha=1 R=546504.939438057 G_phys=1.82980962812202e-06 G_eff=1.82980962812202e-06
Rn1n8n1 in8 n1p 545843.875520112
* n1 input 9 w=+0.256981204903229 w+  bank=n alpha=1 R=129711.172246568 G_phys=7.70943614709688e-06 G_eff=7.70943614709688e-06
Rn1p9n1 in9n n1p 129617.077928032
* n1 input 10 w=+0.073638013162671 w+  bank=n alpha=1 R=452664.756987643 G_phys=2.20914039488013e-06 G_eff=2.20914039488013e-06
Rn1p10n1 in10n n1p 452443.520251236
* n1 input 11 w=-0.149208279345328 w-  bank=n alpha=1 R=223401.365390634 G_phys=4.47624838035983e-06 G_eff=4.47624838035983e-06
Rn1n11n1 in11 n1p 223212.450319606
* n1 input 12 w=-0.475362564845884 w-  bank=n alpha=1 R=70121.9149306388 G_phys=1.42608769453765e-05 G_eff=1.42608769453765e-05
Rn1n12n1 in12 n1p 70157.4945554056
* n1 input 13 w=-0.0533811781970356 w-  bank=n alpha=1 R=624439.820535554 G_phys=1.60143534591107e-06 G_eff=1.60143534591107e-06
Rn1n13n1 in13 n1p 623711.832624691
* n1 input 14 w=+0.279456004632752 w+  bank=n alpha=1 R=119279.359830319 G_phys=8.38368013898257e-06 G_eff=8.38368013898257e-06
Rn1p14n1 in14n n1p 119397.854796189
* n1 input 15 w=-0.0744870090943736 w-  bank=n alpha=1 R=447505.326614748 G_phys=2.23461027283121e-06 G_eff=2.23461027283121e-06
Rn1n15n1 in15 n1p 447509.415274342
* n1 input 16 w=-0.0222148593491043 w-  bank=f alpha=0.001 R=1500.49715865869 G_phys=0.000666445780473128 G_eff=6.66445780473128e-07
Rn1n16f1 tap16 n1p 1501.30758032981
* n1 input 17 w=+0.0088751960388594 w+  bank=f alpha=0.001 R=3755.78558348297 G_phys=0.000266255881165782 G_eff=2.66255881165782e-07
Rn1p17f1 tap17n n1p 3751.52629486806
* n1 input 18 w=-0.194172060066752 w-  bank=n alpha=1 R=171669.051262443 G_phys=5.82516180200256e-06 G_eff=5.82516180200256e-06
Rn1n18n1 in18 n1p 171550.005172582
* n1 input 19 w=+0.341327626188232 w+  bank=n alpha=1 R=97657.8828546125 G_phys=1.0239828785647e-05 G_eff=1.0239828785647e-05
Rn1p19n1 in19n n1p 97615.9786587447
* n1 input 20 w=-0.0323870183321868 w-  bank=f alpha=0.001 R=1029.21896024637 G_phys=0.000971610549965604 G_eff=9.71610549965604e-07
Rn1n20f1 tap20 n1p 1028.53174024801
* n1 input 21 w=-0.0999542141187652 w-  bank=n alpha=1 R=333486.022847689 G_phys=2.99862642356296e-06 G_eff=2.99862642356296e-06
Rn1n21n1 in21 n1p 333485.475633035
* n1 input 22 w=+0.693789300406694 w+  bank=n alpha=1 R=48045.3263170729 G_phys=2.08136790122008e-05 G_eff=2.08136790122008e-05
Rn1p22n1 in22n n1p 48041.6057236294
* n1 input 23 w=+0.0972685864670828 w+  bank=n alpha=1 R=342693.715864925 G_phys=2.91805759401248e-06 G_eff=2.91805759401248e-06
Rn1p23n1 in23n n1p 342574.594747493
* n1 input 24 w=-0.0293783170287994 w-  bank=f alpha=0.001 R=1134.6236512002 G_phys=0.000881349510863982 G_eff=8.81349510863982e-07
Rn1n24f1 tap24 n1p 1135.87772645892
* n1 input 25 w=+0.0497492024826392 w+  bank=n alpha=1 R=670027.491294269 G_phys=1.49247607447918e-06 G_eff=1.49247607447918e-06
Rn1p25n1 in25n n1p 669700.63610812
* n1 input 26 w=-0.466063512962686 w-  bank=n alpha=1 R=71521.0103477937 G_phys=1.39819053888806e-05 G_eff=1.39819053888806e-05
Rn1n26n1 in26 n1p 71487.4447972225
* n1 input 27 w=+0.194887582685885 w+  bank=n alpha=1 R=171038.774630702 G_phys=5.84662748057655e-06 G_eff=5.84662748057655e-06
Rn1p27n1 in27n n1p 171187.681993289
* n1 input 28 w=+0.209047565197081 w+  bank=n alpha=1 R=159453.344036359 G_phys=6.27142695591242e-06 G_eff=6.27142695591242e-06
Rn1p28n1 in28n n1p 159393.84202653
* n1 input 29 w=+0.00919963467526149 w+  bank=f alpha=0.001 R=3623.33228546229 G_phys=0.000275989040257845 G_eff=2.75989040257845e-07
Rn1p29f1 tap29n n1p 3625.05304834625
* n1 input 30 w=-0.379437042796868 w-  bank=n alpha=1 R=87849.4442388387 G_phys=1.13831112839061e-05 G_eff=1.13831112839061e-05
Rn1n30n1 in30 n1p 87740.2109501851
* n1 input 31 w=-0.216631724491884 w-  bank=n alpha=1 R=153870.96885979 G_phys=6.49895173475653e-06 G_eff=6.49895173475653e-06
Rn1n31n1 in31 n1p 153818.290382251
* n1 input 32 w=+0.139103822260271 w+  bank=n alpha=1 R=239629.169002738 G_phys=4.17311466780814e-06 G_eff=4.17311466780814e-06
Rn1p32n1 in32n n1p 239332.55755435
* n1 bias w+  bank=f alpha=0.001 R=1034.77721072674 G_phys=0.000966391595827364 G_eff=9.66391595827364e-07
Rn1bpf1 taprefn n1p 1034.64641823515
* feedback TIA n1: Rf=33333.3333333333 A=100000 V(n1lin) = -I(n1p)*Rf*A/(A+1)  (uncompensated)
Rn1f n1raw n1p 33327.8544848103

* MOS TIA + optional MOS servo. IN- sense at n1p (sum). OUT = n1lin.
* TIA subckt=miller_tia topology=miller
* Vn1ib is a 0 V ammeter: i(Vn1ib) = current from sum into MOS IN-.
Vn1ib n1p n1inn DC 0
Vosinj n1osp n1srv DC 0.000214
Xn1tia n1osp n1inn n1raw vdd vss miller_tia MD=2 MT=2 MO=4 CC=2e-12 IBIAS=4e-05 DW=0.00185 L1=1.4u
* MOS miller leaky integrator servo: tau~Rin*C=5e-05 s
Rn1si n1p n1sint 50000
Cn1int n1sint n1srv 1e-09
Rn1leak n1sint n1srv 100000000
Xn1srv 0 n1sint n1srv vdd vss miller_tia MD=2 MT=2 MO=4 CC=2e-12 IBIAS=2e-05 DW=0.001487
.ic v(n1srv)=0

* Exp 27 unbuffered capacitive CDS. AZ short of n1lin until t=0.0002s.
* After AZ, V(n1lin)=V(n1raw)-V(n1raw,az). High-Z capacitor plate.
Vazclk n1clk 0 PULSE(2.5 -2.5 0.0002 10n 10n 1 2)
Cn1cds n1raw n1lin 2n
Xn1azg n1lin n1clk 0 vss NCH W=5u L=1.4u m=8
.control
set numdgt=15
set wr_singlescale
tran 1.1e-06 0.00044
wrdata mc_85p0_2.dat v(n1lin) v(n1p) v(n1srv) i(Vdd)
print v(n1lin)
print v(n1p)
print v(n1srv)
print i(Vdd)
.endc

.end
