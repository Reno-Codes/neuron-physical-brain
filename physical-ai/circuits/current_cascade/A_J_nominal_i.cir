* Physical AI - Experiment 20 architecture J: current-mode hidden + per-weight CCCS
* Hidden: 0 V + I_y=max(0,I_sum). Each W2 weight is a CCCS copy of I_y. Output: dump onto R_IV. No hidden TIA.
* Frozen Experiment 9 network A. Weights were not edited.
* Behavioral circuit analysis. Not transistor-level or PCB power.
* invert A=100000 rail=15
* shape: 2 -> 4 -> 1

Vin1 in1 0 DC 0
* passive invert in1 -> in1n: R2/R1=1.0000200002 closed-loop -1 at A=100000
Rinv1ia in1 inv1m 10000
Rinv1ib in1n inv1m 10000.200002
Einv1amp in1n 0 0 inv1m 100000
Vin2 in2 0 DC 0
Vref vref 0 DC 1
* passive invert vref -> vrefn: R2/R1=1.0000200002 closed-loop -1 at A=100000
Rinvrefia vref invrefm 10000
Rinvrefib vrefn invrefm 10000.200002
Einvrefamp vrefn 0 0 invrefm 100000
* load-compensated divider vref->tapref: G_load=0.000523133389485774 Ra=655884.774699393 Rb=1000 target beta=0.001 (no tap buffer)
Rdivrefa vref tapref 655884.774699393
Rdivrefb tapref 0 1000
* load-compensated divider vrefn->taprefn: G_load=0.00135041774642313 Ra=425030.827613635 Rb=1000 target beta=0.001 (no tap buffer)
Rdivrefna vrefn taprefn 425030.827613635
Rdivrefnb taprefn 0 1000

* h1 input 1 w=+0.683760795348816 w+  bank=n alpha=1 R=48749.9920441162 G_phys=2.05128238604645e-05 G_eff=2.05128238604645e-05
Rh1p1n1 in1 h1p 48749.9920441162
* h1 input 2 w=+0.309366783045794 w+  bank=n alpha=1 R=107746.969487669 G_phys=9.28100349137382e-06 G_eff=9.28100349137382e-06
Rh1p2n1 in2 h1p 107746.969487669
* h1 bias w-  bank=f alpha=0.001 R=1253.18954325804 G_phys=0.000797963887729386 G_eff=7.97963887729385e-07
Rh1bnf1 taprefn h1p 1253.18954325804
Vh1p h1p 0 DC 0
Bh1crelu 0 h1iy I = max(0, i(Vh1p))
Vh1iy h1iy 0 DC 0
* current-mode hidden h1: I_y = max(0, I_sum), no hidden voltage

* h2 input 1 w=-0.884821731731664 w-  bank=n alpha=1 R=37672.3718890781 G_phys=2.65446519519499e-05 G_eff=2.65446519519499e-05
Rh2n1n1 in1n h2p 37672.3718890781
* h2 input 2 w=+0.782653240240456 w+  bank=n alpha=1 R=42590.1684417639 G_phys=2.34795972072137e-05 G_eff=2.34795972072137e-05
Rh2p2n1 in2 h2p 42590.1684417639
* h2 bias w+  bank=f alpha=0.001 R=560963.988396833 G_phys=1.78264562553806e-06 G_eff=1.78264562553806e-09
Rh2bpf1 tapref h2p 560963.988396833
Vh2p h2p 0 DC 0
Bh2crelu 0 h2iy I = max(0, i(Vh2p))
Vh2iy h2iy 0 DC 0
* current-mode hidden h2: I_y = max(0, I_sum), no hidden voltage

* h3 input 1 w=+0.80723931339229 w+  bank=n alpha=1 R=41293.0004526854 G_phys=2.42171794017687e-05 G_eff=2.42171794017687e-05
Rh3p1n1 in1 h3p 41293.0004526854
* h3 input 2 w=+1.71882311343666 w+  bank=n alpha=1 R=19393.1144355429 G_phys=5.15646934030999e-05 G_eff=5.15646934030999e-05
Rh3p2n1 in2 h3p 19393.1144355429
* h3 bias w+  bank=f alpha=0.001 R=1918.09451080035 G_phys=0.000521350743860236 G_eff=5.21350743860236e-07
Rh3bpf1 tapref h3p 1918.09451080035
Vh3p h3p 0 DC 0
Bh3crelu 0 h3iy I = max(0, i(Vh3p))
Vh3iy h3iy 0 DC 0
* current-mode hidden h3: I_y = max(0, I_sum), no hidden voltage

* h4 input 1 w=-2.16286246457598 w-  bank=n alpha=1 R=15411.6749813161 G_phys=6.48858739372794e-05 G_eff=6.48858739372794e-05
Rh4n1n1 in1n h4p 15411.6749813161
* h4 input 2 w=+0.726967919426763 w+  bank=n alpha=1 R=45852.5506319697 G_phys=2.18090375828029e-05 G_eff=2.18090375828029e-05
Rh4p2n1 in2 h4p 45852.5506319697
* h4 bias w-  bank=f alpha=0.001 R=1810.10591973139 G_phys=0.000552453858693748 G_eff=5.52453858693748e-07
Rh4bnf1 taprefn h4p 1810.10591973139
Vh4p h4p 0 DC 0
Bh4crelu 0 h4iy I = max(0, i(Vh4p))
Vh4iy h4iy 0 DC 0
* current-mode hidden h4: I_y = max(0, I_sum), no hidden voltage

Fo1h1 0 o1p Vh1iy 0.601889648539537
Fo1h2 0 o1p Vh2iy 0.347315954504283
Fo1h3 0 o1p Vh3iy 0.876922607606196
Fo1h4 0 o1p Vh4iy 0.929527796434486
* output bias current o1: I=3.10513544470123e-07 = b*3e-05 (b=0.0103504514823374 frozen)
Bo1bias 0 o1p I = 3.10513544470123e-07
* single-copy I-to-V: 0 V sum o1p, I dump onto R_IV=33333.3333333333
Vo1p o1p 0 DC 0
Bo1iv 0 o1lin I = i(Vo1p)
Ro1iv o1lin 0 33333.3333333333
.control
set numdgt=15
alter Vin1 DC 0.0306215327269026
alter Vin2 DC -0.967286465092307
op
print i(Vin1)
print i(Vin2)
print i(Vref)
.endc

.end
