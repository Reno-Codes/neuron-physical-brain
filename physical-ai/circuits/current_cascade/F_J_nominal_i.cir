* Physical AI - Experiment 20 architecture J: current-mode hidden + per-weight CCCS
* Hidden: 0 V + I_y=max(0,I_sum). Each W2 weight is a CCCS copy of I_y. Output: dump onto R_IV. No hidden TIA.
* Frozen Experiment 9 network F. Weights were not edited.
* Behavioral circuit analysis. Not transistor-level or PCB power.
* invert A=100000 rail=15
* shape: 16 -> 32 -> 16

Vin1 in1 0 DC 0
* passive invert in1 -> in1n: R2/R1=1.0000200002 closed-loop -1 at A=100000
Rinv1ia in1 inv1m 10000
Rinv1ib in1n inv1m 10000.200002
Einv1amp in1n 0 0 inv1m 100000
* load-compensated divider in1->tap1: G_load=0.00138944868118558 Ra=418088.075239315 Rb=1000 target beta=0.001 (no tap buffer)
Rdiv1a in1 tap1 418088.075239315
Rdiv1b tap1 0 1000
* load-compensated divider in1n->tap1n: G_load=0.000710070664287583 Ra=584186.385313021 Rb=1000 target beta=0.001 (no tap buffer)
Rdiv1na in1n tap1n 584186.385313021
Rdiv1nb tap1n 0 1000
Vin2 in2 0 DC 0
* passive invert in2 -> in2n: R2/R1=1.0000200002 closed-loop -1 at A=100000
Rinv2ia in2 inv2m 10000
Rinv2ib in2n inv2m 10000.200002
Einv2amp in2n 0 0 inv2m 100000
* load-compensated divider in2->tap2: G_load=0.000578042323514278 Ra=633062.868539065 Rb=1000 target beta=0.001 (no tap buffer)
Rdiv2a in2 tap2 633062.868539065
Rdiv2b tap2 0 1000
* load-compensated divider in2n->tap2n: G_load=0.000564213455228197 Ra=638659.638594056 Rb=1000 target beta=0.001 (no tap buffer)
Rdiv2na in2n tap2n 638659.638594056
Rdiv2nb tap2n 0 1000
Vin3 in3 0 DC 0
* passive invert in3 -> in3n: R2/R1=1.0000200002 closed-loop -1 at A=100000
Rinv3ia in3 inv3m 10000
Rinv3ib in3n inv3m 10000.200002
Einv3amp in3n 0 0 inv3m 100000
* load-compensated divider in3n->tap3n: G_load=0.000475353763139489 Ra=677125.734152175 Rb=1000 target beta=0.001 (no tap buffer)
Rdiv3na in3n tap3n 677125.734152175
Rdiv3nb tap3n 0 1000
Vin4 in4 0 DC 0
* passive invert in4 -> in4n: R2/R1=1.0000200002 closed-loop -1 at A=100000
Rinv4ia in4 inv4m 10000
Rinv4ib in4n inv4m 10000.200002
Einv4amp in4n 0 0 inv4m 100000
* load-compensated divider in4->tap4: G_load=0.000838243797048297 Ra=543453.486204666 Rb=1000 target beta=0.001 (no tap buffer)
Rdiv4a in4 tap4 543453.486204666
Rdiv4b tap4 0 1000
* load-compensated divider in4n->tap4n: G_load=0.000604265102392725 Ra=622715.035382877 Rb=1000 target beta=0.001 (no tap buffer)
Rdiv4na in4n tap4n 622715.035382877
Rdiv4nb tap4n 0 1000
Vin5 in5 0 DC 0
* passive invert in5 -> in5n: R2/R1=1.0000200002 closed-loop -1 at A=100000
Rinv5ia in5 inv5m 10000
Rinv5ib in5n inv5m 10000.200002
Einv5amp in5n 0 0 inv5m 100000
* load-compensated divider in5->tap5: G_load=0.000124571614130361 Ra=888338.268054662 Rb=1000 target beta=0.001 (no tap buffer)
Rdiv5a in5 tap5 888338.268054662
Rdiv5b tap5 0 1000
Vin6 in6 0 DC 0
* passive invert in6 -> in6n: R2/R1=1.0000200002 closed-loop -1 at A=100000
Rinv6ia in6 inv6m 10000
Rinv6ib in6n inv6m 10000.200002
Einv6amp in6n 0 0 inv6m 100000
Vin7 in7 0 DC 0
* passive invert in7 -> in7n: R2/R1=1.0000200002 closed-loop -1 at A=100000
Rinv7ia in7 inv7m 10000
Rinv7ib in7n inv7m 10000.200002
Einv7amp in7n 0 0 inv7m 100000
* load-compensated divider in7->tap7: G_load=0.000379458526114055 Ra=724197.198457419 Rb=1000 target beta=0.001 (no tap buffer)
Rdiv7a in7 tap7 724197.198457419
Rdiv7b tap7 0 1000
* load-compensated divider in7n->tap7n: G_load=0.000876983911873088 Ra=532236.847466142 Rb=1000 target beta=0.001 (no tap buffer)
Rdiv7na in7n tap7n 532236.847466142
Rdiv7nb tap7n 0 1000
Vin8 in8 0 DC 0
* passive invert in8 -> in8n: R2/R1=1.0000200002 closed-loop -1 at A=100000
Rinv8ia in8 inv8m 10000
Rinv8ib in8n inv8m 10000.200002
Einv8amp in8n 0 0 inv8m 100000
* load-compensated divider in8n->tap8n: G_load=0.00202030909723981 Ra=330760.848587637 Rb=1000 target beta=0.001 (no tap buffer)
Rdiv8na in8n tap8n 330760.848587637
Rdiv8nb tap8n 0 1000
Vin9 in9 0 DC 0
* passive invert in9 -> in9n: R2/R1=1.0000200002 closed-loop -1 at A=100000
Rinv9ia in9 inv9m 10000
Rinv9ib in9n inv9m 10000.200002
Einv9amp in9n 0 0 inv9m 100000
* load-compensated divider in9->tap9: G_load=0.0021264464173835 Ra=319532.103427525 Rb=1000 target beta=0.001 (no tap buffer)
Rdiv9a in9 tap9 319532.103427525
Rdiv9b tap9 0 1000
Vin10 in10 0 DC 0
* passive invert in10 -> in10n: R2/R1=1.0000200002 closed-loop -1 at A=100000
Rinv10ia in10 inv10m 10000
Rinv10ib in10n inv10m 10000.200002
Einv10amp in10n 0 0 inv10m 100000
* load-compensated divider in10->tap10: G_load=0.000661819331650786 Ra=601148.380556888 Rb=1000 target beta=0.001 (no tap buffer)
Rdiv10a in10 tap10 601148.380556888
Rdiv10b tap10 0 1000
* load-compensated divider in10n->tap10n: G_load=0.00154386072332109 Ra=392710.178997446 Rb=1000 target beta=0.001 (no tap buffer)
Rdiv10na in10n tap10n 392710.178997446
Rdiv10nb tap10n 0 1000
Vin11 in11 0 DC 0
* passive invert in11 -> in11n: R2/R1=1.0000200002 closed-loop -1 at A=100000
Rinv11ia in11 inv11m 10000
Rinv11ib in11n inv11m 10000.200002
Einv11amp in11n 0 0 inv11m 100000
* load-compensated divider in11n->tap11n: G_load=0.000923704741727117 Ra=519310.462947183 Rb=1000 target beta=0.001 (no tap buffer)
Rdiv11na in11n tap11n 519310.462947183
Rdiv11nb tap11n 0 1000
Vin12 in12 0 DC 0
* passive invert in12 -> in12n: R2/R1=1.0000200002 closed-loop -1 at A=100000
Rinv12ia in12 inv12m 10000
Rinv12ib in12n inv12m 10000.200002
Einv12amp in12n 0 0 inv12m 100000
* load-compensated divider in12->tap12: G_load=0.000192713812047279 Ra=837585.6721951 Rb=1000 target beta=0.001 (no tap buffer)
Rdiv12a in12 tap12 837585.6721951
Rdiv12b tap12 0 1000
Vin13 in13 0 DC 0
* passive invert in13 -> in13n: R2/R1=1.0000200002 closed-loop -1 at A=100000
Rinv13ia in13 inv13m 10000
Rinv13ib in13n inv13m 10000.200002
Einv13amp in13n 0 0 inv13m 100000
* load-compensated divider in13->tap13: G_load=0.00155701882010588 Ra=390689.341879241 Rb=1000 target beta=0.001 (no tap buffer)
Rdiv13a in13 tap13 390689.341879241
Rdiv13b tap13 0 1000
* load-compensated divider in13n->tap13n: G_load=0.00071375434054134 Ra=582930.689870309 Rb=1000 target beta=0.001 (no tap buffer)
Rdiv13na in13n tap13n 582930.689870309
Rdiv13nb tap13n 0 1000
Vin14 in14 0 DC 0
* passive invert in14 -> in14n: R2/R1=1.0000200002 closed-loop -1 at A=100000
Rinv14ia in14 inv14m 10000
Rinv14ib in14n inv14m 10000.200002
Einv14amp in14n 0 0 inv14m 100000
* load-compensated divider in14n->tap14n: G_load=0.000700934410618815 Ra=587324.234117032 Rb=1000 target beta=0.001 (no tap buffer)
Rdiv14na in14n tap14n 587324.234117032
Rdiv14nb tap14n 0 1000
Vin15 in15 0 DC 0
* passive invert in15 -> in15n: R2/R1=1.0000200002 closed-loop -1 at A=100000
Rinv15ia in15 inv15m 10000
Rinv15ib in15n inv15m 10000.200002
Einv15amp in15n 0 0 inv15m 100000
* load-compensated divider in15n->tap15n: G_load=0.00161191394702755 Ra=382478.144479797 Rb=1000 target beta=0.001 (no tap buffer)
Rdiv15na in15n tap15n 382478.144479797
Rdiv15nb tap15n 0 1000
Vin16 in16 0 DC 0
* passive invert in16 -> in16n: R2/R1=1.0000200002 closed-loop -1 at A=100000
Rinv16ia in16 inv16m 10000
Rinv16ib in16n inv16m 10000.200002
Einv16amp in16n 0 0 inv16m 100000
* load-compensated divider in16->tap16: G_load=0.00225822429382311 Ra=306608.726076314 Rb=1000 target beta=0.001 (no tap buffer)
Rdiv16a in16 tap16 306608.726076314
Rdiv16b tap16 0 1000
Vref vref 0 DC 1
* passive invert vref -> vrefn: R2/R1=1.0000200002 closed-loop -1 at A=100000
Rinvrefia vref invrefm 10000
Rinvrefib vrefn invrefm 10000.200002
Einvrefamp vrefn 0 0 invrefm 100000
* load-compensated divider vref->tapref: G_load=0.00529725650244452 Ra=158640.512675988 Rb=1000 target beta=0.001 (no tap buffer)
Rdivrefa vref tapref 158640.512675988
Rdivrefb tapref 0 1000
* load-compensated divider vrefn->taprefn: G_load=0.00392335029856734 Ra=202910.607496424 Rb=1000 target beta=0.001 (no tap buffer)
Rdivrefna vrefn taprefn 202910.607496424
Rdivrefnb taprefn 0 1000

* h1 input 1 w=-0.0168555731920106 w-  bank=f alpha=0.001 R=1977.58527423636 G_phys=0.000505667195760317 G_eff=5.05667195760317e-07
Rh1n1f1 tap1n h1p 1977.58527423636
* h1 input 2 w=+0.167421682129858 w+  bank=n alpha=1 R=199098.067283059 G_phys=5.02265046389574e-06 G_eff=5.02265046389574e-06
Rh1p2n1 in2 h1p 199098.067283059
* h1 input 3 w=-0.175338604042315 w-  bank=n alpha=1 R=190108.353579049 G_phys=5.26015812126946e-06 G_eff=5.26015812126946e-06
Rh1n3n1 in3n h1p 190108.353579049
* h1 input 4 w=-0.3026243730549 w-  bank=n alpha=1 R=110147.55023478 G_phys=9.078731191647e-06 G_eff=9.078731191647e-06
Rh1n4n1 in4n h1p 110147.55023478
* h1 input 5 w=-0.0731653551060092 w-  bank=n alpha=1 R=455589.032336913 G_phys=2.19496065318027e-06 G_eff=2.19496065318027e-06
Rh1n5n1 in5n h1p 455589.032336913
* h1 input 6 w=+0.135452999280782 w+  bank=n alpha=1 R=246087.820205711 G_phys=4.06358997842346e-06 G_eff=4.06358997842346e-06
Rh1p6n1 in6 h1p 246087.820205711
* h1 input 7 w=+0.21541693193391 w+  bank=n alpha=1 R=154738.687595643 G_phys=6.46250795801731e-06 G_eff=6.46250795801731e-06
Rh1p7n1 in7 h1p 154738.687595643
* h1 input 8 w=-0.0225117532106789 w-  bank=f alpha=0.001 R=1480.70801156087 G_phys=0.000675352596320366 G_eff=6.75352596320366e-07
Rh1n8f1 tap8n h1p 1480.70801156087
* h1 input 9 w=-0.120865686071453 w-  bank=n alpha=1 R=275788.227550601 G_phys=3.62597058214359e-06 G_eff=3.62597058214359e-06
Rh1n9n1 in9n h1p 275788.227550601
* h1 input 10 w=+0.732018397911567 w+  bank=n alpha=1 R=45536.19612353 G_phys=2.1960551937347e-05 G_eff=2.1960551937347e-05
Rh1p10n1 in10 h1p 45536.19612353
* h1 input 11 w=+0.435334885703784 w+  bank=n alpha=1 R=76569.405365814 G_phys=1.30600465711135e-05 G_eff=1.30600465711135e-05
Rh1p11n1 in11 h1p 76569.405365814
* h1 input 12 w=+0.385479984810207 w+  bank=n alpha=1 R=86472.2803954274 G_phys=1.15643995443062e-05 G_eff=1.15643995443062e-05
Rh1p12n1 in12 h1p 86472.2803954274
* h1 input 13 w=-0.42800728852471 w-  bank=n alpha=1 R=77880.2936936643 G_phys=1.28402186557413e-05 G_eff=1.28402186557413e-05
Rh1n13n1 in13n h1p 77880.2936936643
* h1 input 14 w=+0.104452911276431 w+  bank=n alpha=1 R=319123.066327159 G_phys=3.13358733829293e-06 G_eff=3.13358733829293e-06
Rh1p14n1 in14 h1p 319123.066327159
* h1 input 15 w=-0.361295245628978 w-  bank=n alpha=1 R=92260.6475911506 G_phys=1.08388573688693e-05 G_eff=1.08388573688693e-05
Rh1n15n1 in15n h1p 92260.6475911506
* h1 input 16 w=+0.0759383856082483 w+  bank=n alpha=1 R=438952.356786904 G_phys=2.27815156824745e-06 G_eff=2.27815156824745e-06
Rh1p16n1 in16 h1p 438952.356786904
* h1 bias w-  bank=n alpha=1 R=365943.245315286 G_phys=2.73266418441043e-06 G_eff=2.73266418441043e-06
Rh1bnn1 vrefn h1p 365943.245315286
Vh1p h1p 0 DC 0
Bh1crelu 0 h1iy I = max(0, i(Vh1p))
Vh1iy h1iy 0 DC 0
* current-mode hidden h1: I_y = max(0, I_sum), no hidden voltage

* h2 input 1 w=+0.0248542194622879 w+  bank=f alpha=0.001 R=1341.15389879417 G_phys=0.000745626583868636 G_eff=7.45626583868636e-07
Rh2p1f1 tap1 h2p 1341.15389879417
* h2 input 2 w=+0.400223191665755 w+  bank=n alpha=1 R=83286.8610002279 G_phys=1.20066957499727e-05 G_eff=1.20066957499727e-05
Rh2p2n1 in2 h2p 83286.8610002279
* h2 input 3 w=+0.358260577298724 w+  bank=n alpha=1 R=93042.1471004872 G_phys=1.07478173189617e-05 G_eff=1.07478173189617e-05
Rh2p3n1 in3 h2p 93042.1471004872
* h2 input 4 w=+0.348073132477087 w+  bank=n alpha=1 R=95765.315455733 G_phys=1.04421939743126e-05 G_eff=1.04421939743126e-05
Rh2p4n1 in4 h2p 95765.315455733
* h2 input 5 w=-0.489776715185261 w-  bank=n alpha=1 R=68058.2238800895 G_phys=1.46933014555578e-05 G_eff=1.46933014555578e-05
Rh2n5n1 in5n h2p 68058.2238800895
* h2 input 6 w=-0.262585224656684 w-  bank=n alpha=1 R=126942.913017726 G_phys=7.87755673970051e-06 G_eff=7.87755673970051e-06
Rh2n6n1 in6n h2p 126942.913017726
* h2 input 7 w=+0.634452480443638 w+  bank=n alpha=1 R=52538.7390873232 G_phys=1.90335744133091e-05 G_eff=1.90335744133091e-05
Rh2p7n1 in7 h2p 52538.7390873232
* h2 input 8 w=-0.0150494358056585 w-  bank=f alpha=0.001 R=2214.92245714621 G_phys=0.000451483074169756 G_eff=4.51483074169756e-07
Rh2n8f1 tap8n h2p 2214.92245714621
* h2 input 9 w=+0.317089980091076 w+  bank=n alpha=1 R=105122.632142962 G_phys=9.51269940273229e-06 G_eff=9.51269940273229e-06
Rh2p9n1 in9 h2p 105122.632142962
* h2 input 10 w=-0.171694565495531 w-  bank=n alpha=1 R=194143.2056229 G_phys=5.15083696486594e-06 G_eff=5.15083696486594e-06
Rh2n10n1 in10n h2p 194143.2056229
* h2 input 11 w=+0.113535277026032 w+  bank=n alpha=1 R=293594.503897589 G_phys=3.40605831078097e-06 G_eff=3.40605831078097e-06
Rh2p11n1 in11 h2p 293594.503897589
* h2 input 12 w=+0.342235951147447 w+  bank=n alpha=1 R=97398.6900603912 G_phys=1.02670785344234e-05 G_eff=1.02670785344234e-05
Rh2p12n1 in12 h2p 97398.6900603912
* h2 input 13 w=-0.268945400148547 w-  bank=n alpha=1 R=123940.89400645 G_phys=8.0683620044564e-06 G_eff=8.0683620044564e-06
Rh2n13n1 in13n h2p 123940.89400645
* h2 input 14 w=+0.239258603190851 w+  bank=n alpha=1 R=139319.267473714 G_phys=7.17775809572554e-06 G_eff=7.17775809572554e-06
Rh2p14n1 in14 h2p 139319.267473714
* h2 input 15 w=+0.347826837541335 w+  bank=n alpha=1 R=95833.1265320264 G_phys=1.043480512624e-05 G_eff=1.043480512624e-05
Rh2p15n1 in15 h2p 95833.1265320264
* h2 input 16 w=+0.00438097035906581 w+  bank=f alpha=0.001 R=7608.66442849918 G_phys=0.000131429110771974 G_eff=1.31429110771974e-07
Rh2p16f1 tap16 h2p 7608.66442849918
* h2 bias w-  bank=n alpha=1 R=664931.752911819 G_phys=1.50391374095293e-06 G_eff=1.50391374095293e-06
Rh2bnn1 vrefn h2p 664931.752911819
Vh2p h2p 0 DC 0
Bh2crelu 0 h2iy I = max(0, i(Vh2p))
Vh2iy h2iy 0 DC 0
* current-mode hidden h2: I_y = max(0, I_sum), no hidden voltage

* h3 input 1 w=-0.916033562434709 w-  bank=n alpha=1 R=36388.7686000689 G_phys=2.74810068730413e-05 G_eff=2.74810068730413e-05
Rh3n1n1 in1n h3p 36388.7686000689
* h3 input 2 w=+0.507521982744407 w+  bank=n alpha=1 R=65678.6000738028 G_phys=1.52256594823322e-05 G_eff=1.52256594823322e-05
Rh3p2n1 in2 h3p 65678.6000738028
* h3 input 3 w=+0.0871477019742823 w+  bank=n alpha=1 R=382492.395991924 G_phys=2.61443105922847e-06 G_eff=2.61443105922847e-06
Rh3p3n1 in3 h3p 382492.395991924
* h3 input 4 w=-0.0658557100969535 w-  bank=n alpha=1 R=506157.071030889 G_phys=1.97567130290861e-06 G_eff=1.97567130290861e-06
Rh3n4n1 in4n h3p 506157.071030889
* h3 input 5 w=-0.179053685151098 w-  bank=n alpha=1 R=186163.905563878 G_phys=5.37161055453294e-06 G_eff=5.37161055453294e-06
Rh3n5n1 in5n h3p 186163.905563878
* h3 input 6 w=+0.315007728496672 w+  bank=n alpha=1 R=105817.509597024 G_phys=9.45023185490017e-06 G_eff=9.45023185490017e-06
Rh3p6n1 in6 h3p 105817.509597024
* h3 input 7 w=+0.677608935484657 w+  bank=n alpha=1 R=49192.5823107569 G_phys=2.03282680645397e-05 G_eff=2.03282680645397e-05
Rh3p7n1 in7 h3p 49192.5823107569
* h3 input 8 w=+0.295351776524173 w+  bank=n alpha=1 R=112859.769206789 G_phys=8.8605532957252e-06 G_eff=8.8605532957252e-06
Rh3p8n1 in8 h3p 112859.769206789
* h3 input 9 w=+0.00172302579693755 w+  bank=f alpha=0.001 R=19345.8121129578 G_phys=5.16907739081266e-05 G_eff=5.16907739081266e-08
Rh3p9f1 tap9 h3p 19345.8121129578
* h3 input 10 w=+0.317835264102281 w+  bank=n alpha=1 R=104876.132695604 G_phys=9.53505792306844e-06 G_eff=9.53505792306844e-06
Rh3p10n1 in10 h3p 104876.132695604
* h3 input 11 w=-0.530129158700576 w-  bank=n alpha=1 R=62877.7587240027 G_phys=1.59038747610173e-05 G_eff=1.59038747610173e-05
Rh3n11n1 in11n h3p 62877.7587240027
* h3 input 12 w=-0.291249394999097 w-  bank=n alpha=1 R=114449.450902505 G_phys=8.7374818499729e-06 G_eff=8.7374818499729e-06
Rh3n12n1 in12n h3p 114449.450902505
* h3 input 13 w=-0.395820894073244 w-  bank=n alpha=1 R=84213.1727567804 G_phys=1.18746268221973e-05 G_eff=1.18746268221973e-05
Rh3n13n1 in13n h3p 84213.1727567804
* h3 input 14 w=-0.0451489915790311 w-  bank=n alpha=1 R=738296.297825057 G_phys=1.35446974737093e-06 G_eff=1.35446974737093e-06
Rh3n14n1 in14n h3p 738296.297825057
* h3 input 15 w=+0.0633187763010491 w+  bank=n alpha=1 R=526436.789852823 G_phys=1.89956328903147e-06 G_eff=1.89956328903147e-06
Rh3p15n1 in15 h3p 526436.789852823
* h3 input 16 w=-0.149745176344707 w-  bank=n alpha=1 R=222600.381174225 G_phys=4.49235529034122e-06 G_eff=4.49235529034122e-06
Rh3n16n1 in16n h3p 222600.381174225
* h3 bias w-  bank=n alpha=1 R=602168.780003591 G_phys=1.66066397529616e-06 G_eff=1.66066397529616e-06
Rh3bnn1 vrefn h3p 602168.780003591
Vh3p h3p 0 DC 0
Bh3crelu 0 h3iy I = max(0, i(Vh3p))
Vh3iy h3iy 0 DC 0
* current-mode hidden h3: I_y = max(0, I_sum), no hidden voltage

* h4 input 1 w=+0.0673940677866904 w+  bank=n alpha=1 R=494603.374273786 G_phys=2.02182203360071e-06 G_eff=2.02182203360071e-06
Rh4p1n1 in1 h4p 494603.374273786
* h4 input 2 w=-0.087995350925692 w-  bank=n alpha=1 R=378807.891356463 G_phys=2.63986052777076e-06 G_eff=2.63986052777076e-06
Rh4n2n1 in2n h4p 378807.891356463
* h4 input 3 w=-0.354237391786533 w-  bank=n alpha=1 R=94098.8560389478 G_phys=1.0627121753596e-05 G_eff=1.0627121753596e-05
Rh4n3n1 in3n h4p 94098.8560389478
* h4 input 4 w=-0.0201421700797575 w-  bank=f alpha=0.001 R=1654.90278362969 G_phys=0.000604265102392725 G_eff=6.04265102392725e-07
Rh4n4f1 tap4n h4p 1654.90278362969
* h4 input 5 w=-0.808084436849872 w-  bank=n alpha=1 R=41249.814763511 G_phys=2.42425331054962e-05 G_eff=2.42425331054962e-05
Rh4n5n1 in5n h4p 41249.814763511
* h4 input 6 w=-0.290030636557288 w-  bank=n alpha=1 R=114930.387110153 G_phys=8.70091909671864e-06 G_eff=8.70091909671864e-06
Rh4n6n1 in6n h4p 114930.387110153
* h4 input 7 w=+0.344262354214072 w+  bank=n alpha=1 R=96825.3801942158 G_phys=1.03278706264222e-05 G_eff=1.03278706264222e-05
Rh4p7n1 in7 h4p 96825.3801942158
* h4 input 8 w=-0.872472737770673 w-  bank=n alpha=1 R=38205.5872811637 G_phys=2.61741821331202e-05 G_eff=2.61741821331202e-05
Rh4n8n1 in8n h4p 38205.5872811637
* h4 input 9 w=+0.163024654235771 w+  bank=n alpha=1 R=204468.051103029 G_phys=4.89073962707314e-06 G_eff=4.89073962707314e-06
Rh4p9n1 in9 h4p 204468.051103029
* h4 input 10 w=-0.143734302026109 w-  bank=n alpha=1 R=231909.383240185 G_phys=4.31202906078326e-06 G_eff=4.31202906078326e-06
Rh4n10n1 in10n h4p 231909.383240185
* h4 input 11 w=-0.110414936368951 w-  bank=n alpha=1 R=301891.523280421 G_phys=3.31244809106853e-06 G_eff=3.31244809106853e-06
Rh4n11n1 in11n h4p 301891.523280421
* h4 input 12 w=+0.321561566587255 w+  bank=n alpha=1 R=103660.812724298 G_phys=9.64684699761765e-06 G_eff=9.64684699761765e-06
Rh4p12n1 in12 h4p 103660.812724298
* h4 input 13 w=-0.501486514423905 w-  bank=n alpha=1 R=66469.0522568205 G_phys=1.50445954327172e-05 G_eff=1.50445954327172e-05
Rh4n13n1 in13n h4p 66469.0522568205
* h4 input 14 w=-0.0233644803539605 w-  bank=f alpha=0.001 R=1426.66701028012 G_phys=0.000700934410618815 G_eff=7.00934410618815e-07
Rh4n14f1 tap14n h4p 1426.66701028012
* h4 input 15 w=-0.211065663454959 w-  bank=n alpha=1 R=157928.735483053 G_phys=6.33196990364878e-06 G_eff=6.33196990364878e-06
Rh4n15n1 in15n h4p 157928.735483053
* h4 input 16 w=+0.18002446765288 w+  bank=n alpha=1 R=185160.016124064 G_phys=5.40073402958641e-06 G_eff=5.40073402958641e-06
Rh4p16n1 in16 h4p 185160.016124064
* h4 bias w+  bank=n alpha=1 R=704963.006730694 G_phys=1.41851414961128e-06 G_eff=1.41851414961128e-06
Rh4bpn1 vref h4p 704963.006730694
Vh4p h4p 0 DC 0
Bh4crelu 0 h4iy I = max(0, i(Vh4p))
Vh4iy h4iy 0 DC 0
* current-mode hidden h4: I_y = max(0, I_sum), no hidden voltage

* h5 input 1 w=-0.122756848133934 w-  bank=n alpha=1 R=271539.501380525 G_phys=3.68270544401802e-06 G_eff=3.68270544401802e-06
Rh5n1n1 in1n h5p 271539.501380525
* h5 input 2 w=+0.794704720471975 w+  bank=n alpha=1 R=41944.300159104 G_phys=2.38411416141592e-05 G_eff=2.38411416141592e-05
Rh5p2n1 in2 h5p 41944.300159104
* h5 input 3 w=-0.26372184795707 w-  bank=n alpha=1 R=126395.797661631 G_phys=7.91165543871211e-06 G_eff=7.91165543871211e-06
Rh5n3n1 in3n h5p 126395.797661631
* h5 input 4 w=+0.65217090039031 w+  bank=n alpha=1 R=51111.3472149464 G_phys=1.95651270117093e-05 G_eff=1.95651270117093e-05
Rh5p4n1 in4 h5p 51111.3472149464
* h5 input 5 w=-0.272670344884174 w-  bank=n alpha=1 R=122247.739656077 G_phys=8.18011034652521e-06 G_eff=8.18011034652521e-06
Rh5n5n1 in5n h5p 122247.739656077
* h5 input 6 w=+0.0607101548077554 w+  bank=n alpha=1 R=549056.964833751 G_phys=1.82130464423266e-06 G_eff=1.82130464423266e-06
Rh5p6n1 in6 h5p 549056.964833751
* h5 input 7 w=+0.629980287413506 w+  bank=n alpha=1 R=52911.7085078791 G_phys=1.88994086224052e-05 G_eff=1.88994086224052e-05
Rh5p7n1 in7 h5p 52911.7085078791
* h5 input 8 w=-0.369402487956774 w-  bank=n alpha=1 R=90235.8116690157 G_phys=1.10820746387032e-05 G_eff=1.10820746387032e-05
Rh5n8n1 in8n h5p 90235.8116690157
* h5 input 9 w=-0.0924511829208223 w-  bank=n alpha=1 R=360550.641757401 G_phys=2.77353548762467e-06 G_eff=2.77353548762467e-06
Rh5n9n1 in9n h5p 360550.641757401
* h5 input 10 w=-0.00426485730080124 w-  bank=f alpha=0.001 R=7815.81445340996 G_phys=0.000127945719024037 G_eff=1.27945719024037e-07
Rh5n10f1 tap10n h5p 7815.81445340996
* h5 input 11 w=+0.540478898079688 w+  bank=n alpha=1 R=61673.6998461292 G_phys=1.62143669423906e-05 G_eff=1.62143669423906e-05
Rh5p11n1 in11 h5p 61673.6998461292
* h5 input 12 w=+0.161688921548601 w+  bank=n alpha=1 R=206157.187604928 G_phys=4.85066764645802e-06 G_eff=4.85066764645802e-06
Rh5p12n1 in12 h5p 206157.187604928
* h5 input 13 w=+0.0259557799028364 w+  bank=f alpha=0.001 R=1284.23547503154 G_phys=0.000778673397085092 G_eff=7.78673397085092e-07
Rh5p13f1 tap13 h5p 1284.23547503154
* h5 input 14 w=+0.470073429319239 w+  bank=n alpha=1 R=70910.907220616 G_phys=1.41022028795772e-05 G_eff=1.41022028795772e-05
Rh5p14n1 in14 h5p 70910.907220616
* h5 input 15 w=+0.188749264833093 w+  bank=n alpha=1 R=176601.129349083 G_phys=5.66247794499279e-06 G_eff=5.66247794499279e-06
Rh5p15n1 in15 h5p 176601.129349083
* h5 input 16 w=+0.031866913791992 w+  bank=f alpha=0.001 R=1046.01699276288 G_phys=0.000956007413759761 G_eff=9.56007413759761e-07
Rh5p16f1 tap16 h5p 1046.01699276288
* h5 bias w+  bank=f alpha=0.001 R=1837.62567566174 G_phys=0.000544180467896375 G_eff=5.44180467896375e-07
Rh5bpf1 tapref h5p 1837.62567566174
Vh5p h5p 0 DC 0
Bh5crelu 0 h5iy I = max(0, i(Vh5p))
Vh5iy h5iy 0 DC 0
* current-mode hidden h5: I_y = max(0, I_sum), no hidden voltage

* h6 input 1 w=-0.340583473625464 w-  bank=n alpha=1 R=97871.2589266431 G_phys=1.02175042087639e-05 G_eff=1.02175042087639e-05
Rh6n1n1 in1n h6p 97871.2589266431
* h6 input 2 w=-0.593797589144587 w-  bank=n alpha=1 R=56135.8515809279 G_phys=1.78139276743376e-05 G_eff=1.78139276743376e-05
Rh6n2n1 in2n h6p 56135.8515809279
* h6 input 3 w=-0.388639564922933 w-  bank=n alpha=1 R=85769.2740057059 G_phys=1.1659186947688e-05 G_eff=1.1659186947688e-05
Rh6n3n1 in3n h6p 85769.2740057059
* h6 input 4 w=+0.284617429170421 w+  bank=n alpha=1 R=117116.275803947 G_phys=8.53852287511263e-06 G_eff=8.53852287511263e-06
Rh6p4n1 in4 h6p 117116.275803947
* h6 input 5 w=-0.270576674342045 w-  bank=n alpha=1 R=123193.669278364 G_phys=8.11730023026134e-06 G_eff=8.11730023026134e-06
Rh6n5n1 in5n h6p 123193.669278364
* h6 input 6 w=+0.0593082278184784 w+  bank=n alpha=1 R=562035.565037534 G_phys=1.77924683455435e-06 G_eff=1.77924683455435e-06
Rh6p6n1 in6 h6p 562035.565037534
* h6 input 7 w=+0.460681196235491 w+  bank=n alpha=1 R=72356.6179946576 G_phys=1.38204358870647e-05 G_eff=1.38204358870647e-05
Rh6p7n1 in7 h6p 72356.6179946576
* h6 input 8 w=+0.530418434730864 w+  bank=n alpha=1 R=62843.46687582 G_phys=1.59125530419259e-05 G_eff=1.59125530419259e-05
Rh6p8n1 in8 h6p 62843.46687582
* h6 input 9 w=+0.069052799324409 w+  bank=n alpha=1 R=482722.40458687 G_phys=2.07158397973227e-06 G_eff=2.07158397973227e-06
Rh6p9n1 in9 h6p 482722.40458687
* h6 input 10 w=+0.150678240315211 w+  bank=n alpha=1 R=221221.944612585 G_phys=4.52034720945633e-06 G_eff=4.52034720945633e-06
Rh6p10n1 in10 h6p 221221.944612585
* h6 input 11 w=+0.0896190095447204 w+  bank=n alpha=1 R=371944.897658123 G_phys=2.68857028634161e-06 G_eff=2.68857028634161e-06
Rh6p11n1 in11 h6p 371944.897658123
* h6 input 12 w=-0.177342454994274 w-  bank=n alpha=1 R=187960.256524077 G_phys=5.32027364982823e-06 G_eff=5.32027364982823e-06
Rh6n12n1 in12n h6p 187960.256524077
* h6 input 13 w=+0.643544080066549 w+  bank=n alpha=1 R=51796.5037140678 G_phys=1.93063224019965e-05 G_eff=1.93063224019965e-05
Rh6p13n1 in13 h6p 51796.5037140678
* h6 input 14 w=+0.0993069474158396 w+  bank=n alpha=1 R=335659.63108052 G_phys=2.97920842247519e-06 G_eff=2.97920842247519e-06
Rh6p14n1 in14 h6p 335659.63108052
* h6 input 15 w=-0.324176483950696 w-  bank=n alpha=1 R=102824.649484455 G_phys=9.72529451852089e-06 G_eff=9.72529451852089e-06
Rh6n15n1 in15n h6p 102824.649484455
* h6 input 16 w=+0.0932186969347454 w+  bank=n alpha=1 R=357582.056276406 G_phys=2.79656090804236e-06 G_eff=2.79656090804236e-06
Rh6p16n1 in16 h6p 357582.056276406
* h6 bias w-  bank=f alpha=0.001 R=1678.78030803583 G_phys=0.000595670556304058 G_eff=5.95670556304058e-07
Rh6bnf1 taprefn h6p 1678.78030803583
Vh6p h6p 0 DC 0
Bh6crelu 0 h6iy I = max(0, i(Vh6p))
Vh6iy h6iy 0 DC 0
* current-mode hidden h6: I_y = max(0, I_sum), no hidden voltage

* h7 input 1 w=+0.32217720874051 w+  bank=n alpha=1 R=103462.729296227 G_phys=9.6653162622153e-06 G_eff=9.6653162622153e-06
Rh7p1n1 in1 h7p 103462.729296227
* h7 input 2 w=-0.146738476402048 w-  bank=n alpha=1 R=227161.50631143 G_phys=4.40215429206143e-06 G_eff=4.40215429206143e-06
Rh7n2n1 in2n h7p 227161.50631143
* h7 input 3 w=+0.524171111363509 w+  bank=n alpha=1 R=63592.4655340589 G_phys=1.57251333409053e-05 G_eff=1.57251333409053e-05
Rh7p3n1 in3 h7p 63592.4655340589
* h7 input 4 w=-0.439531494343149 w-  bank=n alpha=1 R=75838.3273151968 G_phys=1.31859448302945e-05 G_eff=1.31859448302945e-05
Rh7n4n1 in4n h7p 75838.3273151968
* h7 input 5 w=+0.367500929015048 w+  bank=n alpha=1 R=90702.718555491 G_phys=1.10250278704514e-05 G_eff=1.10250278704514e-05
Rh7p5n1 in5 h7p 90702.718555491
* h7 input 6 w=-1.05409273633464 w-  bank=n alpha=1 R=31622.7711133294 G_phys=3.16227820900391e-05 G_eff=3.16227820900391e-05
Rh7n6n1 in6n h7p 31622.7711133294
* h7 input 7 w=-0.045065971974084 w-  bank=n alpha=1 R=739656.372051673 G_phys=1.35197915922252e-06 G_eff=1.35197915922252e-06
Rh7n7n1 in7n h7p 739656.372051673
* h7 input 8 w=-0.167915862386558 w-  bank=n alpha=1 R=198512.117077998 G_phys=5.03747587159673e-06 G_eff=5.03747587159673e-06
Rh7n8n1 in8n h7p 198512.117077998
* h7 input 9 w=+0.0197430594045346 w+  bank=f alpha=0.001 R=1688.35703982521 G_phys=0.000592291782136037 G_eff=5.92291782136037e-07
Rh7p9f1 tap9 h7p 1688.35703982521
* h7 input 10 w=-0.287534460104587 w-  bank=n alpha=1 R=115928.133696423 G_phys=8.6260338031376e-06 G_eff=8.6260338031376e-06
Rh7n10n1 in10n h7p 115928.133696423
* h7 input 11 w=-0.517871662481308 w-  bank=n alpha=1 R=64366.0114044885 G_phys=1.55361498744393e-05 G_eff=1.55361498744393e-05
Rh7n11n1 in11n h7p 64366.0114044885
* h7 input 12 w=+0.348150035983652 w+  bank=n alpha=1 R=95744.1616777503 G_phys=1.04445010795096e-05 G_eff=1.04445010795096e-05
Rh7p12n1 in12 h7p 95744.1616777503
* h7 input 13 w=-0.408247593362815 w-  bank=n alpha=1 R=81649.7975132203 G_phys=1.22474278008844e-05 G_eff=1.22474278008844e-05
Rh7n13n1 in13n h7p 81649.7975132203
* h7 input 14 w=-0.41711419269885 w-  bank=n alpha=1 R=79914.1671916195 G_phys=1.25134257809655e-05 G_eff=1.25134257809655e-05
Rh7n14n1 in14n h7p 79914.1671916195
* h7 input 15 w=-0.341449872918214 w-  bank=n alpha=1 R=97622.9191372918 G_phys=1.02434961875464e-05 G_eff=1.02434961875464e-05
Rh7n15n1 in15n h7p 97622.9191372918
* h7 input 16 w=-0.0335582003371702 w-  bank=n alpha=1 R=993299.193592697 G_phys=1.00674601011511e-06 G_eff=1.00674601011511e-06
Rh7n16n1 in16n h7p 993299.193592697
* h7 bias w-  bank=f alpha=0.001 R=1569.92559182808 G_phys=0.000636972863685573 G_eff=6.36972863685573e-07
Rh7bnf1 taprefn h7p 1569.92559182808
Vh7p h7p 0 DC 0
Bh7crelu 0 h7iy I = max(0, i(Vh7p))
Vh7iy h7iy 0 DC 0
* current-mode hidden h7: I_y = max(0, I_sum), no hidden voltage

* h8 input 1 w=+0.185544590700454 w+  bank=n alpha=1 R=179651.334525549 G_phys=5.56633772101363e-06 G_eff=5.56633772101363e-06
Rh8p1n1 in1 h8p 179651.334525549
* h8 input 2 w=-0.385658106289114 w-  bank=n alpha=1 R=86432.3419882805 G_phys=1.15697431886734e-05 G_eff=1.15697431886734e-05
Rh8n2n1 in2n h8p 86432.3419882805
* h8 input 3 w=+0.230915543832556 w+  bank=n alpha=1 R=144352.92133259 G_phys=6.92746631497669e-06 G_eff=6.92746631497669e-06
Rh8p3n1 in3 h8p 144352.92133259
* h8 input 4 w=+0.205353187615931 w+  bank=n alpha=1 R=162321.966950307 G_phys=6.16059562847793e-06 G_eff=6.16059562847793e-06
Rh8p4n1 in4 h8p 162321.966950307
* h8 input 5 w=+0.00415238713767869 w+  bank=f alpha=0.001 R=8027.51097817138 G_phys=0.000124571614130361 G_eff=1.24571614130361e-07
Rh8p5f1 tap5 h8p 8027.51097817138
* h8 input 6 w=-0.514726379917983 w-  bank=n alpha=1 R=64759.3257968335 G_phys=1.54417913975395e-05 G_eff=1.54417913975395e-05
Rh8n6n1 in6n h8p 64759.3257968335
* h8 input 7 w=+0.210716479044664 w+  bank=n alpha=1 R=158190.443787113 G_phys=6.32149437133992e-06 G_eff=6.32149437133992e-06
Rh8p7n1 in7 h8p 158190.443787113
* h8 input 8 w=+0.375574589425665 w+  bank=n alpha=1 R=88752.8982839526 G_phys=1.126723768277e-05 G_eff=1.126723768277e-05
Rh8p8n1 in8 h8p 88752.8982839526
* h8 input 9 w=+0.00572491873576676 w+  bank=f alpha=0.001 R=5822.49895096002 G_phys=0.000171747562073003 G_eff=1.71747562073003e-07
Rh8p9f1 tap9 h8p 5822.49895096002
* h8 input 10 w=-0.367556769900021 w-  bank=n alpha=1 R=90688.9385887256 G_phys=1.10267030970006e-05 G_eff=1.10267030970006e-05
Rh8n10n1 in10n h8p 90688.9385887256
* h8 input 11 w=+0.41225604099869 w+  bank=n alpha=1 R=80855.9002618455 G_phys=1.23676812299607e-05 G_eff=1.23676812299607e-05
Rh8p11n1 in11 h8p 80855.9002618455
* h8 input 12 w=+0.21126612483399 w+  bank=n alpha=1 R=157778.883668767 G_phys=6.33798374501969e-06 G_eff=6.33798374501969e-06
Rh8p12n1 in12 h8p 157778.883668767
* h8 input 13 w=+0.318427374873886 w+  bank=n alpha=1 R=104681.117151235 G_phys=9.55282124621658e-06 G_eff=9.55282124621658e-06
Rh8p13n1 in13 h8p 104681.117151235
* h8 input 14 w=-0.262828471961964 w-  bank=n alpha=1 R=126825.427566909 G_phys=7.88485415885892e-06 G_eff=7.88485415885892e-06
Rh8n14n1 in14n h8p 126825.427566909
* h8 input 15 w=+0.319620775512722 w+  bank=n alpha=1 R=104290.258603689 G_phys=9.58862326538165e-06 G_eff=9.58862326538165e-06
Rh8p15n1 in15 h8p 104290.258603689
* h8 input 16 w=+0.15331491024055 w+  bank=n alpha=1 R=217417.427183263 G_phys=4.59944730721651e-06 G_eff=4.59944730721651e-06
Rh8p16n1 in16 h8p 217417.427183263
* h8 bias w-  bank=f alpha=0.001 R=1092.27499465772 G_phys=0.00091552036336176 G_eff=9.1552036336176e-07
Rh8bnf1 taprefn h8p 1092.27499465772
Vh8p h8p 0 DC 0
Bh8crelu 0 h8iy I = max(0, i(Vh8p))
Vh8iy h8iy 0 DC 0
* current-mode hidden h8: I_y = max(0, I_sum), no hidden voltage

* h9 input 1 w=-0.192368051906404 w-  bank=n alpha=1 R=173278.946285486 G_phys=5.77104155719211e-06 G_eff=5.77104155719211e-06
Rh9n1n1 in1n h9p 173278.946285486
* h9 input 2 w=-0.0188071151742732 w-  bank=f alpha=0.001 R=1772.37885898263 G_phys=0.000564213455228197 G_eff=5.64213455228197e-07
Rh9n2f1 tap2n h9p 1772.37885898263
* h9 input 3 w=+0.675590388456855 w+  bank=n alpha=1 R=49339.5612235861 G_phys=2.02677116537057e-05 G_eff=2.02677116537057e-05
Rh9p3n1 in3 h9p 49339.5612235861
* h9 input 4 w=-0.777819910920126 w-  bank=n alpha=1 R=42854.8213607717 G_phys=2.33345973276038e-05 G_eff=2.33345973276038e-05
Rh9n4n1 in4n h9p 42854.8213607717
* h9 input 5 w=-0.0591658911038067 w-  bank=n alpha=1 R=563387.666634648 G_phys=1.7749767331142e-06 G_eff=1.7749767331142e-06
Rh9n5n1 in5n h9p 563387.666634648
* h9 input 6 w=-0.373077376819092 w-  bank=n alpha=1 R=89346.9703725748 G_phys=1.11923213045728e-05 G_eff=1.11923213045728e-05
Rh9n6n1 in6n h9p 89346.9703725748
* h9 input 7 w=+0.173600484730372 w+  bank=n alpha=1 R=192011.752646342 G_phys=5.20801454191117e-06 G_eff=5.20801454191117e-06
Rh9p7n1 in7 h9p 192011.752646342
* h9 input 8 w=+0.21285190098274 w+  bank=n alpha=1 R=156603.409128286 G_phys=6.38555702948219e-06 G_eff=6.38555702948219e-06
Rh9p8n1 in8 h9p 156603.409128286
* h9 input 9 w=+0.47939396555815 w+  bank=n alpha=1 R=69532.2338789223 G_phys=1.43818189667445e-05 G_eff=1.43818189667445e-05
Rh9p9n1 in9 h9p 69532.2338789223
* h9 input 10 w=-0.695860852133009 w-  bank=n alpha=1 R=47902.2971778874 G_phys=2.08758255639903e-05 G_eff=2.08758255639903e-05
Rh9n10n1 in10n h9p 47902.2971778874
* h9 input 11 w=+0.426719797848979 w+  bank=n alpha=1 R=78115.2726012736 G_phys=1.28015939354694e-05 G_eff=1.28015939354694e-05
Rh9p11n1 in11 h9p 78115.2726012736
* h9 input 12 w=+0.190883817865507 w+  bank=n alpha=1 R=174626.292087365 G_phys=5.7265145359652e-06 G_eff=5.7265145359652e-06
Rh9p12n1 in12 h9p 174626.292087365
* h9 input 13 w=-0.203891646942192 w-  bank=n alpha=1 R=163485.526912165 G_phys=6.11674940826577e-06 G_eff=6.11674940826577e-06
Rh9n13n1 in13n h9p 163485.526912165
* h9 input 14 w=-0.0564974778722501 w-  bank=n alpha=1 R=589996.838597032 G_phys=1.6949243361675e-06 G_eff=1.6949243361675e-06
Rh9n14n1 in14n h9p 589996.838597032
* h9 input 15 w=-0.251891815788561 w-  bank=n alpha=1 R=132331.942699216 G_phys=7.55675447365683e-06 G_eff=7.55675447365683e-06
Rh9n15n1 in15n h9p 132331.942699216
* h9 input 16 w=-0.340248378281639 w-  bank=n alpha=1 R=97967.6479331866 G_phys=1.02074513484492e-05 G_eff=1.02074513484492e-05
Rh9n16n1 in16n h9p 97967.6479331866
* h9 bias w-  bank=f alpha=0.001 R=1259.76757958347 G_phys=0.000793797218000037 G_eff=7.93797218000037e-07
Rh9bnf1 taprefn h9p 1259.76757958347
Vh9p h9p 0 DC 0
Bh9crelu 0 h9iy I = max(0, i(Vh9p))
Vh9iy h9iy 0 DC 0
* current-mode hidden h9: I_y = max(0, I_sum), no hidden voltage

* h10 input 1 w=+0.0856004623316453 w+  bank=n alpha=1 R=389405.996479186 G_phys=2.56801386994936e-06 G_eff=2.56801386994936e-06
Rh10p1n1 in1 h10p 389405.996479186
* h10 input 2 w=+0.717707405140542 w+  bank=n alpha=1 R=46444.1819808254 G_phys=2.15312221542163e-05 G_eff=2.15312221542163e-05
Rh10p2n1 in2 h10p 46444.1819808254
* h10 input 3 w=+0.367326370670395 w+  bank=n alpha=1 R=90745.8216857607 G_phys=1.10197911201119e-05 G_eff=1.10197911201119e-05
Rh10p3n1 in3 h10p 90745.8216857607
* h10 input 4 w=+0.5220921972442 w+  bank=n alpha=1 R=63845.6837878046 G_phys=1.5662765917326e-05 G_eff=1.5662765917326e-05
Rh10p4n1 in4 h10p 63845.6837878046
* h10 input 5 w=+0.0909071116243784 w+  bank=n alpha=1 R=366674.649955487 G_phys=2.72721334873135e-06 G_eff=2.72721334873135e-06
Rh10p5n1 in5 h10p 366674.649955487
* h10 input 6 w=-0.0568053629833511 w-  bank=n alpha=1 R=586799.055277631 G_phys=1.70416088950053e-06 G_eff=1.70416088950053e-06
Rh10n6n1 in6n h10p 586799.055277631
* h10 input 7 w=+0.372078007523385 w+  bank=n alpha=1 R=89586.9485950155 G_phys=1.11623402257016e-05 G_eff=1.11623402257016e-05
Rh10p7n1 in7 h10p 89586.9485950155
* h10 input 8 w=+0.384900055079612 w+  bank=n alpha=1 R=86602.568363984 G_phys=1.15470016523884e-05 G_eff=1.15470016523884e-05
Rh10p8n1 in8 h10p 86602.568363984
* h10 input 9 w=+0.617655459577812 w+  bank=n alpha=1 R=53967.5199440765 G_phys=1.85296637873344e-05 G_eff=1.85296637873344e-05
Rh10p9n1 in9 h10p 53967.5199440765
* h10 input 10 w=+0.306521845436409 w+  bank=n alpha=1 R=108747.007202293 G_phys=9.19565536309227e-06 G_eff=9.19565536309227e-06
Rh10p10n1 in10 h10p 108747.007202293
* h10 input 11 w=-0.0307901580575706 w-  bank=f alpha=0.001 R=1082.5970191841 G_phys=0.000923704741727117 G_eff=9.23704741727117e-07
Rh10n11f1 tap11n h10p 1082.5970191841
* h10 input 12 w=+0.163538031424557 w+  bank=n alpha=1 R=203826.186746724 G_phys=4.9061409427367e-06 G_eff=4.9061409427367e-06
Rh10p12n1 in12 h10p 203826.186746724
* h10 input 13 w=-0.0170713095619708 w-  bank=f alpha=0.001 R=1952.59380730749 G_phys=0.000512139286859123 G_eff=5.12139286859123e-07
Rh10n13f1 tap13n h10p 1952.59380730749
* h10 input 14 w=-0.123347220224403 w-  bank=n alpha=1 R=270239.842233093 G_phys=3.7004166067321e-06 G_eff=3.7004166067321e-06
Rh10n14n1 in14n h10p 270239.842233093
* h10 input 15 w=-0.136765368652097 w-  bank=n alpha=1 R=243726.417453869 G_phys=4.10296105956291e-06 G_eff=4.10296105956291e-06
Rh10n15n1 in15n h10p 243726.417453869
* h10 input 16 w=+0.269183781267177 w+  bank=n alpha=1 R=123831.1356517 G_phys=8.07551343801532e-06 G_eff=8.07551343801532e-06
Rh10p16n1 in16 h10p 123831.1356517
* h10 bias w-  bank=n alpha=1 R=519656.094343386 G_phys=1.92434960522027e-06 G_eff=1.92434960522027e-06
Rh10bnn1 vrefn h10p 519656.094343386
Vh10p h10p 0 DC 0
Bh10crelu 0 h10iy I = max(0, i(Vh10p))
Vh10iy h10iy 0 DC 0
* current-mode hidden h10: I_y = max(0, I_sum), no hidden voltage

* h11 input 1 w=+0.100174494534941 w+  bank=n alpha=1 R=332752.69806035 G_phys=3.00523483604823e-06 G_eff=3.00523483604823e-06
Rh11p1n1 in1 h11p 332752.69806035
* h11 input 2 w=-0.350357054027393 w-  bank=n alpha=1 R=95141.0366943178 G_phys=1.05107116208218e-05 G_eff=1.05107116208218e-05
Rh11n2n1 in2n h11p 95141.0366943178
* h11 input 3 w=-0.364058373495884 w-  bank=n alpha=1 R=91560.4083302596 G_phys=1.09217512048765e-05 G_eff=1.09217512048765e-05
Rh11n3n1 in3n h11p 91560.4083302596
* h11 input 4 w=+0.201551043415431 w+  bank=n alpha=1 R=165384.077246515 G_phys=6.04653130246294e-06 G_eff=6.04653130246294e-06
Rh11p4n1 in4 h11p 165384.077246515
* h11 input 5 w=+0.30370864041576 w+  bank=n alpha=1 R=109754.313501591 G_phys=9.1112592124728e-06 G_eff=9.1112592124728e-06
Rh11p5n1 in5 h11p 109754.313501591
* h11 input 6 w=+0.221531530750713 w+  bank=n alpha=1 R=150467.670314809 G_phys=6.64594592252139e-06 G_eff=6.64594592252139e-06
Rh11p6n1 in6 h11p 150467.670314809
* h11 input 7 w=-0.554388667333083 w-  bank=n alpha=1 R=60126.2891856812 G_phys=1.66316600199925e-05 G_eff=1.66316600199925e-05
Rh11n7n1 in7n h11p 60126.2891856812
* h11 input 8 w=+0.382929077760783 w+  bank=n alpha=1 R=87048.3211362621 G_phys=1.14878723328235e-05 G_eff=1.14878723328235e-05
Rh11p8n1 in8 h11p 87048.3211362621
* h11 input 9 w=-0.415059943002996 w-  bank=n alpha=1 R=80309.6851316552 G_phys=1.24517982900899e-05 G_eff=1.24517982900899e-05
Rh11n9n1 in9n h11p 80309.6851316552
* h11 input 10 w=-0.579957638432045 w-  bank=n alpha=1 R=57475.4622138477 G_phys=1.73987291529614e-05 G_eff=1.73987291529614e-05
Rh11n10n1 in10n h11p 57475.4622138477
* h11 input 11 w=+0.208304459025755 w+  bank=n alpha=1 R=160022.178542092 G_phys=6.24913377077265e-06 G_eff=6.24913377077265e-06
Rh11p11n1 in11 h11p 160022.178542092
* h11 input 12 w=+0.150185585205542 w+  bank=n alpha=1 R=221947.620923232 G_phys=4.50556755616625e-06 G_eff=4.50556755616625e-06
Rh11p12n1 in12 h11p 221947.620923232
* h11 input 13 w=-0.130595100347527 w-  bank=n alpha=1 R=255241.837133476 G_phys=3.9178530104258e-06 G_eff=3.9178530104258e-06
Rh11n13n1 in13n h11p 255241.837133476
* h11 input 14 w=+0.223944918125423 w+  bank=n alpha=1 R=148846.125254178 G_phys=6.71834754376269e-06 G_eff=6.71834754376269e-06
Rh11p14n1 in14 h11p 148846.125254178
* h11 input 15 w=+0.219816736012751 w+  bank=n alpha=1 R=151641.471609331 G_phys=6.59450208038254e-06 G_eff=6.59450208038254e-06
Rh11p15n1 in15 h11p 151641.471609331
* h11 input 16 w=-0.0825561420887272 w-  bank=n alpha=1 R=403765.637419301 G_phys=2.47668426266182e-06 G_eff=2.47668426266182e-06
Rh11n16n1 in16n h11p 403765.637419301
* h11 bias w-  bank=f alpha=0.001 R=2978.62482206369 G_phys=0.000335725396697381 G_eff=3.35725396697381e-07
Rh11bnf1 taprefn h11p 2978.62482206369
Vh11p h11p 0 DC 0
Bh11crelu 0 h11iy I = max(0, i(Vh11p))
Vh11iy h11iy 0 DC 0
* current-mode hidden h11: I_y = max(0, I_sum), no hidden voltage

* h12 input 1 w=-0.0647804813106503 w-  bank=n alpha=1 R=514558.284516066 G_phys=1.94341443931951e-06 G_eff=1.94341443931951e-06
Rh12n1n1 in1n h12p 514558.284516066
* h12 input 2 w=-0.668825239918342 w-  bank=n alpha=1 R=49838.6295011879 G_phys=2.00647571975503e-05 G_eff=2.00647571975503e-05
Rh12n2n1 in2n h12p 49838.6295011879
* h12 input 3 w=+0.43152134817872 w+  bank=n alpha=1 R=77246.0817385283 G_phys=1.29456404453616e-05 G_eff=1.29456404453616e-05
Rh12p3n1 in3 h12p 77246.0817385283
* h12 input 4 w=+0.0766102486579458 w+  bank=n alpha=1 R=435102.795216892 G_phys=2.29830745973837e-06 G_eff=2.29830745973837e-06
Rh12p4n1 in4 h12p 435102.795216892
* h12 input 5 w=+0.112143595115044 w+  bank=n alpha=1 R=297237.959057206 G_phys=3.36430785345132e-06 G_eff=3.36430785345132e-06
Rh12p5n1 in5 h12p 297237.959057206
* h12 input 6 w=-0.214387519256146 w-  bank=n alpha=1 R=155481.687781961 G_phys=6.43162557768439e-06 G_eff=6.43162557768439e-06
Rh12n6n1 in6n h12p 155481.687781961
* h12 input 7 w=+0.0362945018752433 w+  bank=n alpha=1 R=918412.751548746 G_phys=1.0888350562573e-06 G_eff=1.0888350562573e-06
Rh12p7n1 in7 h12p 918412.751548746
* h12 input 8 w=-0.654320698371061 w-  bank=n alpha=1 R=50943.4187491196 G_phys=1.96296209511318e-05 G_eff=1.96296209511318e-05
Rh12n8n1 in8n h12p 50943.4187491196
* h12 input 9 w=-0.424313635659581 w-  bank=n alpha=1 R=78558.2421397273 G_phys=1.27294090697874e-05 G_eff=1.27294090697874e-05
Rh12n9n1 in9n h12p 78558.2421397273
* h12 input 10 w=-0.147731830075345 w-  bank=n alpha=1 R=225634.064888609 G_phys=4.43195490226035e-06 G_eff=4.43195490226035e-06
Rh12n10n1 in10n h12p 225634.064888609
* h12 input 11 w=+0.422841356490785 w+  bank=n alpha=1 R=78831.7718256581 G_phys=1.26852406947236e-05 G_eff=1.26852406947236e-05
Rh12p11n1 in11 h12p 78831.7718256581
* h12 input 12 w=+0.250573650346706 w+  bank=n alpha=1 R=133028.086900644 G_phys=7.51720951040119e-06 G_eff=7.51720951040119e-06
Rh12p12n1 in12 h12p 133028.086900644
* h12 input 13 w=+0.0601122436783251 w+  bank=n alpha=1 R=554518.202842467 G_phys=1.80336731034975e-06 G_eff=1.80336731034975e-06
Rh12p13n1 in13 h12p 554518.202842467
* h12 input 14 w=-0.651755086554606 w-  bank=n alpha=1 R=51143.9557910386 G_phys=1.95526525966382e-05 G_eff=1.95526525966382e-05
Rh12n14n1 in14n h12p 51143.9557910386
* h12 input 15 w=+0.130109285988943 w+  bank=n alpha=1 R=256194.88324735 G_phys=3.90327857966829e-06 G_eff=3.90327857966829e-06
Rh12p15n1 in15 h12p 256194.88324735
* h12 input 16 w=-0.0778767908450736 w-  bank=n alpha=1 R=428026.54002071 G_phys=2.33630372535221e-06 G_eff=2.33630372535221e-06
Rh12n16n1 in16n h12p 428026.54002071
* h12 bias w+  bank=f alpha=0.001 R=1892.24272993526 G_phys=0.000528473426891809 G_eff=5.28473426891809e-07
Rh12bpf1 tapref h12p 1892.24272993526
Vh12p h12p 0 DC 0
Bh12crelu 0 h12iy I = max(0, i(Vh12p))
Vh12iy h12iy 0 DC 0
* current-mode hidden h12: I_y = max(0, I_sum), no hidden voltage

* h13 input 1 w=+0.034343742118514 w+  bank=n alpha=1 R=970579.537264929 G_phys=1.03031226355542e-06 G_eff=1.03031226355542e-06
Rh13p1n1 in1 h13p 970579.537264929
* h13 input 2 w=-0.102232912320493 w-  bank=n alpha=1 R=326052.858876169 G_phys=3.06698736961478e-06 G_eff=3.06698736961478e-06
Rh13n2n1 in2n h13p 326052.858876169
* h13 input 3 w=+1.31993068300228 w+  bank=n alpha=1 R=25253.8514049194 G_phys=3.95979204900683e-05 G_eff=3.95979204900683e-05
Rh13p3n1 in3 h13p 25253.8514049194
* h13 input 4 w=-0.233319639483811 w-  bank=n alpha=1 R=142865.527338714 G_phys=6.99958918451433e-06 G_eff=6.99958918451433e-06
Rh13n4n1 in4n h13p 142865.527338714
* h13 input 5 w=-0.375430599339701 w-  bank=n alpha=1 R=88786.9379639253 G_phys=1.1262917980191e-05 G_eff=1.1262917980191e-05
Rh13n5n1 in5n h13p 88786.9379639253
* h13 input 6 w=+0.442115486842334 w+  bank=n alpha=1 R=75395.0818855177 G_phys=1.326346460527e-05 G_eff=1.326346460527e-05
Rh13p6n1 in6 h13p 75395.0818855177
* h13 input 7 w=-0.102130412545238 w-  bank=n alpha=1 R=326380.090930979 G_phys=3.06391237635715e-06 G_eff=3.06391237635715e-06
Rh13n7n1 in7n h13p 326380.090930979
* h13 input 8 w=-0.136235661297007 w-  bank=n alpha=1 R=244674.067098066 G_phys=4.08706983891021e-06 G_eff=4.08706983891021e-06
Rh13n8n1 in8n h13p 244674.067098066
* h13 input 9 w=+0.0915800560074952 w+  bank=n alpha=1 R=363980.268046628 G_phys=2.74740168022485e-06 G_eff=2.74740168022485e-06
Rh13p9n1 in9 h13p 363980.268046628
* h13 input 10 w=-0.194905587913072 w-  bank=n alpha=1 R=171022.974201232 G_phys=5.84716763739217e-06 G_eff=5.84716763739217e-06
Rh13n10n1 in10n h13p 171022.974201232
* h13 input 11 w=-0.611958537828416 w-  bank=n alpha=1 R=54469.9212002489 G_phys=1.83587561348525e-05 G_eff=1.83587561348525e-05
Rh13n11n1 in11n h13p 54469.9212002489
* h13 input 12 w=+0.19411196838682 w+  bank=n alpha=1 R=171722.195237894 G_phys=5.8233590516046e-06 G_eff=5.8233590516046e-06
Rh13p12n1 in12 h13p 171722.195237894
* h13 input 13 w=+0.146421986160596 w+  bank=n alpha=1 R=227652.514539539 G_phys=4.39265958481789e-06 G_eff=4.39265958481789e-06
Rh13p13n1 in13 h13p 227652.514539539
* h13 input 14 w=+0.246088955287688 w+  bank=n alpha=1 R=135452.374505655 G_phys=7.38266865863065e-06 G_eff=7.38266865863065e-06
Rh13p14n1 in14 h13p 135452.374505655
* h13 input 15 w=-0.101801651380703 w-  bank=n alpha=1 R=327434.112131228 G_phys=3.05404954142109e-06 G_eff=3.05404954142109e-06
Rh13n15n1 in15n h13p 327434.112131228
* h13 input 16 w=-0.212672591801914 w-  bank=n alpha=1 R=156735.445084435 G_phys=6.38017775405741e-06 G_eff=6.38017775405741e-06
Rh13n16n1 in16n h13p 156735.445084435
* h13 bias w+  bank=f alpha=0.001 R=1569.64655542844 G_phys=0.000637086098486067 G_eff=6.37086098486067e-07
Rh13bpf1 tapref h13p 1569.64655542844
Vh13p h13p 0 DC 0
Bh13crelu 0 h13iy I = max(0, i(Vh13p))
Vh13iy h13iy 0 DC 0
* current-mode hidden h13: I_y = max(0, I_sum), no hidden voltage

* h14 input 1 w=-0.089975491938664 w-  bank=n alpha=1 R=370471.254061679 G_phys=2.69926475815992e-06 G_eff=2.69926475815992e-06
Rh14n1n1 in1n h14p 370471.254061679
* h14 input 2 w=-0.0792638889786837 w-  bank=n alpha=1 R=420536.183157725 G_phys=2.37791666936051e-06 G_eff=2.37791666936051e-06
Rh14n2n1 in2n h14p 420536.183157725
* h14 input 3 w=-0.392380373690676 w-  bank=n alpha=1 R=84951.5815987547 G_phys=1.17714112107203e-05 G_eff=1.17714112107203e-05
Rh14n3n1 in3n h14p 84951.5815987547
* h14 input 4 w=+0.471386854681532 w+  bank=n alpha=1 R=70713.3281343902 G_phys=1.4141605640446e-05 G_eff=1.4141605640446e-05
Rh14p4n1 in4 h14p 70713.3281343902
* h14 input 5 w=-0.118903138220599 w-  bank=n alpha=1 R=280340.231823744 G_phys=3.56709414661796e-06 G_eff=3.56709414661796e-06
Rh14n5n1 in5n h14p 280340.231823744
* h14 input 6 w=+0.618408634475196 w+  bank=n alpha=1 R=53901.7915906385 G_phys=1.85522590342559e-05 G_eff=1.85522590342559e-05
Rh14p6n1 in6 h14p 53901.7915906385
* h14 input 7 w=-0.0462466843022721 w-  bank=n alpha=1 R=720772.393442608 G_phys=1.38740052906816e-06 G_eff=1.38740052906816e-06
Rh14n7n1 in7n h14p 720772.393442608
* h14 input 8 w=-0.0297824475583231 w-  bank=f alpha=0.001 R=1119.22746671698 G_phys=0.000893473426749692 G_eff=8.93473426749692e-07
Rh14n8f1 tap8n h14p 1119.22746671698
* h14 input 9 w=+0.0766531636417715 w+  bank=n alpha=1 R=434859.198885937 G_phys=2.29959490925314e-06 G_eff=2.29959490925314e-06
Rh14p9n1 in9 h14p 434859.198885937
* h14 input 10 w=-0.0192124865162136 w-  bank=f alpha=0.001 R=1734.98278347277 G_phys=0.000576374595486407 G_eff=5.76374595486407e-07
Rh14n10f1 tap10n h14p 1734.98278347277
* h14 input 11 w=-0.118584174544602 w-  bank=n alpha=1 R=281094.281436313 G_phys=3.55752523633807e-06 G_eff=3.55752523633807e-06
Rh14n11n1 in11n h14p 281094.281436313
* h14 input 12 w=+0.498792575097448 w+  bank=n alpha=1 R=66828.0463613979 G_phys=1.49637772529234e-05 G_eff=1.49637772529234e-05
Rh14p12n1 in12 h14p 66828.0463613979
* h14 input 13 w=+0.131240430694277 w+  bank=n alpha=1 R=253986.771888785 G_phys=3.93721292082832e-06 G_eff=3.93721292082832e-06
Rh14p13n1 in13 h14p 253986.771888785
* h14 input 14 w=-0.699789872634837 w-  bank=n alpha=1 R=47633.346289833 G_phys=2.09936961790451e-05 G_eff=2.09936961790451e-05
Rh14n14n1 in14n h14p 47633.346289833
* h14 input 15 w=+0.0882030102342884 w+  bank=n alpha=1 R=377916.051218569 G_phys=2.64609030702865e-06 G_eff=2.64609030702865e-06
Rh14p15n1 in15 h14p 377916.051218569
* h14 input 16 w=-0.409062788225599 w-  bank=n alpha=1 R=81487.082894839 G_phys=1.2271883646768e-05 G_eff=1.2271883646768e-05
Rh14n16n1 in16n h14p 81487.082894839
* h14 bias w+  bank=n alpha=1 R=404190.380335226 G_phys=2.47408164234543e-06 G_eff=2.47408164234543e-06
Rh14bpn1 vref h14p 404190.380335226
Vh14p h14p 0 DC 0
Bh14crelu 0 h14iy I = max(0, i(Vh14p))
Vh14iy h14iy 0 DC 0
* current-mode hidden h14: I_y = max(0, I_sum), no hidden voltage

* h15 input 1 w=-0.104362920527351 w-  bank=n alpha=1 R=319398.241874589 G_phys=3.13088761582053e-06 G_eff=3.13088761582053e-06
Rh15n1n1 in1n h15p 319398.241874589
* h15 input 2 w=+0.0920701784982539 w+  bank=n alpha=1 R=362042.670895501 G_phys=2.76210535494762e-06 G_eff=2.76210535494762e-06
Rh15p2n1 in2 h15p 362042.670895501
* h15 input 3 w=+0.710914651543076 w+  bank=n alpha=1 R=46887.9537944276 G_phys=2.13274395462923e-05 G_eff=2.13274395462923e-05
Rh15p3n1 in3 h15p 46887.9537944276
* h15 input 4 w=+0.0431405504557543 w+  bank=n alpha=1 R=772668.243246468 G_phys=1.29421651367263e-06 G_eff=1.29421651367263e-06
Rh15p4n1 in4 h15p 772668.243246468
* h15 input 5 w=-0.544653793286569 w-  bank=n alpha=1 R=61200.9569091444 G_phys=1.63396137985971e-05 G_eff=1.63396137985971e-05
Rh15n5n1 in5n h15p 61200.9569091444
* h15 input 6 w=+0.236607896967987 w+  bank=n alpha=1 R=140880.054133795 G_phys=7.0982369090396e-06 G_eff=7.0982369090396e-06
Rh15p6n1 in6 h15p 140880.054133795
* h15 input 7 w=+0.205722108048513 w+  bank=n alpha=1 R=162030.875774774 G_phys=6.17166324145539e-06 G_eff=6.17166324145539e-06
Rh15p7n1 in7 h15p 162030.875774774
* h15 input 8 w=+0.119910326826568 w+  bank=n alpha=1 R=277985.509801377 G_phys=3.59730980479705e-06 G_eff=3.59730980479705e-06
Rh15p8n1 in8 h15p 277985.509801377
* h15 input 9 w=-0.0351999996705356 w-  bank=n alpha=1 R=946969.705833129 G_phys=1.05599999011607e-06 G_eff=1.05599999011607e-06
Rh15n9n1 in9n h15p 946969.705833129
* h15 input 10 w=-0.0279846802936883 w-  bank=f alpha=0.001 R=1191.12789510236 G_phys=0.000839540408810648 G_eff=8.39540408810648e-07
Rh15n10f1 tap10n h15p 1191.12789510236
* h15 input 11 w=-0.155672537202176 w-  bank=n alpha=1 R=214124.68719542 G_phys=4.67017611606528e-06 G_eff=4.67017611606528e-06
Rh15n11n1 in11n h15p 214124.68719542
* h15 input 12 w=-0.248740189524738 w-  bank=n alpha=1 R=134008.635263254 G_phys=7.46220568574215e-06 G_eff=7.46220568574215e-06
Rh15n12n1 in12n h15p 134008.635263254
* h15 input 13 w=+0.142944744841187 w+  bank=n alpha=1 R=233190.337779587 G_phys=4.28834234523561e-06 G_eff=4.28834234523561e-06
Rh15p13n1 in13 h15p 233190.337779587
* h15 input 14 w=-0.364164748984914 w-  bank=n alpha=1 R=91533.6627892949 G_phys=1.09249424695474e-05 G_eff=1.09249424695474e-05
Rh15n14n1 in14n h15p 91533.6627892949
* h15 input 15 w=-0.240848341925517 w-  bank=n alpha=1 R=138399.679511357 G_phys=7.22545025776552e-06 G_eff=7.22545025776552e-06
Rh15n15n1 in15n h15p 138399.679511357
* h15 input 16 w=-0.736896288827917 w-  bank=n alpha=1 R=45234.7689066968 G_phys=2.21068886648375e-05 G_eff=2.21068886648375e-05
Rh15n16n1 in16n h15p 45234.7689066968
* h15 bias w+  bank=f alpha=0.001 R=23679.3163125671 G_phys=4.22309490189663e-05 G_eff=4.22309490189663e-08
Rh15bpf1 tapref h15p 23679.3163125671
Vh15p h15p 0 DC 0
Bh15crelu 0 h15iy I = max(0, i(Vh15p))
Vh15iy h15iy 0 DC 0
* current-mode hidden h15: I_y = max(0, I_sum), no hidden voltage

* h16 input 1 w=-0.211528252190937 w-  bank=n alpha=1 R=157583.362922343 G_phys=6.3458475657281e-06 G_eff=6.3458475657281e-06
Rh16n1n1 in1n h16p 157583.362922343
* h16 input 2 w=-0.194947045242045 w-  bank=n alpha=1 R=170986.604551748 G_phys=5.84841135726135e-06 G_eff=5.84841135726135e-06
Rh16n2n1 in2n h16p 170986.604551748
* h16 input 3 w=-0.281660896127353 w-  bank=n alpha=1 R=118345.619827403 G_phys=8.44982688382059e-06 G_eff=8.44982688382059e-06
Rh16n3n1 in3n h16p 118345.619827403
* h16 input 4 w=-0.246854224570453 w-  bank=n alpha=1 R=135032.460519305 G_phys=7.4056267371136e-06 G_eff=7.4056267371136e-06
Rh16n4n1 in4n h16p 135032.460519305
* h16 input 5 w=+0.785179968580328 w+  bank=n alpha=1 R=42453.112238208 G_phys=2.35553990574098e-05 G_eff=2.35553990574098e-05
Rh16p5n1 in5 h16p 42453.112238208
* h16 input 6 w=-0.342055263707418 w-  bank=n alpha=1 R=97450.1399921314 G_phys=1.02616579112226e-05 G_eff=1.02616579112226e-05
Rh16n6n1 in6n h16p 97450.1399921314
* h16 input 7 w=-0.213390213186068 w-  bank=n alpha=1 R=156208.351056231 G_phys=6.40170639558203e-06 G_eff=6.40170639558203e-06
Rh16n7n1 in7n h16p 156208.351056231
* h16 input 8 w=-0.06183287092446 w-  bank=n alpha=1 R=539087.589415927 G_phys=1.8549861277338e-06 G_eff=1.8549861277338e-06
Rh16n8n1 in8n h16p 539087.589415927
* h16 input 9 w=+0.114369297885863 w+  bank=n alpha=1 R=291453.510247121 G_phys=3.43107893657588e-06 G_eff=3.43107893657588e-06
Rh16p9n1 in9 h16p 291453.510247121
* h16 input 10 w=+0.418702574206734 w+  bank=n alpha=1 R=79611.0064440994 G_phys=1.2561077226202e-05 G_eff=1.2561077226202e-05
Rh16p10n1 in10 h16p 79611.0064440994
* h16 input 11 w=-0.38263995973155 w-  bank=n alpha=1 R=87114.0937729534 G_phys=1.14791987919465e-05 G_eff=1.14791987919465e-05
Rh16n11n1 in11n h16p 87114.0937729534
* h16 input 12 w=-0.447982918675276 w-  bank=n alpha=1 R=74407.5989144918 G_phys=1.34394875602583e-05 G_eff=1.34394875602583e-05
Rh16n12n1 in12n h16p 74407.5989144918
* h16 input 13 w=-0.354860709093241 w-  bank=n alpha=1 R=93933.5702126856 G_phys=1.06458212727972e-05 G_eff=1.06458212727972e-05
Rh16n13n1 in13n h16p 93933.5702126856
* h16 input 14 w=-0.245379266072843 w-  bank=n alpha=1 R=135844.131685674 G_phys=7.36137798218528e-06 G_eff=7.36137798218528e-06
Rh16n14n1 in14n h16p 135844.131685674
* h16 input 15 w=-0.0999148922371372 w-  bank=n alpha=1 R=333617.267526249 G_phys=2.99744676711412e-06 G_eff=2.99744676711412e-06
Rh16n15n1 in15n h16p 333617.267526249
* h16 input 16 w=-0.428765175056332 w-  bank=n alpha=1 R=77742.632267077 G_phys=1.286295525169e-05 G_eff=1.286295525169e-05
Rh16n16n1 in16n h16p 77742.632267077
* h16 bias w+  bank=n alpha=1 R=388758.166916054 G_phys=2.572293227774e-06 G_eff=2.572293227774e-06
Rh16bpn1 vref h16p 388758.166916054
Vh16p h16p 0 DC 0
Bh16crelu 0 h16iy I = max(0, i(Vh16p))
Vh16iy h16iy 0 DC 0
* current-mode hidden h16: I_y = max(0, I_sum), no hidden voltage

* h17 input 1 w=+0.690050155404084 w+  bank=n alpha=1 R=48305.667453714 G_phys=2.07015046621225e-05 G_eff=2.07015046621225e-05
Rh17p1n1 in1 h17p 48305.667453714
* h17 input 2 w=-0.128803090681736 w-  bank=n alpha=1 R=258792.961852894 G_phys=3.86409272045207e-06 G_eff=3.86409272045207e-06
Rh17n2n1 in2n h17p 258792.961852894
* h17 input 3 w=-0.49836012605351 w-  bank=n alpha=1 R=66886.036002315 G_phys=1.49508037816053e-05 G_eff=1.49508037816053e-05
Rh17n3n1 in3n h17p 66886.036002315
* h17 input 4 w=-0.0597081457071854 w-  bank=n alpha=1 R=558271.119267432 G_phys=1.79124437121556e-06 G_eff=1.79124437121556e-06
Rh17n4n1 in4n h17p 558271.119267432
* h17 input 5 w=+0.0531710366485299 w+  bank=n alpha=1 R=626907.71958562 G_phys=1.5951310994559e-06 G_eff=1.5951310994559e-06
Rh17p5n1 in5 h17p 626907.71958562
* h17 input 6 w=+0.325686197829899 w+  bank=n alpha=1 R=102348.007239603 G_phys=9.77058593489698e-06 G_eff=9.77058593489698e-06
Rh17p6n1 in6 h17p 102348.007239603
* h17 input 7 w=-0.138446110206034 w-  bank=n alpha=1 R=240767.568577601 G_phys=4.15338330618101e-06 G_eff=4.15338330618101e-06
Rh17n7n1 in7n h17p 240767.568577601
* h17 input 8 w=-0.354640771144099 w-  bank=n alpha=1 R=93991.8250961316 G_phys=1.0639223134323e-05 G_eff=1.0639223134323e-05
Rh17n8n1 in8n h17p 93991.8250961316
* h17 input 9 w=+0.283153126675736 w+  bank=n alpha=1 R=117721.932738911 G_phys=8.49459380027208e-06 G_eff=8.49459380027208e-06
Rh17p9n1 in9 h17p 117721.932738911
* h17 input 10 w=+0.187509087652136 w+  bank=n alpha=1 R=177769.161754831 G_phys=5.62527262956408e-06 G_eff=5.62527262956408e-06
Rh17p10n1 in10 h17p 177769.161754831
* h17 input 11 w=+0.286891884918939 w+  bank=n alpha=1 R=116187.78740553 G_phys=8.60675654756817e-06 G_eff=8.60675654756817e-06
Rh17p11n1 in11 h17p 116187.78740553
* h17 input 12 w=-0.663420236101193 w-  bank=n alpha=1 R=50244.6737670041 G_phys=1.99026070830358e-05 G_eff=1.99026070830358e-05
Rh17n12n1 in12n h17p 50244.6737670041
* h17 input 13 w=-0.00672050178940724 w-  bank=f alpha=0.001 R=4959.94709589586 G_phys=0.000201615053682217 G_eff=2.01615053682217e-07
Rh17n13f1 tap13n h17p 4959.94709589586
* h17 input 14 w=+0.213870810385993 w+  bank=n alpha=1 R=155857.32935305 G_phys=6.41612431157979e-06 G_eff=6.41612431157979e-06
Rh17p14n1 in14 h17p 155857.32935305
* h17 input 15 w=+0.856655380645102 w+  bank=n alpha=1 R=38911.0184637278 G_phys=2.56996614193531e-05 G_eff=2.56996614193531e-05
Rh17p15n1 in15 h17p 38911.0184637278
* h17 input 16 w=-0.153994690926048 w-  bank=n alpha=1 R=216457.6787218 G_phys=4.61984072778143e-06 G_eff=4.61984072778143e-06
Rh17n16n1 in16n h17p 216457.6787218
* h17 bias w+  bank=n alpha=1 R=358017.249275869 G_phys=2.79316150834244e-06 G_eff=2.79316150834244e-06
Rh17bpn1 vref h17p 358017.249275869
Vh17p h17p 0 DC 0
Bh17crelu 0 h17iy I = max(0, i(Vh17p))
Vh17iy h17iy 0 DC 0
* current-mode hidden h17: I_y = max(0, I_sum), no hidden voltage

* h18 input 1 w=+0.00309692999044255 w+  bank=f alpha=0.001 R=10763.3473911917 G_phys=9.29078997132766e-05 G_eff=9.29078997132766e-08
Rh18p1f1 tap1 h18p 10763.3473911917
* h18 input 2 w=-0.290006429631547 w-  bank=n alpha=1 R=114939.98038486 G_phys=8.70019288894641e-06 G_eff=8.70019288894641e-06
Rh18n2n1 in2n h18p 114939.98038486
* h18 input 3 w=+0.161902441115013 w+  bank=n alpha=1 R=205885.304160755 G_phys=4.8570732334504e-06 G_eff=4.8570732334504e-06
Rh18p3n1 in3 h18p 205885.304160755
* h18 input 4 w=-0.201165440039706 w-  bank=n alpha=1 R=165701.093223339 G_phys=6.03496320119118e-06 G_eff=6.03496320119118e-06
Rh18n4n1 in4n h18p 165701.093223339
* h18 input 5 w=+0.167521926893116 w+  bank=n alpha=1 R=198978.927424831 G_phys=5.02565780679349e-06 G_eff=5.02565780679349e-06
Rh18p5n1 in5 h18p 198978.927424831
* h18 input 6 w=+0.306365656745506 w+  bank=n alpha=1 R=108802.447661498 G_phys=9.19096970236517e-06 G_eff=9.19096970236517e-06
Rh18p6n1 in6 h18p 108802.447661498
* h18 input 7 w=+0.567135277617062 w+  bank=n alpha=1 R=58774.9248704654 G_phys=1.70140583285119e-05 G_eff=1.70140583285119e-05
Rh18p7n1 in7 h18p 58774.9248704654
* h18 input 8 w=+0.27754647202065 w+  bank=n alpha=1 R=120100.007363283 G_phys=8.3263941606195e-06 G_eff=8.3263941606195e-06
Rh18p8n1 in8 h18p 120100.007363283
* h18 input 9 w=-0.295299170614896 w-  bank=n alpha=1 R=112879.874548662 G_phys=8.85897511844687e-06 G_eff=8.85897511844687e-06
Rh18n9n1 in9n h18p 112879.874548662
* h18 input 10 w=+0.627786354607437 w+  bank=n alpha=1 R=53096.6197157584 G_phys=1.88335906382231e-05 G_eff=1.88335906382231e-05
Rh18p10n1 in10 h18p 53096.6197157584
* h18 input 11 w=+0.158870042328046 w+  bank=n alpha=1 R=209815.09694889 G_phys=4.76610126984139e-06 G_eff=4.76610126984139e-06
Rh18p11n1 in11 h18p 209815.09694889
* h18 input 12 w=+0.503831351799562 w+  bank=n alpha=1 R=66159.704461175 G_phys=1.51149405539869e-05 G_eff=1.51149405539869e-05
Rh18p12n1 in12 h18p 66159.704461175
* h18 input 13 w=+0.0259448474340262 w+  bank=f alpha=0.001 R=1284.77661771166 G_phys=0.000778345423020786 G_eff=7.78345423020786e-07
Rh18p13f1 tap13 h18p 1284.77661771166
* h18 input 14 w=-0.0445667146819355 w-  bank=n alpha=1 R=747942.350501428 G_phys=1.33700144045806e-06 G_eff=1.33700144045806e-06
Rh18n14n1 in14n h18p 747942.350501428
* h18 input 15 w=-0.425048584977393 w-  bank=n alpha=1 R=78422.4074880905 G_phys=1.27514575493218e-05 G_eff=1.27514575493218e-05
Rh18n15n1 in15n h18p 78422.4074880905
* h18 input 16 w=-0.290071708244206 w-  bank=n alpha=1 R=114914.113944786 G_phys=8.70215124732617e-06 G_eff=8.70215124732617e-06
Rh18n16n1 in16n h18p 114914.113944786
* h18 bias w+  bank=n alpha=1 R=322935.946819115 G_phys=3.09658930772463e-06 G_eff=3.09658930772463e-06
Rh18bpn1 vref h18p 322935.946819115
Vh18p h18p 0 DC 0
Bh18crelu 0 h18iy I = max(0, i(Vh18p))
Vh18iy h18iy 0 DC 0
* current-mode hidden h18: I_y = max(0, I_sum), no hidden voltage

* h19 input 1 w=+0.361917529899694 w+  bank=n alpha=1 R=92102.0138001377 G_phys=1.08575258969908e-05 G_eff=1.08575258969908e-05
Rh19p1n1 in1 h19p 92102.0138001377
* h19 input 2 w=+0.460196491117441 w+  bank=n alpha=1 R=72432.8281000013 G_phys=1.38058947335232e-05 G_eff=1.38058947335232e-05
Rh19p2n1 in2 h19p 72432.8281000013
* h19 input 3 w=+0.284766719035728 w+  bank=n alpha=1 R=117054.877220927 G_phys=8.54300157107185e-06 G_eff=8.54300157107185e-06
Rh19p3n1 in3 h19p 117054.877220927
* h19 input 4 w=-0.664899666016021 w-  bank=n alpha=1 R=50132.8772400529 G_phys=1.99469899804806e-05 G_eff=1.99469899804806e-05
Rh19n4n1 in4n h19p 50132.8772400529
* h19 input 5 w=+0.507213486118456 w+  bank=n alpha=1 R=65718.5470134534 G_phys=1.52164045835537e-05 G_eff=1.52164045835537e-05
Rh19p5n1 in5 h19p 65718.5470134534
* h19 input 6 w=+0.130688397719858 w+  bank=n alpha=1 R=255059.622085094 G_phys=3.92065193159573e-06 G_eff=3.92065193159573e-06
Rh19p6n1 in6 h19p 255059.622085094
* h19 input 7 w=+0.0897047942241856 w+  bank=n alpha=1 R=371589.206815729 G_phys=2.69114382672557e-06 G_eff=2.69114382672557e-06
Rh19p7n1 in7 h19p 371589.206815729
* h19 input 8 w=+0.0897866911799249 w+  bank=n alpha=1 R=371250.269892853 G_phys=2.69360073539775e-06 G_eff=2.69360073539775e-06
Rh19p8n1 in8 h19p 371250.269892853
* h19 input 9 w=-0.272382660879323 w-  bank=n alpha=1 R=122376.854773812 G_phys=8.17147982637969e-06 G_eff=8.17147982637969e-06
Rh19n9n1 in9n h19p 122376.854773812
* h19 input 10 w=+0.0908546616405757 w+  bank=n alpha=1 R=366886.329566679 G_phys=2.72563984921727e-06 G_eff=2.72563984921727e-06
Rh19p10n1 in10 h19p 366886.329566679
* h19 input 11 w=-0.0411180740799587 w-  bank=n alpha=1 R=810673.507434053 G_phys=1.23354222239876e-06 G_eff=1.23354222239876e-06
Rh19n11n1 in11n h19p 810673.507434053
* h19 input 12 w=-0.14910928160707 w-  bank=n alpha=1 R=223549.687679219 G_phys=4.47327844821211e-06 G_eff=4.47327844821211e-06
Rh19n12n1 in12n h19p 223549.687679219
* h19 input 13 w=-0.0351824330179761 w-  bank=n alpha=1 R=947442.529523243 G_phys=1.05547299053928e-06 G_eff=1.05547299053928e-06
Rh19n13n1 in13n h19p 947442.529523243
* h19 input 14 w=+0.491588757414346 w+  bank=n alpha=1 R=67807.3548887889 G_phys=1.47476627224304e-05 G_eff=1.47476627224304e-05
Rh19p14n1 in14 h19p 67807.3548887889
* h19 input 15 w=-0.0385925197286318 w-  bank=n alpha=1 R=863725.239184197 G_phys=1.15777559185895e-06 G_eff=1.15777559185895e-06
Rh19n15n1 in15n h19p 863725.239184197
* h19 input 16 w=-0.690622583753164 w-  bank=n alpha=1 R=48265.628894127 G_phys=2.07186775125949e-05 G_eff=2.07186775125949e-05
Rh19n16n1 in16n h19p 48265.628894127
* h19 bias w+  bank=f alpha=0.001 R=1659.50290630424 G_phys=0.000602590086586248 G_eff=6.02590086586248e-07
Rh19bpf1 tapref h19p 1659.50290630424
Vh19p h19p 0 DC 0
Bh19crelu 0 h19iy I = max(0, i(Vh19p))
Vh19iy h19iy 0 DC 0
* current-mode hidden h19: I_y = max(0, I_sum), no hidden voltage

* h20 input 1 w=-0.0810043123301717 w-  bank=n alpha=1 R=411500.72600416 G_phys=2.43012936990515e-06 G_eff=2.43012936990515e-06
Rh20n1n1 in1n h20p 411500.72600416
* h20 input 2 w=+0.646296718361532 w+  bank=n alpha=1 R=51575.8975503369 G_phys=1.9388901550846e-05 G_eff=1.9388901550846e-05
Rh20p2n1 in2 h20p 51575.8975503369
* h20 input 3 w=-0.000929252010170944 w-  bank=f alpha=0.001 R=35871.1447147705 G_phys=2.78775603051283e-05 G_eff=2.78775603051283e-08
Rh20n3f1 tap3n h20p 35871.1447147705
* h20 input 4 w=+0.269987692172837 w+  bank=n alpha=1 R=123462.418101617 G_phys=8.09963076518511e-06 G_eff=8.09963076518511e-06
Rh20p4n1 in4 h20p 123462.418101617
* h20 input 5 w=+0.140155013181344 w+  bank=n alpha=1 R=237831.901811489 G_phys=4.20465039544031e-06 G_eff=4.20465039544031e-06
Rh20p5n1 in5 h20p 237831.901811489
* h20 input 6 w=+0.15481044132605 w+  bank=n alpha=1 R=215317.087451028 G_phys=4.6443132397815e-06 G_eff=4.6443132397815e-06
Rh20p6n1 in6 h20p 215317.087451028
* h20 input 7 w=-0.803119096824844 w-  bank=n alpha=1 R=41504.8446302892 G_phys=2.40935729047453e-05 G_eff=2.40935729047453e-05
Rh20n7n1 in7n h20p 41504.8446302892
* h20 input 8 w=+0.12095822380885 w+  bank=n alpha=1 R=275577.238849092 G_phys=3.62874671426549e-06 G_eff=3.62874671426549e-06
Rh20p8n1 in8 h20p 275577.238849092
* h20 input 9 w=+0.307944073046154 w+  bank=n alpha=1 R=108244.763419549 G_phys=9.23832219138461e-06 G_eff=9.23832219138461e-06
Rh20p9n1 in9 h20p 108244.763419549
* h20 input 10 w=+0.100067069291622 w+  bank=n alpha=1 R=333109.918870425 G_phys=3.00201207874865e-06 G_eff=3.00201207874865e-06
Rh20p10n1 in10 h20p 333109.918870425
* h20 input 11 w=+0.376050768766317 w+  bank=n alpha=1 R=88640.513733525 G_phys=1.12815230629895e-05 G_eff=1.12815230629895e-05
Rh20p11n1 in11 h20p 88640.513733525
* h20 input 12 w=-0.859853426992325 w-  bank=n alpha=1 R=38766.2970070722 G_phys=2.57956028097698e-05 G_eff=2.57956028097698e-05
Rh20n12n1 in12n h20p 38766.2970070722
* h20 input 13 w=+0.0677970111280841 w+  bank=n alpha=1 R=491663.758898737 G_phys=2.03391033384252e-06 G_eff=2.03391033384252e-06
Rh20p13n1 in13 h20p 491663.758898737
* h20 input 14 w=-0.43012675419833 w-  bank=n alpha=1 R=77496.5356327578 G_phys=1.29038026259499e-05 G_eff=1.29038026259499e-05
Rh20n14n1 in14n h20p 77496.5356327578
* h20 input 15 w=-0.0800571778528839 w-  bank=n alpha=1 R=416369.078043045 G_phys=2.40171533558652e-06 G_eff=2.40171533558652e-06
Rh20n15n1 in15n h20p 416369.078043045
* h20 input 16 w=-0.127529601563162 w-  bank=n alpha=1 R=261377.224775726 G_phys=3.82588804689485e-06 G_eff=3.82588804689485e-06
Rh20n16n1 in16n h20p 261377.224775726
* h20 bias w+  bank=f alpha=0.001 R=1236.06584989005 G_phys=0.000809018386915995 G_eff=8.09018386915995e-07
Rh20bpf1 tapref h20p 1236.06584989005
Vh20p h20p 0 DC 0
Bh20crelu 0 h20iy I = max(0, i(Vh20p))
Vh20iy h20iy 0 DC 0
* current-mode hidden h20: I_y = max(0, I_sum), no hidden voltage

* h21 input 1 w=-0.00681344895090886 w-  bank=f alpha=0.001 R=4892.28488736045 G_phys=0.000204403468527266 G_eff=2.04403468527266e-07
Rh21n1f1 tap1n h21p 4892.28488736045
* h21 input 2 w=+0.17215275761211 w+  bank=n alpha=1 R=193626.484964238 G_phys=5.1645827283633e-06 G_eff=5.1645827283633e-06
Rh21p2n1 in2 h21p 193626.484964238
* h21 input 3 w=-0.241244992284912 w-  bank=n alpha=1 R=138172.12542993 G_phys=7.23734976854735e-06 G_eff=7.23734976854735e-06
Rh21n3n1 in3n h21p 138172.12542993
* h21 input 4 w=-0.253516997925259 w-  bank=n alpha=1 R=131483.622818698 G_phys=7.60550993775776e-06 G_eff=7.60550993775776e-06
Rh21n4n1 in4n h21p 131483.622818698
* h21 input 5 w=+0.732528033504134 w+  bank=n alpha=1 R=45504.515607245 G_phys=2.1975841005124e-05 G_eff=2.1975841005124e-05
Rh21p5n1 in5 h21p 45504.515607245
* h21 input 6 w=-0.335745026911547 w-  bank=n alpha=1 R=99281.6889648676 G_phys=1.00723508073464e-05 G_eff=1.00723508073464e-05
Rh21n6n1 in6n h21p 99281.6889648676
* h21 input 7 w=-0.133397447206163 w-  bank=n alpha=1 R=249879.844265815 G_phys=4.00192341618489e-06 G_eff=4.00192341618489e-06
Rh21n7n1 in7n h21p 249879.844265815
* h21 input 8 w=-0.602502751086194 w-  bank=n alpha=1 R=55324.7819586548 G_phys=1.80750825325858e-05 G_eff=1.80750825325858e-05
Rh21n8n1 in8n h21p 55324.7819586548
* h21 input 9 w=-0.464313715662176 w-  bank=n alpha=1 R=71790.5420601142 G_phys=1.39294114698653e-05 G_eff=1.39294114698653e-05
Rh21n9n1 in9n h21p 71790.5420601142
* h21 input 10 w=+0.0220606443883595 w+  bank=f alpha=0.001 R=1510.98638582479 G_phys=0.000661819331650786 G_eff=6.61819331650786e-07
Rh21p10f1 tap10 h21p 1510.98638582479
* h21 input 11 w=+0.293613135845564 w+  bank=n alpha=1 R=113528.072364127 G_phys=8.80839407536691e-06 G_eff=8.80839407536691e-06
Rh21p11n1 in11 h21p 113528.072364127
* h21 input 12 w=+0.585788543436 w+  bank=n alpha=1 R=56903.3548143728 G_phys=1.757365630308e-05 G_eff=1.757365630308e-05
Rh21p12n1 in12 h21p 56903.3548143728
* h21 input 13 w=-0.255400978522459 w-  bank=n alpha=1 R=130513.726009089 G_phys=7.66202935567376e-06 G_eff=7.66202935567376e-06
Rh21n13n1 in13n h21p 130513.726009089
* h21 input 14 w=+0.15251581562556 w+  bank=n alpha=1 R=218556.568685111 G_phys=4.57547446876679e-06 G_eff=4.57547446876679e-06
Rh21p14n1 in14 h21p 218556.568685111
* h21 input 15 w=-0.610279514665944 w-  bank=n alpha=1 R=54619.7808254787 G_phys=1.83083854399783e-05 G_eff=1.83083854399783e-05
Rh21n15n1 in15n h21p 54619.7808254787
* h21 input 16 w=+0.0580238118020399 w+  bank=n alpha=1 R=574476.793200985 G_phys=1.7407143540612e-06 G_eff=1.7407143540612e-06
Rh21p16n1 in16 h21p 574476.793200985
* h21 bias w-  bank=f alpha=0.001 R=5534.66769609038 G_phys=0.00018067932076688 G_eff=1.8067932076688e-07
Rh21bnf1 taprefn h21p 5534.66769609038
Vh21p h21p 0 DC 0
Bh21crelu 0 h21iy I = max(0, i(Vh21p))
Vh21iy h21iy 0 DC 0
* current-mode hidden h21: I_y = max(0, I_sum), no hidden voltage

* h22 input 1 w=+0.733134048211177 w+  bank=n alpha=1 R=45466.901195853 G_phys=2.19940214463353e-05 G_eff=2.19940214463353e-05
Rh22p1n1 in1 h22p 45466.901195853
* h22 input 2 w=-0.468945077984231 w-  bank=n alpha=1 R=71081.5293693183 G_phys=1.40683523395269e-05 G_eff=1.40683523395269e-05
Rh22n2n1 in2n h22p 71081.5293693183
* h22 input 3 w=+0.0425168801269381 w+  bank=n alpha=1 R=784002.335867861 G_phys=1.27550640380814e-06 G_eff=1.27550640380814e-06
Rh22p3n1 in3 h22p 784002.335867861
* h22 input 4 w=-0.440513463519883 w-  bank=n alpha=1 R=75669.2725506874 G_phys=1.32154039055965e-05 G_eff=1.32154039055965e-05
Rh22n4n1 in4n h22p 75669.2725506874
* h22 input 5 w=+0.139436850403416 w+  bank=n alpha=1 R=239056.843559604 G_phys=4.18310551210248e-06 G_eff=4.18310551210248e-06
Rh22p5n1 in5 h22p 239056.843559604
* h22 input 6 w=-0.216633688080034 w-  bank=n alpha=1 R=153869.574158838 G_phys=6.49901064240101e-06 G_eff=6.49901064240101e-06
Rh22n6n1 in6n h22p 153869.574158838
* h22 input 7 w=+0.3413541130964 w+  bank=n alpha=1 R=97650.305224006 G_phys=1.0240623392892e-05 G_eff=1.0240623392892e-05
Rh22p7n1 in7 h22p 97650.305224006
* h22 input 8 w=+0.375494249585175 w+  bank=n alpha=1 R=88771.88763918 G_phys=1.12648274875552e-05 G_eff=1.12648274875552e-05
Rh22p8n1 in8 h22p 88771.88763918
* h22 input 9 w=-0.0598723775607 w-  bank=n alpha=1 R=556739.763667131 G_phys=1.796171326821e-06 G_eff=1.796171326821e-06
Rh22n9n1 in9n h22p 556739.763667131
* h22 input 10 w=-0.886177024526985 w-  bank=n alpha=1 R=37614.7568835083 G_phys=2.65853107358095e-05 G_eff=2.65853107358095e-05
Rh22n10n1 in10n h22p 37614.7568835083
* h22 input 11 w=-0.158397755226926 w-  bank=n alpha=1 R=210440.692707917 G_phys=4.75193265680777e-06 G_eff=4.75193265680777e-06
Rh22n11n1 in11n h22p 210440.692707917
* h22 input 12 w=+0.00642379373490928 w+  bank=f alpha=0.001 R=5189.04166430307 G_phys=0.000192713812047279 G_eff=1.92713812047279e-07
Rh22p12f1 tap12 h22p 5189.04166430307
* h22 input 13 w=+0.483338726494796 w+  bank=n alpha=1 R=68964.7477144421 G_phys=1.45001617948439e-05 G_eff=1.45001617948439e-05
Rh22p13n1 in13 h22p 68964.7477144421
* h22 input 14 w=+0.995892890290009 w+  bank=n alpha=1 R=33470.8015875347 G_phys=2.98767867087003e-05 G_eff=2.98767867087003e-05
Rh22p14n1 in14 h22p 33470.8015875347
* h22 input 15 w=-0.0635579626600016 w-  bank=n alpha=1 R=524455.661230796 G_phys=1.90673887980005e-06 G_eff=1.90673887980005e-06
Rh22n15n1 in15n h22p 524455.661230796
* h22 input 16 w=+0.143429643183018 w+  bank=n alpha=1 R=232401.981860887 G_phys=4.30288929549054e-06 G_eff=4.30288929549054e-06
Rh22p16n1 in16 h22p 232401.981860887
* h22 bias w+  bank=f alpha=0.001 R=8748.48537925215 G_phys=0.000114305500512305 G_eff=1.14305500512305e-07
Rh22bpf1 tapref h22p 8748.48537925215
Vh22p h22p 0 DC 0
Bh22crelu 0 h22iy I = max(0, i(Vh22p))
Vh22iy h22iy 0 DC 0
* current-mode hidden h22: I_y = max(0, I_sum), no hidden voltage

* h23 input 1 w=-0.311855168471888 w-  bank=n alpha=1 R=106887.224273592 G_phys=9.35565505415663e-06 G_eff=9.35565505415663e-06
Rh23n1n1 in1n h23p 106887.224273592
* h23 input 2 w=-0.519305850985266 w-  bank=n alpha=1 R=64188.2491215741 G_phys=1.5579175529558e-05 G_eff=1.5579175529558e-05
Rh23n2n1 in2n h23p 64188.2491215741
* h23 input 3 w=+0.0590711076347425 w+  bank=n alpha=1 R=564291.659121157 G_phys=1.77213322904228e-06 G_eff=1.77213322904228e-06
Rh23p3n1 in3 h23p 564291.659121157
* h23 input 4 w=-0.153433475387477 w-  bank=n alpha=1 R=217249.418675776 G_phys=4.60300426162431e-06 G_eff=4.60300426162431e-06
Rh23n4n1 in4n h23p 217249.418675776
* h23 input 5 w=+0.565735693190981 w+  bank=n alpha=1 R=58920.3292889647 G_phys=1.69720707957294e-05 G_eff=1.69720707957294e-05
Rh23p5n1 in5 h23p 58920.3292889647
* h23 input 6 w=-0.371646754353268 w-  bank=n alpha=1 R=89690.90391046 G_phys=1.1149402630598e-05 G_eff=1.1149402630598e-05
Rh23n6n1 in6n h23p 89690.90391046
* h23 input 7 w=-0.111660278324499 w-  bank=n alpha=1 R=298524.540987283 G_phys=3.34980834973497e-06 G_eff=3.34980834973497e-06
Rh23n7n1 in7n h23p 298524.540987283
* h23 input 8 w=+0.496809212320021 w+  bank=n alpha=1 R=67094.8374279775 G_phys=1.49042763696006e-05 G_eff=1.49042763696006e-05
Rh23p8n1 in8 h23p 67094.8374279775
* h23 input 9 w=-0.177241184436762 w-  bank=n alpha=1 R=188067.65165365 G_phys=5.31723553310286e-06 G_eff=5.31723553310286e-06
Rh23n9n1 in9n h23p 188067.65165365
* h23 input 10 w=-0.405292848695184 w-  bank=n alpha=1 R=82245.0567303322 G_phys=1.21587854608555e-05 G_eff=1.21587854608555e-05
Rh23n10n1 in10n h23p 82245.0567303322
* h23 input 11 w=-0.16052467280172 w-  bank=n alpha=1 R=207652.398547522 G_phys=4.81574018405159e-06 G_eff=4.81574018405159e-06
Rh23n11n1 in11n h23p 207652.398547522
* h23 input 12 w=+0.846508036935069 w+  bank=n alpha=1 R=39377.4564196963 G_phys=2.53952411080521e-05 G_eff=2.53952411080521e-05
Rh23p12n1 in12 h23p 39377.4564196963
* h23 input 13 w=-0.0538311215013525 w-  bank=n alpha=1 R=619220.488142641 G_phys=1.61493364504058e-06 G_eff=1.61493364504058e-06
Rh23n13n1 in13n h23p 619220.488142641
* h23 input 14 w=+0.31071243911676 w+  bank=n alpha=1 R=107280.331061375 G_phys=9.3213731735028e-06 G_eff=9.3213731735028e-06
Rh23p14n1 in14 h23p 107280.331061375
* h23 input 15 w=+0.331311012578656 w+  bank=n alpha=1 R=100610.399497118 G_phys=9.93933037735967e-06 G_eff=9.93933037735967e-06
Rh23p15n1 in15 h23p 100610.399497118
* h23 input 16 w=-0.486368816876819 w-  bank=n alpha=1 R=68535.0955420638 G_phys=1.45910645063046e-05 G_eff=1.45910645063046e-05
Rh23n16n1 in16n h23p 68535.0955420638
* h23 bias w-  bank=n alpha=1 R=642782.148246781 G_phys=1.55573704516771e-06 G_eff=1.55573704516771e-06
Rh23bnn1 vrefn h23p 642782.148246781
Vh23p h23p 0 DC 0
Bh23crelu 0 h23iy I = max(0, i(Vh23p))
Vh23iy h23iy 0 DC 0
* current-mode hidden h23: I_y = max(0, I_sum), no hidden voltage

* h24 input 1 w=+0.61389120350986 w+  bank=n alpha=1 R=54298.4378058415 G_phys=1.84167361052958e-05 G_eff=1.84167361052958e-05
Rh24p1n1 in1 h24p 54298.4378058415
* h24 input 2 w=-0.0429199313830527 w-  bank=n alpha=1 R=776639.949300928 G_phys=1.28759794149158e-06 G_eff=1.28759794149158e-06
Rh24n2n1 in2n h24p 776639.949300928
* h24 input 3 w=-0.014915873427812 w-  bank=f alpha=0.001 R=2234.75571140073 G_phys=0.000447476202834361 G_eff=4.47476202834361e-07
Rh24n3f1 tap3n h24p 2234.75571140073
* h24 input 4 w=-0.169036355792668 w-  bank=n alpha=1 R=197196.237324345 G_phys=5.07109067378003e-06 G_eff=5.07109067378003e-06
Rh24n4n1 in4n h24p 197196.237324345
* h24 input 5 w=-0.510336523880732 w-  bank=n alpha=1 R=65316.378063357 G_phys=1.5310095716422e-05 G_eff=1.5310095716422e-05
Rh24n5n1 in5n h24p 65316.378063357
* h24 input 6 w=-0.303361656916169 w-  bank=n alpha=1 R=109879.849919678 G_phys=9.10084970748506e-06 G_eff=9.10084970748506e-06
Rh24n6n1 in6n h24p 109879.849919678
* h24 input 7 w=-0.0292327970624363 w-  bank=f alpha=0.001 R=1140.27177290422 G_phys=0.000876983911873088 G_eff=8.76983911873088e-07
Rh24n7f1 tap7n h24p 1140.27177290422
* h24 input 8 w=-0.329334996951297 w-  bank=n alpha=1 R=101214.063618823 G_phys=9.88004990853891e-06 G_eff=9.88004990853891e-06
Rh24n8n1 in8n h24p 101214.063618823
* h24 input 9 w=+0.0109599477370603 w+  bank=f alpha=0.001 R=3041.37703326988 G_phys=0.000328798432111809 G_eff=3.28798432111809e-07
Rh24p9f1 tap9 h24p 3041.37703326988
* h24 input 10 w=+0.0571459019805778 w+  bank=n alpha=1 R=583302.252271078 G_phys=1.71437705941734e-06 G_eff=1.71437705941734e-06
Rh24p10n1 in10 h24p 583302.252271078
* h24 input 11 w=+0.243568584743939 w+  bank=n alpha=1 R=136853.992760915 G_phys=7.30705754231816e-06 G_eff=7.30705754231816e-06
Rh24p11n1 in11 h24p 136853.992760915
* h24 input 12 w=-0.323004255102081 w-  bank=n alpha=1 R=103197.814910515 G_phys=9.69012765306243e-06 G_eff=9.69012765306243e-06
Rh24n12n1 in12n h24p 103197.814910515
* h24 input 13 w=+0.243938800887145 w+  bank=n alpha=1 R=136646.294939994 G_phys=7.31816402661434e-06 G_eff=7.31816402661434e-06
Rh24p13n1 in13 h24p 136646.294939994
* h24 input 14 w=+0.0840399613598874 w+  bank=n alpha=1 R=396636.704657547 G_phys=2.52119884079662e-06 G_eff=2.52119884079662e-06
Rh24p14n1 in14 h24p 396636.704657547
* h24 input 15 w=-0.352451854106752 w-  bank=n alpha=1 R=94575.5652720646 G_phys=1.05735556232026e-05 G_eff=1.05735556232026e-05
Rh24n15n1 in15n h24p 94575.5652720646
* h24 input 16 w=+0.406056698737055 w+  bank=n alpha=1 R=82090.3421542089 G_phys=1.21817009621116e-05 G_eff=1.21817009621116e-05
Rh24p16n1 in16 h24p 82090.3421542089
* h24 bias w+  bank=f alpha=0.001 R=1792.9894089827 G_phys=0.000557727778530147 G_eff=5.57727778530147e-07
Rh24bpf1 tapref h24p 1792.9894089827
Vh24p h24p 0 DC 0
Bh24crelu 0 h24iy I = max(0, i(Vh24p))
Vh24iy h24iy 0 DC 0
* current-mode hidden h24: I_y = max(0, I_sum), no hidden voltage

* h25 input 1 w=-0.507226781565224 w-  bank=n alpha=1 R=65716.824396519 G_phys=1.52168034469567e-05 G_eff=1.52168034469567e-05
Rh25n1n1 in1n h25p 65716.824396519
* h25 input 2 w=-0.323616844242374 w-  bank=n alpha=1 R=103002.467042068 G_phys=9.70850532727122e-06 G_eff=9.70850532727122e-06
Rh25n2n1 in2n h25p 103002.467042068
* h25 input 3 w=+0.251581142719107 w+  bank=n alpha=1 R=132495.35705683 G_phys=7.5474342815732e-06 G_eff=7.5474342815732e-06
Rh25p3n1 in3 h25p 132495.35705683
* h25 input 4 w=+0.0279414599016099 w+  bank=f alpha=0.001 R=1192.97035483149 G_phys=0.000838243797048297 G_eff=8.38243797048297e-07
Rh25p4f1 tap4 h25p 1192.97035483149
* h25 input 5 w=+0.310516223746861 w+  bank=n alpha=1 R=107348.121560654 G_phys=9.31548671240582e-06 G_eff=9.31548671240582e-06
Rh25p5n1 in5 h25p 107348.121560654
* h25 input 6 w=-0.583310440311788 w-  bank=n alpha=1 R=57145.0998125736 G_phys=1.74993132093536e-05 G_eff=1.74993132093536e-05
Rh25n6n1 in6n h25p 57145.0998125736
* h25 input 7 w=-0.128366308561082 w-  bank=n alpha=1 R=259673.536670037 G_phys=3.85098925683245e-06 G_eff=3.85098925683245e-06
Rh25n7n1 in7n h25p 259673.536670037
* h25 input 8 w=-0.237966635841971 w-  bank=n alpha=1 R=140075.658990571 G_phys=7.13899907525912e-06 G_eff=7.13899907525912e-06
Rh25n8n1 in8n h25p 140075.658990571
* h25 input 9 w=+0.869293927250567 w+  bank=n alpha=1 R=38345.2964393311 G_phys=2.6078817817517e-05 G_eff=2.6078817817517e-05
Rh25p9n1 in9 h25p 38345.2964393311
* h25 input 10 w=-0.700407093798758 w-  bank=n alpha=1 R=47591.3702594662 G_phys=2.10122128139627e-05 G_eff=2.10122128139627e-05
Rh25n10n1 in10n h25p 47591.3702594662
* h25 input 11 w=+0.176416664646434 w+  bank=n alpha=1 R=188946.624742841 G_phys=5.29249993939301e-06 G_eff=5.29249993939301e-06
Rh25p11n1 in11 h25p 188946.624742841
* h25 input 12 w=+0.165054591787149 w+  bank=n alpha=1 R=201953.383861743 G_phys=4.95163775361447e-06 G_eff=4.95163775361447e-06
Rh25p12n1 in12 h25p 201953.383861743
* h25 input 13 w=+0.414882742059982 w+  bank=n alpha=1 R=80343.9862738715 G_phys=1.24464822617995e-05 G_eff=1.24464822617995e-05
Rh25p13n1 in13 h25p 80343.9862738715
* h25 input 14 w=-0.441614461314228 w-  bank=n alpha=1 R=75480.619982721 G_phys=1.32484338394269e-05 G_eff=1.32484338394269e-05
Rh25n14n1 in14n h25p 75480.619982721
* h25 input 15 w=+0.152726206779301 w+  bank=n alpha=1 R=218255.491550983 G_phys=4.58178620337902e-06 G_eff=4.58178620337902e-06
Rh25p15n1 in15 h25p 218255.491550983
* h25 input 16 w=-0.0538945970745783 w-  bank=n alpha=1 R=618491.187292992 G_phys=1.61683791223735e-06 G_eff=1.61683791223735e-06
Rh25n16n1 in16n h25p 618491.187292992
* h25 bias w+  bank=n alpha=1 R=396065.019631007 G_phys=2.52483796961329e-06 G_eff=2.52483796961329e-06
Rh25bpn1 vref h25p 396065.019631007
Vh25p h25p 0 DC 0
Bh25crelu 0 h25iy I = max(0, i(Vh25p))
Vh25iy h25iy 0 DC 0
* current-mode hidden h25: I_y = max(0, I_sum), no hidden voltage

* h26 input 1 w=-0.733410608571861 w-  bank=n alpha=1 R=45449.7561717056 G_phys=2.20023182571558e-05 G_eff=2.20023182571558e-05
Rh26n1n1 in1n h26p 45449.7561717056
* h26 input 2 w=+0.207000343516658 w+  bank=n alpha=1 R=161030.328583251 G_phys=6.21001030549975e-06 G_eff=6.21001030549975e-06
Rh26p2n1 in2 h26p 161030.328583251
* h26 input 3 w=-0.0671817515718929 w-  bank=n alpha=1 R=496166.482019488 G_phys=2.01545254715679e-06 G_eff=2.01545254715679e-06
Rh26n3n1 in3n h26p 496166.482019488
* h26 input 4 w=+0.312724326896377 w+  bank=n alpha=1 R=106590.151345592 G_phys=9.38172980689131e-06 G_eff=9.38172980689131e-06
Rh26p4n1 in4 h26p 106590.151345592
* h26 input 5 w=+0.0982363551813243 w+  bank=n alpha=1 R=339317.692231219 G_phys=2.94709065543973e-06 G_eff=2.94709065543973e-06
Rh26p5n1 in5 h26p 339317.692231219
* h26 input 6 w=+0.0433697195878843 w+  bank=n alpha=1 R=768585.401291025 G_phys=1.30109158763653e-06 G_eff=1.30109158763653e-06
Rh26p6n1 in6 h26p 768585.401291025
* h26 input 7 w=-0.253243820471769 w-  bank=n alpha=1 R=131625.45593901 G_phys=7.59731461415306e-06 G_eff=7.59731461415306e-06
Rh26n7n1 in7n h26p 131625.45593901
* h26 input 8 w=+0.388367135047654 w+  bank=n alpha=1 R=85829.4390158508 G_phys=1.16510140514296e-05 G_eff=1.16510140514296e-05
Rh26p8n1 in8 h26p 85829.4390158508
* h26 input 9 w=+0.190562655499984 w+  bank=n alpha=1 R=174920.596304013 G_phys=5.71687966499952e-06 G_eff=5.71687966499952e-06
Rh26p9n1 in9 h26p 174920.596304013
* h26 input 10 w=-0.282938574156096 w-  bank=n alpha=1 R=117811.201363245 G_phys=8.48815722468287e-06 G_eff=8.48815722468287e-06
Rh26n10n1 in10n h26p 117811.201363245
* h26 input 11 w=+0.123317846030254 w+  bank=n alpha=1 R=270304.21310761 G_phys=3.69953538090763e-06 G_eff=3.69953538090763e-06
Rh26p11n1 in11 h26p 270304.21310761
* h26 input 12 w=-0.494646699470857 w-  bank=n alpha=1 R=67388.1648639146 G_phys=1.48394009841257e-05 G_eff=1.48394009841257e-05
Rh26n12n1 in12n h26p 67388.1648639146
* h26 input 13 w=-0.136127092468903 w-  bank=n alpha=1 R=244869.208096457 G_phys=4.08381277406708e-06 G_eff=4.08381277406708e-06
Rh26n13n1 in13n h26p 244869.208096457
* h26 input 14 w=+0.481522107274068 w+  bank=n alpha=1 R=69224.928263493 G_phys=1.4445663218222e-05 G_eff=1.4445663218222e-05
Rh26p14n1 in14 h26p 69224.928263493
* h26 input 15 w=+0.0644124429905188 w+  bank=n alpha=1 R=517498.355686336 G_phys=1.93237328971556e-06 G_eff=1.93237328971556e-06
Rh26p15n1 in15 h26p 517498.355686336
* h26 input 16 w=+0.0297993400818282 w+  bank=f alpha=0.001 R=1118.5930037981 G_phys=0.000893980202454845 G_eff=8.93980202454845e-07
Rh26p16f1 tap16 h26p 1118.5930037981
* h26 bias w-  bank=f alpha=0.001 R=2150.60895252505 G_phys=0.000464984579751652 G_eff=4.64984579751652e-07
Rh26bnf1 taprefn h26p 2150.60895252505
Vh26p h26p 0 DC 0
Bh26crelu 0 h26iy I = max(0, i(Vh26p))
Vh26iy h26iy 0 DC 0
* current-mode hidden h26: I_y = max(0, I_sum), no hidden voltage

* h27 input 1 w=-0.473232380174693 w-  bank=n alpha=1 R=70437.5582267393 G_phys=1.41969714052408e-05 G_eff=1.41969714052408e-05
Rh27n1n1 in1n h27p 70437.5582267393
* h27 input 2 w=+0.0192680774504759 w+  bank=f alpha=0.001 R=1729.97713025645 G_phys=0.000578042323514278 G_eff=5.78042323514278e-07
Rh27p2f1 tap2 h27p 1729.97713025645
* h27 input 3 w=-0.33925202928177 w-  bank=n alpha=1 R=98255.3690361212 G_phys=1.01775608784531e-05 G_eff=1.01775608784531e-05
Rh27n3n1 in3n h27p 98255.3690361212
* h27 input 4 w=+0.300608725256371 w+  bank=n alpha=1 R=110886.113850838 G_phys=9.01826175769113e-06 G_eff=9.01826175769113e-06
Rh27p4n1 in4 h27p 110886.113850838
* h27 input 5 w=-0.265937781386581 w-  bank=n alpha=1 R=125342.60141427 G_phys=7.97813344159742e-06 G_eff=7.97813344159742e-06
Rh27n5n1 in5n h27p 125342.60141427
* h27 input 6 w=-0.0714924370091341 w-  bank=n alpha=1 R=466249.784282421 G_phys=2.14477311027402e-06 G_eff=2.14477311027402e-06
Rh27n6n1 in6n h27p 466249.784282421
* h27 input 7 w=+0.32365049129675 w+  bank=n alpha=1 R=102991.758794429 G_phys=9.7095147389025e-06 G_eff=9.7095147389025e-06
Rh27p7n1 in7 h27p 102991.758794429
* h27 input 8 w=+0.264468500812474 w+  bank=n alpha=1 R=126038.954472574 G_phys=7.93405502437422e-06 G_eff=7.93405502437422e-06
Rh27p8n1 in8 h27p 126038.954472574
* h27 input 9 w=-0.251852607935664 w-  bank=n alpha=1 R=132352.543841231 G_phys=7.55557823806993e-06 G_eff=7.55557823806993e-06
Rh27n9n1 in9n h27p 132352.543841231
* h27 input 10 w=-0.0922567674902895 w-  bank=n alpha=1 R=361310.440850226 G_phys=2.76770302470868e-06 G_eff=2.76770302470868e-06
Rh27n10n1 in10n h27p 361310.440850226
* h27 input 11 w=-0.519972660308657 w-  bank=n alpha=1 R=64105.9345573026 G_phys=1.55991798092597e-05 G_eff=1.55991798092597e-05
Rh27n11n1 in11n h27p 64105.9345573026
* h27 input 12 w=+0.109096005067641 w+  bank=n alpha=1 R=305541.282768935 G_phys=3.27288015202924e-06 G_eff=3.27288015202924e-06
Rh27p12n1 in12 h27p 305541.282768935
* h27 input 13 w=+0.0733868764952063 w+  bank=n alpha=1 R=454213.817582367 G_phys=2.20160629485619e-06 G_eff=2.20160629485619e-06
Rh27p13n1 in13 h27p 454213.817582367
* h27 input 14 w=-0.779894486957924 w-  bank=n alpha=1 R=42740.8244201779 G_phys=2.33968346087377e-05 G_eff=2.33968346087377e-05
Rh27n14n1 in14n h27p 42740.8244201779
* h27 input 15 w=+0.520337169546291 w+  bank=n alpha=1 R=64061.0267423301 G_phys=1.56101150863887e-05 G_eff=1.56101150863887e-05
Rh27p15n1 in15 h27p 64061.0267423301
* h27 input 16 w=+0.00922691889455085 w+  bank=f alpha=0.001 R=3612.61800545565 G_phys=0.000276807566836526 G_eff=2.76807566836526e-07
Rh27p16f1 tap16 h27p 3612.61800545565
* h27 bias w+  bank=f alpha=0.001 R=2714.58121636714 G_phys=0.000368380947297011 G_eff=3.68380947297011e-07
Rh27bpf1 tapref h27p 2714.58121636714
Vh27p h27p 0 DC 0
Bh27crelu 0 h27iy I = max(0, i(Vh27p))
Vh27iy h27iy 0 DC 0
* current-mode hidden h27: I_y = max(0, I_sum), no hidden voltage

* h28 input 1 w=+0.0928477001370985 w+  bank=n alpha=1 R=359010.86708786 G_phys=2.78543100411296e-06 G_eff=2.78543100411296e-06
Rh28p1n1 in1 h28p 359010.86708786
* h28 input 2 w=+0.628866123797832 w+  bank=n alpha=1 R=53005.4523083984 G_phys=1.8865983713935e-05 G_eff=1.8865983713935e-05
Rh28p2n1 in2 h28p 53005.4523083984
* h28 input 3 w=-0.429442295580587 w-  bank=n alpha=1 R=77620.0520451022 G_phys=1.28832688674176e-05 G_eff=1.28832688674176e-05
Rh28n3n1 in3n h28p 77620.0520451022
* h28 input 4 w=+0.0390774584408687 w+  bank=n alpha=1 R=853006.686291349 G_phys=1.17232375322606e-06 G_eff=1.17232375322606e-06
Rh28p4n1 in4 h28p 853006.686291349
* h28 input 5 w=-0.500231352741198 w-  bank=n alpha=1 R=66635.8339009967 G_phys=1.50069405822359e-05 G_eff=1.50069405822359e-05
Rh28n5n1 in5n h28p 66635.8339009967
* h28 input 6 w=-0.374880121408735 w-  bank=n alpha=1 R=88917.3136416848 G_phys=1.1246403642262e-05 G_eff=1.1246403642262e-05
Rh28n6n1 in6n h28p 88917.3136416848
* h28 input 7 w=-0.575469641796179 w-  bank=n alpha=1 R=57923.7042449224 G_phys=1.72640892538854e-05 G_eff=1.72640892538854e-05
Rh28n7n1 in7n h28p 57923.7042449224
* h28 input 8 w=+0.475130253886277 w+  bank=n alpha=1 R=70156.2004538479 G_phys=1.42539076165883e-05 G_eff=1.42539076165883e-05
Rh28p8n1 in8 h28p 70156.2004538479
* h28 input 9 w=-0.381841652824232 w-  bank=n alpha=1 R=87296.221056002 G_phys=1.1455249584727e-05 G_eff=1.1455249584727e-05
Rh28n9n1 in9n h28p 87296.221056002
* h28 input 10 w=+0.758567082707225 w+  bank=n alpha=1 R=43942.4990791469 G_phys=2.27570124812167e-05 G_eff=2.27570124812167e-05
Rh28p10n1 in10 h28p 43942.4990791469
* h28 input 11 w=-0.0530277840915393 w-  bank=n alpha=1 R=628601.287125096 G_phys=1.59083352274618e-06 G_eff=1.59083352274618e-06
Rh28n11n1 in11n h28p 628601.287125096
* h28 input 12 w=+0.0401492881024246 w+  bank=n alpha=1 R=830234.729151284 G_phys=1.20447864307274e-06 G_eff=1.20447864307274e-06
Rh28p12n1 in12 h28p 830234.729151284
* h28 input 13 w=-0.344979802042177 w-  bank=n alpha=1 R=96624.0143220269 G_phys=1.03493940612653e-05 G_eff=1.03493940612653e-05
Rh28n13n1 in13n h28p 96624.0143220269
* h28 input 14 w=+0.139059200435423 w+  bank=n alpha=1 R=239706.062086937 G_phys=4.1717760130627e-06 G_eff=4.1717760130627e-06
Rh28p14n1 in14 h28p 239706.062086937
* h28 input 15 w=-0.317012120275182 w-  bank=n alpha=1 R=105148.450804967 G_phys=9.51036360825546e-06 G_eff=9.51036360825546e-06
Rh28n15n1 in15n h28p 105148.450804967
* h28 input 16 w=-0.398313118116402 w-  bank=n alpha=1 R=83686.2554037001 G_phys=1.1949393543492e-05 G_eff=1.1949393543492e-05
Rh28n16n1 in16n h28p 83686.2554037001
* h28 bias w-  bank=n alpha=1 R=393235.409243175 G_phys=2.54300598698528e-06 G_eff=2.54300598698528e-06
Rh28bnn1 vrefn h28p 393235.409243175
Vh28p h28p 0 DC 0
Bh28crelu 0 h28iy I = max(0, i(Vh28p))
Vh28iy h28iy 0 DC 0
* current-mode hidden h28: I_y = max(0, I_sum), no hidden voltage

* h29 input 1 w=+0.125932002984804 w+  bank=n alpha=1 R=264693.108529018 G_phys=3.77796008954411e-06 G_eff=3.77796008954411e-06
Rh29p1n1 in1 h29p 264693.108529018
* h29 input 2 w=-0.650061827874195 w-  bank=n alpha=1 R=51277.1738072033 G_phys=1.95018548362258e-05 G_eff=1.95018548362258e-05
Rh29n2n1 in2n h29p 51277.1738072033
* h29 input 3 w=-0.0394473233812264 w-  bank=n alpha=1 R=845008.747772155 G_phys=1.18341970143679e-06 G_eff=1.18341970143679e-06
Rh29n3n1 in3n h29p 845008.747772155
* h29 input 4 w=-0.231823015010513 w-  bank=n alpha=1 R=143787.85183094 G_phys=6.9546904503154e-06 G_eff=6.9546904503154e-06
Rh29n4n1 in4n h29p 143787.85183094
* h29 input 5 w=+0.19053303604273 w+  bank=n alpha=1 R=174947.788717637 G_phys=5.71599108128189e-06 G_eff=5.71599108128189e-06
Rh29p5n1 in5 h29p 174947.788717637
* h29 input 6 w=+0.447719174196915 w+  bank=n alpha=1 R=74451.4312864178 G_phys=1.34315752259074e-05 G_eff=1.34315752259074e-05
Rh29p6n1 in6 h29p 74451.4312864178
* h29 input 7 w=+0.0126486175371352 w+  bank=f alpha=0.001 R=2635.33411738237 G_phys=0.000379458526114055 G_eff=3.79458526114055e-07
Rh29p7f1 tap7 h29p 2635.33411738237
* h29 input 8 w=+0.108364236263017 w+  bank=n alpha=1 R=307604.561088107 G_phys=3.25092708789052e-06 G_eff=3.25092708789052e-06
Rh29p8n1 in8 h29p 307604.561088107
* h29 input 9 w=+0.430118110319429 w+  bank=n alpha=1 R=77498.0930437414 G_phys=1.29035433095829e-05 G_eff=1.29035433095829e-05
Rh29p9n1 in9 h29p 77498.0930437414
* h29 input 10 w=+0.849664650654267 w+  bank=n alpha=1 R=39231.1640924048 G_phys=2.5489939519628e-05 G_eff=2.5489939519628e-05
Rh29p10n1 in10 h29p 39231.1640924048
* h29 input 11 w=+0.430581993177771 w+  bank=n alpha=1 R=77414.6013104902 G_phys=1.29174597953331e-05 G_eff=1.29174597953331e-05
Rh29p11n1 in11 h29p 77414.6013104902
* h29 input 12 w=-0.974573192285427 w-  bank=n alpha=1 R=34203.006605553 G_phys=2.92371957685628e-05 G_eff=2.92371957685628e-05
Rh29n12n1 in12n h29p 34203.006605553
* h29 input 13 w=+0.16029064712382 w+  bank=n alpha=1 R=207955.572776396 G_phys=4.80871941371461e-06 G_eff=4.80871941371461e-06
Rh29p13n1 in13 h29p 207955.572776396
* h29 input 14 w=+0.466636118473806 w+  bank=n alpha=1 R=71433.2474784727 G_phys=1.39990835542142e-05 G_eff=1.39990835542142e-05
Rh29p14n1 in14 h29p 71433.2474784727
* h29 input 15 w=-0.0331745755104183 w-  bank=f alpha=0.001 R=1004.78552688233 G_phys=0.000995237265312548 G_eff=9.95237265312548e-07
Rh29n15f1 tap15n h29p 1004.78552688233
* h29 input 16 w=-0.589046477086867 w-  bank=n alpha=1 R=56588.6303202822 G_phys=1.7671394312606e-05 G_eff=1.7671394312606e-05
Rh29n16n1 in16n h29p 56588.6303202822
* h29 bias w-  bank=n alpha=1 R=500623.285959049 G_phys=1.99750996017752e-06 G_eff=1.99750996017752e-06
Rh29bnn1 vrefn h29p 500623.285959049
Vh29p h29p 0 DC 0
Bh29crelu 0 h29iy I = max(0, i(Vh29p))
Vh29iy h29iy 0 DC 0
* current-mode hidden h29: I_y = max(0, I_sum), no hidden voltage

* h30 input 1 w=-0.507901838841989 w-  bank=n alpha=1 R=65629.4795256756 G_phys=1.52370551652597e-05 G_eff=1.52370551652597e-05
Rh30n1n1 in1n h30p 65629.4795256756
* h30 input 2 w=-0.0392944483392576 w-  bank=n alpha=1 R=848296.254105474 G_phys=1.17883345017773e-06 G_eff=1.17883345017773e-06
Rh30n2n1 in2n h30p 848296.254105474
* h30 input 3 w=+0.205776196534446 w+  bank=n alpha=1 R=161988.285791615 G_phys=6.17328589603337e-06 G_eff=6.17328589603337e-06
Rh30p3n1 in3 h30p 161988.285791615
* h30 input 4 w=+0.172383143604269 w+  bank=n alpha=1 R=193367.707749053 G_phys=5.17149430812806e-06 G_eff=5.17149430812806e-06
Rh30p4n1 in4 h30p 193367.707749053
* h30 input 5 w=-0.0737740397875715 w-  bank=n alpha=1 R=451830.121128177 G_phys=2.21322119362714e-06 G_eff=2.21322119362714e-06
Rh30n5n1 in5n h30p 451830.121128177
* h30 input 6 w=-0.113337981854853 w-  bank=n alpha=1 R=294105.583916448 G_phys=3.40013945564559e-06 G_eff=3.40013945564559e-06
Rh30n6n1 in6n h30p 294105.583916448
* h30 input 7 w=-0.199472534274412 w-  bank=n alpha=1 R=167107.383753781 G_phys=5.98417602823235e-06 G_eff=5.98417602823235e-06
Rh30n7n1 in7n h30p 167107.383753781
* h30 input 8 w=+0.667476408484971 w+  bank=n alpha=1 R=49939.3430383448 G_phys=2.00242922545491e-05 G_eff=2.00242922545491e-05
Rh30p8n1 in8 h30p 49939.3430383448
* h30 input 9 w=+0.0327305955718174 w+  bank=f alpha=0.001 R=1018.41511744549 G_phys=0.000981917867154523 G_eff=9.81917867154523e-07
Rh30p9f1 tap9 h30p 1018.41511744549
* h30 input 10 w=-0.112124407230259 w-  bank=n alpha=1 R=297288.825481859 G_phys=3.36373221690776e-06 G_eff=3.36373221690776e-06
Rh30n10n1 in10n h30p 297288.825481859
* h30 input 11 w=+0.283868618501327 w+  bank=n alpha=1 R=117425.214204076 G_phys=8.51605855503981e-06 G_eff=8.51605855503981e-06
Rh30p11n1 in11 h30p 117425.214204076
* h30 input 12 w=-0.058671072800694 w-  bank=n alpha=1 R=568139.148342606 G_phys=1.76013218402082e-06 G_eff=1.76013218402082e-06
Rh30n12n1 in12n h30p 568139.148342606
* h30 input 13 w=-0.679698898194489 w-  bank=n alpha=1 R=49041.323182777 G_phys=2.03909669458347e-05 G_eff=2.03909669458347e-05
Rh30n13n1 in13n h30p 49041.323182777
* h30 input 14 w=+0.213421552049108 w+  bank=n alpha=1 R=156185.413390975 G_phys=6.40264656147323e-06 G_eff=6.40264656147323e-06
Rh30p14n1 in14 h30p 156185.413390975
* h30 input 15 w=+0.353043376484901 w+  bank=n alpha=1 R=94417.1043944198 G_phys=1.0591301294547e-05 G_eff=1.0591301294547e-05
Rh30p15n1 in15 h30p 94417.1043944198
* h30 input 16 w=-0.0402310971621178 w-  bank=n alpha=1 R=828546.464915216 G_phys=1.20693291486354e-06 G_eff=1.20693291486354e-06
Rh30n16n1 in16n h30p 828546.464915216
* h30 bias w+  bank=f alpha=0.001 R=1174.50422834716 G_phys=0.000851423073552715 G_eff=8.51423073552714e-07
Rh30bpf1 tapref h30p 1174.50422834716
Vh30p h30p 0 DC 0
Bh30crelu 0 h30iy I = max(0, i(Vh30p))
Vh30iy h30iy 0 DC 0
* current-mode hidden h30: I_y = max(0, I_sum), no hidden voltage

* h31 input 1 w=+0.786523739677983 w+  bank=n alpha=1 R=42380.5813502598 G_phys=2.35957121903395e-05 G_eff=2.35957121903395e-05
Rh31p1n1 in1 h31p 42380.5813502598
* h31 input 2 w=+0.575951127580127 w+  bank=n alpha=1 R=57875.2809693839 G_phys=1.72785338274038e-05 G_eff=1.72785338274038e-05
Rh31p2n1 in2 h31p 57875.2809693839
* h31 input 3 w=+0.131568206508636 w+  bank=n alpha=1 R=253354.014756941 G_phys=3.94704619525908e-06 G_eff=3.94704619525908e-06
Rh31p3n1 in3 h31p 253354.014756941
* h31 input 4 w=+0.217046331869883 w+  bank=n alpha=1 R=153577.040653773 G_phys=6.51138995609649e-06 G_eff=6.51138995609649e-06
Rh31p4n1 in4 h31p 153577.040653773
* h31 input 5 w=+0.0670548023806797 w+  bank=n alpha=1 R=497105.832093803 G_phys=2.01164407142039e-06 G_eff=2.01164407142039e-06
Rh31p5n1 in5 h31p 497105.832093803
* h31 input 6 w=-0.0924541633789126 w-  bank=n alpha=1 R=360539.018634786 G_phys=2.77362490136738e-06 G_eff=2.77362490136738e-06
Rh31n6n1 in6n h31p 360539.018634786
* h31 input 7 w=+0.532768880755568 w+  bank=n alpha=1 R=62566.2168669842 G_phys=1.59830664226671e-05 G_eff=1.59830664226671e-05
Rh31p7n1 in7 h31p 62566.2168669842
* h31 input 8 w=-0.213038536483163 w-  bank=n alpha=1 R=156466.214439883 G_phys=6.39115609449489e-06 G_eff=6.39115609449489e-06
Rh31n8n1 in8n h31p 156466.214439883
* h31 input 9 w=+0.217996086164886 w+  bank=n alpha=1 R=152907.943989971 G_phys=6.53988258494657e-06 G_eff=6.53988258494657e-06
Rh31p9n1 in9 h31p 152907.943989971
* h31 input 10 w=-0.173189336412784 w-  bank=n alpha=1 R=192467.58503587 G_phys=5.19568009238351e-06 G_eff=5.19568009238351e-06
Rh31n10n1 in10n h31p 192467.58503587
* h31 input 11 w=+0.227561810267943 w+  bank=n alpha=1 R=146480.348763639 G_phys=6.8268543080383e-06 G_eff=6.8268543080383e-06
Rh31p11n1 in11 h31p 146480.348763639
* h31 input 12 w=+0.400647928830177 w+  bank=n alpha=1 R=83198.5664587384 G_phys=1.20194378649053e-05 G_eff=1.20194378649053e-05
Rh31p12n1 in12 h31p 83198.5664587384
* h31 input 13 w=+0.0924404555732517 w+  bank=n alpha=1 R=360592.482226781 G_phys=2.77321366719755e-06 G_eff=2.77321366719755e-06
Rh31p13n1 in13 h31p 360592.482226781
* h31 input 14 w=+0.340918137300815 w+  bank=n alpha=1 R=97775.1832074605 G_phys=1.02275441190244e-05 G_eff=1.02275441190244e-05
Rh31p14n1 in14 h31p 97775.1832074605
* h31 input 15 w=+0.631456773568415 w+  bank=n alpha=1 R=52787.9891840638 G_phys=1.89437032070525e-05 G_eff=1.89437032070525e-05
Rh31p15n1 in15 h31p 52787.9891840638
* h31 input 16 w=+0.19173700817347 w+  bank=n alpha=1 R=173849.240951834 G_phys=5.75211024520409e-06 G_eff=5.75211024520409e-06
Rh31p16n1 in16 h31p 173849.240951834
* h31 bias w-  bank=n alpha=1 R=620531.31238591 G_phys=1.61152222303666e-06 G_eff=1.61152222303666e-06
Rh31bnn1 vrefn h31p 620531.31238591
Vh31p h31p 0 DC 0
Bh31crelu 0 h31iy I = max(0, i(Vh31p))
Vh31iy h31iy 0 DC 0
* current-mode hidden h31: I_y = max(0, I_sum), no hidden voltage

* h32 input 1 w=+0.018363806586789 w+  bank=f alpha=0.001 R=1815.16469234181 G_phys=0.000550914197603669 G_eff=5.50914197603669e-07
Rh32p1f1 tap1 h32p 1815.16469234181
* h32 input 2 w=+0.274234487929714 w+  bank=n alpha=1 R=121550.478880237 G_phys=8.22703463789143e-06 G_eff=8.22703463789143e-06
Rh32p2n1 in2 h32p 121550.478880237
* h32 input 3 w=+0.286642259390481 w+  bank=n alpha=1 R=116288.970803585 G_phys=8.59926778171444e-06 G_eff=8.59926778171444e-06
Rh32p3n1 in3 h32p 116288.970803585
* h32 input 4 w=-0.106012181190002 w-  bank=n alpha=1 R=314429.275571559 G_phys=3.18036543570007e-06 G_eff=3.18036543570007e-06
Rh32n4n1 in4n h32p 314429.275571559
* h32 input 5 w=-0.539184466126997 w-  bank=n alpha=1 R=61821.7612476287 G_phys=1.61755339838099e-05 G_eff=1.61755339838099e-05
Rh32n5n1 in5n h32p 61821.7612476287
* h32 input 6 w=-0.141969883388357 w-  bank=n alpha=1 R=234791.580705539 G_phys=4.25909650165071e-06 G_eff=4.25909650165071e-06
Rh32n6n1 in6n h32p 234791.580705539
* h32 input 7 w=-0.343812430494534 w-  bank=n alpha=1 R=96952.0889206571 G_phys=1.0314372914836e-05 G_eff=1.0314372914836e-05
Rh32n7n1 in7n h32p 96952.0889206571
* h32 input 8 w=-0.197072814561277 w-  bank=n alpha=1 R=169142.219882229 G_phys=5.91218443683832e-06 G_eff=5.91218443683832e-06
Rh32n8n1 in8n h32p 169142.219882229
* h32 input 9 w=-0.180430465047897 w-  bank=n alpha=1 R=184743.376482927 G_phys=5.41291395143692e-06 G_eff=5.41291395143692e-06
Rh32n9n1 in9n h32p 184743.376482927
* h32 input 10 w=+0.113268490856906 w+  bank=n alpha=1 R=294286.019714378 G_phys=3.39805472570718e-06 G_eff=3.39805472570718e-06
Rh32p10n1 in10 h32p 294286.019714378
* h32 input 11 w=+0.0737822862098911 w+  bank=n alpha=1 R=451779.621446112 G_phys=2.21346858629673e-06 G_eff=2.21346858629673e-06
Rh32p11n1 in11 h32p 451779.621446112
* h32 input 12 w=+0.131260687318804 w+  bank=n alpha=1 R=253947.575730529 G_phys=3.93782061956414e-06 G_eff=3.93782061956414e-06
Rh32p12n1 in12 h32p 253947.575730529
* h32 input 13 w=-0.105796213840622 w-  bank=n alpha=1 R=315071.136511074 G_phys=3.17388641521865e-06 G_eff=3.17388641521865e-06
Rh32n13n1 in13n h32p 315071.136511074
* h32 input 14 w=-0.365435123738796 w-  bank=n alpha=1 R=91215.4611529876 G_phys=1.09630537121639e-05 G_eff=1.09630537121639e-05
Rh32n14n1 in14n h32p 91215.4611529876
* h32 input 15 w=-0.0205558893905 w-  bank=f alpha=0.001 R=1621.59528591055 G_phys=0.000616676681714999 G_eff=6.16676681714999e-07
Rh32n15f1 tap15n h32p 1621.59528591055
* h32 input 16 w=-0.212152037098157 w-  bank=n alpha=1 R=157120.024814614 G_phys=6.36456111294471e-06 G_eff=6.36456111294471e-06
Rh32n16n1 in16n h32p 157120.024814614
* h32 bias w+  bank=f alpha=0.001 R=4134.96891231251 G_phys=0.000241839786756884 G_eff=2.41839786756884e-07
Rh32bpf1 tapref h32p 4134.96891231251
Vh32p h32p 0 DC 0
Bh32crelu 0 h32iy I = max(0, i(Vh32p))
Vh32iy h32iy 0 DC 0
* current-mode hidden h32: I_y = max(0, I_sum), no hidden voltage

Fo1h1 0 o1p Vh1iy 0.115109951768787
Fo1h2 0 o1p Vh2iy 0.416557305918275
Fo1h3 0 o1p Vh3iy 0.460762298204741
Fo1h4 0 o1p Vh4iy 0.128235529120638
Fo1h5 0 o1p Vh5iy 0.25946188501651
Fo1h6 0 o1p Vh6iy 0.0121141451968155
Fo1h7 0 o1p Vh7iy -0.240253536162518
Fo1h8 0 o1p Vh8iy 0.187475674056081
Fo1h9 0 o1p Vh9iy -0.249792136720497
Fo1h10 0 o1p Vh10iy -0.0478130377197742
Fo1h11 0 o1p Vh11iy 0.103135444855694
Fo1h12 0 o1p Vh12iy -0.0209153710838255
Fo1h13 0 o1p Vh13iy -0.0177641479719743
Fo1h14 0 o1p Vh14iy -0.162077236015947
Fo1h15 0 o1p Vh15iy 0.156787201998635
Fo1h16 0 o1p Vh16iy -0.00694237968883333
Fo1h17 0 o1p Vh17iy 0.263424706628807
Fo1h18 0 o1p Vh18iy 0.403807796552332
Fo1h19 0 o1p Vh19iy 0.415931315874452
Fo1h20 0 o1p Vh20iy 0.0719298844689274
Fo1h21 0 o1p Vh21iy -0.387164693396724
Fo1h22 0 o1p Vh22iy 0.13881898843949
Fo1h23 0 o1p Vh23iy -0.118143194098524
Fo1h24 0 o1p Vh24iy -0.494956544406075
Fo1h25 0 o1p Vh25iy -0.0137314432186455
Fo1h26 0 o1p Vh26iy 0.00762307525297978
Fo1h27 0 o1p Vh27iy 0.187160704798257
Fo1h28 0 o1p Vh28iy 0.0939442280900053
Fo1h29 0 o1p Vh29iy 0.0315398664392492
Fo1h30 0 o1p Vh30iy 0.183835448783735
Fo1h31 0 o1p Vh31iy -0.236627512253244
Fo1h32 0 o1p Vh32iy -0.230869865069063
* output bias current o1: I=-2.42895707137462e-06 = b*3e-05 (b=-0.0809652357124875 frozen)
Bo1bias 0 o1p I = -2.42895707137462e-06
* single-copy I-to-V: 0 V sum o1p, I dump onto R_IV=33333.3333333333
Vo1p o1p 0 DC 0
Bo1iv 0 o1lin I = i(Vo1p)
Ro1iv o1lin 0 33333.3333333333

Fo2h1 0 o2p Vh1iy -0.195521390350609
Fo2h2 0 o2p Vh2iy 0.386445174905558
Fo2h3 0 o2p Vh3iy 0.296294588630229
Fo2h4 0 o2p Vh4iy -0.299308681857295
Fo2h5 0 o2p Vh5iy 0.732671792857329
Fo2h6 0 o2p Vh6iy 0.124925987288217
Fo2h7 0 o2p Vh7iy -0.0857938493267301
Fo2h8 0 o2p Vh8iy -0.0609936542707342
Fo2h9 0 o2p Vh9iy 0.256981204903229
Fo2h10 0 o2p Vh10iy 0.073638013162671
Fo2h11 0 o2p Vh11iy -0.149208279345328
Fo2h12 0 o2p Vh12iy -0.475362564845884
Fo2h13 0 o2p Vh13iy -0.0533811781970356
Fo2h14 0 o2p Vh14iy 0.279456004632752
Fo2h15 0 o2p Vh15iy -0.0744870090943736
Fo2h16 0 o2p Vh16iy -0.0222148593491043
Fo2h17 0 o2p Vh17iy 0.0088751960388594
Fo2h18 0 o2p Vh18iy -0.194172060066752
Fo2h19 0 o2p Vh19iy 0.341327626188232
Fo2h20 0 o2p Vh20iy -0.0323870183321868
Fo2h21 0 o2p Vh21iy -0.0999542141187652
Fo2h22 0 o2p Vh22iy 0.693789300406694
Fo2h23 0 o2p Vh23iy 0.0972685864670828
Fo2h24 0 o2p Vh24iy -0.0293783170287994
Fo2h25 0 o2p Vh25iy 0.0497492024826392
Fo2h26 0 o2p Vh26iy -0.466063512962686
Fo2h27 0 o2p Vh27iy 0.194887582685885
Fo2h28 0 o2p Vh28iy 0.209047565197081
Fo2h29 0 o2p Vh29iy 0.00919963467526149
Fo2h30 0 o2p Vh30iy -0.379437042796868
Fo2h31 0 o2p Vh31iy -0.216631724491884
Fo2h32 0 o2p Vh32iy 0.139103822260271
* output bias current o2: I=9.66391595827364e-07 = b*3e-05 (b=0.0322130531942455 frozen)
Bo2bias 0 o2p I = 9.66391595827364e-07
* single-copy I-to-V: 0 V sum o2p, I dump onto R_IV=33333.3333333333
Vo2p o2p 0 DC 0
Bo2iv 0 o2lin I = i(Vo2p)
Ro2iv o2lin 0 33333.3333333333

Fo3h1 0 o3p Vh1iy -0.100595944434035
Fo3h2 0 o3p Vh2iy -0.265315115107159
Fo3h3 0 o3p Vh3iy -0.0591677372187977
Fo3h4 0 o3p Vh4iy -0.0695954531730398
Fo3h5 0 o3p Vh5iy -0.284313347850547
Fo3h6 0 o3p Vh6iy 0.314440272159438
Fo3h7 0 o3p Vh7iy -0.349535009995164
Fo3h8 0 o3p Vh8iy -0.295696300813859
Fo3h9 0 o3p Vh9iy -0.735854867565559
Fo3h10 0 o3p Vh10iy -0.0859238760568894
Fo3h11 0 o3p Vh11iy -0.105996934570411
Fo3h12 0 o3p Vh12iy -0.193541479603888
Fo3h13 0 o3p Vh13iy -0.351950930756974
Fo3h14 0 o3p Vh14iy 0.0402342325324318
Fo3h15 0 o3p Vh15iy 0.188158881095559
Fo3h16 0 o3p Vh16iy 0.204693314484602
Fo3h17 0 o3p Vh17iy 0.153640089266272
Fo3h18 0 o3p Vh18iy 0.463153650429953
Fo3h19 0 o3p Vh19iy -0.0426705918571366
Fo3h20 0 o3p Vh20iy 0.210331327799834
Fo3h21 0 o3p Vh21iy -0.0625815721904128
Fo3h22 0 o3p Vh22iy 0.238697201684848
Fo3h23 0 o3p Vh23iy -0.0558624260671465
Fo3h24 0 o3p Vh24iy 0.439236044835332
Fo3h25 0 o3p Vh25iy 0.113742741787302
Fo3h26 0 o3p Vh26iy -0.433617266896606
Fo3h27 0 o3p Vh27iy 0.230315174630548
Fo3h28 0 o3p Vh28iy -0.12398109066818
Fo3h29 0 o3p Vh29iy -0.26178305647614
Fo3h30 0 o3p Vh30iy -0.44647126763401
Fo3h31 0 o3p Vh31iy -0.53039390006668
Fo3h32 0 o3p Vh32iy 0.288818654520262
* output bias current o3: I=1.90502107711084e-06 = b*3e-05 (b=0.0635007025703613 frozen)
Bo3bias 0 o3p I = 1.90502107711084e-06
* single-copy I-to-V: 0 V sum o3p, I dump onto R_IV=33333.3333333333
Vo3p o3p 0 DC 0
Bo3iv 0 o3lin I = i(Vo3p)
Ro3iv o3lin 0 33333.3333333333

Fo4h1 0 o4p Vh1iy 0.274757256178841
Fo4h2 0 o4p Vh2iy -0.133159767354893
Fo4h3 0 o4p Vh3iy -0.106623598682841
Fo4h4 0 o4p Vh4iy 0.10049322803724
Fo4h5 0 o4p Vh5iy -0.195742340683107
Fo4h6 0 o4p Vh6iy -0.202179592890339
Fo4h7 0 o4p Vh7iy -0.112561544712497
Fo4h8 0 o4p Vh8iy 0.0264861793940817
Fo4h9 0 o4p Vh9iy -0.0974936293293829
Fo4h10 0 o4p Vh10iy -0.296895349286464
Fo4h11 0 o4p Vh11iy -0.580818210763829
Fo4h12 0 o4p Vh12iy -0.276549005245937
Fo4h13 0 o4p Vh13iy -0.164579538023522
Fo4h14 0 o4p Vh14iy -0.00939321676538441
Fo4h15 0 o4p Vh15iy -0.0690593814994067
Fo4h16 0 o4p Vh16iy -0.272869230842632
Fo4h17 0 o4p Vh17iy 0.168866320874711
Fo4h18 0 o4p Vh18iy -0.0339148293163791
Fo4h19 0 o4p Vh19iy -0.0805852645818897
Fo4h20 0 o4p Vh20iy 0.0499049155841609
Fo4h21 0 o4p Vh21iy 0.0630428027700635
Fo4h22 0 o4p Vh22iy 0.077534797791833
Fo4h23 0 o4p Vh23iy 0.0744829629231984
Fo4h24 0 o4p Vh24iy -0.00836970221956497
Fo4h25 0 o4p Vh25iy -0.0959555339157937
Fo4h26 0 o4p Vh26iy -0.27047998771669
Fo4h27 0 o4p Vh27iy -0.0478904255869687
Fo4h28 0 o4p Vh28iy -0.311644423649809
Fo4h29 0 o4p Vh29iy -0.0286856006407659
Fo4h30 0 o4p Vh30iy -0.016265879828258
Fo4h31 0 o4p Vh31iy -0.119685509607977
Fo4h32 0 o4p Vh32iy -0.0356690164245122
* output bias current o4: I=2.01393623959048e-06 = b*3e-05 (b=0.0671312079863495 frozen)
Bo4bias 0 o4p I = 2.01393623959048e-06
* single-copy I-to-V: 0 V sum o4p, I dump onto R_IV=33333.3333333333
Vo4p o4p 0 DC 0
Bo4iv 0 o4lin I = i(Vo4p)
Ro4iv o4lin 0 33333.3333333333

Fo5h1 0 o5p Vh1iy 0.0860510418468527
Fo5h2 0 o5p Vh2iy -0.140209371980717
Fo5h3 0 o5p Vh3iy -0.298670153474102
Fo5h4 0 o5p Vh4iy 0.194023589749981
Fo5h5 0 o5p Vh5iy 0.104223096266613
Fo5h6 0 o5p Vh6iy 0.179601423642336
Fo5h7 0 o5p Vh7iy -0.15816414054373
Fo5h8 0 o5p Vh8iy -0.249576912278698
Fo5h9 0 o5p Vh9iy -0.031381439286146
Fo5h10 0 o5p Vh10iy 0.375618440651073
Fo5h11 0 o5p Vh11iy 0.0953608962368974
Fo5h12 0 o5p Vh12iy 0.235920649298708
Fo5h13 0 o5p Vh13iy -0.0940916695355706
Fo5h14 0 o5p Vh14iy 0.00295126144933853
Fo5h15 0 o5p Vh15iy 0.529616924207031
Fo5h16 0 o5p Vh16iy 0.319042125899952
Fo5h17 0 o5p Vh17iy -0.466616152697173
Fo5h18 0 o5p Vh18iy -0.243973793531226
Fo5h19 0 o5p Vh19iy -0.167620412829882
Fo5h20 0 o5p Vh20iy 0.191248887162316
Fo5h21 0 o5p Vh21iy 0.174220054558956
Fo5h22 0 o5p Vh22iy -0.14737880105185
Fo5h23 0 o5p Vh23iy -0.261133636281725
Fo5h24 0 o5p Vh24iy 0.130521837388059
Fo5h25 0 o5p Vh25iy -0.326372621774105
Fo5h26 0 o5p Vh26iy 0.16696553546102
Fo5h27 0 o5p Vh27iy -0.105618085709112
Fo5h28 0 o5p Vh28iy 0.0630335864648206
Fo5h29 0 o5p Vh29iy 0.231531157265063
Fo5h30 0 o5p Vh30iy -0.0894419530377066
Fo5h31 0 o5p Vh31iy 0.216486138811528
Fo5h32 0 o5p Vh32iy -0.32037829849107
* output bias current o5: I=6.89979425044561e-08 = b*3e-05 (b=0.0022999314168152 frozen)
Bo5bias 0 o5p I = 6.89979425044561e-08
* single-copy I-to-V: 0 V sum o5p, I dump onto R_IV=33333.3333333333
Vo5p o5p 0 DC 0
Bo5iv 0 o5lin I = i(Vo5p)
Ro5iv o5lin 0 33333.3333333333

Fo6h1 0 o6p Vh1iy 0.177051530119574
Fo6h2 0 o6p Vh2iy 0.301592495922723
Fo6h3 0 o6p Vh3iy 0.171870982949934
Fo6h4 0 o6p Vh4iy -0.3405205591368
Fo6h5 0 o6p Vh5iy -0.19025500833844
Fo6h6 0 o6p Vh6iy 0.141724280050197
Fo6h7 0 o6p Vh7iy -0.0326153624876146
Fo6h8 0 o6p Vh8iy 0.106637930601
Fo6h9 0 o6p Vh9iy 0.167194950685368
Fo6h10 0 o6p Vh10iy -0.113695758135469
Fo6h11 0 o6p Vh11iy 0.174899957381211
Fo6h12 0 o6p Vh12iy -0.244360694504916
Fo6h13 0 o6p Vh13iy 0.255772583539878
Fo6h14 0 o6p Vh14iy 0.139949769298614
Fo6h15 0 o6p Vh15iy -0.401168375335584
Fo6h16 0 o6p Vh16iy 0.405832076822582
Fo6h17 0 o6p Vh17iy -0.113061682974004
Fo6h18 0 o6p Vh18iy -0.197513353657142
Fo6h19 0 o6p Vh19iy -0.228990652840289
Fo6h20 0 o6p Vh20iy -0.216778558754084
Fo6h21 0 o6p Vh21iy -0.139531541535413
Fo6h22 0 o6p Vh22iy -0.394983843934915
Fo6h23 0 o6p Vh23iy -0.193849822273603
Fo6h24 0 o6p Vh24iy -0.0741873589980665
Fo6h25 0 o6p Vh25iy -0.172655508406202
Fo6h26 0 o6p Vh26iy 0.0670699610875517
Fo6h27 0 o6p Vh27iy 0.25363855276468
Fo6h28 0 o6p Vh28iy -0.179185579156039
Fo6h29 0 o6p Vh29iy -0.129923130427228
Fo6h30 0 o6p Vh30iy -0.169171092451912
Fo6h31 0 o6p Vh31iy 0.218686712022964
Fo6h32 0 o6p Vh32iy 0.133370937368681
* output bias current o6: I=1.94473836254393e-06 = b*3e-05 (b=0.0648246120847975 frozen)
Bo6bias 0 o6p I = 1.94473836254393e-06
* single-copy I-to-V: 0 V sum o6p, I dump onto R_IV=33333.3333333333
Vo6p o6p 0 DC 0
Bo6iv 0 o6lin I = i(Vo6p)
Ro6iv o6lin 0 33333.3333333333

Fo7h1 0 o7p Vh1iy 0.130193574665561
Fo7h2 0 o7p Vh2iy 0.394190134763453
Fo7h3 0 o7p Vh3iy 0.206617853142924
Fo7h4 0 o7p Vh4iy -0.378033462280536
Fo7h5 0 o7p Vh5iy -0.580108461232067
Fo7h6 0 o7p Vh6iy 0.107934080055711
Fo7h7 0 o7p Vh7iy 0.101501144533757
Fo7h8 0 o7p Vh8iy 0.0692471666647439
Fo7h9 0 o7p Vh9iy -0.335430638558454
Fo7h10 0 o7p Vh10iy 0.101094797691112
Fo7h11 0 o7p Vh11iy -0.148243371766924
Fo7h12 0 o7p Vh12iy -0.334713947003149
Fo7h13 0 o7p Vh13iy -0.322800486422993
Fo7h14 0 o7p Vh14iy -0.104357857187523
Fo7h15 0 o7p Vh15iy 0.182195051802482
Fo7h16 0 o7p Vh16iy 0.0146234127477982
Fo7h17 0 o7p Vh17iy -0.0268461940667064
Fo7h18 0 o7p Vh18iy 0.263886686193095
Fo7h19 0 o7p Vh19iy 0.184182739421503
Fo7h20 0 o7p Vh20iy -0.16994338127458
Fo7h21 0 o7p Vh21iy -0.17515931490212
Fo7h22 0 o7p Vh22iy 0.170460541565249
Fo7h23 0 o7p Vh23iy -0.342102206419994
Fo7h24 0 o7p Vh24iy -0.0940891241579366
Fo7h25 0 o7p Vh25iy -0.147263798833488
Fo7h26 0 o7p Vh26iy -0.0975787524659246
Fo7h27 0 o7p Vh27iy -0.201262065009158
Fo7h28 0 o7p Vh28iy -0.060609790215781
Fo7h29 0 o7p Vh29iy -0.355920486311588
Fo7h30 0 o7p Vh30iy 0.0702967455487947
Fo7h31 0 o7p Vh31iy 0.188674793501044
Fo7h32 0 o7p Vh32iy -0.221533996080022
* output bias current o7: I=1.43919421012378e-06 = b*3e-05 (b=0.0479731403374592 frozen)
Bo7bias 0 o7p I = 1.43919421012378e-06
* single-copy I-to-V: 0 V sum o7p, I dump onto R_IV=33333.3333333333
Vo7p o7p 0 DC 0
Bo7iv 0 o7lin I = i(Vo7p)
Ro7iv o7lin 0 33333.3333333333

Fo8h1 0 o8p Vh1iy -0.264579445854062
Fo8h2 0 o8p Vh2iy -0.461651647659873
Fo8h3 0 o8p Vh3iy -0.248506615035073
Fo8h4 0 o8p Vh4iy -0.0596907059046396
Fo8h5 0 o8p Vh5iy -0.142952779428107
Fo8h6 0 o8p Vh6iy 0.230947580946818
Fo8h7 0 o8p Vh7iy 0.224542704495923
Fo8h8 0 o8p Vh8iy -0.0814289785611842
Fo8h9 0 o8p Vh9iy 0.151871407153412
Fo8h10 0 o8p Vh10iy -0.0439376442611886
Fo8h11 0 o8p Vh11iy -0.0114777570667242
Fo8h12 0 o8p Vh12iy -0.184091969163629
Fo8h13 0 o8p Vh13iy 0.167375709493599
Fo8h14 0 o8p Vh14iy 0.639794426458427
Fo8h15 0 o8p Vh15iy 0.00251732875304732
Fo8h16 0 o8p Vh16iy 0.510552134317183
Fo8h17 0 o8p Vh17iy -0.402994248540282
Fo8h18 0 o8p Vh18iy 0.141582671709231
Fo8h19 0 o8p Vh19iy 0.181760587882604
Fo8h20 0 o8p Vh20iy 0.465247625040388
Fo8h21 0 o8p Vh21iy -0.129997678502292
Fo8h22 0 o8p Vh22iy 0.727771195072513
Fo8h23 0 o8p Vh23iy 0.0590279674258587
Fo8h24 0 o8p Vh24iy -0.0219880792573176
Fo8h25 0 o8p Vh25iy -0.000673889145733125
Fo8h26 0 o8p Vh26iy -0.0895992045192751
Fo8h27 0 o8p Vh27iy -0.161030155307918
Fo8h28 0 o8p Vh28iy -0.0515875057732319
Fo8h29 0 o8p Vh29iy -0.167333727666792
Fo8h30 0 o8p Vh30iy 0.117154510339097
Fo8h31 0 o8p Vh31iy -0.114263857072683
Fo8h32 0 o8p Vh32iy 0.185068242761295
* output bias current o8: I=2.11002751111431e-06 = b*3e-05 (b=0.070334250370477 frozen)
Bo8bias 0 o8p I = 2.11002751111431e-06
* single-copy I-to-V: 0 V sum o8p, I dump onto R_IV=33333.3333333333
Vo8p o8p 0 DC 0
Bo8iv 0 o8lin I = i(Vo8p)
Ro8iv o8lin 0 33333.3333333333

Fo9h1 0 o9p Vh1iy -0.342788496026982
Fo9h2 0 o9p Vh2iy 0.117901804588507
Fo9h3 0 o9p Vh3iy -0.555835720214104
Fo9h4 0 o9p Vh4iy 0.355136587925528
Fo9h5 0 o9p Vh5iy 0.236432436172994
Fo9h6 0 o9p Vh6iy -0.00589463242951189
Fo9h7 0 o9p Vh7iy -0.175810166557473
Fo9h8 0 o9p Vh8iy 0.162552656301944
Fo9h9 0 o9p Vh9iy -0.443497798175432
Fo9h10 0 o9p Vh10iy 0.114863161009978
Fo9h11 0 o9p Vh11iy -0.051706338551111
Fo9h12 0 o9p Vh12iy -0.247913853258797
Fo9h13 0 o9p Vh13iy 0.0720916431840902
Fo9h14 0 o9p Vh14iy 0.00473033723811417
Fo9h15 0 o9p Vh15iy -0.290577914446662
Fo9h16 0 o9p Vh16iy -0.0531648681945055
Fo9h17 0 o9p Vh17iy 0.0157425177085947
Fo9h18 0 o9p Vh18iy -0.104777957691913
Fo9h19 0 o9p Vh19iy -0.368259428743895
Fo9h20 0 o9p Vh20iy 0.100989358745228
Fo9h21 0 o9p Vh21iy 0.084258883556939
Fo9h22 0 o9p Vh22iy 0.093068688723566
Fo9h23 0 o9p Vh23iy 0.153137872499505
Fo9h24 0 o9p Vh24iy 0.0107021071757068
Fo9h25 0 o9p Vh25iy 0.151859492007221
Fo9h26 0 o9p Vh26iy -0.0745603298060184
Fo9h27 0 o9p Vh27iy 0.475223780202243
Fo9h28 0 o9p Vh28iy 0.715956917954612
Fo9h29 0 o9p Vh29iy -0.520384445309866
Fo9h30 0 o9p Vh30iy 0.217731604854565
Fo9h31 0 o9p Vh31iy -0.123913004875871
Fo9h32 0 o9p Vh32iy 0.0869405958454977
* output bias current o9: I=-2.35730874650366e-07 = b*3e-05 (b=-0.00785769582167887 frozen)
Bo9bias 0 o9p I = -2.35730874650366e-07
* single-copy I-to-V: 0 V sum o9p, I dump onto R_IV=33333.3333333333
Vo9p o9p 0 DC 0
Bo9iv 0 o9lin I = i(Vo9p)
Ro9iv o9lin 0 33333.3333333333

Fo10h1 0 o10p Vh1iy -0.0381763956958746
Fo10h2 0 o10p Vh2iy 0.410781186996451
Fo10h3 0 o10p Vh3iy 0.475033421735393
Fo10h4 0 o10p Vh4iy 0.0271427582394968
Fo10h5 0 o10p Vh5iy 0.0212799641995083
Fo10h6 0 o10p Vh6iy 0.0201273268189427
Fo10h7 0 o10p Vh7iy -0.036291550108304
Fo10h8 0 o10p Vh8iy 0.0509688710938526
Fo10h9 0 o10p Vh9iy -0.135969386219015
Fo10h10 0 o10p Vh10iy 0.542965243347564
Fo10h11 0 o10p Vh11iy 0.200790198383509
Fo10h12 0 o10p Vh12iy -0.0602452386161185
Fo10h13 0 o10p Vh13iy -0.18784742953156
Fo10h14 0 o10p Vh14iy -0.0121063802780956
Fo10h15 0 o10p Vh15iy 0.162912924713055
Fo10h16 0 o10p Vh16iy 0.000496602144198326
Fo10h17 0 o10p Vh17iy 0.150471984074884
Fo10h18 0 o10p Vh18iy -0.0993574349593851
Fo10h19 0 o10p Vh19iy -0.0430450321763909
Fo10h20 0 o10p Vh20iy -0.498578232263262
Fo10h21 0 o10p Vh21iy -0.135185117923925
Fo10h22 0 o10p Vh22iy 0.00794231626553338
Fo10h23 0 o10p Vh23iy -0.411689837989046
Fo10h24 0 o10p Vh24iy 0.321047972853849
Fo10h25 0 o10p Vh25iy -0.130972309748016
Fo10h26 0 o10p Vh26iy 0.0365278526067883
Fo10h27 0 o10p Vh27iy -0.205674584301975
Fo10h28 0 o10p Vh28iy -0.0123163999797875
Fo10h29 0 o10p Vh29iy -0.120487475126756
Fo10h30 0 o10p Vh30iy -0.421650115672696
Fo10h31 0 o10p Vh31iy 0.15176529701113
Fo10h32 0 o10p Vh32iy 0.00307524765960727
* output bias current o10: I=-9.37907383028131e-07 = b*3e-05 (b=-0.031263579434271 frozen)
Bo10bias 0 o10p I = -9.37907383028131e-07
* single-copy I-to-V: 0 V sum o10p, I dump onto R_IV=33333.3333333333
Vo10p o10p 0 DC 0
Bo10iv 0 o10lin I = i(Vo10p)
Ro10iv o10lin 0 33333.3333333333

Fo11h1 0 o11p Vh1iy -0.160102279955593
Fo11h2 0 o11p Vh2iy 0.011469223690656
Fo11h3 0 o11p Vh3iy 0.0176041755498141
Fo11h4 0 o11p Vh4iy -0.0193710750418404
Fo11h5 0 o11p Vh5iy 0.112602634979867
Fo11h6 0 o11p Vh6iy 0.00163262396170036
Fo11h7 0 o11p Vh7iy -0.0344149127536822
Fo11h8 0 o11p Vh8iy 0.0140339587694358
Fo11h9 0 o11p Vh9iy 0.200472625000294
Fo11h10 0 o11p Vh10iy 0.127220756971711
Fo11h11 0 o11p Vh11iy -0.215899699488286
Fo11h12 0 o11p Vh12iy -0.0276713436872213
Fo11h13 0 o11p Vh13iy 0.188664634231365
Fo11h14 0 o11p Vh14iy -0.119078372545684
Fo11h15 0 o11p Vh15iy 0.15422975355602
Fo11h16 0 o11p Vh16iy -0.104607206722078
Fo11h17 0 o11p Vh17iy 0.106639727219858
Fo11h18 0 o11p Vh18iy 0.310905721051453
Fo11h19 0 o11p Vh19iy 0.210141672521531
Fo11h20 0 o11p Vh20iy 0.009349861892821
Fo11h21 0 o11p Vh21iy -0.148461029214851
Fo11h22 0 o11p Vh22iy -0.118671866129314
Fo11h23 0 o11p Vh23iy -0.109207143921327
Fo11h24 0 o11p Vh24iy -0.0902417819363344
Fo11h25 0 o11p Vh25iy 0.314745464583241
Fo11h26 0 o11p Vh26iy 0.0956381358816812
Fo11h27 0 o11p Vh27iy -0.150311342322866
Fo11h28 0 o11p Vh28iy -0.0832874521070705
Fo11h29 0 o11p Vh29iy 0.0404370827831914
Fo11h30 0 o11p Vh30iy -0.0722629324126473
Fo11h31 0 o11p Vh31iy -0.0830409064130833
Fo11h32 0 o11p Vh32iy -0.390143512242536
* output bias current o11: I=-4.32806954110902e-08 = b*3e-05 (b=-0.00144268984703634 frozen)
Bo11bias 0 o11p I = -4.32806954110902e-08
* single-copy I-to-V: 0 V sum o11p, I dump onto R_IV=33333.3333333333
Vo11p o11p 0 DC 0
Bo11iv 0 o11lin I = i(Vo11p)
Ro11iv o11lin 0 33333.3333333333

Fo12h1 0 o12p Vh1iy -0.0568819810826339
Fo12h2 0 o12p Vh2iy -0.116449760348513
Fo12h3 0 o12p Vh3iy -0.394245634375715
Fo12h4 0 o12p Vh4iy -0.0304757769901363
Fo12h5 0 o12p Vh5iy -0.225077356892672
Fo12h6 0 o12p Vh6iy -0.48876360312342
Fo12h7 0 o12p Vh7iy 0.269859073889073
Fo12h8 0 o12p Vh8iy -0.0167144075003679
Fo12h9 0 o12p Vh9iy -0.271168635938693
Fo12h10 0 o12p Vh10iy -0.229866523415109
Fo12h11 0 o12p Vh11iy 0.111794037161303
Fo12h12 0 o12p Vh12iy -0.187970289472281
Fo12h13 0 o12p Vh13iy 0.219867348390274
Fo12h14 0 o12p Vh14iy -0.127058880326711
Fo12h15 0 o12p Vh15iy 0.40629100094033
Fo12h16 0 o12p Vh16iy -0.479164967789437
Fo12h17 0 o12p Vh17iy -0.142691971348636
Fo12h18 0 o12p Vh18iy 0.0750962927559542
Fo12h19 0 o12p Vh19iy -0.0357891000093011
Fo12h20 0 o12p Vh20iy -0.274882313904053
Fo12h21 0 o12p Vh21iy 0.0723735016816067
Fo12h22 0 o12p Vh22iy -0.42830678611073
Fo12h23 0 o12p Vh23iy -0.495732058756383
Fo12h24 0 o12p Vh24iy -0.0511653226482421
Fo12h25 0 o12p Vh25iy 0.0558940521557335
Fo12h26 0 o12p Vh26iy 0.307817092263132
Fo12h27 0 o12p Vh27iy -0.124284155438311
Fo12h28 0 o12p Vh28iy 0.511620988407946
Fo12h29 0 o12p Vh29iy -0.110998740438628
Fo12h30 0 o12p Vh30iy 0.0696620617055659
Fo12h31 0 o12p Vh31iy 0.219973071991933
Fo12h32 0 o12p Vh32iy 0.138023444689957
* output bias current o12: I=1.87593854280111e-07 = b*3e-05 (b=0.00625312847600372 frozen)
Bo12bias 0 o12p I = 1.87593854280111e-07
* single-copy I-to-V: 0 V sum o12p, I dump onto R_IV=33333.3333333333
Vo12p o12p 0 DC 0
Bo12iv 0 o12lin I = i(Vo12p)
Ro12iv o12lin 0 33333.3333333333

Fo13h1 0 o13p Vh1iy 0.00200007413415942
Fo13h2 0 o13p Vh2iy -0.0237460165980216
Fo13h3 0 o13p Vh3iy -0.481641955158027
Fo13h4 0 o13p Vh4iy -0.401500412219866
Fo13h5 0 o13p Vh5iy -0.324731283585407
Fo13h6 0 o13p Vh6iy 0.0791891194793975
Fo13h7 0 o13p Vh7iy 0.286949833874567
Fo13h8 0 o13p Vh8iy -0.153846131933853
Fo13h9 0 o13p Vh9iy -0.0455077430770376
Fo13h10 0 o13p Vh10iy 0.122909253832841
Fo13h11 0 o13p Vh11iy 0.0797228425783465
Fo13h12 0 o13p Vh12iy -0.0916703213430956
Fo13h13 0 o13p Vh13iy -0.00253109868008519
Fo13h14 0 o13p Vh14iy 0.523873822520012
Fo13h15 0 o13p Vh15iy 0.0718975606852002
Fo13h16 0 o13p Vh16iy 0.212010526629755
Fo13h17 0 o13p Vh17iy 0.50252589011925
Fo13h18 0 o13p Vh18iy -0.0631368164337741
Fo13h19 0 o13p Vh19iy 0.124615759492256
Fo13h20 0 o13p Vh20iy -0.0825374863137293
Fo13h21 0 o13p Vh21iy -0.0332297714786912
Fo13h22 0 o13p Vh22iy 0.217350752944783
Fo13h23 0 o13p Vh23iy 0.00620341639632115
Fo13h24 0 o13p Vh24iy -0.56329887647671
Fo13h25 0 o13p Vh25iy 0.121217122487375
Fo13h26 0 o13p Vh26iy -0.0619389520134905
Fo13h27 0 o13p Vh27iy -0.148385692307615
Fo13h28 0 o13p Vh28iy 0.0960859107643036
Fo13h29 0 o13p Vh29iy -0.0967464729103534
Fo13h30 0 o13p Vh30iy 0.0502110731232858
Fo13h31 0 o13p Vh31iy 0.0717291842082243
Fo13h32 0 o13p Vh32iy 0.117218732023777
* output bias current o13: I=1.42284252719918e-07 = b*3e-05 (b=0.00474280842399728 frozen)
Bo13bias 0 o13p I = 1.42284252719918e-07
* single-copy I-to-V: 0 V sum o13p, I dump onto R_IV=33333.3333333333
Vo13p o13p 0 DC 0
Bo13iv 0 o13lin I = i(Vo13p)
Ro13iv o13lin 0 33333.3333333333

Fo14h1 0 o14p Vh1iy -0.25477230027339
Fo14h2 0 o14p Vh2iy 0.102637632071701
Fo14h3 0 o14p Vh3iy 0.107208211835011
Fo14h4 0 o14p Vh4iy -0.361346054145307
Fo14h5 0 o14p Vh5iy 0.0565127294479513
Fo14h6 0 o14p Vh6iy -0.166023137794918
Fo14h7 0 o14p Vh7iy 0.0533068959488943
Fo14h8 0 o14p Vh8iy -0.334728977765226
Fo14h9 0 o14p Vh9iy -0.184424571200296
Fo14h10 0 o14p Vh10iy 0.263838736865495
Fo14h11 0 o14p Vh11iy 0.0215454170832462
Fo14h12 0 o14p Vh12iy -0.0509620245346412
Fo14h13 0 o14p Vh13iy -0.289718223355261
Fo14h14 0 o14p Vh14iy 0.114352462647064
Fo14h15 0 o14p Vh15iy -0.172686817087866
Fo14h16 0 o14p Vh16iy -0.0880371911025684
Fo14h17 0 o14p Vh17iy -0.0970577820037651
Fo14h18 0 o14p Vh18iy 0.279065168461303
Fo14h19 0 o14p Vh19iy 0.12574844379754
Fo14h20 0 o14p Vh20iy 0.196093228285189
Fo14h21 0 o14p Vh21iy 0.0606582432664274
Fo14h22 0 o14p Vh22iy 0.471542863591523
Fo14h23 0 o14p Vh23iy 0.132895212526076
Fo14h24 0 o14p Vh24iy -0.150700282102261
Fo14h25 0 o14p Vh25iy -0.172018927572569
Fo14h26 0 o14p Vh26iy -0.144277203051731
Fo14h27 0 o14p Vh27iy -0.0456897569368309
Fo14h28 0 o14p Vh28iy -0.269930966859316
Fo14h29 0 o14p Vh29iy -0.380176315173873
Fo14h30 0 o14p Vh30iy 0.211443520189348
Fo14h31 0 o14p Vh31iy 0.0784944631218348
Fo14h32 0 o14p Vh32iy 0.0843025902123393
* output bias current o14: I=-3.74467099852129e-07 = b*3e-05 (b=-0.0124822366617376 frozen)
Bo14bias 0 o14p I = -3.74467099852129e-07
* single-copy I-to-V: 0 V sum o14p, I dump onto R_IV=33333.3333333333
Vo14p o14p 0 DC 0
Bo14iv 0 o14lin I = i(Vo14p)
Ro14iv o14lin 0 33333.3333333333

Fo15h1 0 o15p Vh1iy -0.113449668897813
Fo15h2 0 o15p Vh2iy -0.169978823552936
Fo15h3 0 o15p Vh3iy 0.0133598434574407
Fo15h4 0 o15p Vh4iy -0.169966115485037
Fo15h5 0 o15p Vh5iy -0.0418903282162887
Fo15h6 0 o15p Vh6iy -0.324291927905124
Fo15h7 0 o15p Vh7iy 0.558916704640692
Fo15h8 0 o15p Vh8iy -0.047599242693459
Fo15h9 0 o15p Vh9iy -0.103084990895521
Fo15h10 0 o15p Vh10iy -0.115049291784761
Fo15h11 0 o15p Vh11iy 0.0920546297717411
Fo15h12 0 o15p Vh12iy 0.0505985364133342
Fo15h13 0 o15p Vh13iy -0.145296396139138
Fo15h14 0 o15p Vh14iy -0.379881852318272
Fo15h15 0 o15p Vh15iy 0.223112491519187
Fo15h16 0 o15p Vh16iy -0.14757878301826
Fo15h17 0 o15p Vh17iy 0.173921977011029
Fo15h18 0 o15p Vh18iy 0.133725887369399
Fo15h19 0 o15p Vh19iy 0.209560948195519
Fo15h20 0 o15p Vh20iy -0.0239329977507233
Fo15h21 0 o15p Vh21iy 0.196041920231295
Fo15h22 0 o15p Vh22iy -0.0995510863910355
Fo15h23 0 o15p Vh23iy 0.102107365264583
Fo15h24 0 o15p Vh24iy -0.21795159550845
Fo15h25 0 o15p Vh25iy 0.202525001628457
Fo15h26 0 o15p Vh26iy -0.281017181998367
Fo15h27 0 o15p Vh27iy 0.141610254018665
Fo15h28 0 o15p Vh28iy 0.444984802739648
Fo15h29 0 o15p Vh29iy -0.120073433142323
Fo15h30 0 o15p Vh30iy -0.0538706707421541
Fo15h31 0 o15p Vh31iy 0.148090323839994
Fo15h32 0 o15p Vh32iy -0.347735979661958
* output bias current o15: I=2.13368751786374e-06 = b*3e-05 (b=0.0711229172621247 frozen)
Bo15bias 0 o15p I = 2.13368751786374e-06
* single-copy I-to-V: 0 V sum o15p, I dump onto R_IV=33333.3333333333
Vo15p o15p 0 DC 0
Bo15iv 0 o15lin I = i(Vo15p)
Ro15iv o15lin 0 33333.3333333333

Fo16h1 0 o16p Vh1iy -0.0239168211298723
Fo16h2 0 o16p Vh2iy -0.455843018824687
Fo16h3 0 o16p Vh3iy -0.360558107273835
Fo16h4 0 o16p Vh4iy 0.281324980833712
Fo16h5 0 o16p Vh5iy -0.0789059543438914
Fo16h6 0 o16p Vh6iy 0.0459206910877794
Fo16h7 0 o16p Vh7iy -0.348093944852844
Fo16h8 0 o16p Vh8iy -0.0796710739452782
Fo16h9 0 o16p Vh9iy -0.173339228342165
Fo16h10 0 o16p Vh10iy 0.194262181446587
Fo16h11 0 o16p Vh11iy 0.155708231075043
Fo16h12 0 o16p Vh12iy 0.124882648574468
Fo16h13 0 o16p Vh13iy 0.270423516346849
Fo16h14 0 o16p Vh14iy -0.22936067173287
Fo16h15 0 o16p Vh15iy 0.0349795005301705
Fo16h16 0 o16p Vh16iy 0.104322324768401
Fo16h17 0 o16p Vh17iy -0.351176137449102
Fo16h18 0 o16p Vh18iy 0.119462358831177
Fo16h19 0 o16p Vh19iy 0.230688311648174
Fo16h20 0 o16p Vh20iy -0.0614748986253126
Fo16h21 0 o16p Vh21iy 0.36727529530057
Fo16h22 0 o16p Vh22iy 0.579638140801163
Fo16h23 0 o16p Vh23iy -0.0387096142803063
Fo16h24 0 o16p Vh24iy 0.0384174368738491
Fo16h25 0 o16p Vh25iy 0.201641208818347
Fo16h26 0 o16p Vh26iy -0.606109769372092
Fo16h27 0 o16p Vh27iy -0.101484914332963
Fo16h28 0 o16p Vh28iy 0.04265872854179
Fo16h29 0 o16p Vh29iy 0.0889131834636398
Fo16h30 0 o16p Vh30iy 0.0420485970959956
Fo16h31 0 o16p Vh31iy -0.332324220948992
Fo16h32 0 o16p Vh32iy 0.137132637809711
* output bias current o16: I=1.23234023845389e-06 = b*3e-05 (b=0.0410780079484629 frozen)
Bo16bias 0 o16p I = 1.23234023845389e-06
* single-copy I-to-V: 0 V sum o16p, I dump onto R_IV=33333.3333333333
Vo16p o16p 0 DC 0
Bo16iv 0 o16lin I = i(Vo16p)
Ro16iv o16lin 0 33333.3333333333
.control
set numdgt=15
alter Vin1 DC -0.317613426971599
alter Vin2 DC -0.104191311968312
alter Vin3 DC -0.175804174704678
alter Vin4 DC 0.601597397726495
alter Vin5 DC -0.730243251939292
alter Vin6 DC 0.404321866058759
alter Vin7 DC -0.880677844918323
alter Vin8 DC -0.971435745073449
alter Vin9 DC -0.99840482513586
alter Vin10 DC -0.84865302293809
alter Vin11 DC 0.222980894086205
alter Vin12 DC -0.421763974173089
alter Vin13 DC 0.248509929026783
alter Vin14 DC -0.888851885809331
alter Vin15 DC -0.994706471359062
alter Vin16 DC -0.554681079702378
op
print i(Vin1)
print i(Vin2)
print i(Vin3)
print i(Vin4)
print i(Vin5)
print i(Vin6)
print i(Vin7)
print i(Vin8)
print i(Vin9)
print i(Vin10)
print i(Vin11)
print i(Vin12)
print i(Vin13)
print i(Vin14)
print i(Vin15)
print i(Vin16)
print i(Vref)
.endc

.end
