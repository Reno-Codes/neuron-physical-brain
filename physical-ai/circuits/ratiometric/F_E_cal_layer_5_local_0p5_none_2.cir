* Physical AI - Experiment 14 architecture E: layer-calibration VCVS on Architecture C I-to-V
* Frozen Experiment 9 weights. No Python output correction.
* Behavioral variation study. Not transistor-level or PCB power.
* divider Ra=999000 Rb=1000 beta=0.001 Ileak=0 rail=15 linear=False k1=1 k2=1 physical_iv=False
* shape: 16 -> 32 -> 16

Vin1 in1 0 DC 0
Rdiv1a in1 tap1 976058.133087737
Rdiv1b tap1 0 978.047048257216
Ediv1 inf1 0 tap1 0 1
Vin2 in2 0 DC 0
Rdiv2a in2 tap2 976399.983679842
Rdiv2b tap2 0 985.024229002101
Ediv2 inf2 0 tap2 0 1
Vin3 in3 0 DC 0
Rdiv3a in3 tap3 975628.691732276
Rdiv3b tap3 0 977.656428153399
Ediv3 inf3 0 tap3 0 1
Vin4 in4 0 DC 0
Rdiv4a in4 tap4 983415.161353734
Rdiv4b tap4 0 977.355173531836
Ediv4 inf4 0 tap4 0 1
Vin5 in5 0 DC 0
Rdiv5a in5 tap5 978634.907759455
Rdiv5b tap5 0 983.118437039143
Ediv5 inf5 0 tap5 0 1
Vin6 in6 0 DC 0
Rdiv6a in6 tap6 977115.839219581
Rdiv6b tap6 0 979.036863499848
Ediv6 inf6 0 tap6 0 1
Vin7 in7 0 DC 0
Rdiv7a in7 tap7 976775.403573664
Rdiv7b tap7 0 977.779894328201
Ediv7 inf7 0 tap7 0 1
Vin8 in8 0 DC 0
Rdiv8a in8 tap8 981514.376988122
Rdiv8b tap8 0 983.927920412481
Ediv8 inf8 0 tap8 0 1
Vin9 in9 0 DC 0
Rdiv9a in9 tap9 975574.09647241
Rdiv9b tap9 0 983.921299946181
Ediv9 inf9 0 tap9 0 1
Vin10 in10 0 DC 0
Rdiv10a in10 tap10 984147.68440247
Rdiv10b tap10 0 982.601837509874
Ediv10 inf10 0 tap10 0 1
Vin11 in11 0 DC 0
Rdiv11a in11 tap11 979131.026128731
Rdiv11b tap11 0 978.49583744771
Ediv11 inf11 0 tap11 0 1
Vin12 in12 0 DC 0
Rdiv12a in12 tap12 981768.872651452
Rdiv12b tap12 0 984.957130717442
Ediv12 inf12 0 tap12 0 1
Vin13 in13 0 DC 0
Rdiv13a in13 tap13 985335.415869229
Rdiv13b tap13 0 976.863695130773
Ediv13 inf13 0 tap13 0 1
Vin14 in14 0 DC 0
Rdiv14a in14 tap14 980663.482527704
Rdiv14b tap14 0 978.835969603501
Ediv14 inf14 0 tap14 0 1
Vin15 in15 0 DC 0
Rdiv15a in15 tap15 977573.169613654
Rdiv15b tap15 0 977.445476106143
Ediv15 inf15 0 tap15 0 1
Vin16 in16 0 DC 0
Rdiv16a in16 tap16 980024.436841381
Rdiv16b tap16 0 978.069213104225
Ediv16 inf16 0 tap16 0 1
Vref vref 0 DC 1
Rdivrefa vref tapref 984715.556619269
Rdivrefb tapref 0 984.502167019038
Edivref vreff 0 tapref 0 1

* h1 input 1 w=-0.0168555731920106 w-  bank=f alpha=0.001 R=1977.58527423636 G_phys=0.000505667195760317 G_eff=5.05667195760317e-07
Rh1n1f1 inf1 h1n 1935.04015527899
* h1 input 2 w=+0.167421682129858 w+  bank=n alpha=1 R=199098.067283059 G_phys=5.02265046389574e-06 G_eff=5.02265046389574e-06
Rh1p2n1 in2 h1p 195162.809844869
* h1 input 3 w=-0.175338604042315 w-  bank=n alpha=1 R=190108.353579049 G_phys=5.26015812126946e-06 G_eff=5.26015812126946e-06
Rh1n3n1 in3 h1n 186175.233511506
* h1 input 4 w=-0.3026243730549 w-  bank=n alpha=1 R=110147.55023478 G_phys=9.078731191647e-06 G_eff=9.078731191647e-06
Rh1n4n1 in4 h1n 107702.169570559
* h1 input 5 w=-0.0731653551060092 w-  bank=n alpha=1 R=455589.032336913 G_phys=2.19496065318027e-06 G_eff=2.19496065318027e-06
Rh1n5n1 in5 h1n 445718.193766666
* h1 input 6 w=+0.135452999280782 w+  bank=n alpha=1 R=246087.820205711 G_phys=4.06358997842346e-06 G_eff=4.06358997842346e-06
Rh1p6n1 in6 h1p 240976.797433005
* h1 input 7 w=+0.21541693193391 w+  bank=n alpha=1 R=154738.687595643 G_phys=6.46250795801731e-06 G_eff=6.46250795801731e-06
Rh1p7n1 in7 h1p 151970.692141717
* h1 input 8 w=-0.0225117532106789 w-  bank=f alpha=0.001 R=1480.70801156087 G_phys=0.000675352596320366 G_eff=6.75352596320366e-07
Rh1n8f1 inf8 h1n 1448.71032226718
* h1 input 9 w=-0.120865686071453 w-  bank=n alpha=1 R=275788.227550601 G_phys=3.62597058214359e-06 G_eff=3.62597058214359e-06
Rh1n9n1 in9 h1n 269759.456834771
* h1 input 10 w=+0.732018397911567 w+  bank=n alpha=1 R=45536.19612353 G_phys=2.1960551937347e-05 G_eff=2.1960551937347e-05
Rh1p10n1 in10 h1p 44595.4622349849
* h1 input 11 w=+0.435334885703784 w+  bank=n alpha=1 R=76569.405365814 G_phys=1.30600465711135e-05 G_eff=1.30600465711135e-05
Rh1p11n1 in11 h1p 74778.0662895304
* h1 input 12 w=+0.385479984810207 w+  bank=n alpha=1 R=86472.2803954274 G_phys=1.15643995443062e-05 G_eff=1.15643995443062e-05
Rh1p12n1 in12 h1p 84526.6798266305
* h1 input 13 w=-0.42800728852471 w-  bank=n alpha=1 R=77880.2936936643 G_phys=1.28402186557413e-05 G_eff=1.28402186557413e-05
Rh1n13n1 in13 h1n 76742.326336476
* h1 input 14 w=+0.104452911276431 w+  bank=n alpha=1 R=319123.066327159 G_phys=3.13358733829293e-06 G_eff=3.13358733829293e-06
Rh1p14n1 in14 h1p 312444.701515004
* h1 input 15 w=-0.361295245628978 w-  bank=n alpha=1 R=92260.6475911506 G_phys=1.08388573688693e-05 G_eff=1.08388573688693e-05
Rh1n15n1 in15 h1n 90697.8008996682
* h1 input 16 w=+0.0759383856082483 w+  bank=n alpha=1 R=438952.356786904 G_phys=2.27815156824745e-06 G_eff=2.27815156824745e-06
Rh1p16n1 in16 h1p 431674.533187321
* h1 bias=-0.0910888061470142 b-  bank=n alpha=1 R=365943.245315286 G_phys=2.73266418441043e-06 G_eff=2.73266418441043e-06
Rh1bnn1 vref h1n 359155.435921532
Vh1p h1p 0 DC 0
Vh1n h1n 0 DC 0
Fh1p 0 h1d Vh1p 1
Fh1n h1d 0 Vh1n 1
Vh1d h1d 0 DC 0
Hh1 h1raw 0 Vh1d 33333.3333333333
Eh1sc h1lin 0 h1raw 0 1
* direct bounded ReLU: y=max(0, min(15, v(h1lin))) no high-gain op-amp loop
Bh1relu h1y 0 V = max(0, min(15, v(h1lin)))
Eh1 h1buf 0 h1y 0 1

* h2 input 1 w=+0.0248542194622879 w+  bank=f alpha=0.001 R=1341.15389879417 G_phys=0.000745626583868636 G_eff=7.45626583868636e-07
Rh2p1f1 inf1 h2p 1321.65475441934
* h2 input 2 w=+0.400223191665755 w+  bank=n alpha=1 R=83286.8610002279 G_phys=1.20066957499727e-05 G_eff=1.20066957499727e-05
Rh2p2n1 in2 h2p 81673.8174128399
* h2 input 3 w=+0.358260577298724 w+  bank=n alpha=1 R=93042.1471004872 G_phys=1.07478173189617e-05 G_eff=1.07478173189617e-05
Rh2p3n1 in3 h2p 91479.5512734389
* h2 input 4 w=+0.348073132477087 w+  bank=n alpha=1 R=95765.315455733 G_phys=1.04421939743126e-05 G_eff=1.04421939743126e-05
Rh2p4n1 in4 h2p 94149.9926521159
* h2 input 5 w=-0.489776715185261 w-  bank=n alpha=1 R=68058.2238800895 G_phys=1.46933014555578e-05 G_eff=1.46933014555578e-05
Rh2n5n1 in5 h2n 66757.2262699329
* h2 input 6 w=-0.262585224656684 w-  bank=n alpha=1 R=126942.913017726 G_phys=7.87755673970051e-06 G_eff=7.87755673970051e-06
Rh2n6n1 in6 h2n 124472.48716532
* h2 input 7 w=+0.634452480443638 w+  bank=n alpha=1 R=52538.7390873232 G_phys=1.90335744133091e-05 G_eff=1.90335744133091e-05
Rh2p7n1 in7 h2p 51508.3921543502
* h2 input 8 w=-0.0150494358056585 w-  bank=f alpha=0.001 R=2214.92245714621 G_phys=0.000451483074169756 G_eff=4.51483074169756e-07
Rh2n8f1 inf8 h2n 2164.21504280514
* h2 input 9 w=+0.317089980091076 w+  bank=n alpha=1 R=105122.632142962 G_phys=9.51269940273229e-06 G_eff=9.51269940273229e-06
Rh2p9n1 in9 h2p 102818.225674289
* h2 input 10 w=-0.171694565495531 w-  bank=n alpha=1 R=194143.2056229 G_phys=5.15083696486594e-06 G_eff=5.15083696486594e-06
Rh2n10n1 in10 h2n 189983.408442952
* h2 input 11 w=+0.113535277026032 w+  bank=n alpha=1 R=293594.503897589 G_phys=3.40605831078097e-06 G_eff=3.40605831078097e-06
Rh2p11n1 in11 h2p 288554.591310712
* h2 input 12 w=+0.342235951147447 w+  bank=n alpha=1 R=97398.6900603912 G_phys=1.02670785344234e-05 G_eff=1.02670785344234e-05
Rh2p12n1 in12 h2p 95569.9930784909
* h2 input 13 w=-0.268945400148547 w-  bank=n alpha=1 R=123940.89400645 G_phys=8.0683620044564e-06 G_eff=8.0683620044564e-06
Rh2n13n1 in13 h2n 121420.516065013
* h2 input 14 w=+0.239258603190851 w+  bank=n alpha=1 R=139319.267473714 G_phys=7.17775809572554e-06 G_eff=7.17775809572554e-06
Rh2p14n1 in14 h2p 136618.861398977
* h2 input 15 w=+0.347826837541335 w+  bank=n alpha=1 R=95833.1265320264 G_phys=1.043480512624e-05 G_eff=1.043480512624e-05
Rh2p15n1 in15 h2p 93604.1429512464
* h2 input 16 w=+0.00438097035906581 w+  bank=f alpha=0.001 R=7608.66442849918 G_phys=0.000131429110771974 G_eff=1.31429110771974e-07
Rh2p16f1 inf16 h2p 7453.996666868
* h2 bias=-0.0501304580317642 b-  bank=n alpha=1 R=664931.752911819 G_phys=1.50391374095293e-06 G_eff=1.50391374095293e-06
Rh2bnn1 vref h2n 653058.361690977
Vh2p h2p 0 DC 0
Vh2n h2n 0 DC 0
Fh2p 0 h2d Vh2p 1
Fh2n h2d 0 Vh2n 1
Vh2d h2d 0 DC 0
Hh2 h2raw 0 Vh2d 33333.3333333333
Eh2sc h2lin 0 h2raw 0 1
* direct bounded ReLU: y=max(0, min(15, v(h2lin))) no high-gain op-amp loop
Bh2relu h2y 0 V = max(0, min(15, v(h2lin)))
Eh2 h2buf 0 h2y 0 1

* h3 input 1 w=-0.916033562434709 w-  bank=n alpha=1 R=36388.7686000689 G_phys=2.74810068730413e-05 G_eff=2.74810068730413e-05
Rh3n1n1 in1 h3n 35806.4559708737
* h3 input 2 w=+0.507521982744407 w+  bank=n alpha=1 R=65678.6000738028 G_phys=1.52256594823322e-05 G_eff=1.52256594823322e-05
Rh3p2n1 in2 h3p 64309.7745241673
* h3 input 3 w=+0.0871477019742823 w+  bank=n alpha=1 R=382492.395991924 G_phys=2.61443105922847e-06 G_eff=2.61443105922847e-06
Rh3p3n1 in3 h3p 373488.121514413
* h3 input 4 w=-0.0658557100969535 w-  bank=n alpha=1 R=506157.071030889 G_phys=1.97567130290861e-06 G_eff=1.97567130290861e-06
Rh3n4n1 in4 h3n 498501.620192594
* h3 input 5 w=-0.179053685151098 w-  bank=n alpha=1 R=186163.905563878 G_phys=5.37161055453294e-06 G_eff=5.37161055453294e-06
Rh3n5n1 in5 h3n 182065.958400324
* h3 input 6 w=+0.315007728496672 w+  bank=n alpha=1 R=105817.509597024 G_phys=9.45023185490017e-06 G_eff=9.45023185490017e-06
Rh3p6n1 in6 h3p 103791.825325601
* h3 input 7 w=+0.677608935484657 w+  bank=n alpha=1 R=49192.5823107569 G_phys=2.03282680645397e-05 G_eff=2.03282680645397e-05
Rh3p7n1 in7 h3p 48155.8326309771
* h3 input 8 w=+0.295351776524173 w+  bank=n alpha=1 R=112859.769206789 G_phys=8.8605532957252e-06 G_eff=8.8605532957252e-06
Rh3p8n1 in8 h3p 111251.317757278
* h3 input 9 w=+0.00172302579693755 w+  bank=f alpha=0.001 R=19345.8121129578 G_phys=5.16907739081266e-05 G_eff=5.16907739081266e-08
Rh3p9f1 inf9 h3p 19065.0416255918
* h3 input 10 w=+0.317835264102281 w+  bank=n alpha=1 R=104876.132695604 G_phys=9.53505792306844e-06 G_eff=9.53505792306844e-06
Rh3p10n1 in10 h3p 102925.024460929
* h3 input 11 w=-0.530129158700576 w-  bank=n alpha=1 R=62877.7587240027 G_phys=1.59038747610173e-05 G_eff=1.59038747610173e-05
Rh3n11n1 in11 h3n 61616.8936881822
* h3 input 12 w=-0.291249394999097 w-  bank=n alpha=1 R=114449.450902505 G_phys=8.7374818499729e-06 G_eff=8.7374818499729e-06
Rh3n12n1 in12 h3n 112596.505319458
* h3 input 13 w=-0.395820894073244 w-  bank=n alpha=1 R=84213.1727567804 G_phys=1.18746268221973e-05 G_eff=1.18746268221973e-05
Rh3n13n1 in13 h3n 82999.7613894207
* h3 input 14 w=-0.0451489915790311 w-  bank=n alpha=1 R=738296.297825057 G_phys=1.35446974737093e-06 G_eff=1.35446974737093e-06
Rh3n14n1 in14 h3n 724483.665196646
* h3 input 15 w=+0.0633187763010491 w+  bank=n alpha=1 R=526436.789852823 G_phys=1.89956328903147e-06 G_eff=1.89956328903147e-06
Rh3p15n1 in15 h3p 518462.810349187
* h3 input 16 w=-0.149745176344707 w-  bank=n alpha=1 R=222600.381174225 G_phys=4.49235529034122e-06 G_eff=4.49235529034122e-06
Rh3n16n1 in16 h3n 219041.051430225
* h3 bias=-0.0553554658432052 b-  bank=n alpha=1 R=602168.780003591 G_phys=1.66066397529616e-06 G_eff=1.66066397529616e-06
Rh3bnn1 vref h3n 589519.494071665
Vh3p h3p 0 DC 0
Vh3n h3n 0 DC 0
Fh3p 0 h3d Vh3p 1
Fh3n h3d 0 Vh3n 1
Vh3d h3d 0 DC 0
Hh3 h3raw 0 Vh3d 33333.3333333333
Eh3sc h3lin 0 h3raw 0 1
* direct bounded ReLU: y=max(0, min(15, v(h3lin))) no high-gain op-amp loop
Bh3relu h3y 0 V = max(0, min(15, v(h3lin)))
Eh3 h3buf 0 h3y 0 1

* h4 input 1 w=+0.0673940677866904 w+  bank=n alpha=1 R=494603.374273786 G_phys=2.02182203360071e-06 G_eff=2.02182203360071e-06
Rh4p1n1 in1 h4p 483212.661991674
* h4 input 2 w=-0.087995350925692 w-  bank=n alpha=1 R=378807.891356463 G_phys=2.63986052777076e-06 G_eff=2.63986052777076e-06
Rh4n2n1 in2 h4n 373376.061930311
* h4 input 3 w=-0.354237391786533 w-  bank=n alpha=1 R=94098.8560389478 G_phys=1.0627121753596e-05 G_eff=1.0627121753596e-05
Rh4n3n1 in3 h4n 92176.5712731258
* h4 input 4 w=-0.0201421700797575 w-  bank=f alpha=0.001 R=1654.90278362969 G_phys=0.000604265102392725 G_eff=6.04265102392725e-07
Rh4n4f1 inf4 h4n 1622.06186865715
* h4 input 5 w=-0.808084436849872 w-  bank=n alpha=1 R=41249.814763511 G_phys=2.42425331054962e-05 G_eff=2.42425331054962e-05
Rh4n5n1 in5 h4n 40690.5687737602
* h4 input 6 w=-0.290030636557288 w-  bank=n alpha=1 R=114930.387110153 G_phys=8.70091909671864e-06 G_eff=8.70091909671864e-06
Rh4n6n1 in6 h4n 113097.803265394
* h4 input 7 w=+0.344262354214072 w+  bank=n alpha=1 R=96825.3801942158 G_phys=1.03278706264222e-05 G_eff=1.03278706264222e-05
Rh4p7n1 in7 h4p 94970.426749406
* h4 input 8 w=-0.872472737770673 w-  bank=n alpha=1 R=38205.5872811637 G_phys=2.61741821331202e-05 G_eff=2.61741821331202e-05
Rh4n8n1 in8 h4n 37399.528002201
* h4 input 9 w=+0.163024654235771 w+  bank=n alpha=1 R=204468.051103029 G_phys=4.89073962707314e-06 G_eff=4.89073962707314e-06
Rh4p9n1 in9 h4p 199675.384061704
* h4 input 10 w=-0.143734302026109 w-  bank=n alpha=1 R=231909.383240185 G_phys=4.31202906078326e-06 G_eff=4.31202906078326e-06
Rh4n10n1 in10 h4n 228270.494640008
* h4 input 11 w=-0.110414936368951 w-  bank=n alpha=1 R=301891.523280421 G_phys=3.31244809106853e-06 G_eff=3.31244809106853e-06
Rh4n11n1 in11 h4n 297788.558013518
* h4 input 12 w=+0.321561566587255 w+  bank=n alpha=1 R=103660.812724298 G_phys=9.64684699761765e-06 G_eff=9.64684699761765e-06
Rh4p12n1 in12 h4p 101797.091608796
* h4 input 13 w=-0.501486514423905 w-  bank=n alpha=1 R=66469.0522568205 G_phys=1.50445954327172e-05 G_eff=1.50445954327172e-05
Rh4n13n1 in13 h4n 65481.7481938862
* h4 input 14 w=-0.0233644803539605 w-  bank=f alpha=0.001 R=1426.66701028012 G_phys=0.000700934410618815 G_eff=7.00934410618815e-07
Rh4n14f1 inf14 h4n 1398.43363873781
* h4 input 15 w=-0.211065663454959 w-  bank=n alpha=1 R=157928.735483053 G_phys=6.33196990364878e-06 G_eff=6.33196990364878e-06
Rh4n15n1 in15 h4n 154450.174189879
* h4 input 16 w=+0.18002446765288 w+  bank=n alpha=1 R=185160.016124064 G_phys=5.40073402958641e-06 G_eff=5.40073402958641e-06
Rh4p16n1 in16 h4p 182263.92591625
* h4 bias=+0.0472838049870426 b+  bank=n alpha=1 R=704963.006730694 G_phys=1.41851414961128e-06 G_eff=1.41851414961128e-06
Rh4bpn1 vref h4p 694562.057569738
Vh4p h4p 0 DC 0
Vh4n h4n 0 DC 0
Fh4p 0 h4d Vh4p 1
Fh4n h4d 0 Vh4n 1
Vh4d h4d 0 DC 0
Hh4 h4raw 0 Vh4d 33333.3333333333
Eh4sc h4lin 0 h4raw 0 1
* direct bounded ReLU: y=max(0, min(15, v(h4lin))) no high-gain op-amp loop
Bh4relu h4y 0 V = max(0, min(15, v(h4lin)))
Eh4 h4buf 0 h4y 0 1

* h5 input 1 w=-0.122756848133934 w-  bank=n alpha=1 R=271539.501380525 G_phys=3.68270544401802e-06 G_eff=3.68270544401802e-06
Rh5n1n1 in1 h5n 266794.919404149
* h5 input 2 w=+0.794704720471975 w+  bank=n alpha=1 R=41944.300159104 G_phys=2.38411416141592e-05 G_eff=2.38411416141592e-05
Rh5p2n1 in2 h5p 41000.3472024701
* h5 input 3 w=-0.26372184795707 w-  bank=n alpha=1 R=126395.797661631 G_phys=7.91165543871211e-06 G_eff=7.91165543871211e-06
Rh5n3n1 in3 h5n 124056.440345295
* h5 input 4 w=+0.65217090039031 w+  bank=n alpha=1 R=51111.3472149464 G_phys=1.95651270117093e-05 G_eff=1.95651270117093e-05
Rh5p4n1 in4 h5p 50244.5913463089
* h5 input 5 w=-0.272670344884174 w-  bank=n alpha=1 R=122247.739656077 G_phys=8.18011034652521e-06 G_eff=8.18011034652521e-06
Rh5n5n1 in5 h5n 120143.324022404
* h5 input 6 w=+0.0607101548077554 w+  bank=n alpha=1 R=549056.964833751 G_phys=1.82130464423266e-06 G_eff=1.82130464423266e-06
Rh5p6n1 in6 h5p 538820.168045956
* h5 input 7 w=+0.629980287413506 w+  bank=n alpha=1 R=52911.7085078791 G_phys=1.88994086224052e-05 G_eff=1.88994086224052e-05
Rh5p7n1 in7 h5p 51676.9366810724
* h5 input 8 w=-0.369402487956774 w-  bank=n alpha=1 R=90235.8116690157 G_phys=1.10820746387032e-05 G_eff=1.10820746387032e-05
Rh5n8n1 in8 h5n 88716.7392074377
* h5 input 9 w=-0.0924511829208223 w-  bank=n alpha=1 R=360550.641757401 G_phys=2.77353548762467e-06 G_eff=2.77353548762467e-06
Rh5n9n1 in9 h5n 353037.743930344
* h5 input 10 w=-0.00426485730080124 w-  bank=f alpha=0.001 R=7815.81445340996 G_phys=0.000127945719024037 G_eff=1.27945719024037e-07
Rh5n10f1 inf10 h5n 7705.34782718242
* h5 input 11 w=+0.540478898079688 w+  bank=n alpha=1 R=61673.6998461292 G_phys=1.62143669423906e-05 G_eff=1.62143669423906e-05
Rh5p11n1 in11 h5p 60635.1968472109
* h5 input 12 w=+0.161688921548601 w+  bank=n alpha=1 R=206157.187604928 G_phys=4.85066764645802e-06 G_eff=4.85066764645802e-06
Rh5p12n1 in12 h5p 203071.550594877
* h5 input 13 w=+0.0259557799028364 w+  bank=f alpha=0.001 R=1284.23547503154 G_phys=0.000778673397085092 G_eff=7.78673397085092e-07
Rh5p13f1 inf13 h5p 1259.92528932569
* h5 input 14 w=+0.470073429319239 w+  bank=n alpha=1 R=70910.907220616 G_phys=1.41022028795772e-05 G_eff=1.41022028795772e-05
Rh5p14n1 in14 h5p 69732.6653372035
* h5 input 15 w=+0.188749264833093 w+  bank=n alpha=1 R=176601.129349083 G_phys=5.66247794499279e-06 G_eff=5.66247794499279e-06
Rh5p15n1 in15 h5p 173914.224229959
* h5 input 16 w=+0.031866913791992 w+  bank=f alpha=0.001 R=1046.01699276288 G_phys=0.000956007413759761 G_eff=9.56007413759761e-07
Rh5p16f1 inf16 h5p 1025.62229796273
* h5 bias=+0.0181393489298792 b+  bank=f alpha=0.001 R=1837.62567566174 G_phys=0.000544180467896375 G_eff=5.44180467896375e-07
Rh5bpf1 vreff h5p 1805.64376656495
Vh5p h5p 0 DC 0
Vh5n h5n 0 DC 0
Fh5p 0 h5d Vh5p 1
Fh5n h5d 0 Vh5n 1
Vh5d h5d 0 DC 0
Hh5 h5raw 0 Vh5d 33333.3333333333
Eh5sc h5lin 0 h5raw 0 1
* direct bounded ReLU: y=max(0, min(15, v(h5lin))) no high-gain op-amp loop
Bh5relu h5y 0 V = max(0, min(15, v(h5lin)))
Eh5 h5buf 0 h5y 0 1

* h6 input 1 w=-0.340583473625464 w-  bank=n alpha=1 R=97871.2589266431 G_phys=1.02175042087639e-05 G_eff=1.02175042087639e-05
Rh6n1n1 in1 h6n 96235.642091604
* h6 input 2 w=-0.593797589144587 w-  bank=n alpha=1 R=56135.8515809279 G_phys=1.78139276743376e-05 G_eff=1.78139276743376e-05
Rh6n2n1 in2 h6n 54940.2817774209
* h6 input 3 w=-0.388639564922933 w-  bank=n alpha=1 R=85769.2740057059 G_phys=1.1659186947688e-05 G_eff=1.1659186947688e-05
Rh6n3n1 in3 h6n 83754.7898816551
* h6 input 4 w=+0.284617429170421 w+  bank=n alpha=1 R=117116.275803947 G_phys=8.53852287511263e-06 G_eff=8.53852287511263e-06
Rh6p4n1 in4 h6p 115134.244997016
* h6 input 5 w=-0.270576674342045 w-  bank=n alpha=1 R=123193.669278364 G_phys=8.11730023026134e-06 G_eff=8.11730023026134e-06
Rh6n5n1 in5 h6n 120892.570622194
* h6 input 6 w=+0.0593082278184784 w+  bank=n alpha=1 R=562035.565037534 G_phys=1.77924683455435e-06 G_eff=1.77924683455435e-06
Rh6p6n1 in6 h6p 553577.538172583
* h6 input 7 w=+0.460681196235491 w+  bank=n alpha=1 R=72356.6179946576 G_phys=1.38204358870647e-05 G_eff=1.38204358870647e-05
Rh6p7n1 in7 h6p 71310.2850677189
* h6 input 8 w=+0.530418434730864 w+  bank=n alpha=1 R=62843.46687582 G_phys=1.59125530419259e-05 G_eff=1.59125530419259e-05
Rh6p8n1 in8 h6p 61924.409967512
* h6 input 9 w=+0.069052799324409 w+  bank=n alpha=1 R=482722.40458687 G_phys=2.07158397973227e-06 G_eff=2.07158397973227e-06
Rh6p9n1 in9 h6p 472558.948218524
* h6 input 10 w=+0.150678240315211 w+  bank=n alpha=1 R=221221.944612585 G_phys=4.52034720945633e-06 G_eff=4.52034720945633e-06
Rh6p10n1 in10 h6p 217363.526278857
* h6 input 11 w=+0.0896190095447204 w+  bank=n alpha=1 R=371944.897658123 G_phys=2.68857028634161e-06 G_eff=2.68857028634161e-06
Rh6p11n1 in11 h6p 365696.143623918
* h6 input 12 w=-0.177342454994274 w-  bank=n alpha=1 R=187960.256524077 G_phys=5.32027364982823e-06 G_eff=5.32027364982823e-06
Rh6n12n1 in12 h6n 185110.924761019
* h6 input 13 w=+0.643544080066549 w+  bank=n alpha=1 R=51796.5037140678 G_phys=1.93063224019965e-05 G_eff=1.93063224019965e-05
Rh6p13n1 in13 h6p 50997.1530488379
* h6 input 14 w=+0.0993069474158396 w+  bank=n alpha=1 R=335659.63108052 G_phys=2.97920842247519e-06 G_eff=2.97920842247519e-06
Rh6p14n1 in14 h6p 328789.475026774
* h6 input 15 w=-0.324176483950696 w-  bank=n alpha=1 R=102824.649484455 G_phys=9.72529451852089e-06 G_eff=9.72529451852089e-06
Rh6n15n1 in15 h6n 101254.526476956
* h6 input 16 w=+0.0932186969347454 w+  bank=n alpha=1 R=357582.056276406 G_phys=2.79656090804236e-06 G_eff=2.79656090804236e-06
Rh6p16n1 in16 h6p 351016.988295113
* h6 bias=-0.0198556852101353 b-  bank=f alpha=0.001 R=1678.78030803583 G_phys=0.000595670556304058 G_eff=5.95670556304058e-07
Rh6bnf1 vreff h6n 1644.85067122404
Vh6p h6p 0 DC 0
Vh6n h6n 0 DC 0
Fh6p 0 h6d Vh6p 1
Fh6n h6d 0 Vh6n 1
Vh6d h6d 0 DC 0
Hh6 h6raw 0 Vh6d 33333.3333333333
Eh6sc h6lin 0 h6raw 0 1
* direct bounded ReLU: y=max(0, min(15, v(h6lin))) no high-gain op-amp loop
Bh6relu h6y 0 V = max(0, min(15, v(h6lin)))
Eh6 h6buf 0 h6y 0 1

* h7 input 1 w=+0.32217720874051 w+  bank=n alpha=1 R=103462.729296227 G_phys=9.6653162622153e-06 G_eff=9.6653162622153e-06
Rh7p1n1 in1 h7p 101827.648264583
* h7 input 2 w=-0.146738476402048 w-  bank=n alpha=1 R=227161.50631143 G_phys=4.40215429206143e-06 G_eff=4.40215429206143e-06
Rh7n2n1 in2 h7n 223709.366296007
* h7 input 3 w=+0.524171111363509 w+  bank=n alpha=1 R=63592.4655340589 G_phys=1.57251333409053e-05 G_eff=1.57251333409053e-05
Rh7p3n1 in3 h7p 62634.6028652748
* h7 input 4 w=-0.439531494343149 w-  bank=n alpha=1 R=75838.3273151968 G_phys=1.31859448302945e-05 G_eff=1.31859448302945e-05
Rh7n4n1 in4 h7n 74393.8058888635
* h7 input 5 w=+0.367500929015048 w+  bank=n alpha=1 R=90702.718555491 G_phys=1.10250278704514e-05 G_eff=1.10250278704514e-05
Rh7p5n1 in5 h7p 88890.4155105783
* h7 input 6 w=-1.05409273633464 w-  bank=n alpha=1 R=31622.7711133294 G_phys=3.16227820900391e-05 G_eff=3.16227820900391e-05
Rh7n6n1 in6 h7n 31098.8520370077
* h7 input 7 w=-0.045065971974084 w-  bank=n alpha=1 R=739656.372051673 G_phys=1.35197915922252e-06 G_eff=1.35197915922252e-06
Rh7n7n1 in7 h7n 728838.736458524
* h7 input 8 w=-0.167915862386558 w-  bank=n alpha=1 R=198512.117077998 G_phys=5.03747587159673e-06 G_eff=5.03747587159673e-06
Rh7n8n1 in8 h7n 194967.088355308
* h7 input 9 w=+0.0197430594045346 w+  bank=f alpha=0.001 R=1688.35703982521 G_phys=0.000592291782136037 G_eff=5.92291782136037e-07
Rh7p9f1 inf9 h7p 1654.13513415799
* h7 input 10 w=-0.287534460104587 w-  bank=n alpha=1 R=115928.133696423 G_phys=8.6260338031376e-06 G_eff=8.6260338031376e-06
Rh7n10n1 in10 h7n 113348.252684826
* h7 input 11 w=-0.517871662481308 w-  bank=n alpha=1 R=64366.0114044885 G_phys=1.55361498744393e-05 G_eff=1.55361498744393e-05
Rh7n11n1 in11 h7n 63243.5792626251
* h7 input 12 w=+0.348150035983652 w+  bank=n alpha=1 R=95744.1616777503 G_phys=1.04445010795096e-05 G_eff=1.04445010795096e-05
Rh7p12n1 in12 h7p 93642.0397804748
* h7 input 13 w=-0.408247593362815 w-  bank=n alpha=1 R=81649.7975132203 G_phys=1.22474278008844e-05 G_eff=1.22474278008844e-05
Rh7n13n1 in13 h7n 80391.2913993922
* h7 input 14 w=-0.41711419269885 w-  bank=n alpha=1 R=79914.1671916195 G_phys=1.25134257809655e-05 G_eff=1.25134257809655e-05
Rh7n14n1 in14 h7n 78135.8217115622
* h7 input 15 w=-0.341449872918214 w-  bank=n alpha=1 R=97622.9191372918 G_phys=1.02434961875464e-05 G_eff=1.02434961875464e-05
Rh7n15n1 in15 h7n 95830.2626585791
* h7 input 16 w=-0.0335582003371702 w-  bank=n alpha=1 R=993299.193592697 G_phys=1.00674601011511e-06 G_eff=1.00674601011511e-06
Rh7n16n1 in16 h7n 973571.101830816
* h7 bias=-0.0212324287895191 b-  bank=f alpha=0.001 R=1569.92559182808 G_phys=0.000636972863685573 G_eff=6.36972863685573e-07
Rh7bnf1 vreff h7n 1539.7846142394
Vh7p h7p 0 DC 0
Vh7n h7n 0 DC 0
Fh7p 0 h7d Vh7p 1
Fh7n h7d 0 Vh7n 1
Vh7d h7d 0 DC 0
Hh7 h7raw 0 Vh7d 33333.3333333333
Eh7sc h7lin 0 h7raw 0 1
* direct bounded ReLU: y=max(0, min(15, v(h7lin))) no high-gain op-amp loop
Bh7relu h7y 0 V = max(0, min(15, v(h7lin)))
Eh7 h7buf 0 h7y 0 1

* h8 input 1 w=+0.185544590700454 w+  bank=n alpha=1 R=179651.334525549 G_phys=5.56633772101363e-06 G_eff=5.56633772101363e-06
Rh8p1n1 in1 h8p 175459.284878954
* h8 input 2 w=-0.385658106289114 w-  bank=n alpha=1 R=86432.3419882805 G_phys=1.15697431886734e-05 G_eff=1.15697431886734e-05
Rh8n2n1 in2 h8n 84466.1931285279
* h8 input 3 w=+0.230915543832556 w+  bank=n alpha=1 R=144352.92133259 G_phys=6.92746631497669e-06 G_eff=6.92746631497669e-06
Rh8p3n1 in3 h8p 141878.106347947
* h8 input 4 w=+0.205353187615931 w+  bank=n alpha=1 R=162321.966950307 G_phys=6.16059562847793e-06 G_eff=6.16059562847793e-06
Rh8p4n1 in4 h8p 159406.188978987
* h8 input 5 w=+0.00415238713767869 w+  bank=f alpha=0.001 R=8027.51097817138 G_phys=0.000124571614130361 G_eff=1.24571614130361e-07
Rh8p5f1 inf5 h8p 7878.43665139752
* h8 input 6 w=-0.514726379917983 w-  bank=n alpha=1 R=64759.3257968335 G_phys=1.54417913975395e-05 G_eff=1.54417913975395e-05
Rh8n6n1 in6 h8n 63280.0371808675
* h8 input 7 w=+0.210716479044664 w+  bank=n alpha=1 R=158190.443787113 G_phys=6.32149437133992e-06 G_eff=6.32149437133992e-06
Rh8p7n1 in7 h8p 155901.051767445
* h8 input 8 w=+0.375574589425665 w+  bank=n alpha=1 R=88752.8982839526 G_phys=1.126723768277e-05 G_eff=1.126723768277e-05
Rh8p8n1 in8 h8p 87201.4045651476
* h8 input 9 w=+0.00572491873576676 w+  bank=f alpha=0.001 R=5822.49895096002 G_phys=0.000171747562073003 G_eff=1.71747562073003e-07
Rh8p9f1 inf9 h8p 5738.47505210234
* h8 input 10 w=-0.367556769900021 w-  bank=n alpha=1 R=90688.9385887256 G_phys=1.10267030970006e-05 G_eff=1.10267030970006e-05
Rh8n10n1 in10 h8n 89341.8671175175
* h8 input 11 w=+0.41225604099869 w+  bank=n alpha=1 R=80855.9002618455 G_phys=1.23676812299607e-05 G_eff=1.23676812299607e-05
Rh8p11n1 in11 h8p 79717.8810619468
* h8 input 12 w=+0.21126612483399 w+  bank=n alpha=1 R=157778.883668767 G_phys=6.33798374501969e-06 G_eff=6.33798374501969e-06
Rh8p12n1 in12 h8p 154739.204698934
* h8 input 13 w=+0.318427374873886 w+  bank=n alpha=1 R=104681.117151235 G_phys=9.55282124621658e-06 G_eff=9.55282124621658e-06
Rh8p13n1 in13 h8p 102835.444821916
* h8 input 14 w=-0.262828471961964 w-  bank=n alpha=1 R=126825.427566909 G_phys=7.88485415885892e-06 G_eff=7.88485415885892e-06
Rh8n14n1 in14 h8n 125044.89056657
* h8 input 15 w=+0.319620775512722 w+  bank=n alpha=1 R=104290.258603689 G_phys=9.58862326538165e-06 G_eff=9.58862326538165e-06
Rh8p15n1 in15 h8p 102296.539768618
* h8 input 16 w=+0.15331491024055 w+  bank=n alpha=1 R=217417.427183263 G_phys=4.59944730721651e-06 G_eff=4.59944730721651e-06
Rh8p16n1 in16 h8p 212422.266110519
* h8 bias=-0.030517345445392 b-  bank=f alpha=0.001 R=1092.27499465772 G_phys=0.00091552036336176 G_eff=9.1552036336176e-07
Rh8bnf1 vreff h8n 1070.47634398359
Vh8p h8p 0 DC 0
Vh8n h8n 0 DC 0
Fh8p 0 h8d Vh8p 1
Fh8n h8d 0 Vh8n 1
Vh8d h8d 0 DC 0
Hh8 h8raw 0 Vh8d 33333.3333333333
Eh8sc h8lin 0 h8raw 0 1
* direct bounded ReLU: y=max(0, min(15, v(h8lin))) no high-gain op-amp loop
Bh8relu h8y 0 V = max(0, min(15, v(h8lin)))
Eh8 h8buf 0 h8y 0 1

* h9 input 1 w=-0.192368051906404 w-  bank=n alpha=1 R=173278.946285486 G_phys=5.77104155719211e-06 G_eff=5.77104155719211e-06
Rh9n1n1 in1 h9n 170179.84045669
* h9 input 2 w=-0.0188071151742732 w-  bank=f alpha=0.001 R=1772.37885898263 G_phys=0.000564213455228197 G_eff=5.64213455228197e-07
Rh9n2f1 inf2 h9n 1742.47690790594
* h9 input 3 w=+0.675590388456855 w+  bank=n alpha=1 R=49339.5612235861 G_phys=2.02677116537057e-05 G_eff=2.02677116537057e-05
Rh9p3n1 in3 h9p 48241.5632130618
* h9 input 4 w=-0.777819910920126 w-  bank=n alpha=1 R=42854.8213607717 G_phys=2.33345973276038e-05 G_eff=2.33345973276038e-05
Rh9n4n1 in4 h9n 41930.0792635948
* h9 input 5 w=-0.0591658911038067 w-  bank=n alpha=1 R=563387.666634648 G_phys=1.7749767331142e-06 G_eff=1.7749767331142e-06
Rh9n5n1 in5 h9n 554209.739605248
* h9 input 6 w=-0.373077376819092 w-  bank=n alpha=1 R=89346.9703725748 G_phys=1.11923213045728e-05 G_eff=1.11923213045728e-05
Rh9n6n1 in6 h9n 87424.0070787245
* h9 input 7 w=+0.173600484730372 w+  bank=n alpha=1 R=192011.752646342 G_phys=5.20801454191117e-06 G_eff=5.20801454191117e-06
Rh9p7n1 in7 h9p 189180.227573684
* h9 input 8 w=+0.21285190098274 w+  bank=n alpha=1 R=156603.409128286 G_phys=6.38555702948219e-06 G_eff=6.38555702948219e-06
Rh9p8n1 in8 h9p 153203.505499095
* h9 input 9 w=+0.47939396555815 w+  bank=n alpha=1 R=69532.2338789223 G_phys=1.43818189667445e-05 G_eff=1.43818189667445e-05
Rh9p9n1 in9 h9p 67959.8063618405
* h9 input 10 w=-0.695860852133009 w-  bank=n alpha=1 R=47902.2971778874 G_phys=2.08758255639903e-05 G_eff=2.08758255639903e-05
Rh9n10n1 in10 h9n 46930.0093048953
* h9 input 11 w=+0.426719797848979 w+  bank=n alpha=1 R=78115.2726012736 G_phys=1.28015939354694e-05 G_eff=1.28015939354694e-05
Rh9p11n1 in11 h9p 76491.6789737439
* h9 input 12 w=+0.190883817865507 w+  bank=n alpha=1 R=174626.292087365 G_phys=5.7265145359652e-06 G_eff=5.7265145359652e-06
Rh9p12n1 in12 h9p 172042.493430282
* h9 input 13 w=-0.203891646942192 w-  bank=n alpha=1 R=163485.526912165 G_phys=6.11674940826577e-06 G_eff=6.11674940826577e-06
Rh9n13n1 in13 h9n 159988.834094043
* h9 input 14 w=-0.0564974778722501 w-  bank=n alpha=1 R=589996.838597032 G_phys=1.6949243361675e-06 G_eff=1.6949243361675e-06
Rh9n14n1 in14 h9n 576871.59711076
* h9 input 15 w=-0.251891815788561 w-  bank=n alpha=1 R=132331.942699216 G_phys=7.55675447365683e-06 G_eff=7.55675447365683e-06
Rh9n15n1 in15 h9n 130034.145112522
* h9 input 16 w=-0.340248378281639 w-  bank=n alpha=1 R=97967.6479331866 G_phys=1.02074513484492e-05 G_eff=1.02074513484492e-05
Rh9n16n1 in16 h9n 96498.0226454086
* h9 bias=-0.0264599072666679 b-  bank=f alpha=0.001 R=1259.76757958347 G_phys=0.000793797218000037 G_eff=7.93797218000037e-07
Rh9bnf1 vreff h9n 1240.57324822094
Vh9p h9p 0 DC 0
Vh9n h9n 0 DC 0
Fh9p 0 h9d Vh9p 1
Fh9n h9d 0 Vh9n 1
Vh9d h9d 0 DC 0
Hh9 h9raw 0 Vh9d 33333.3333333333
Eh9sc h9lin 0 h9raw 0 1
* direct bounded ReLU: y=max(0, min(15, v(h9lin))) no high-gain op-amp loop
Bh9relu h9y 0 V = max(0, min(15, v(h9lin)))
Eh9 h9buf 0 h9y 0 1

* h10 input 1 w=+0.0856004623316453 w+  bank=n alpha=1 R=389405.996479186 G_phys=2.56801386994936e-06 G_eff=2.56801386994936e-06
Rh10p1n1 in1 h10p 380754.074202544
* h10 input 2 w=+0.717707405140542 w+  bank=n alpha=1 R=46444.1819808254 G_phys=2.15312221542163e-05 G_eff=2.15312221542163e-05
Rh10p2n1 in2 h10p 45428.2300997631
* h10 input 3 w=+0.367326370670395 w+  bank=n alpha=1 R=90745.8216857607 G_phys=1.10197911201119e-05 G_eff=1.10197911201119e-05
Rh10p3n1 in3 h10p 88851.2661259867
* h10 input 4 w=+0.5220921972442 w+  bank=n alpha=1 R=63845.6837878046 G_phys=1.5662765917326e-05 G_eff=1.5662765917326e-05
Rh10p4n1 in4 h10p 62380.4699211189
* h10 input 5 w=+0.0909071116243784 w+  bank=n alpha=1 R=366674.649955487 G_phys=2.72721334873135e-06 G_eff=2.72721334873135e-06
Rh10p5n1 in5 h10p 358341.754997067
* h10 input 6 w=-0.0568053629833511 w-  bank=n alpha=1 R=586799.055277631 G_phys=1.70416088950053e-06 G_eff=1.70416088950053e-06
Rh10n6n1 in6 h10n 576021.700635349
* h10 input 7 w=+0.372078007523385 w+  bank=n alpha=1 R=89586.9485950155 G_phys=1.11623402257016e-05 G_eff=1.11623402257016e-05
Rh10p7n1 in7 h10p 87943.2796283831
* h10 input 8 w=+0.384900055079612 w+  bank=n alpha=1 R=86602.568363984 G_phys=1.15470016523884e-05 G_eff=1.15470016523884e-05
Rh10p8n1 in8 h10p 85062.1076515414
* h10 input 9 w=+0.617655459577812 w+  bank=n alpha=1 R=53967.5199440765 G_phys=1.85296637873344e-05 G_eff=1.85296637873344e-05
Rh10p9n1 in9 h10p 52756.3790455508
* h10 input 10 w=+0.306521845436409 w+  bank=n alpha=1 R=108747.007202293 G_phys=9.19565536309227e-06 G_eff=9.19565536309227e-06
Rh10p10n1 in10 h10p 107236.7943124
* h10 input 11 w=-0.0307901580575706 w-  bank=f alpha=0.001 R=1082.5970191841 G_phys=0.000923704741727117 G_eff=9.23704741727117e-07
Rh10n11f1 inf11 h10n 1064.56712144565
* h10 input 12 w=+0.163538031424557 w+  bank=n alpha=1 R=203826.186746724 G_phys=4.9061409427367e-06 G_eff=4.9061409427367e-06
Rh10p12n1 in12 h10p 201017.453952024
* h10 input 13 w=-0.0170713095619708 w-  bank=f alpha=0.001 R=1952.59380730749 G_phys=0.000512139286859123 G_eff=5.12139286859123e-07
Rh10n13f1 inf13 h10n 1907.20610606372
* h10 input 14 w=-0.123347220224403 w-  bank=n alpha=1 R=270239.842233093 G_phys=3.7004166067321e-06 G_eff=3.7004166067321e-06
Rh10n14n1 in14 h10n 265434.73799474
* h10 input 15 w=-0.136765368652097 w-  bank=n alpha=1 R=243726.417453869 G_phys=4.10296105956291e-06 G_eff=4.10296105956291e-06
Rh10n15n1 in15 h10n 240187.334897035
* h10 input 16 w=+0.269183781267177 w+  bank=n alpha=1 R=123831.1356517 G_phys=8.07551343801532e-06 G_eff=8.07551343801532e-06
Rh10p16n1 in16 h10p 121179.124697637
* h10 bias=-0.0641449868406755 b-  bank=n alpha=1 R=519656.094343386 G_phys=1.92434960522027e-06 G_eff=1.92434960522027e-06
Rh10bnn1 vref h10n 511580.574185141
Vh10p h10p 0 DC 0
Vh10n h10n 0 DC 0
Fh10p 0 h10d Vh10p 1
Fh10n h10d 0 Vh10n 1
Vh10d h10d 0 DC 0
Hh10 h10raw 0 Vh10d 33333.3333333333
Eh10sc h10lin 0 h10raw 0 1
* direct bounded ReLU: y=max(0, min(15, v(h10lin))) no high-gain op-amp loop
Bh10relu h10y 0 V = max(0, min(15, v(h10lin)))
Eh10 h10buf 0 h10y 0 1

* h11 input 1 w=+0.100174494534941 w+  bank=n alpha=1 R=332752.69806035 G_phys=3.00523483604823e-06 G_eff=3.00523483604823e-06
Rh11p1n1 in1 h11p 327852.535978487
* h11 input 2 w=-0.350357054027393 w-  bank=n alpha=1 R=95141.0366943178 G_phys=1.05107116208218e-05 G_eff=1.05107116208218e-05
Rh11n2n1 in2 h11n 93590.7308535094
* h11 input 3 w=-0.364058373495884 w-  bank=n alpha=1 R=91560.4083302596 G_phys=1.09217512048765e-05 G_eff=1.09217512048765e-05
Rh11n3n1 in3 h11n 90189.1423791691
* h11 input 4 w=+0.201551043415431 w+  bank=n alpha=1 R=165384.077246515 G_phys=6.04653130246294e-06 G_eff=6.04653130246294e-06
Rh11p4n1 in4 h11p 162686.151130071
* h11 input 5 w=+0.30370864041576 w+  bank=n alpha=1 R=109754.313501591 G_phys=9.1112592124728e-06 G_eff=9.1112592124728e-06
Rh11p5n1 in5 h11p 107838.217601332
* h11 input 6 w=+0.221531530750713 w+  bank=n alpha=1 R=150467.670314809 G_phys=6.64594592252139e-06 G_eff=6.64594592252139e-06
Rh11p6n1 in6 h11p 147707.261518865
* h11 input 7 w=-0.554388667333083 w-  bank=n alpha=1 R=60126.2891856812 G_phys=1.66316600199925e-05 G_eff=1.66316600199925e-05
Rh11n7n1 in7 h11n 59036.2342754862
* h11 input 8 w=+0.382929077760783 w+  bank=n alpha=1 R=87048.3211362621 G_phys=1.14878723328235e-05 G_eff=1.14878723328235e-05
Rh11p8n1 in8 h11p 85169.4906633575
* h11 input 9 w=-0.415059943002996 w-  bank=n alpha=1 R=80309.6851316552 G_phys=1.24517982900899e-05 G_eff=1.24517982900899e-05
Rh11n9n1 in9 h11n 79024.4718659486
* h11 input 10 w=-0.579957638432045 w-  bank=n alpha=1 R=57475.4622138477 G_phys=1.73987291529614e-05 G_eff=1.73987291529614e-05
Rh11n10n1 in10 h11n 56686.7137371879
* h11 input 11 w=+0.208304459025755 w+  bank=n alpha=1 R=160022.178542092 G_phys=6.24913377077265e-06 G_eff=6.24913377077265e-06
Rh11p11n1 in11 h11p 156877.686427554
* h11 input 12 w=+0.150185585205542 w+  bank=n alpha=1 R=221947.620923232 G_phys=4.50556755616625e-06 G_eff=4.50556755616625e-06
Rh11p12n1 in12 h11p 217280.904683203
* h11 input 13 w=-0.130595100347527 w-  bank=n alpha=1 R=255241.837133476 G_phys=3.9178530104258e-06 G_eff=3.9178530104258e-06
Rh11n13n1 in13 h11n 250577.163219402
* h11 input 14 w=+0.223944918125423 w+  bank=n alpha=1 R=148846.125254178 G_phys=6.71834754376269e-06 G_eff=6.71834754376269e-06
Rh11p14n1 in14 h11p 146605.945741228
* h11 input 15 w=+0.219816736012751 w+  bank=n alpha=1 R=151641.471609331 G_phys=6.59450208038254e-06 G_eff=6.59450208038254e-06
Rh11p15n1 in15 h11p 149205.862940794
* h11 input 16 w=-0.0825561420887272 w-  bank=n alpha=1 R=403765.637419301 G_phys=2.47668426266182e-06 G_eff=2.47668426266182e-06
Rh11n16n1 in16 h11n 396971.372053996
* h11 bias=-0.0111908465565794 b-  bank=f alpha=0.001 R=2978.62482206369 G_phys=0.000335725396697381 G_eff=3.35725396697381e-07
Rh11bnf1 vreff h11n 2921.9487089422
Vh11p h11p 0 DC 0
Vh11n h11n 0 DC 0
Fh11p 0 h11d Vh11p 1
Fh11n h11d 0 Vh11n 1
Vh11d h11d 0 DC 0
Hh11 h11raw 0 Vh11d 33333.3333333333
Eh11sc h11lin 0 h11raw 0 1
* direct bounded ReLU: y=max(0, min(15, v(h11lin))) no high-gain op-amp loop
Bh11relu h11y 0 V = max(0, min(15, v(h11lin)))
Eh11 h11buf 0 h11y 0 1

* h12 input 1 w=-0.0647804813106503 w-  bank=n alpha=1 R=514558.284516066 G_phys=1.94341443931951e-06 G_eff=1.94341443931951e-06
Rh12n1n1 in1 h12n 504833.27746114
* h12 input 2 w=-0.668825239918342 w-  bank=n alpha=1 R=49838.6295011879 G_phys=2.00647571975503e-05 G_eff=2.00647571975503e-05
Rh12n2n1 in2 h12n 48780.532327519
* h12 input 3 w=+0.43152134817872 w+  bank=n alpha=1 R=77246.0817385283 G_phys=1.29456404453616e-05 G_eff=1.29456404453616e-05
Rh12p3n1 in3 h12p 75495.9086703118
* h12 input 4 w=+0.0766102486579458 w+  bank=n alpha=1 R=435102.795216892 G_phys=2.29830745973837e-06 G_eff=2.29830745973837e-06
Rh12p4n1 in4 h12p 425411.720268316
* h12 input 5 w=+0.112143595115044 w+  bank=n alpha=1 R=297237.959057206 G_phys=3.36430785345132e-06 G_eff=3.36430785345132e-06
Rh12p5n1 in5 h12p 292150.872648802
* h12 input 6 w=-0.214387519256146 w-  bank=n alpha=1 R=155481.687781961 G_phys=6.43162557768439e-06 G_eff=6.43162557768439e-06
Rh12n6n1 in6 h12n 152683.946441223
* h12 input 7 w=+0.0362945018752433 w+  bank=n alpha=1 R=918412.751548746 G_phys=1.0888350562573e-06 G_eff=1.0888350562573e-06
Rh12p7n1 in7 h12p 898484.291897151
* h12 input 8 w=-0.654320698371061 w-  bank=n alpha=1 R=50943.4187491196 G_phys=1.96296209511318e-05 G_eff=1.96296209511318e-05
Rh12n8n1 in8 h12n 50224.4961649925
* h12 input 9 w=-0.424313635659581 w-  bank=n alpha=1 R=78558.2421397273 G_phys=1.27294090697874e-05 G_eff=1.27294090697874e-05
Rh12n9n1 in9 h12n 77449.1222354476
* h12 input 10 w=-0.147731830075345 w-  bank=n alpha=1 R=225634.064888609 G_phys=4.43195490226035e-06 G_eff=4.43195490226035e-06
Rh12n10n1 in10 h12n 220904.039579507
* h12 input 11 w=+0.422841356490785 w+  bank=n alpha=1 R=78831.7718256581 G_phys=1.26852406947236e-05 G_eff=1.26852406947236e-05
Rh12p11n1 in11 h12p 77194.5214109296
* h12 input 12 w=+0.250573650346706 w+  bank=n alpha=1 R=133028.086900644 G_phys=7.51720951040119e-06 G_eff=7.51720951040119e-06
Rh12p12n1 in12 h12p 131200.576907096
* h12 input 13 w=+0.0601122436783251 w+  bank=n alpha=1 R=554518.202842467 G_phys=1.80336731034975e-06 G_eff=1.80336731034975e-06
Rh12p13n1 in13 h12p 542160.867008903
* h12 input 14 w=-0.651755086554606 w-  bank=n alpha=1 R=51143.9557910386 G_phys=1.95526525966382e-05 G_eff=1.95526525966382e-05
Rh12n14n1 in14 h12n 49983.0114994791
* h12 input 15 w=+0.130109285988943 w+  bank=n alpha=1 R=256194.88324735 G_phys=3.90327857966829e-06 G_eff=3.90327857966829e-06
Rh12p15n1 in15 h12p 251408.767542308
* h12 input 16 w=-0.0778767908450736 w-  bank=n alpha=1 R=428026.54002071 G_phys=2.33630372535221e-06 G_eff=2.33630372535221e-06
Rh12n16n1 in16 h12n 418415.694826239
* h12 bias=+0.0176157808963936 b+  bank=f alpha=0.001 R=1892.24272993526 G_phys=0.000528473426891809 G_eff=5.28473426891809e-07
Rh12bpf1 vreff h12p 1864.61267889952
Vh12p h12p 0 DC 0
Vh12n h12n 0 DC 0
Fh12p 0 h12d Vh12p 1
Fh12n h12d 0 Vh12n 1
Vh12d h12d 0 DC 0
Hh12 h12raw 0 Vh12d 33333.3333333333
Eh12sc h12lin 0 h12raw 0 1
* direct bounded ReLU: y=max(0, min(15, v(h12lin))) no high-gain op-amp loop
Bh12relu h12y 0 V = max(0, min(15, v(h12lin)))
Eh12 h12buf 0 h12y 0 1

* h13 input 1 w=+0.034343742118514 w+  bank=n alpha=1 R=970579.537264929 G_phys=1.03031226355542e-06 G_eff=1.03031226355542e-06
Rh13p1n1 in1 h13p 954340.979147939
* h13 input 2 w=-0.102232912320493 w-  bank=n alpha=1 R=326052.858876169 G_phys=3.06698736961478e-06 G_eff=3.06698736961478e-06
Rh13n2n1 in2 h13n 318640.796389471
* h13 input 3 w=+1.31993068300228 w+  bank=n alpha=1 R=25253.8514049194 G_phys=3.95979204900683e-05 G_eff=3.95979204900683e-05
Rh13p3n1 in3 h13p 24692.6813036832
* h13 input 4 w=-0.233319639483811 w-  bank=n alpha=1 R=142865.527338714 G_phys=6.99958918451433e-06 G_eff=6.99958918451433e-06
Rh13n4n1 in4 h13n 139808.985401132
* h13 input 5 w=-0.375430599339701 w-  bank=n alpha=1 R=88786.9379639253 G_phys=1.1262917980191e-05 G_eff=1.1262917980191e-05
Rh13n5n1 in5 h13n 87461.2570026213
* h13 input 6 w=+0.442115486842334 w+  bank=n alpha=1 R=75395.0818855177 G_phys=1.326346460527e-05 G_eff=1.326346460527e-05
Rh13p6n1 in6 h13p 73992.0585815048
* h13 input 7 w=-0.102130412545238 w-  bank=n alpha=1 R=326380.090930979 G_phys=3.06391237635715e-06 G_eff=3.06391237635715e-06
Rh13n7n1 in7 h13n 321786.966110932
* h13 input 8 w=-0.136235661297007 w-  bank=n alpha=1 R=244674.067098066 G_phys=4.08706983891021e-06 G_eff=4.08706983891021e-06
Rh13n8n1 in8 h13n 240132.558354868
* h13 input 9 w=+0.0915800560074952 w+  bank=n alpha=1 R=363980.268046628 G_phys=2.74740168022485e-06 G_eff=2.74740168022485e-06
Rh13p9n1 in9 h13p 358179.487334033
* h13 input 10 w=-0.194905587913072 w-  bank=n alpha=1 R=171022.974201232 G_phys=5.84716763739217e-06 G_eff=5.84716763739217e-06
Rh13n10n1 in10 h13n 167016.13395826
* h13 input 11 w=-0.611958537828416 w-  bank=n alpha=1 R=54469.9212002489 G_phys=1.83587561348525e-05 G_eff=1.83587561348525e-05
Rh13n11n1 in11 h13n 53480.67515745
* h13 input 12 w=+0.19411196838682 w+  bank=n alpha=1 R=171722.195237894 G_phys=5.8233590516046e-06 G_eff=5.8233590516046e-06
Rh13p12n1 in12 h13p 168222.707016716
* h13 input 13 w=+0.146421986160596 w+  bank=n alpha=1 R=227652.514539539 G_phys=4.39265958481789e-06 G_eff=4.39265958481789e-06
Rh13p13n1 in13 h13p 222742.378220076
* h13 input 14 w=+0.246088955287688 w+  bank=n alpha=1 R=135452.374505655 G_phys=7.38266865863065e-06 G_eff=7.38266865863065e-06
Rh13p14n1 in14 h13p 133445.345217467
* h13 input 15 w=-0.101801651380703 w-  bank=n alpha=1 R=327434.112131228 G_phys=3.05404954142109e-06 G_eff=3.05404954142109e-06
Rh13n15n1 in15 h13n 321649.533982842
* h13 input 16 w=-0.212672591801914 w-  bank=n alpha=1 R=156735.445084435 G_phys=6.38017775405741e-06 G_eff=6.38017775405741e-06
Rh13n16n1 in16 h13n 154506.69790032
* h13 bias=+0.0212362032828689 b+  bank=f alpha=0.001 R=1569.64655542844 G_phys=0.000637086098486067 G_eff=6.37086098486067e-07
Rh13bpf1 vreff h13p 1533.79825611
Vh13p h13p 0 DC 0
Vh13n h13n 0 DC 0
Fh13p 0 h13d Vh13p 1
Fh13n h13d 0 Vh13n 1
Vh13d h13d 0 DC 0
Hh13 h13raw 0 Vh13d 33333.3333333333
Eh13sc h13lin 0 h13raw 0 1
* direct bounded ReLU: y=max(0, min(15, v(h13lin))) no high-gain op-amp loop
Bh13relu h13y 0 V = max(0, min(15, v(h13lin)))
Eh13 h13buf 0 h13y 0 1

* h14 input 1 w=-0.089975491938664 w-  bank=n alpha=1 R=370471.254061679 G_phys=2.69926475815992e-06 G_eff=2.69926475815992e-06
Rh14n1n1 in1 h14n 364205.626820453
* h14 input 2 w=-0.0792638889786837 w-  bank=n alpha=1 R=420536.183157725 G_phys=2.37791666936051e-06 G_eff=2.37791666936051e-06
Rh14n2n1 in2 h14n 411337.413863334
* h14 input 3 w=-0.392380373690676 w-  bank=n alpha=1 R=84951.5815987547 G_phys=1.17714112107203e-05 G_eff=1.17714112107203e-05
Rh14n3n1 in3 h14n 83662.1173514307
* h14 input 4 w=+0.471386854681532 w+  bank=n alpha=1 R=70713.3281343902 G_phys=1.4141605640446e-05 G_eff=1.4141605640446e-05
Rh14p4n1 in4 h14p 69218.652302268
* h14 input 5 w=-0.118903138220599 w-  bank=n alpha=1 R=280340.231823744 G_phys=3.56709414661796e-06 G_eff=3.56709414661796e-06
Rh14n5n1 in5 h14n 274158.068972275
* h14 input 6 w=+0.618408634475196 w+  bank=n alpha=1 R=53901.7915906385 G_phys=1.85522590342559e-05 G_eff=1.85522590342559e-05
Rh14p6n1 in6 h14p 52915.8695915293
* h14 input 7 w=-0.0462466843022721 w-  bank=n alpha=1 R=720772.393442608 G_phys=1.38740052906816e-06 G_eff=1.38740052906816e-06
Rh14n7n1 in7 h14n 707685.905640235
* h14 input 8 w=-0.0297824475583231 w-  bank=f alpha=0.001 R=1119.22746671698 G_phys=0.000893473426749692 G_eff=8.93473426749692e-07
Rh14n8f1 inf8 h14n 1095.53579556898
* h14 input 9 w=+0.0766531636417715 w+  bank=n alpha=1 R=434859.198885937 G_phys=2.29959490925314e-06 G_eff=2.29959490925314e-06
Rh14p9n1 in9 h14p 428065.750643386
* h14 input 10 w=-0.0192124865162136 w-  bank=f alpha=0.001 R=1734.98278347277 G_phys=0.000576374595486407 G_eff=5.76374595486407e-07
Rh14n10f1 inf10 h14n 1697.87400405613
* h14 input 11 w=-0.118584174544602 w-  bank=n alpha=1 R=281094.281436313 G_phys=3.55752523633807e-06 G_eff=3.55752523633807e-06
Rh14n11n1 in11 h14n 275079.478564317
* h14 input 12 w=+0.498792575097448 w+  bank=n alpha=1 R=66828.0463613979 G_phys=1.49637772529234e-05 G_eff=1.49637772529234e-05
Rh14p12n1 in12 h14p 65903.5683769201
* h14 input 13 w=+0.131240430694277 w+  bank=n alpha=1 R=253986.771888785 G_phys=3.93721292082832e-06 G_eff=3.93721292082832e-06
Rh14p13n1 in13 h14p 248992.343237717
* h14 input 14 w=-0.699789872634837 w-  bank=n alpha=1 R=47633.346289833 G_phys=2.09936961790451e-05 G_eff=2.09936961790451e-05
Rh14n14n1 in14 h14n 46684.3530894625
* h14 input 15 w=+0.0882030102342884 w+  bank=n alpha=1 R=377916.051218569 G_phys=2.64609030702865e-06 G_eff=2.64609030702865e-06
Rh14p15n1 in15 h14p 372415.925902053
* h14 input 16 w=-0.409062788225599 w-  bank=n alpha=1 R=81487.082894839 G_phys=1.2271883646768e-05 G_eff=1.2271883646768e-05
Rh14n16n1 in16 h14n 79576.0222868769
* h14 bias=+0.0824693880781811 b+  bank=n alpha=1 R=404190.380335226 G_phys=2.47408164234543e-06 G_eff=2.47408164234543e-06
Rh14bpn1 vref h14p 398171.746822812
Vh14p h14p 0 DC 0
Vh14n h14n 0 DC 0
Fh14p 0 h14d Vh14p 1
Fh14n h14d 0 Vh14n 1
Vh14d h14d 0 DC 0
Hh14 h14raw 0 Vh14d 33333.3333333333
Eh14sc h14lin 0 h14raw 0 1
* direct bounded ReLU: y=max(0, min(15, v(h14lin))) no high-gain op-amp loop
Bh14relu h14y 0 V = max(0, min(15, v(h14lin)))
Eh14 h14buf 0 h14y 0 1

* h15 input 1 w=-0.104362920527351 w-  bank=n alpha=1 R=319398.241874589 G_phys=3.13088761582053e-06 G_eff=3.13088761582053e-06
Rh15n1n1 in1 h15n 313916.800411083
* h15 input 2 w=+0.0920701784982539 w+  bank=n alpha=1 R=362042.670895501 G_phys=2.76210535494762e-06 G_eff=2.76210535494762e-06
Rh15p2n1 in2 h15p 354513.410612042
* h15 input 3 w=+0.710914651543076 w+  bank=n alpha=1 R=46887.9537944276 G_phys=2.13274395462923e-05 G_eff=2.13274395462923e-05
Rh15p3n1 in3 h15p 46063.5781150774
* h15 input 4 w=+0.0431405504557543 w+  bank=n alpha=1 R=772668.243246468 G_phys=1.29421651367263e-06 G_eff=1.29421651367263e-06
Rh15p4n1 in4 h15p 758767.933756681
* h15 input 5 w=-0.544653793286569 w-  bank=n alpha=1 R=61200.9569091444 G_phys=1.63396137985971e-05 G_eff=1.63396137985971e-05
Rh15n5n1 in5 h15n 59768.5225837737
* h15 input 6 w=+0.236607896967987 w+  bank=n alpha=1 R=140880.054133795 G_phys=7.0982369090396e-06 G_eff=7.0982369090396e-06
Rh15p6n1 in6 h15p 138435.019637601
* h15 input 7 w=+0.205722108048513 w+  bank=n alpha=1 R=162030.875774774 G_phys=6.17166324145539e-06 G_eff=6.17166324145539e-06
Rh15p7n1 in7 h15p 159687.482244046
* h15 input 8 w=+0.119910326826568 w+  bank=n alpha=1 R=277985.509801377 G_phys=3.59730980479705e-06 G_eff=3.59730980479705e-06
Rh15p8n1 in8 h15p 272268.714118541
* h15 input 9 w=-0.0351999996705356 w-  bank=n alpha=1 R=946969.705833129 G_phys=1.05599999011607e-06 G_eff=1.05599999011607e-06
Rh15n9n1 in9 h15n 925993.424477859
* h15 input 10 w=-0.0279846802936883 w-  bank=f alpha=0.001 R=1191.12789510236 G_phys=0.000839540408810648 G_eff=8.39540408810648e-07
Rh15n10f1 inf10 h15n 1169.63863390181
* h15 input 11 w=-0.155672537202176 w-  bank=n alpha=1 R=214124.68719542 G_phys=4.67017611606528e-06 G_eff=4.67017611606528e-06
Rh15n11n1 in11 h15n 209911.405687704
* h15 input 12 w=-0.248740189524738 w-  bank=n alpha=1 R=134008.635263254 G_phys=7.46220568574215e-06 G_eff=7.46220568574215e-06
Rh15n12n1 in12 h15n 131650.23951292
* h15 input 13 w=+0.142944744841187 w+  bank=n alpha=1 R=233190.337779587 G_phys=4.28834234523561e-06 G_eff=4.28834234523561e-06
Rh15p13n1 in13 h15p 227750.22727688
* h15 input 14 w=-0.364164748984914 w-  bank=n alpha=1 R=91533.6627892949 G_phys=1.09249424695474e-05 G_eff=1.09249424695474e-05
Rh15n14n1 in14 h15n 89931.2594342925
* h15 input 15 w=-0.240848341925517 w-  bank=n alpha=1 R=138399.679511357 G_phys=7.22545025776552e-06 G_eff=7.22545025776552e-06
Rh15n15n1 in15 h15n 136001.790133358
* h15 input 16 w=-0.736896288827917 w-  bank=n alpha=1 R=45234.7689066968 G_phys=2.21068886648375e-05 G_eff=2.21068886648375e-05
Rh15n16n1 in16 h15n 44374.7704932697
* h15 bias=+0.00140769830063221 b+  bank=f alpha=0.001 R=23679.3163125671 G_phys=4.22309490189663e-05 G_eff=4.22309490189663e-08
Rh15bpf1 vreff h15p 23349.054663499
Vh15p h15p 0 DC 0
Vh15n h15n 0 DC 0
Fh15p 0 h15d Vh15p 1
Fh15n h15d 0 Vh15n 1
Vh15d h15d 0 DC 0
Hh15 h15raw 0 Vh15d 33333.3333333333
Eh15sc h15lin 0 h15raw 0 1
* direct bounded ReLU: y=max(0, min(15, v(h15lin))) no high-gain op-amp loop
Bh15relu h15y 0 V = max(0, min(15, v(h15lin)))
Eh15 h15buf 0 h15y 0 1

* h16 input 1 w=-0.211528252190937 w-  bank=n alpha=1 R=157583.362922343 G_phys=6.3458475657281e-06 G_eff=6.3458475657281e-06
Rh16n1n1 in1 h16n 154683.011779282
* h16 input 2 w=-0.194947045242045 w-  bank=n alpha=1 R=170986.604551748 G_phys=5.84841135726135e-06 G_eff=5.84841135726135e-06
Rh16n2n1 in2 h16n 167520.800888655
* h16 input 3 w=-0.281660896127353 w-  bank=n alpha=1 R=118345.619827403 G_phys=8.44982688382059e-06 G_eff=8.44982688382059e-06
Rh16n3n1 in3 h16n 115894.423467234
* h16 input 4 w=-0.246854224570453 w-  bank=n alpha=1 R=135032.460519305 G_phys=7.4056267371136e-06 G_eff=7.4056267371136e-06
Rh16n4n1 in4 h16n 132922.359928856
* h16 input 5 w=+0.785179968580328 w+  bank=n alpha=1 R=42453.112238208 G_phys=2.35553990574098e-05 G_eff=2.35553990574098e-05
Rh16p5n1 in5 h16p 41866.8269551342
* h16 input 6 w=-0.342055263707418 w-  bank=n alpha=1 R=97450.1399921314 G_phys=1.02616579112226e-05 G_eff=1.02616579112226e-05
Rh16n6n1 in6 h16n 95206.4671558195
* h16 input 7 w=-0.213390213186068 w-  bank=n alpha=1 R=156208.351056231 G_phys=6.40170639558203e-06 G_eff=6.40170639558203e-06
Rh16n7n1 in7 h16n 152742.466284699
* h16 input 8 w=-0.06183287092446 w-  bank=n alpha=1 R=539087.589415927 G_phys=1.8549861277338e-06 G_eff=1.8549861277338e-06
Rh16n8n1 in8 h16n 531700.957591091
* h16 input 9 w=+0.114369297885863 w+  bank=n alpha=1 R=291453.510247121 G_phys=3.43107893657588e-06 G_eff=3.43107893657588e-06
Rh16p9n1 in9 h16p 286272.474837139
* h16 input 10 w=+0.418702574206734 w+  bank=n alpha=1 R=79611.0064440994 G_phys=1.2561077226202e-05 G_eff=1.2561077226202e-05
Rh16p10n1 in10 h16p 77756.8055722338
* h16 input 11 w=-0.38263995973155 w-  bank=n alpha=1 R=87114.0937729534 G_phys=1.14791987919465e-05 G_eff=1.14791987919465e-05
Rh16n11n1 in11 h16n 85385.5843207859
* h16 input 12 w=-0.447982918675276 w-  bank=n alpha=1 R=74407.5989144918 G_phys=1.34394875602583e-05 G_eff=1.34394875602583e-05
Rh16n12n1 in12 h16n 72733.9231972196
* h16 input 13 w=-0.354860709093241 w-  bank=n alpha=1 R=93933.5702126856 G_phys=1.06458212727972e-05 G_eff=1.06458212727972e-05
Rh16n13n1 in13 h16n 92217.4204150522
* h16 input 14 w=-0.245379266072843 w-  bank=n alpha=1 R=135844.131685674 G_phys=7.36137798218528e-06 G_eff=7.36137798218528e-06
Rh16n14n1 in14 h16n 133070.647082011
* h16 input 15 w=-0.0999148922371372 w-  bank=n alpha=1 R=333617.267526249 G_phys=2.99744676711412e-06 G_eff=2.99744676711412e-06
Rh16n15n1 in15 h16n 325780.615038726
* h16 input 16 w=-0.428765175056332 w-  bank=n alpha=1 R=77742.632267077 G_phys=1.286295525169e-05 G_eff=1.286295525169e-05
Rh16n16n1 in16 h16n 76291.1583147669
* h16 bias=+0.0857431075924666 b+  bank=n alpha=1 R=388758.166916054 G_phys=2.572293227774e-06 G_eff=2.572293227774e-06
Rh16bpn1 vref h16p 380588.046052388
Vh16p h16p 0 DC 0
Vh16n h16n 0 DC 0
Fh16p 0 h16d Vh16p 1
Fh16n h16d 0 Vh16n 1
Vh16d h16d 0 DC 0
Hh16 h16raw 0 Vh16d 33333.3333333333
Eh16sc h16lin 0 h16raw 0 1
* direct bounded ReLU: y=max(0, min(15, v(h16lin))) no high-gain op-amp loop
Bh16relu h16y 0 V = max(0, min(15, v(h16lin)))
Eh16 h16buf 0 h16y 0 1

* h17 input 1 w=+0.690050155404084 w+  bank=n alpha=1 R=48305.667453714 G_phys=2.07015046621225e-05 G_eff=2.07015046621225e-05
Rh17p1n1 in1 h17p 47367.2184805419
* h17 input 2 w=-0.128803090681736 w-  bank=n alpha=1 R=258792.961852894 G_phys=3.86409272045207e-06 G_eff=3.86409272045207e-06
Rh17n2n1 in2 h17n 253432.572657611
* h17 input 3 w=-0.49836012605351 w-  bank=n alpha=1 R=66886.036002315 G_phys=1.49508037816053e-05 G_eff=1.49508037816053e-05
Rh17n3n1 in3 h17n 65757.6857707361
* h17 input 4 w=-0.0597081457071854 w-  bank=n alpha=1 R=558271.119267432 G_phys=1.79124437121556e-06 G_eff=1.79124437121556e-06
Rh17n4n1 in4 h17n 549277.396015219
* h17 input 5 w=+0.0531710366485299 w+  bank=n alpha=1 R=626907.71958562 G_phys=1.5951310994559e-06 G_eff=1.5951310994559e-06
Rh17p5n1 in5 h17p 614402.283133012
* h17 input 6 w=+0.325686197829899 w+  bank=n alpha=1 R=102348.007239603 G_phys=9.77058593489698e-06 G_eff=9.77058593489698e-06
Rh17p6n1 in6 h17p 100765.325571811
* h17 input 7 w=-0.138446110206034 w-  bank=n alpha=1 R=240767.568577601 G_phys=4.15338330618101e-06 G_eff=4.15338330618101e-06
Rh17n7n1 in7 h17n 235215.177281502
* h17 input 8 w=-0.354640771144099 w-  bank=n alpha=1 R=93991.8250961316 G_phys=1.0639223134323e-05 G_eff=1.0639223134323e-05
Rh17n8n1 in8 h17n 91997.8569598537
* h17 input 9 w=+0.283153126675736 w+  bank=n alpha=1 R=117721.932738911 G_phys=8.49459380027208e-06 G_eff=8.49459380027208e-06
Rh17p9n1 in9 h17p 115410.721975593
* h17 input 10 w=+0.187509087652136 w+  bank=n alpha=1 R=177769.161754831 G_phys=5.62527262956408e-06 G_eff=5.62527262956408e-06
Rh17p10n1 in10 h17p 173763.48680649
* h17 input 11 w=+0.286891884918939 w+  bank=n alpha=1 R=116187.78740553 G_phys=8.60675654756817e-06 G_eff=8.60675654756817e-06
Rh17p11n1 in11 h17p 114223.491977147
* h17 input 12 w=-0.663420236101193 w-  bank=n alpha=1 R=50244.6737670041 G_phys=1.99026070830358e-05 G_eff=1.99026070830358e-05
Rh17n12n1 in12 h17n 49135.6380094243
* h17 input 13 w=-0.00672050178940724 w-  bank=f alpha=0.001 R=4959.94709589586 G_phys=0.000201615053682217 G_eff=2.01615053682217e-07
Rh17n13f1 inf13 h17n 4847.38176542336
* h17 input 14 w=+0.213870810385993 w+  bank=n alpha=1 R=155857.32935305 G_phys=6.41612431157979e-06 G_eff=6.41612431157979e-06
Rh17p14n1 in14 h17p 153217.734109069
* h17 input 15 w=+0.856655380645102 w+  bank=n alpha=1 R=38911.0184637278 G_phys=2.56996614193531e-05 G_eff=2.56996614193531e-05
Rh17p15n1 in15 h17p 38128.2433605175
* h17 input 16 w=-0.153994690926048 w-  bank=n alpha=1 R=216457.6787218 G_phys=4.61984072778143e-06 G_eff=4.61984072778143e-06
Rh17n16n1 in16 h17n 212703.052194818
* h17 bias=+0.0931053836114148 b+  bank=n alpha=1 R=358017.249275869 G_phys=2.79316150834244e-06 G_eff=2.79316150834244e-06
Rh17bpn1 vref h17p 350901.224416753
Vh17p h17p 0 DC 0
Vh17n h17n 0 DC 0
Fh17p 0 h17d Vh17p 1
Fh17n h17d 0 Vh17n 1
Vh17d h17d 0 DC 0
Hh17 h17raw 0 Vh17d 33333.3333333333
Eh17sc h17lin 0 h17raw 0 1
* direct bounded ReLU: y=max(0, min(15, v(h17lin))) no high-gain op-amp loop
Bh17relu h17y 0 V = max(0, min(15, v(h17lin)))
Eh17 h17buf 0 h17y 0 1

* h18 input 1 w=+0.00309692999044255 w+  bank=f alpha=0.001 R=10763.3473911917 G_phys=9.29078997132766e-05 G_eff=9.29078997132766e-08
Rh18p1f1 inf1 h18p 10616.6230279936
* h18 input 2 w=-0.290006429631547 w-  bank=n alpha=1 R=114939.98038486 G_phys=8.70019288894641e-06 G_eff=8.70019288894641e-06
Rh18n2n1 in2 h18n 112953.093959578
* h18 input 3 w=+0.161902441115013 w+  bank=n alpha=1 R=205885.304160755 G_phys=4.8570732334504e-06 G_eff=4.8570732334504e-06
Rh18p3n1 in3 h18p 202196.118324972
* h18 input 4 w=-0.201165440039706 w-  bank=n alpha=1 R=165701.093223339 G_phys=6.03496320119118e-06 G_eff=6.03496320119118e-06
Rh18n4n1 in4 h18n 162913.000677742
* h18 input 5 w=+0.167521926893116 w+  bank=n alpha=1 R=198978.927424831 G_phys=5.02565780679349e-06 G_eff=5.02565780679349e-06
Rh18p5n1 in5 h18p 194418.973533775
* h18 input 6 w=+0.306365656745506 w+  bank=n alpha=1 R=108802.447661498 G_phys=9.19096970236517e-06 G_eff=9.19096970236517e-06
Rh18p6n1 in6 h18p 106488.015307236
* h18 input 7 w=+0.567135277617062 w+  bank=n alpha=1 R=58774.9248704654 G_phys=1.70140583285119e-05 G_eff=1.70140583285119e-05
Rh18p7n1 in7 h18p 57438.6732632882
* h18 input 8 w=+0.27754647202065 w+  bank=n alpha=1 R=120100.007363283 G_phys=8.3263941606195e-06 G_eff=8.3263941606195e-06
Rh18p8n1 in8 h18p 117935.909171749
* h18 input 9 w=-0.295299170614896 w-  bank=n alpha=1 R=112879.874548662 G_phys=8.85897511844687e-06 G_eff=8.85897511844687e-06
Rh18n9n1 in9 h18n 110317.206590068
* h18 input 10 w=+0.627786354607437 w+  bank=n alpha=1 R=53096.6197157584 G_phys=1.88335906382231e-05 G_eff=1.88335906382231e-05
Rh18p10n1 in10 h18p 51908.0559744338
* h18 input 11 w=+0.158870042328046 w+  bank=n alpha=1 R=209815.09694889 G_phys=4.76610126984139e-06 G_eff=4.76610126984139e-06
Rh18p11n1 in11 h18p 206655.890626795
* h18 input 12 w=+0.503831351799562 w+  bank=n alpha=1 R=66159.704461175 G_phys=1.51149405539869e-05 G_eff=1.51149405539869e-05
Rh18p12n1 in12 h18p 65038.2314414748
* h18 input 13 w=+0.0259448474340262 w+  bank=f alpha=0.001 R=1284.77661771166 G_phys=0.000778345423020786 G_eff=7.78345423020786e-07
Rh18p13f1 inf13 h18p 1258.27540127426
* h18 input 14 w=-0.0445667146819355 w-  bank=n alpha=1 R=747942.350501428 G_phys=1.33700144045806e-06 G_eff=1.33700144045806e-06
Rh18n14n1 in14 h18n 733254.212051339
* h18 input 15 w=-0.425048584977393 w-  bank=n alpha=1 R=78422.4074880905 G_phys=1.27514575493218e-05 G_eff=1.27514575493218e-05
Rh18n15n1 in15 h18n 77171.5803651958
* h18 input 16 w=-0.290071708244206 w-  bank=n alpha=1 R=114914.113944786 G_phys=8.70215124732617e-06 G_eff=8.70215124732617e-06
Rh18n16n1 in16 h18n 112358.099503497
* h18 bias=+0.103219643590821 b+  bank=n alpha=1 R=322935.946819115 G_phys=3.09658930772463e-06 G_eff=3.09658930772463e-06
Rh18bpn1 vref h18p 317791.938988509
Vh18p h18p 0 DC 0
Vh18n h18n 0 DC 0
Fh18p 0 h18d Vh18p 1
Fh18n h18d 0 Vh18n 1
Vh18d h18d 0 DC 0
Hh18 h18raw 0 Vh18d 33333.3333333333
Eh18sc h18lin 0 h18raw 0 1
* direct bounded ReLU: y=max(0, min(15, v(h18lin))) no high-gain op-amp loop
Bh18relu h18y 0 V = max(0, min(15, v(h18lin)))
Eh18 h18buf 0 h18y 0 1

* h19 input 1 w=+0.361917529899694 w+  bank=n alpha=1 R=92102.0138001377 G_phys=1.08575258969908e-05 G_eff=1.08575258969908e-05
Rh19p1n1 in1 h19p 90233.0915910392
* h19 input 2 w=+0.460196491117441 w+  bank=n alpha=1 R=72432.8281000013 G_phys=1.38058947335232e-05 G_eff=1.38058947335232e-05
Rh19p2n1 in2 h19p 71141.9600751582
* h19 input 3 w=+0.284766719035728 w+  bank=n alpha=1 R=117054.877220927 G_phys=8.54300157107185e-06 G_eff=8.54300157107185e-06
Rh19p3n1 in3 h19p 114449.81152786
* h19 input 4 w=-0.664899666016021 w-  bank=n alpha=1 R=50132.8772400529 G_phys=1.99469899804806e-05 G_eff=1.99469899804806e-05
Rh19n4n1 in4 h19n 49219.8852423062
* h19 input 5 w=+0.507213486118456 w+  bank=n alpha=1 R=65718.5470134534 G_phys=1.52164045835537e-05 G_eff=1.52164045835537e-05
Rh19p5n1 in5 h19p 64559.8244013172
* h19 input 6 w=+0.130688397719858 w+  bank=n alpha=1 R=255059.622085094 G_phys=3.92065193159573e-06 G_eff=3.92065193159573e-06
Rh19p6n1 in6 h19p 250475.527384032
* h19 input 7 w=+0.0897047942241856 w+  bank=n alpha=1 R=371589.206815729 G_phys=2.69114382672557e-06 G_eff=2.69114382672557e-06
Rh19p7n1 in7 h19p 363839.424814761
* h19 input 8 w=+0.0897866911799249 w+  bank=n alpha=1 R=371250.269892853 G_phys=2.69360073539775e-06 G_eff=2.69360073539775e-06
Rh19p8n1 in8 h19p 365790.576374807
* h19 input 9 w=-0.272382660879323 w-  bank=n alpha=1 R=122376.854773812 G_phys=8.17147982637969e-06 G_eff=8.17147982637969e-06
Rh19n9n1 in9 h19n 120081.00984194
* h19 input 10 w=+0.0908546616405757 w+  bank=n alpha=1 R=366886.329566679 G_phys=2.72563984921727e-06 G_eff=2.72563984921727e-06
Rh19p10n1 in10 h19p 359146.835440808
* h19 input 11 w=-0.0411180740799587 w-  bank=n alpha=1 R=810673.507434053 G_phys=1.23354222239876e-06 G_eff=1.23354222239876e-06
Rh19n11n1 in11 h19n 793127.492586588
* h19 input 12 w=-0.14910928160707 w-  bank=n alpha=1 R=223549.687679219 G_phys=4.47327844821211e-06 G_eff=4.47327844821211e-06
Rh19n12n1 in12 h19n 218523.961560521
* h19 input 13 w=-0.0351824330179761 w-  bank=n alpha=1 R=947442.529523243 G_phys=1.05547299053928e-06 G_eff=1.05547299053928e-06
Rh19n13n1 in13 h19n 933964.386325156
* h19 input 14 w=+0.491588757414346 w+  bank=n alpha=1 R=67807.3548887889 G_phys=1.47476627224304e-05 G_eff=1.47476627224304e-05
Rh19p14n1 in14 h19p 66571.8532991964
* h19 input 15 w=-0.0385925197286318 w-  bank=n alpha=1 R=863725.239184197 G_phys=1.15777559185895e-06 G_eff=1.15777559185895e-06
Rh19n15n1 in15 h19n 844405.096998935
* h19 input 16 w=-0.690622583753164 w-  bank=n alpha=1 R=48265.628894127 G_phys=2.07186775125949e-05 G_eff=2.07186775125949e-05
Rh19n16n1 in16 h19n 47557.9014414837
* h19 bias=+0.0200863362195416 b+  bank=f alpha=0.001 R=1659.50290630424 G_phys=0.000602590086586248 G_eff=6.02590086586248e-07
Rh19bpf1 vreff h19p 1633.63329986842
Vh19p h19p 0 DC 0
Vh19n h19n 0 DC 0
Fh19p 0 h19d Vh19p 1
Fh19n h19d 0 Vh19n 1
Vh19d h19d 0 DC 0
Hh19 h19raw 0 Vh19d 33333.3333333333
Eh19sc h19lin 0 h19raw 0 1
* direct bounded ReLU: y=max(0, min(15, v(h19lin))) no high-gain op-amp loop
Bh19relu h19y 0 V = max(0, min(15, v(h19lin)))
Eh19 h19buf 0 h19y 0 1

* h20 input 1 w=-0.0810043123301717 w-  bank=n alpha=1 R=411500.72600416 G_phys=2.43012936990515e-06 G_eff=2.43012936990515e-06
Rh20n1n1 in1 h20n 403036.137907576
* h20 input 2 w=+0.646296718361532 w+  bank=n alpha=1 R=51575.8975503369 G_phys=1.9388901550846e-05 G_eff=1.9388901550846e-05
Rh20p2n1 in2 h20p 50607.9623452789
* h20 input 3 w=-0.000929252010170944 w-  bank=f alpha=0.001 R=35871.1447147705 G_phys=2.78775603051283e-05 G_eff=2.78775603051283e-08
Rh20n3f1 inf3 h20n 35075.8324239698
* h20 input 4 w=+0.269987692172837 w+  bank=n alpha=1 R=123462.418101617 G_phys=8.09963076518511e-06 G_eff=8.09963076518511e-06
Rh20p4n1 in4 h20p 121212.066276844
* h20 input 5 w=+0.140155013181344 w+  bank=n alpha=1 R=237831.901811489 G_phys=4.20465039544031e-06 G_eff=4.20465039544031e-06
Rh20p5n1 in5 h20p 232981.990833953
* h20 input 6 w=+0.15481044132605 w+  bank=n alpha=1 R=215317.087451028 G_phys=4.6443132397815e-06 G_eff=4.6443132397815e-06
Rh20p6n1 in6 h20p 211777.037701495
* h20 input 7 w=-0.803119096824844 w-  bank=n alpha=1 R=41504.8446302892 G_phys=2.40935729047453e-05 G_eff=2.40935729047453e-05
Rh20n7n1 in7 h20n 40873.5758843924
* h20 input 8 w=+0.12095822380885 w+  bank=n alpha=1 R=275577.238849092 G_phys=3.62874671426549e-06 G_eff=3.62874671426549e-06
Rh20p8n1 in8 h20p 270692.454347215
* h20 input 9 w=+0.307944073046154 w+  bank=n alpha=1 R=108244.763419549 G_phys=9.23832219138461e-06 G_eff=9.23832219138461e-06
Rh20p9n1 in9 h20p 106143.950119929
* h20 input 10 w=+0.100067069291622 w+  bank=n alpha=1 R=333109.918870425 G_phys=3.00201207874865e-06 G_eff=3.00201207874865e-06
Rh20p10n1 in10 h20p 325468.116535002
* h20 input 11 w=+0.376050768766317 w+  bank=n alpha=1 R=88640.513733525 G_phys=1.12815230629895e-05 G_eff=1.12815230629895e-05
Rh20p11n1 in11 h20p 86818.4400524574
* h20 input 12 w=-0.859853426992325 w-  bank=n alpha=1 R=38766.2970070722 G_phys=2.57956028097698e-05 G_eff=2.57956028097698e-05
Rh20n12n1 in12 h20n 37860.0013921455
* h20 input 13 w=+0.0677970111280841 w+  bank=n alpha=1 R=491663.758898737 G_phys=2.03391033384252e-06 G_eff=2.03391033384252e-06
Rh20p13n1 in13 h20p 481677.009311213
* h20 input 14 w=-0.43012675419833 w-  bank=n alpha=1 R=77496.5356327578 G_phys=1.29038026259499e-05 G_eff=1.29038026259499e-05
Rh20n14n1 in14 h20n 76057.2729647398
* h20 input 15 w=-0.0800571778528839 w-  bank=n alpha=1 R=416369.078043045 G_phys=2.40171533558652e-06 G_eff=2.40171533558652e-06
Rh20n15n1 in15 h20n 406611.949571941
* h20 input 16 w=-0.127529601563162 w-  bank=n alpha=1 R=261377.224775726 G_phys=3.82588804689485e-06 G_eff=3.82588804689485e-06
Rh20n16n1 in16 h20n 257056.491100205
* h20 bias=+0.0269672795638665 b+  bank=f alpha=0.001 R=1236.06584989005 G_phys=0.000809018386915995 G_eff=8.09018386915995e-07
Rh20bpf1 vreff h20p 1209.16511644048
Vh20p h20p 0 DC 0
Vh20n h20n 0 DC 0
Fh20p 0 h20d Vh20p 1
Fh20n h20d 0 Vh20n 1
Vh20d h20d 0 DC 0
Hh20 h20raw 0 Vh20d 33333.3333333333
Eh20sc h20lin 0 h20raw 0 1
* direct bounded ReLU: y=max(0, min(15, v(h20lin))) no high-gain op-amp loop
Bh20relu h20y 0 V = max(0, min(15, v(h20lin)))
Eh20 h20buf 0 h20y 0 1

* h21 input 1 w=-0.00681344895090886 w-  bank=f alpha=0.001 R=4892.28488736045 G_phys=0.000204403468527266 G_eff=2.04403468527266e-07
Rh21n1f1 inf1 h21n 4780.99830921225
* h21 input 2 w=+0.17215275761211 w+  bank=n alpha=1 R=193626.484964238 G_phys=5.1645827283633e-06 G_eff=5.1645827283633e-06
Rh21p2n1 in2 h21p 189647.883891548
* h21 input 3 w=-0.241244992284912 w-  bank=n alpha=1 R=138172.12542993 G_phys=7.23734976854735e-06 G_eff=7.23734976854735e-06
Rh21n3n1 in3 h21n 135560.55769395
* h21 input 4 w=-0.253516997925259 w-  bank=n alpha=1 R=131483.622818698 G_phys=7.60550993775776e-06 G_eff=7.60550993775776e-06
Rh21n4n1 in4 h21n 129040.46765571
* h21 input 5 w=+0.732528033504134 w+  bank=n alpha=1 R=45504.515607245 G_phys=2.1975841005124e-05 G_eff=2.1975841005124e-05
Rh21p5n1 in5 h21p 44453.3504823387
* h21 input 6 w=-0.335745026911547 w-  bank=n alpha=1 R=99281.6889648676 G_phys=1.00723508073464e-05 G_eff=1.00723508073464e-05
Rh21n6n1 in6 h21n 97380.2451483237
* h21 input 7 w=-0.133397447206163 w-  bank=n alpha=1 R=249879.844265815 G_phys=4.00192341618489e-06 G_eff=4.00192341618489e-06
Rh21n7n1 in7 h21n 245917.458260395
* h21 input 8 w=-0.602502751086194 w-  bank=n alpha=1 R=55324.7819586548 G_phys=1.80750825325858e-05 G_eff=1.80750825325858e-05
Rh21n8n1 in8 h21n 54485.0036308389
* h21 input 9 w=-0.464313715662176 w-  bank=n alpha=1 R=71790.5420601142 G_phys=1.39294114698653e-05 G_eff=1.39294114698653e-05
Rh21n9n1 in9 h21n 70614.2864170651
* h21 input 10 w=+0.0220606443883595 w+  bank=f alpha=0.001 R=1510.98638582479 G_phys=0.000661819331650786 G_eff=6.61819331650786e-07
Rh21p10f1 inf10 h21p 1478.90972524384
* h21 input 11 w=+0.293613135845564 w+  bank=n alpha=1 R=113528.072364127 G_phys=8.80839407536691e-06 G_eff=8.80839407536691e-06
Rh21p11n1 in11 h21p 111921.002881248
* h21 input 12 w=+0.585788543436 w+  bank=n alpha=1 R=56903.3548143728 G_phys=1.757365630308e-05 G_eff=1.757365630308e-05
Rh21p12n1 in12 h21p 55800.4300250847
* h21 input 13 w=-0.255400978522459 w-  bank=n alpha=1 R=130513.726009089 G_phys=7.66202935567376e-06 G_eff=7.66202935567376e-06
Rh21n13n1 in13 h21n 128406.877474315
* h21 input 14 w=+0.15251581562556 w+  bank=n alpha=1 R=218556.568685111 G_phys=4.57547446876679e-06 G_eff=4.57547446876679e-06
Rh21p14n1 in14 h21p 215111.007152743
* h21 input 15 w=-0.610279514665944 w-  bank=n alpha=1 R=54619.7808254787 G_phys=1.83083854399783e-05 G_eff=1.83083854399783e-05
Rh21n15n1 in15 h21n 53727.5573666696
* h21 input 16 w=+0.0580238118020399 w+  bank=n alpha=1 R=574476.793200985 G_phys=1.7407143540612e-06 G_eff=1.7407143540612e-06
Rh21p16n1 in16 h21p 563271.494402052
* h21 bias=-0.00602264402556266 b-  bank=f alpha=0.001 R=5534.66769609038 G_phys=0.00018067932076688 G_eff=1.8067932076688e-07
Rh21bnf1 vreff h21n 5406.98102359944
Vh21p h21p 0 DC 0
Vh21n h21n 0 DC 0
Fh21p 0 h21d Vh21p 1
Fh21n h21d 0 Vh21n 1
Vh21d h21d 0 DC 0
Hh21 h21raw 0 Vh21d 33333.3333333333
Eh21sc h21lin 0 h21raw 0 1
* direct bounded ReLU: y=max(0, min(15, v(h21lin))) no high-gain op-amp loop
Bh21relu h21y 0 V = max(0, min(15, v(h21lin)))
Eh21 h21buf 0 h21y 0 1

* h22 input 1 w=+0.733134048211177 w+  bank=n alpha=1 R=45466.901195853 G_phys=2.19940214463353e-05 G_eff=2.19940214463353e-05
Rh22p1n1 in1 h22p 44493.723814483
* h22 input 2 w=-0.468945077984231 w-  bank=n alpha=1 R=71081.5293693183 G_phys=1.40683523395269e-05 G_eff=1.40683523395269e-05
Rh22n2n1 in2 h22n 69525.1426171316
* h22 input 3 w=+0.0425168801269381 w+  bank=n alpha=1 R=784002.335867861 G_phys=1.27550640380814e-06 G_eff=1.27550640380814e-06
Rh22p3n1 in3 h22p 768416.557565515
* h22 input 4 w=-0.440513463519883 w-  bank=n alpha=1 R=75669.2725506874 G_phys=1.32154039055965e-05 G_eff=1.32154039055965e-05
Rh22n4n1 in4 h22n 74234.978461053
* h22 input 5 w=+0.139436850403416 w+  bank=n alpha=1 R=239056.843559604 G_phys=4.18310551210248e-06 G_eff=4.18310551210248e-06
Rh22p5n1 in5 h22p 233819.540143962
* h22 input 6 w=-0.216633688080034 w-  bank=n alpha=1 R=153869.574158838 G_phys=6.49901064240101e-06 G_eff=6.49901064240101e-06
Rh22n6n1 in6 h22n 150291.686539171
* h22 input 7 w=+0.3413541130964 w+  bank=n alpha=1 R=97650.305224006 G_phys=1.0240623392892e-05 G_eff=1.0240623392892e-05
Rh22p7n1 in7 h22p 95943.7998452211
* h22 input 8 w=+0.375494249585175 w+  bank=n alpha=1 R=88771.88763918 G_phys=1.12648274875552e-05 G_eff=1.12648274875552e-05
Rh22p8n1 in8 h22p 86906.1668058775
* h22 input 9 w=-0.0598723775607 w-  bank=n alpha=1 R=556739.763667131 G_phys=1.796171326821e-06 G_eff=1.796171326821e-06
Rh22n9n1 in9 h22n 544965.988000553
* h22 input 10 w=-0.886177024526985 w-  bank=n alpha=1 R=37614.7568835083 G_phys=2.65853107358095e-05 G_eff=2.65853107358095e-05
Rh22n10n1 in10 h22n 36952.4004165711
* h22 input 11 w=-0.158397755226926 w-  bank=n alpha=1 R=210440.692707917 G_phys=4.75193265680777e-06 G_eff=4.75193265680777e-06
Rh22n11n1 in11 h22n 206712.912577401
* h22 input 12 w=+0.00642379373490928 w+  bank=f alpha=0.001 R=5189.04166430307 G_phys=0.000192713812047279 G_eff=1.92713812047279e-07
Rh22p12f1 inf12 h22p 5108.75973453597
* h22 input 13 w=+0.483338726494796 w+  bank=n alpha=1 R=68964.7477144421 G_phys=1.45001617948439e-05 G_eff=1.45001617948439e-05
Rh22p13n1 in13 h22p 67505.392978826
* h22 input 14 w=+0.995892890290009 w+  bank=n alpha=1 R=33470.8015875347 G_phys=2.98767867087003e-05 G_eff=2.98767867087003e-05
Rh22p14n1 in14 h22p 32882.6579478625
* h22 input 15 w=-0.0635579626600016 w-  bank=n alpha=1 R=524455.661230796 G_phys=1.90673887980005e-06 G_eff=1.90673887980005e-06
Rh22n15n1 in15 h22n 515439.27480276
* h22 input 16 w=+0.143429643183018 w+  bank=n alpha=1 R=232401.981860887 G_phys=4.30288929549054e-06 G_eff=4.30288929549054e-06
Rh22p16n1 in16 h22p 227967.818676279
* h22 bias=+0.00381018335041017 b+  bank=f alpha=0.001 R=8748.48537925215 G_phys=0.000114305500512305 G_eff=1.14305500512305e-07
Rh22bpf1 vreff h22p 8611.17936281546
Vh22p h22p 0 DC 0
Vh22n h22n 0 DC 0
Fh22p 0 h22d Vh22p 1
Fh22n h22d 0 Vh22n 1
Vh22d h22d 0 DC 0
Hh22 h22raw 0 Vh22d 33333.3333333333
Eh22sc h22lin 0 h22raw 0 1
* direct bounded ReLU: y=max(0, min(15, v(h22lin))) no high-gain op-amp loop
Bh22relu h22y 0 V = max(0, min(15, v(h22lin)))
Eh22 h22buf 0 h22y 0 1

* h23 input 1 w=-0.311855168471888 w-  bank=n alpha=1 R=106887.224273592 G_phys=9.35565505415663e-06 G_eff=9.35565505415663e-06
Rh23n1n1 in1 h23n 105389.599422321
* h23 input 2 w=-0.519305850985266 w-  bank=n alpha=1 R=64188.2491215741 G_phys=1.5579175529558e-05 G_eff=1.5579175529558e-05
Rh23n2n1 in2 h23n 62802.5975901546
* h23 input 3 w=+0.0590711076347425 w+  bank=n alpha=1 R=564291.659121157 G_phys=1.77213322904228e-06 G_eff=1.77213322904228e-06
Rh23p3n1 in3 h23p 555827.852908765
* h23 input 4 w=-0.153433475387477 w-  bank=n alpha=1 R=217249.418675776 G_phys=4.60300426162431e-06 G_eff=4.60300426162431e-06
Rh23n4n1 in4 h23n 213882.728989264
* h23 input 5 w=+0.565735693190981 w+  bank=n alpha=1 R=58920.3292889647 G_phys=1.69720707957294e-05 G_eff=1.69720707957294e-05
Rh23p5n1 in5 h23p 57726.2253823851
* h23 input 6 w=-0.371646754353268 w-  bank=n alpha=1 R=89690.90391046 G_phys=1.1149402630598e-05 G_eff=1.1149402630598e-05
Rh23n6n1 in6 h23n 88302.495124375
* h23 input 7 w=-0.111660278324499 w-  bank=n alpha=1 R=298524.540987283 G_phys=3.34980834973497e-06 G_eff=3.34980834973497e-06
Rh23n7n1 in7 h23n 293594.978923028
* h23 input 8 w=+0.496809212320021 w+  bank=n alpha=1 R=67094.8374279775 G_phys=1.49042763696006e-05 G_eff=1.49042763696006e-05
Rh23p8n1 in8 h23p 66029.2390617293
* h23 input 9 w=-0.177241184436762 w-  bank=n alpha=1 R=188067.65165365 G_phys=5.31723553310286e-06 G_eff=5.31723553310286e-06
Rh23n9n1 in9 h23n 185487.677211465
* h23 input 10 w=-0.405292848695184 w-  bank=n alpha=1 R=82245.0567303322 G_phys=1.21587854608555e-05 G_eff=1.21587854608555e-05
Rh23n10n1 in10 h23n 80580.867332262
* h23 input 11 w=-0.16052467280172 w-  bank=n alpha=1 R=207652.398547522 G_phys=4.81574018405159e-06 G_eff=4.81574018405159e-06
Rh23n11n1 in11 h23n 204733.35172064
* h23 input 12 w=+0.846508036935069 w+  bank=n alpha=1 R=39377.4564196963 G_phys=2.53952411080521e-05 G_eff=2.53952411080521e-05
Rh23p12n1 in12 h23p 38749.5384868305
* h23 input 13 w=-0.0538311215013525 w-  bank=n alpha=1 R=619220.488142641 G_phys=1.61493364504058e-06 G_eff=1.61493364504058e-06
Rh23n13n1 in13 h23n 609878.57575058
* h23 input 14 w=+0.31071243911676 w+  bank=n alpha=1 R=107280.331061375 G_phys=9.3213731735028e-06 G_eff=9.3213731735028e-06
Rh23p14n1 in14 h23p 105722.450375454
* h23 input 15 w=+0.331311012578656 w+  bank=n alpha=1 R=100610.399497118 G_phys=9.93933037735967e-06 G_eff=9.93933037735967e-06
Rh23p15n1 in15 h23p 98754.6257268237
* h23 input 16 w=-0.486368816876819 w-  bank=n alpha=1 R=68535.0955420638 G_phys=1.45910645063046e-05 G_eff=1.45910645063046e-05
Rh23n16n1 in16 h23n 67380.7990138053
* h23 bias=-0.0518579015055903 b-  bank=n alpha=1 R=642782.148246781 G_phys=1.55573704516771e-06 G_eff=1.55573704516771e-06
Rh23bnn1 vref h23n 630814.486350605
Vh23p h23p 0 DC 0
Vh23n h23n 0 DC 0
Fh23p 0 h23d Vh23p 1
Fh23n h23d 0 Vh23n 1
Vh23d h23d 0 DC 0
Hh23 h23raw 0 Vh23d 33333.3333333333
Eh23sc h23lin 0 h23raw 0 1
* direct bounded ReLU: y=max(0, min(15, v(h23lin))) no high-gain op-amp loop
Bh23relu h23y 0 V = max(0, min(15, v(h23lin)))
Eh23 h23buf 0 h23y 0 1

* h24 input 1 w=+0.61389120350986 w+  bank=n alpha=1 R=54298.4378058415 G_phys=1.84167361052958e-05 G_eff=1.84167361052958e-05
Rh24p1n1 in1 h24p 53361.7925259268
* h24 input 2 w=-0.0429199313830527 w-  bank=n alpha=1 R=776639.949300928 G_phys=1.28759794149158e-06 G_eff=1.28759794149158e-06
Rh24n2n1 in2 h24n 765191.699189454
* h24 input 3 w=-0.014915873427812 w-  bank=f alpha=0.001 R=2234.75571140073 G_phys=0.000447476202834361 G_eff=4.47476202834361e-07
Rh24n3f1 inf3 h24n 2194.93346542302
* h24 input 4 w=-0.169036355792668 w-  bank=n alpha=1 R=197196.237324345 G_phys=5.07109067378003e-06 G_eff=5.07109067378003e-06
Rh24n4n1 in4 h24n 193370.970375758
* h24 input 5 w=-0.510336523880732 w-  bank=n alpha=1 R=65316.378063357 G_phys=1.5310095716422e-05 G_eff=1.5310095716422e-05
Rh24n5n1 in5 h24n 64042.2044322007
* h24 input 6 w=-0.303361656916169 w-  bank=n alpha=1 R=109879.849919678 G_phys=9.10084970748506e-06 G_eff=9.10084970748506e-06
Rh24n6n1 in6 h24n 108235.937989578
* h24 input 7 w=-0.0292327970624363 w-  bank=f alpha=0.001 R=1140.27177290422 G_phys=0.000876983911873088 G_eff=8.76983911873088e-07
Rh24n7f1 inf7 h24n 1124.01256832251
* h24 input 8 w=-0.329334996951297 w-  bank=n alpha=1 R=101214.063618823 G_phys=9.88004990853891e-06 G_eff=9.88004990853891e-06
Rh24n8n1 in8 h24n 99595.5996525847
* h24 input 9 w=+0.0109599477370603 w+  bank=f alpha=0.001 R=3041.37703326988 G_phys=0.000328798432111809 G_eff=3.28798432111809e-07
Rh24p9f1 inf9 h24p 2976.53157788207
* h24 input 10 w=+0.0571459019805778 w+  bank=n alpha=1 R=583302.252271078 G_phys=1.71437705941734e-06 G_eff=1.71437705941734e-06
Rh24p10n1 in10 h24p 570194.526405186
* h24 input 11 w=+0.243568584743939 w+  bank=n alpha=1 R=136853.992760915 G_phys=7.30705754231816e-06 G_eff=7.30705754231816e-06
Rh24p11n1 in11 h24p 133910.637443541
* h24 input 12 w=-0.323004255102081 w-  bank=n alpha=1 R=103197.814910515 G_phys=9.69012765306243e-06 G_eff=9.69012765306243e-06
Rh24n12n1 in12 h24n 100912.030779832
* h24 input 13 w=+0.243938800887145 w+  bank=n alpha=1 R=136646.294939994 G_phys=7.31816402661434e-06 G_eff=7.31816402661434e-06
Rh24p13n1 in13 h24p 134523.198790166
* h24 input 14 w=+0.0840399613598874 w+  bank=n alpha=1 R=396636.704657547 G_phys=2.52119884079662e-06 G_eff=2.52119884079662e-06
Rh24p14n1 in14 h24p 388833.790165765
* h24 input 15 w=-0.352451854106752 w-  bank=n alpha=1 R=94575.5652720646 G_phys=1.05735556232026e-05 G_eff=1.05735556232026e-05
Rh24n15n1 in15 h24n 92997.454787083
* h24 input 16 w=+0.406056698737055 w+  bank=n alpha=1 R=82090.3421542089 G_phys=1.21817009621116e-05 G_eff=1.21817009621116e-05
Rh24p16n1 in16 h24p 80451.6326321833
* h24 bias=+0.0185909259510049 b+  bank=f alpha=0.001 R=1792.9894089827 G_phys=0.000557727778530147 G_eff=5.57727778530147e-07
Rh24bpf1 vreff h24p 1751.77788505175
Vh24p h24p 0 DC 0
Vh24n h24n 0 DC 0
Fh24p 0 h24d Vh24p 1
Fh24n h24d 0 Vh24n 1
Vh24d h24d 0 DC 0
Hh24 h24raw 0 Vh24d 33333.3333333333
Eh24sc h24lin 0 h24raw 0 1
* direct bounded ReLU: y=max(0, min(15, v(h24lin))) no high-gain op-amp loop
Bh24relu h24y 0 V = max(0, min(15, v(h24lin)))
Eh24 h24buf 0 h24y 0 1

* h25 input 1 w=-0.507226781565224 w-  bank=n alpha=1 R=65716.824396519 G_phys=1.52168034469567e-05 G_eff=1.52168034469567e-05
Rh25n1n1 in1 h25n 64755.6258993685
* h25 input 2 w=-0.323616844242374 w-  bank=n alpha=1 R=103002.467042068 G_phys=9.70850532727122e-06 G_eff=9.70850532727122e-06
Rh25n2n1 in2 h25n 101045.399679061
* h25 input 3 w=+0.251581142719107 w+  bank=n alpha=1 R=132495.35705683 G_phys=7.5474342815732e-06 G_eff=7.5474342815732e-06
Rh25p3n1 in3 h25p 129809.075509409
* h25 input 4 w=+0.0279414599016099 w+  bank=f alpha=0.001 R=1192.97035483149 G_phys=0.000838243797048297 G_eff=8.38243797048297e-07
Rh25p4f1 inf4 h25p 1175.78356592628
* h25 input 5 w=+0.310516223746861 w+  bank=n alpha=1 R=107348.121560654 G_phys=9.31548671240582e-06 G_eff=9.31548671240582e-06
Rh25p5n1 in5 h25p 105248.822792727
* h25 input 6 w=-0.583310440311788 w-  bank=n alpha=1 R=57145.0998125736 G_phys=1.74993132093536e-05 G_eff=1.74993132093536e-05
Rh25n6n1 in6 h25n 56200.04192843
* h25 input 7 w=-0.128366308561082 w-  bank=n alpha=1 R=259673.536670037 G_phys=3.85098925683245e-06 G_eff=3.85098925683245e-06
Rh25n7n1 in7 h25n 254901.943964506
* h25 input 8 w=-0.237966635841971 w-  bank=n alpha=1 R=140075.658990571 G_phys=7.13899907525912e-06 G_eff=7.13899907525912e-06
Rh25n8n1 in8 h25n 138030.715290258
* h25 input 9 w=+0.869293927250567 w+  bank=n alpha=1 R=38345.2964393311 G_phys=2.6078817817517e-05 G_eff=2.6078817817517e-05
Rh25p9n1 in9 h25p 37489.7039620945
* h25 input 10 w=-0.700407093798758 w-  bank=n alpha=1 R=47591.3702594662 G_phys=2.10122128139627e-05 G_eff=2.10122128139627e-05
Rh25n10n1 in10 h25n 46749.6288455072
* h25 input 11 w=+0.176416664646434 w+  bank=n alpha=1 R=188946.624742841 G_phys=5.29249993939301e-06 G_eff=5.29249993939301e-06
Rh25p11n1 in11 h25p 184895.883577733
* h25 input 12 w=+0.165054591787149 w+  bank=n alpha=1 R=201953.383861743 G_phys=4.95163775361447e-06 G_eff=4.95163775361447e-06
Rh25p12n1 in12 h25p 197540.399054033
* h25 input 13 w=+0.414882742059982 w+  bank=n alpha=1 R=80343.9862738715 G_phys=1.24464822617995e-05 G_eff=1.24464822617995e-05
Rh25p13n1 in13 h25p 79034.764269794
* h25 input 14 w=-0.441614461314228 w-  bank=n alpha=1 R=75480.619982721 G_phys=1.32484338394269e-05 G_eff=1.32484338394269e-05
Rh25n14n1 in14 h25n 74019.6088721156
* h25 input 15 w=+0.152726206779301 w+  bank=n alpha=1 R=218255.491550983 G_phys=4.58178620337902e-06 G_eff=4.58178620337902e-06
Rh25p15n1 in15 h25p 213844.071247811
* h25 input 16 w=-0.0538945970745783 w-  bank=n alpha=1 R=618491.187292992 G_phys=1.61683791223735e-06 G_eff=1.61683791223735e-06
Rh25n16n1 in16 h25n 608788.572277154
* h25 bias=+0.0841612656537764 b+  bank=n alpha=1 R=396065.019631007 G_phys=2.52483796961329e-06 G_eff=2.52483796961329e-06
Rh25bpn1 vref h25p 390277.888060276
Vh25p h25p 0 DC 0
Vh25n h25n 0 DC 0
Fh25p 0 h25d Vh25p 1
Fh25n h25d 0 Vh25n 1
Vh25d h25d 0 DC 0
Hh25 h25raw 0 Vh25d 33333.3333333333
Eh25sc h25lin 0 h25raw 0 1
* direct bounded ReLU: y=max(0, min(15, v(h25lin))) no high-gain op-amp loop
Bh25relu h25y 0 V = max(0, min(15, v(h25lin)))
Eh25 h25buf 0 h25y 0 1

* h26 input 1 w=-0.733410608571861 w-  bank=n alpha=1 R=45449.7561717056 G_phys=2.20023182571558e-05 G_eff=2.20023182571558e-05
Rh26n1n1 in1 h26n 44648.8326589694
* h26 input 2 w=+0.207000343516658 w+  bank=n alpha=1 R=161030.328583251 G_phys=6.21001030549975e-06 G_eff=6.21001030549975e-06
Rh26p2n1 in2 h26p 157731.55216964
* h26 input 3 w=-0.0671817515718929 w-  bank=n alpha=1 R=496166.482019488 G_phys=2.01545254715679e-06 G_eff=2.01545254715679e-06
Rh26n3n1 in3 h26n 488216.717974467
* h26 input 4 w=+0.312724326896377 w+  bank=n alpha=1 R=106590.151345592 G_phys=9.38172980689131e-06 G_eff=9.38172980689131e-06
Rh26p4n1 in4 h26p 104342.829235269
* h26 input 5 w=+0.0982363551813243 w+  bank=n alpha=1 R=339317.692231219 G_phys=2.94709065543973e-06 G_eff=2.94709065543973e-06
Rh26p5n1 in5 h26p 332153.018495937
* h26 input 6 w=+0.0433697195878843 w+  bank=n alpha=1 R=768585.401291025 G_phys=1.30109158763653e-06 G_eff=1.30109158763653e-06
Rh26p6n1 in6 h26p 758149.609966362
* h26 input 7 w=-0.253243820471769 w-  bank=n alpha=1 R=131625.45593901 G_phys=7.59731461415306e-06 G_eff=7.59731461415306e-06
Rh26n7n1 in7 h26n 128717.667741225
* h26 input 8 w=+0.388367135047654 w+  bank=n alpha=1 R=85829.4390158508 G_phys=1.16510140514296e-05 G_eff=1.16510140514296e-05
Rh26p8n1 in8 h26p 84033.3296075113
* h26 input 9 w=+0.190562655499984 w+  bank=n alpha=1 R=174920.596304013 G_phys=5.71687966499952e-06 G_eff=5.71687966499952e-06
Rh26p9n1 in9 h26p 171278.534138338
* h26 input 10 w=-0.282938574156096 w-  bank=n alpha=1 R=117811.201363245 G_phys=8.48815722468287e-06 G_eff=8.48815722468287e-06
Rh26n10n1 in10 h26n 115930.116726724
* h26 input 11 w=+0.123317846030254 w+  bank=n alpha=1 R=270304.21310761 G_phys=3.69953538090763e-06 G_eff=3.69953538090763e-06
Rh26p11n1 in11 h26p 265106.113883183
* h26 input 12 w=-0.494646699470857 w-  bank=n alpha=1 R=67388.1648639146 G_phys=1.48394009841257e-05 G_eff=1.48394009841257e-05
Rh26n12n1 in12 h26n 66410.0076865268
* h26 input 13 w=-0.136127092468903 w-  bank=n alpha=1 R=244869.208096457 G_phys=4.08381277406708e-06 G_eff=4.08381277406708e-06
Rh26n13n1 in13 h26n 240083.802850667
* h26 input 14 w=+0.481522107274068 w+  bank=n alpha=1 R=69224.928263493 G_phys=1.4445663218222e-05 G_eff=1.4445663218222e-05
Rh26p14n1 in14 h26p 67850.9812363198
* h26 input 15 w=+0.0644124429905188 w+  bank=n alpha=1 R=517498.355686336 G_phys=1.93237328971556e-06 G_eff=1.93237328971556e-06
Rh26p15n1 in15 h26p 508102.74346617
* h26 input 16 w=+0.0297993400818282 w+  bank=f alpha=0.001 R=1118.5930037981 G_phys=0.000893980202454845 G_eff=8.93980202454845e-07
Rh26p16f1 inf16 h26p 1098.13024802245
* h26 bias=-0.0154994859917217 b-  bank=f alpha=0.001 R=2150.60895252505 G_phys=0.000464984579751652 G_eff=4.64984579751652e-07
Rh26bnf1 vreff h26n 2114.04930348225
Vh26p h26p 0 DC 0
Vh26n h26n 0 DC 0
Fh26p 0 h26d Vh26p 1
Fh26n h26d 0 Vh26n 1
Vh26d h26d 0 DC 0
Hh26 h26raw 0 Vh26d 33333.3333333333
Eh26sc h26lin 0 h26raw 0 1
* direct bounded ReLU: y=max(0, min(15, v(h26lin))) no high-gain op-amp loop
Bh26relu h26y 0 V = max(0, min(15, v(h26lin)))
Eh26 h26buf 0 h26y 0 1

* h27 input 1 w=-0.473232380174693 w-  bank=n alpha=1 R=70437.5582267393 G_phys=1.41969714052408e-05 G_eff=1.41969714052408e-05
Rh27n1n1 in1 h27n 68957.7368056777
* h27 input 2 w=+0.0192680774504759 w+  bank=f alpha=0.001 R=1729.97713025645 G_phys=0.000578042323514278 G_eff=5.78042323514278e-07
Rh27p2f1 inf2 h27p 1694.35871598467
* h27 input 3 w=-0.33925202928177 w-  bank=n alpha=1 R=98255.3690361212 G_phys=1.01775608784531e-05 G_eff=1.01775608784531e-05
Rh27n3n1 in3 h27n 96035.3682705131
* h27 input 4 w=+0.300608725256371 w+  bank=n alpha=1 R=110886.113850838 G_phys=9.01826175769113e-06 G_eff=9.01826175769113e-06
Rh27p4n1 in4 h27p 109350.457797219
* h27 input 5 w=-0.265937781386581 w-  bank=n alpha=1 R=125342.60141427 G_phys=7.97813344159742e-06 G_eff=7.97813344159742e-06
Rh27n5n1 in5 h27n 122516.084487745
* h27 input 6 w=-0.0714924370091341 w-  bank=n alpha=1 R=466249.784282421 G_phys=2.14477311027402e-06 G_eff=2.14477311027402e-06
Rh27n6n1 in6 h27n 456864.557187985
* h27 input 7 w=+0.32365049129675 w+  bank=n alpha=1 R=102991.758794429 G_phys=9.7095147389025e-06 G_eff=9.7095147389025e-06
Rh27p7n1 in7 h27p 101204.02579495
* h27 input 8 w=+0.264468500812474 w+  bank=n alpha=1 R=126038.954472574 G_phys=7.93405502437422e-06 G_eff=7.93405502437422e-06
Rh27p8n1 in8 h27p 123139.712120905
* h27 input 9 w=-0.251852607935664 w-  bank=n alpha=1 R=132352.543841231 G_phys=7.55557823806993e-06 G_eff=7.55557823806993e-06
Rh27n9n1 in9 h27n 129648.205834375
* h27 input 10 w=-0.0922567674902895 w-  bank=n alpha=1 R=361310.440850226 G_phys=2.76770302470868e-06 G_eff=2.76770302470868e-06
Rh27n10n1 in10 h27n 355563.131345509
* h27 input 11 w=-0.519972660308657 w-  bank=n alpha=1 R=64105.9345573026 G_phys=1.55991798092597e-05 G_eff=1.55991798092597e-05
Rh27n11n1 in11 h27n 63162.1076469437
* h27 input 12 w=+0.109096005067641 w+  bank=n alpha=1 R=305541.282768935 G_phys=3.27288015202924e-06 G_eff=3.27288015202924e-06
Rh27p12n1 in12 h27p 301236.750654382
* h27 input 13 w=+0.0733868764952063 w+  bank=n alpha=1 R=454213.817582367 G_phys=2.20160629485619e-06 G_eff=2.20160629485619e-06
Rh27p13n1 in13 h27p 447483.168617457
* h27 input 14 w=-0.779894486957924 w-  bank=n alpha=1 R=42740.8244201779 G_phys=2.33968346087377e-05 G_eff=2.33968346087377e-05
Rh27n14n1 in14 h27n 41995.2328464567
* h27 input 15 w=+0.520337169546291 w+  bank=n alpha=1 R=64061.0267423301 G_phys=1.56101150863887e-05 G_eff=1.56101150863887e-05
Rh27p15n1 in15 h27p 62585.8742919976
* h27 input 16 w=+0.00922691889455085 w+  bank=f alpha=0.001 R=3612.61800545565 G_phys=0.000276807566836526 G_eff=2.76807566836526e-07
Rh27p16f1 inf16 h27p 3559.49768663172
* h27 bias=+0.0122793649099004 b+  bank=f alpha=0.001 R=2714.58121636714 G_phys=0.000368380947297011 G_eff=3.68380947297011e-07
Rh27bpf1 vreff h27p 2665.54658646685
Vh27p h27p 0 DC 0
Vh27n h27n 0 DC 0
Fh27p 0 h27d Vh27p 1
Fh27n h27d 0 Vh27n 1
Vh27d h27d 0 DC 0
Hh27 h27raw 0 Vh27d 33333.3333333333
Eh27sc h27lin 0 h27raw 0 1
* direct bounded ReLU: y=max(0, min(15, v(h27lin))) no high-gain op-amp loop
Bh27relu h27y 0 V = max(0, min(15, v(h27lin)))
Eh27 h27buf 0 h27y 0 1

* h28 input 1 w=+0.0928477001370985 w+  bank=n alpha=1 R=359010.86708786 G_phys=2.78543100411296e-06 G_eff=2.78543100411296e-06
Rh28p1n1 in1 h28p 350780.665009753
* h28 input 2 w=+0.628866123797832 w+  bank=n alpha=1 R=53005.4523083984 G_phys=1.8865983713935e-05 G_eff=1.8865983713935e-05
Rh28p2n1 in2 h28p 51809.9419934769
* h28 input 3 w=-0.429442295580587 w-  bank=n alpha=1 R=77620.0520451022 G_phys=1.28832688674176e-05 G_eff=1.28832688674176e-05
Rh28n3n1 in3 h28n 75818.2015889138
* h28 input 4 w=+0.0390774584408687 w+  bank=n alpha=1 R=853006.686291349 G_phys=1.17232375322606e-06 G_eff=1.17232375322606e-06
Rh28p4n1 in4 h28p 836856.48639215
* h28 input 5 w=-0.500231352741198 w-  bank=n alpha=1 R=66635.8339009967 G_phys=1.50069405822359e-05 G_eff=1.50069405822359e-05
Rh28n5n1 in5 h28n 65488.6991766663
* h28 input 6 w=-0.374880121408735 w-  bank=n alpha=1 R=88917.3136416848 G_phys=1.1246403642262e-05 G_eff=1.1246403642262e-05
Rh28n6n1 in6 h28n 86887.189845855
* h28 input 7 w=-0.575469641796179 w-  bank=n alpha=1 R=57923.7042449224 G_phys=1.72640892538854e-05 G_eff=1.72640892538854e-05
Rh28n7n1 in7 h28n 57123.7902544858
* h28 input 8 w=+0.475130253886277 w+  bank=n alpha=1 R=70156.2004538479 G_phys=1.42539076165883e-05 G_eff=1.42539076165883e-05
Rh28p8n1 in8 h28p 68969.1586453106
* h28 input 9 w=-0.381841652824232 w-  bank=n alpha=1 R=87296.221056002 G_phys=1.1455249584727e-05 G_eff=1.1455249584727e-05
Rh28n9n1 in9 h28n 85322.4811781603
* h28 input 10 w=+0.758567082707225 w+  bank=n alpha=1 R=43942.4990791469 G_phys=2.27570124812167e-05 G_eff=2.27570124812167e-05
Rh28p10n1 in10 h28p 43276.3181895641
* h28 input 11 w=-0.0530277840915393 w-  bank=n alpha=1 R=628601.287125096 G_phys=1.59083352274618e-06 G_eff=1.59083352274618e-06
Rh28n11n1 in11 h28n 617083.585729498
* h28 input 12 w=+0.0401492881024246 w+  bank=n alpha=1 R=830234.729151284 G_phys=1.20447864307274e-06 G_eff=1.20447864307274e-06
Rh28p12n1 in12 h28p 813721.344837236
* h28 input 13 w=-0.344979802042177 w-  bank=n alpha=1 R=96624.0143220269 G_phys=1.03493940612653e-05 G_eff=1.03493940612653e-05
Rh28n13n1 in13 h28n 94811.4645054803
* h28 input 14 w=+0.139059200435423 w+  bank=n alpha=1 R=239706.062086937 G_phys=4.1717760130627e-06 G_eff=4.1717760130627e-06
Rh28p14n1 in14 h28p 236446.647614479
* h28 input 15 w=-0.317012120275182 w-  bank=n alpha=1 R=105148.450804967 G_phys=9.51036360825546e-06 G_eff=9.51036360825546e-06
Rh28n15n1 in15 h28n 103636.275019464
* h28 input 16 w=-0.398313118116402 w-  bank=n alpha=1 R=83686.2554037001 G_phys=1.1949393543492e-05 G_eff=1.1949393543492e-05
Rh28n16n1 in16 h28n 82425.0977060821
* h28 bias=-0.0847668662328426 b-  bank=n alpha=1 R=393235.409243175 G_phys=2.54300598698528e-06 G_eff=2.54300598698528e-06
Rh28bnn1 vref h28n 384876.320877434
Vh28p h28p 0 DC 0
Vh28n h28n 0 DC 0
Fh28p 0 h28d Vh28p 1
Fh28n h28d 0 Vh28n 1
Vh28d h28d 0 DC 0
Hh28 h28raw 0 Vh28d 33333.3333333333
Eh28sc h28lin 0 h28raw 0 1
* direct bounded ReLU: y=max(0, min(15, v(h28lin))) no high-gain op-amp loop
Bh28relu h28y 0 V = max(0, min(15, v(h28lin)))
Eh28 h28buf 0 h28y 0 1

* h29 input 1 w=+0.125932002984804 w+  bank=n alpha=1 R=264693.108529018 G_phys=3.77796008954411e-06 G_eff=3.77796008954411e-06
Rh29p1n1 in1 h29p 260248.542558147
* h29 input 2 w=-0.650061827874195 w-  bank=n alpha=1 R=51277.1738072033 G_phys=1.95018548362258e-05 G_eff=1.95018548362258e-05
Rh29n2n1 in2 h29n 50393.9320424527
* h29 input 3 w=-0.0394473233812264 w-  bank=n alpha=1 R=845008.747772155 G_phys=1.18341970143679e-06 G_eff=1.18341970143679e-06
Rh29n3n1 in3 h29n 832516.904481011
* h29 input 4 w=-0.231823015010513 w-  bank=n alpha=1 R=143787.85183094 G_phys=6.9546904503154e-06 G_eff=6.9546904503154e-06
Rh29n4n1 in4 h29n 141254.051017653
* h29 input 5 w=+0.19053303604273 w+  bank=n alpha=1 R=174947.788717637 G_phys=5.71599108128189e-06 G_eff=5.71599108128189e-06
Rh29p5n1 in5 h29p 171476.486278336
* h29 input 6 w=+0.447719174196915 w+  bank=n alpha=1 R=74451.4312864178 G_phys=1.34315752259074e-05 G_eff=1.34315752259074e-05
Rh29p6n1 in6 h29p 73341.6376137411
* h29 input 7 w=+0.0126486175371352 w+  bank=f alpha=0.001 R=2635.33411738237 G_phys=0.000379458526114055 G_eff=3.79458526114055e-07
Rh29p7f1 inf7 h29p 2589.93881242647
* h29 input 8 w=+0.108364236263017 w+  bank=n alpha=1 R=307604.561088107 G_phys=3.25092708789052e-06 G_eff=3.25092708789052e-06
Rh29p8n1 in8 h29p 300751.488110446
* h29 input 9 w=+0.430118110319429 w+  bank=n alpha=1 R=77498.0930437414 G_phys=1.29035433095829e-05 G_eff=1.29035433095829e-05
Rh29p9n1 in9 h29p 76386.8983445961
* h29 input 10 w=+0.849664650654267 w+  bank=n alpha=1 R=39231.1640924048 G_phys=2.5489939519628e-05 G_eff=2.5489939519628e-05
Rh29p10n1 in10 h29p 38333.2369270417
* h29 input 11 w=+0.430581993177771 w+  bank=n alpha=1 R=77414.6013104902 G_phys=1.29174597953331e-05 G_eff=1.29174597953331e-05
Rh29p11n1 in11 h29p 76185.398305942
* h29 input 12 w=-0.974573192285427 w-  bank=n alpha=1 R=34203.006605553 G_phys=2.92371957685628e-05 G_eff=2.92371957685628e-05
Rh29n12n1 in12 h29n 33424.5134432786
* h29 input 13 w=+0.16029064712382 w+  bank=n alpha=1 R=207955.572776396 G_phys=4.80871941371461e-06 G_eff=4.80871941371461e-06
Rh29p13n1 in13 h29p 204754.47747995
* h29 input 14 w=+0.466636118473806 w+  bank=n alpha=1 R=71433.2474784727 G_phys=1.39990835542142e-05 G_eff=1.39990835542142e-05
Rh29p14n1 in14 h29p 70050.3075302425
* h29 input 15 w=-0.0331745755104183 w-  bank=f alpha=0.001 R=1004.78552688233 G_phys=0.000995237265312548 G_eff=9.95237265312548e-07
Rh29n15f1 inf15 h29n 984.880657057267
* h29 input 16 w=-0.589046477086867 w-  bank=n alpha=1 R=56588.6303202822 G_phys=1.7671394312606e-05 G_eff=1.7671394312606e-05
Rh29n16n1 in16 h29n 55685.7336238613
* h29 bias=-0.0665836653392507 b-  bank=n alpha=1 R=500623.285959049 G_phys=1.99750996017752e-06 G_eff=1.99750996017752e-06
Rh29bnn1 vref h29n 493616.374146563
Vh29p h29p 0 DC 0
Vh29n h29n 0 DC 0
Fh29p 0 h29d Vh29p 1
Fh29n h29d 0 Vh29n 1
Vh29d h29d 0 DC 0
Hh29 h29raw 0 Vh29d 33333.3333333333
Eh29sc h29lin 0 h29raw 0 1
* direct bounded ReLU: y=max(0, min(15, v(h29lin))) no high-gain op-amp loop
Bh29relu h29y 0 V = max(0, min(15, v(h29lin)))
Eh29 h29buf 0 h29y 0 1

* h30 input 1 w=-0.507901838841989 w-  bank=n alpha=1 R=65629.4795256756 G_phys=1.52370551652597e-05 G_eff=1.52370551652597e-05
Rh30n1n1 in1 h30n 64539.718406925
* h30 input 2 w=-0.0392944483392576 w-  bank=n alpha=1 R=848296.254105474 G_phys=1.17883345017773e-06 G_eff=1.17883345017773e-06
Rh30n2n1 in2 h30n 832875.714021703
* h30 input 3 w=+0.205776196534446 w+  bank=n alpha=1 R=161988.285791615 G_phys=6.17328589603337e-06 G_eff=6.17328589603337e-06
Rh30p3n1 in3 h30p 159067.142280728
* h30 input 4 w=+0.172383143604269 w+  bank=n alpha=1 R=193367.707749053 G_phys=5.17149430812806e-06 G_eff=5.17149430812806e-06
Rh30p4n1 in4 h30p 189806.268412217
* h30 input 5 w=-0.0737740397875715 w-  bank=n alpha=1 R=451830.121128177 G_phys=2.21322119362714e-06 G_eff=2.21322119362714e-06
Rh30n5n1 in5 h30n 442945.948449483
* h30 input 6 w=-0.113337981854853 w-  bank=n alpha=1 R=294105.583916448 G_phys=3.40013945564559e-06 G_eff=3.40013945564559e-06
Rh30n6n1 in6 h30n 287582.489670841
* h30 input 7 w=-0.199472534274412 w-  bank=n alpha=1 R=167107.383753781 G_phys=5.98417602823235e-06 G_eff=5.98417602823235e-06
Rh30n7n1 in7 h30n 164434.306787469
* h30 input 8 w=+0.667476408484971 w+  bank=n alpha=1 R=49939.3430383448 G_phys=2.00242922545491e-05 G_eff=2.00242922545491e-05
Rh30p8n1 in8 h30p 49122.6377058222
* h30 input 9 w=+0.0327305955718174 w+  bank=f alpha=0.001 R=1018.41511744549 G_phys=0.000981917867154523 G_eff=9.81917867154523e-07
Rh30p9f1 inf9 h30p 1000.18493993474
* h30 input 10 w=-0.112124407230259 w-  bank=n alpha=1 R=297288.825481859 G_phys=3.36373221690776e-06 G_eff=3.36373221690776e-06
Rh30n10n1 in10 h30n 292609.702630971
* h30 input 11 w=+0.283868618501327 w+  bank=n alpha=1 R=117425.214204076 G_phys=8.51605855503981e-06 G_eff=8.51605855503981e-06
Rh30p11n1 in11 h30p 115325.376676996
* h30 input 12 w=-0.058671072800694 w-  bank=n alpha=1 R=568139.148342606 G_phys=1.76013218402082e-06 G_eff=1.76013218402082e-06
Rh30n12n1 in12 h30n 558378.238030749
* h30 input 13 w=-0.679698898194489 w-  bank=n alpha=1 R=49041.323182777 G_phys=2.03909669458347e-05 G_eff=2.03909669458347e-05
Rh30n13n1 in13 h30n 48153.3213178926
* h30 input 14 w=+0.213421552049108 w+  bank=n alpha=1 R=156185.413390975 G_phys=6.40264656147323e-06 G_eff=6.40264656147323e-06
Rh30p14n1 in14 h30p 152528.144067435
* h30 input 15 w=+0.353043376484901 w+  bank=n alpha=1 R=94417.1043944198 G_phys=1.0591301294547e-05 G_eff=1.0591301294547e-05
Rh30p15n1 in15 h30p 93042.1241566328
* h30 input 16 w=-0.0402310971621178 w-  bank=n alpha=1 R=828546.464915216 G_phys=1.20693291486354e-06 G_eff=1.20693291486354e-06
Rh30n16n1 in16 h30n 816929.388745353
* h30 bias=+0.0283807691184238 b+  bank=f alpha=0.001 R=1174.50422834716 G_phys=0.000851423073552715 G_eff=8.51423073552714e-07
Rh30bpf1 vreff h30p 1148.58505091133
Vh30p h30p 0 DC 0
Vh30n h30n 0 DC 0
Fh30p 0 h30d Vh30p 1
Fh30n h30d 0 Vh30n 1
Vh30d h30d 0 DC 0
Hh30 h30raw 0 Vh30d 33333.3333333333
Eh30sc h30lin 0 h30raw 0 1
* direct bounded ReLU: y=max(0, min(15, v(h30lin))) no high-gain op-amp loop
Bh30relu h30y 0 V = max(0, min(15, v(h30lin)))
Eh30 h30buf 0 h30y 0 1

* h31 input 1 w=+0.786523739677983 w+  bank=n alpha=1 R=42380.5813502598 G_phys=2.35957121903395e-05 G_eff=2.35957121903395e-05
Rh31p1n1 in1 h31p 41790.5462773695
* h31 input 2 w=+0.575951127580127 w+  bank=n alpha=1 R=57875.2809693839 G_phys=1.72785338274038e-05 G_eff=1.72785338274038e-05
Rh31p2n1 in2 h31p 57006.6104592415
* h31 input 3 w=+0.131568206508636 w+  bank=n alpha=1 R=253354.014756941 G_phys=3.94704619525908e-06 G_eff=3.94704619525908e-06
Rh31p3n1 in3 h31p 248493.068021746
* h31 input 4 w=+0.217046331869883 w+  bank=n alpha=1 R=153577.040653773 G_phys=6.51138995609649e-06 G_eff=6.51138995609649e-06
Rh31p4n1 in4 h31p 151398.746508643
* h31 input 5 w=+0.0670548023806797 w+  bank=n alpha=1 R=497105.832093803 G_phys=2.01164407142039e-06 G_eff=2.01164407142039e-06
Rh31p5n1 in5 h31p 485644.042497463
* h31 input 6 w=-0.0924541633789126 w-  bank=n alpha=1 R=360539.018634786 G_phys=2.77362490136738e-06 G_eff=2.77362490136738e-06
Rh31n6n1 in6 h31n 352362.870259616
* h31 input 7 w=+0.532768880755568 w+  bank=n alpha=1 R=62566.2168669842 G_phys=1.59830664226671e-05 G_eff=1.59830664226671e-05
Rh31p7n1 in7 h31p 61206.5910698666
* h31 input 8 w=-0.213038536483163 w-  bank=n alpha=1 R=156466.214439883 G_phys=6.39115609449489e-06 G_eff=6.39115609449489e-06
Rh31n8n1 in8 h31n 153418.319735585
* h31 input 9 w=+0.217996086164886 w+  bank=n alpha=1 R=152907.943989971 G_phys=6.53988258494657e-06 G_eff=6.53988258494657e-06
Rh31p9n1 in9 h31p 149650.461671457
* h31 input 10 w=-0.173189336412784 w-  bank=n alpha=1 R=192467.58503587 G_phys=5.19568009238351e-06 G_eff=5.19568009238351e-06
Rh31n10n1 in10 h31n 188298.251522823
* h31 input 11 w=+0.227561810267943 w+  bank=n alpha=1 R=146480.348763639 G_phys=6.8268543080383e-06 G_eff=6.8268543080383e-06
Rh31p11n1 in11 h31p 143522.883427899
* h31 input 12 w=+0.400647928830177 w+  bank=n alpha=1 R=83198.5664587384 G_phys=1.20194378649053e-05 G_eff=1.20194378649053e-05
Rh31p12n1 in12 h31p 81699.4938339373
* h31 input 13 w=+0.0924404555732517 w+  bank=n alpha=1 R=360592.482226781 G_phys=2.77321366719755e-06 G_eff=2.77321366719755e-06
Rh31p13n1 in13 h31p 354353.683618204
* h31 input 14 w=+0.340918137300815 w+  bank=n alpha=1 R=97775.1832074605 G_phys=1.02275441190244e-05 G_eff=1.02275441190244e-05
Rh31p14n1 in14 h31p 96254.3407780842
* h31 input 15 w=+0.631456773568415 w+  bank=n alpha=1 R=52787.9891840638 G_phys=1.89437032070525e-05 G_eff=1.89437032070525e-05
Rh31p15n1 in15 h31p 51966.2782212435
* h31 input 16 w=+0.19173700817347 w+  bank=n alpha=1 R=173849.240951834 G_phys=5.75211024520409e-06 G_eff=5.75211024520409e-06
Rh31p16n1 in16 h31p 170831.722129047
* h31 bias=-0.0537174074345555 b-  bank=n alpha=1 R=620531.31238591 G_phys=1.61152222303666e-06 G_eff=1.61152222303666e-06
Rh31bnn1 vref h31n 606463.934552312
Vh31p h31p 0 DC 0
Vh31n h31n 0 DC 0
Fh31p 0 h31d Vh31p 1
Fh31n h31d 0 Vh31n 1
Vh31d h31d 0 DC 0
Hh31 h31raw 0 Vh31d 33333.3333333333
Eh31sc h31lin 0 h31raw 0 1
* direct bounded ReLU: y=max(0, min(15, v(h31lin))) no high-gain op-amp loop
Bh31relu h31y 0 V = max(0, min(15, v(h31lin)))
Eh31 h31buf 0 h31y 0 1

* h32 input 1 w=+0.018363806586789 w+  bank=f alpha=0.001 R=1815.16469234181 G_phys=0.000550914197603669 G_eff=5.50914197603669e-07
Rh32p1f1 inf1 h32p 1785.23215523441
* h32 input 2 w=+0.274234487929714 w+  bank=n alpha=1 R=121550.478880237 G_phys=8.22703463789143e-06 G_eff=8.22703463789143e-06
Rh32p2n1 in2 h32p 118868.657466996
* h32 input 3 w=+0.286642259390481 w+  bank=n alpha=1 R=116288.970803585 G_phys=8.59926778171444e-06 G_eff=8.59926778171444e-06
Rh32p3n1 in3 h32p 114508.969059357
* h32 input 4 w=-0.106012181190002 w-  bank=n alpha=1 R=314429.275571559 G_phys=3.18036543570007e-06 G_eff=3.18036543570007e-06
Rh32n4n1 in4 h32n 308909.299921333
* h32 input 5 w=-0.539184466126997 w-  bank=n alpha=1 R=61821.7612476287 G_phys=1.61755339838099e-05 G_eff=1.61755339838099e-05
Rh32n5n1 in5 h32n 60922.8707729304
* h32 input 6 w=-0.141969883388357 w-  bank=n alpha=1 R=234791.580705539 G_phys=4.25909650165071e-06 G_eff=4.25909650165071e-06
Rh32n6n1 in6 h32n 229566.561583985
* h32 input 7 w=-0.343812430494534 w-  bank=n alpha=1 R=96952.0889206571 G_phys=1.0314372914836e-05 G_eff=1.0314372914836e-05
Rh32n7n1 in7 h32n 94769.3131839224
* h32 input 8 w=-0.197072814561277 w-  bank=n alpha=1 R=169142.219882229 G_phys=5.91218443683832e-06 G_eff=5.91218443683832e-06
Rh32n8n1 in8 h32n 165298.916261247
* h32 input 9 w=-0.180430465047897 w-  bank=n alpha=1 R=184743.376482927 G_phys=5.41291395143692e-06 G_eff=5.41291395143692e-06
Rh32n9n1 in9 h32n 181522.094080308
* h32 input 10 w=+0.113268490856906 w+  bank=n alpha=1 R=294286.019714378 G_phys=3.39805472570718e-06 G_eff=3.39805472570718e-06
Rh32p10n1 in10 h32p 289899.18424979
* h32 input 11 w=+0.0737822862098911 w+  bank=n alpha=1 R=451779.621446112 G_phys=2.21346858629673e-06 G_eff=2.21346858629673e-06
Rh32p11n1 in11 h32p 442512.077618233
* h32 input 12 w=+0.131260687318804 w+  bank=n alpha=1 R=253947.575730529 G_phys=3.93782061956414e-06 G_eff=3.93782061956414e-06
Rh32p12n1 in12 h32p 249734.500248864
* h32 input 13 w=-0.105796213840622 w-  bank=n alpha=1 R=315071.136511074 G_phys=3.17388641521865e-06 G_eff=3.17388641521865e-06
Rh32n13n1 in13 h32n 307798.77970671
* h32 input 14 w=-0.365435123738796 w-  bank=n alpha=1 R=91215.4611529876 G_phys=1.09630537121639e-05 G_eff=1.09630537121639e-05
Rh32n14n1 in14 h32n 89134.1815329562
* h32 input 15 w=-0.0205558893905 w-  bank=f alpha=0.001 R=1621.59528591055 G_phys=0.000616676681714999 G_eff=6.16676681714999e-07
Rh32n15f1 inf15 h32n 1596.06151903686
* h32 input 16 w=-0.212152037098157 w-  bank=n alpha=1 R=157120.024814614 G_phys=6.36456111294471e-06 G_eff=6.36456111294471e-06
Rh32n16n1 in16 h32n 153961.165484834
* h32 bias=+0.00806132622522946 b+  bank=f alpha=0.001 R=4134.96891231251 G_phys=0.000241839786756884 G_eff=2.41839786756884e-07
Rh32bpf1 vreff h32p 4046.42482932591
Vh32p h32p 0 DC 0
Vh32n h32n 0 DC 0
Fh32p 0 h32d Vh32p 1
Fh32n h32d 0 Vh32n 1
Vh32d h32d 0 DC 0
Hh32 h32raw 0 Vh32d 33333.3333333333
Eh32sc h32lin 0 h32raw 0 1
* direct bounded ReLU: y=max(0, min(15, v(h32lin))) no high-gain op-amp loop
Bh32relu h32y 0 V = max(0, min(15, v(h32lin)))
Eh32 h32buf 0 h32y 0 1

Rdivh1a h1buf htap1 970214.418558395
Rdivh1b htap1 0 964.099629142184
Edivh1 h1f 0 htap1 0 1
Rdivh2a h2buf htap2 968919.912903311
Rdivh2b htap2 0 966.580328221394
Edivh2 h2f 0 htap2 0 1
Rdivh3a h3buf htap3 966124.82584452
Rdivh3b htap3 0 970.416255661837
Edivh3 h3f 0 htap3 0 1
Rdivh4a h4buf htap4 967056.491585536
Rdivh4b htap4 0 965.931451064658
Edivh4 h4f 0 htap4 0 1
Rdivh5a h5buf htap5 968997.880708159
Rdivh5b htap5 0 973.518785972673
Edivh5 h5f 0 htap5 0 1
Rdivh6a h6buf htap6 963529.071058546
Rdivh6b htap6 0 971.774303229378
Edivh6 h6f 0 htap6 0 1
Rdivh7a h7buf htap7 971353.015804312
Rdivh7b htap7 0 973.664885377121
Edivh7 h7f 0 htap7 0 1
Rdivh8a h8buf htap8 971090.156374839
Rdivh8b htap8 0 967.846750476091
Edivh8 h8f 0 htap8 0 1
Rdivh9a h9buf htap9 971499.637657914
Rdivh9b htap9 0 972.369572524715
Edivh9 h9f 0 htap9 0 1
Rdivh10a h10buf htap10 971604.247174754
Rdivh10b htap10 0 967.635974037941
Edivh10 h10f 0 htap10 0 1
Rdivh11a h11buf htap11 971269.488421243
Rdivh11b htap11 0 973.565529231103
Edivh11 h11f 0 htap11 0 1
Rdivh12a h12buf htap12 966829.755654456
Rdivh12b htap12 0 968.058400694204
Edivh12 h12f 0 htap12 0 1
Rdivh13a h13buf htap13 969023.135624819
Rdivh13b htap13 0 963.898520257509
Edivh13 h13f 0 htap13 0 1
Rdivh14a h14buf htap14 968568.403876935
Rdivh14b htap14 0 972.158224095596
Edivh14 h14f 0 htap14 0 1
Rdivh15a h15buf htap15 966166.60153016
Rdivh15b htap15 0 973.279384942423
Edivh15 h15f 0 htap15 0 1
Rdivh16a h16buf htap16 971209.561506683
Rdivh16b htap16 0 969.445033232684
Edivh16 h16f 0 htap16 0 1
Rdivh17a h17buf htap17 967060.899728889
Rdivh17b htap17 0 968.294496393394
Edivh17 h17f 0 htap17 0 1
Rdivh18a h18buf htap18 972421.991239533
Rdivh18b htap18 0 970.041144304435
Edivh18 h18f 0 htap18 0 1
Rdivh19a h19buf htap19 968086.028543965
Rdivh19b htap19 0 966.535592852116
Edivh19 h19f 0 htap19 0 1
Rdivh20a h20buf htap20 964877.420500194
Rdivh20b htap20 0 968.241339227425
Edivh20 h20f 0 htap20 0 1
Rdivh21a h21buf htap21 972315.493902798
Rdivh21b htap21 0 966.08701867279
Edivh21 h21f 0 htap21 0 1
Rdivh22a h22buf htap22 964561.426738794
Rdivh22b htap22 0 967.15745948766
Edivh22 h22f 0 htap22 0 1
Rdivh23a h23buf htap23 964565.462403217
Rdivh23b htap23 0 967.482865083762
Edivh23 h23f 0 htap23 0 1
Rdivh24a h24buf htap24 964051.675068402
Rdivh24b htap24 0 968.633492158314
Edivh24 h24f 0 htap24 0 1
Rdivh25a h25buf htap25 963463.134011509
Rdivh25b htap25 0 964.881512370816
Edivh25 h25f 0 htap25 0 1
Rdivh26a h26buf htap26 969933.559045522
Rdivh26b htap26 0 973.110232134739
Edivh26 h26f 0 htap26 0 1
Rdivh27a h27buf htap27 971161.654508509
Rdivh27b htap27 0 968.89875047932
Edivh27 h27f 0 htap27 0 1
Rdivh28a h28buf htap28 968082.339515465
Rdivh28b htap28 0 969.222800626944
Edivh28 h28f 0 htap28 0 1
Rdivh29a h29buf htap29 965816.48042094
Rdivh29b htap29 0 973.401533803171
Edivh29 h29f 0 htap29 0 1
Rdivh30a h30buf htap30 964787.792553433
Rdivh30b htap30 0 972.723413752374
Edivh30 h30f 0 htap30 0 1
Rdivh31a h31buf htap31 967236.06142826
Rdivh31b htap31 0 966.658122735905
Edivh31 h31f 0 htap31 0 1
Rdivh32a h32buf htap32 972538.18736604
Rdivh32b htap32 0 973.162910667126
Edivh32 h32f 0 htap32 0 1
* o1 input 1 w=+0.115109951768787 w+  bank=n alpha=1 R=289578.206064126 G_phys=3.4532985530636e-06 G_eff=3.4532985530636e-06
Ro1p1n1 h1buf o1p 281961.900845112
* o1 input 2 w=+0.416557305918275 w+  bank=n alpha=1 R=80021.0027762017 G_phys=1.24967191775482e-05 G_eff=1.24967191775482e-05
Ro1p2n1 h2buf o1p 77850.8410680523
* o1 input 3 w=+0.460762298204741 w+  bank=n alpha=1 R=72343.8820042555 G_phys=1.38228689461422e-05 G_eff=1.38228689461422e-05
Ro1p3n1 h3buf o1p 69737.5004729168
* o1 input 4 w=+0.128235529120638 w+  bank=n alpha=1 R=259938.361559493 G_phys=3.84706587361914e-06 G_eff=3.84706587361914e-06
Ro1p4n1 h4buf o1p 250853.776562142
* o1 input 5 w=+0.25946188501651 w+  bank=n alpha=1 R=128471.021210735 G_phys=7.78385655049531e-06 G_eff=7.78385655049531e-06
Ro1p5n1 h5buf o1p 124534.68043398
* o1 input 6 w=+0.0121141451968155 w+  bank=f alpha=0.001 R=2751.60424378073 G_phys=0.000363424355904464 G_eff=3.63424355904464e-07
Ro1p6f1 h6f o1p 2669.41289100466
* o1 input 7 w=-0.240253536162518 w-  bank=n alpha=1 R=138742.321406604 G_phys=7.20760608487554e-06 G_eff=7.20760608487554e-06
Ro1n7n1 h7buf o1n 134160.014233974
* o1 input 8 w=+0.187475674056081 w+  bank=n alpha=1 R=177800.845369208 G_phys=5.62427022168244e-06 G_eff=5.62427022168244e-06
Ro1p8n1 h8buf o1p 171410.96340689
* o1 input 9 w=-0.249792136720497 w-  bank=n alpha=1 R=133444.28600101 G_phys=7.4937641016149e-06 G_eff=7.4937641016149e-06
Ro1n9n1 h9buf o1n 129773.033471123
* o1 input 10 w=-0.0478130377197742 w-  bank=n alpha=1 R=697159.915433434 G_phys=1.43439113159322e-06 G_eff=1.43439113159322e-06
Ro1n10n1 h10buf o1n 674967.841586765
* o1 input 11 w=+0.103135444855694 w+  bank=n alpha=1 R=323199.588463238 G_phys=3.09406334567083e-06 G_eff=3.09406334567083e-06
Ro1p11n1 h11buf o1p 313756.340006772
* o1 input 12 w=-0.0209153710838255 w-  bank=f alpha=0.001 R=1593.72421362923 G_phys=0.000627461132514765 G_eff=6.27461132514765e-07
Ro1n12f1 h12f o1n 1543.39097840169
* o1 input 13 w=-0.0177641479719743 w-  bank=f alpha=0.001 R=1876.43862153827 G_phys=0.00053292443915923 G_eff=5.3292443915923e-07
Ro1n13f1 h13f o1n 1825.38805908156
* o1 input 14 w=-0.162077236015947 w-  bank=n alpha=1 R=205663.263717389 G_phys=4.86231708047842e-06 G_eff=4.86231708047842e-06
Ro1n14n1 h14buf o1n 198830.363300661
* o1 input 15 w=+0.156787201998635 w+  bank=n alpha=1 R=212602.386600556 G_phys=4.70361605995906e-06 G_eff=4.70361605995906e-06
Ro1p15n1 h15buf o1p 205241.2518233
* o1 input 16 w=-0.00694237968883333 w-  bank=f alpha=0.001 R=4801.42758353441 G_phys=0.000208271390665 G_eff=2.08271390665e-07
Ro1n16f1 h16f o1n 4630.90182271184
* o1 input 17 w=+0.263424706628807 w+  bank=n alpha=1 R=126538.37128612 G_phys=7.90274119886422e-06 G_eff=7.90274119886422e-06
Ro1p17n1 h17buf o1p 122636.835984237
* o1 input 18 w=+0.403807796552332 w+  bank=n alpha=1 R=82547.5229005725 G_phys=1.211423389657e-05 G_eff=1.211423389657e-05
Ro1p18n1 h18buf o1p 79865.7840339765
* o1 input 19 w=+0.415931315874452 w+  bank=n alpha=1 R=80141.4369659891 G_phys=1.24779394762336e-05 G_eff=1.24779394762336e-05
Ro1p19n1 h19buf o1p 77448.1049298534
* o1 input 20 w=+0.0719298844689274 w+  bank=n alpha=1 R=463414.248186827 G_phys=2.15789653406782e-06 G_eff=2.15789653406782e-06
Ro1p20n1 h20buf o1p 449066.60799201
* o1 input 21 w=-0.387164693396724 w-  bank=n alpha=1 R=86096.0048833198 G_phys=1.16149408019017e-05 G_eff=1.16149408019017e-05
Ro1n21n1 h21buf o1n 83358.9770982859
* o1 input 22 w=+0.13881898843949 w+  bank=n alpha=1 R=240120.848797735 G_phys=4.1645696531847e-06 G_eff=4.1645696531847e-06
Ro1p22n1 h22buf o1p 232322.109281167
* o1 input 23 w=-0.118143194098524 w-  bank=n alpha=1 R=282143.491952108 G_phys=3.54429582295573e-06 G_eff=3.54429582295573e-06
Ro1n23n1 h23buf o1n 274505.993461036
* o1 input 24 w=-0.494956544406075 w-  bank=n alpha=1 R=67345.9795815646 G_phys=1.48486963321823e-05 G_eff=1.48486963321823e-05
Ro1n24n1 h24buf o1n 65522.927812682
* o1 input 25 w=-0.0137314432186455 w-  bank=f alpha=0.001 R=2427.51856469617 G_phys=0.000411943296559366 G_eff=4.11943296559366e-07
Ro1n25f1 h25f o1n 2352.06621976964
* o1 input 26 w=+0.00762307525297978 w+  bank=f alpha=0.001 R=4372.68847901032 G_phys=0.000228692257589393 G_eff=2.28692257589393e-07
Ro1p26f1 h26f o1p 4214.58843857495
* o1 input 27 w=+0.187160704798257 w+  bank=n alpha=1 R=178100.063094247 G_phys=5.6148211439477e-06 G_eff=5.6148211439477e-06
Ro1p27n1 h27buf o1p 172572.839809805
* o1 input 28 w=+0.0939442280900053 w+  bank=n alpha=1 R=354820.450505992 G_phys=2.81832684270016e-06 G_eff=2.81832684270016e-06
Ro1p28n1 h28buf o1p 343022.451227871
* o1 input 29 w=+0.0315398664392492 w+  bank=f alpha=0.001 R=1056.86349045069 G_phys=0.000946195993177476 G_eff=9.46195993177476e-07
Ro1p29f1 h29f o1p 1019.1067072133
* o1 input 30 w=+0.183835448783735 w+  bank=n alpha=1 R=181321.576191471 G_phys=5.51506346351205e-06 G_eff=5.51506346351205e-06
Ro1p30n1 h30buf o1p 175048.860688301
* o1 input 31 w=-0.236627512253244 w-  bank=n alpha=1 R=140868.375853351 G_phys=7.09882536759733e-06 G_eff=7.09882536759733e-06
Ro1n31n1 h31buf o1n 136091.107228579
* o1 input 32 w=-0.230869865069063 w-  bank=n alpha=1 R=144381.482283805 G_phys=6.92609595207188e-06 G_eff=6.92609595207188e-06
Ro1n32n1 h32buf o1n 139967.81595889
* o1 bias=-0.0809652357124875 b-  bank=n alpha=1 R=411699.330459582 G_phys=2.42895707137462e-06 G_eff=2.42895707137462e-06
Ro1bnn1 vref o1n 397679.949773975
Vo1p o1p 0 DC 0
Vo1n o1n 0 DC 0
Fo1p 0 o1d Vo1p 1
Fo1n o1d 0 Vo1n 1
Vo1d o1d 0 DC 0
Ho1 o1raw 0 Vo1d 33333.3333333333
Eo1sc o1lin 0 o1raw 0 1

* o2 input 1 w=-0.195521390350609 w-  bank=n alpha=1 R=170484.330505015 G_phys=5.86564171051827e-06 G_eff=5.86564171051827e-06
Ro2n1n1 h1buf o2n 165456.088455462
* o2 input 2 w=+0.386445174905558 w+  bank=n alpha=1 R=86256.3061926689 G_phys=1.15933552471668e-05 G_eff=1.15933552471668e-05
Ro2p2n1 h2buf o2p 83627.3382319685
* o2 input 3 w=+0.296294588630229 w+  bank=n alpha=1 R=112500.648383197 G_phys=8.88883765890688e-06 G_eff=8.88883765890688e-06
Ro2p3n1 h3buf o2p 108742.784513452
* o2 input 4 w=-0.299308681857295 w-  bank=n alpha=1 R=111367.746256108 G_phys=8.97926045571886e-06 G_eff=8.97926045571886e-06
Ro2n4n1 h4buf o2n 107530.393352291
* o2 input 5 w=+0.732671792857329 w+  bank=n alpha=1 R=45495.5870531571 G_phys=2.19801537857199e-05 G_eff=2.19801537857199e-05
Ro2p5n1 h5buf o2p 44265.0946066365
* o2 input 6 w=+0.124925987288217 w+  bank=n alpha=1 R=266824.65399637 G_phys=3.7477796186465e-06 G_eff=3.7477796186465e-06
Ro2p6n1 h6buf o2p 259350.840845866
* o2 input 7 w=-0.0857938493267301 w-  bank=n alpha=1 R=388528.240601368 G_phys=2.5738154798019e-06 G_eff=2.5738154798019e-06
Ro2n7n1 h7buf o2n 375700.354417697
* o2 input 8 w=-0.0609936542707342 w-  bank=n alpha=1 R=546504.939438057 G_phys=1.82980962812202e-06 G_eff=1.82980962812202e-06
Ro2n8n1 h8buf o2n 529924.979102434
* o2 input 9 w=+0.256981204903229 w+  bank=n alpha=1 R=129711.172246568 G_phys=7.70943614709688e-06 G_eff=7.70943614709688e-06
Ro2p9n1 h9buf o2p 125911.108684734
* o2 input 10 w=+0.073638013162671 w+  bank=n alpha=1 R=452664.756987643 G_phys=2.20914039488013e-06 G_eff=2.20914039488013e-06
Ro2p10n1 h10buf o2p 438756.092001044
* o2 input 11 w=-0.149208279345328 w-  bank=n alpha=1 R=223401.365390634 G_phys=4.47624838035983e-06 G_eff=4.47624838035983e-06
Ro2n11n1 h11buf o2n 215621.888669743
* o2 input 12 w=-0.475362564845884 w-  bank=n alpha=1 R=70121.9149306388 G_phys=1.42608769453765e-05 G_eff=1.42608769453765e-05
Ro2n12n1 h12buf o2n 67765.1970939983
* o2 input 13 w=-0.0533811781970356 w-  bank=n alpha=1 R=624439.820535554 G_phys=1.60143534591107e-06 G_eff=1.60143534591107e-06
Ro2n13n1 h13buf o2n 606374.608055815
* o2 input 14 w=+0.279456004632752 w+  bank=n alpha=1 R=119279.359830319 G_phys=8.38368013898257e-06 G_eff=8.38368013898257e-06
Ro2p14n1 h14buf o2p 115425.700102841
* o2 input 15 w=-0.0744870090943736 w-  bank=n alpha=1 R=447505.326614748 G_phys=2.23461027283121e-06 G_eff=2.23461027283121e-06
Ro2n15n1 h15buf o2n 433353.831573953
* o2 input 16 w=-0.0222148593491043 w-  bank=f alpha=0.001 R=1500.49715865869 G_phys=0.000666445780473128 G_eff=6.66445780473128e-07
Ro2n16f1 h16f o2n 1459.54171059565
* o2 input 17 w=+0.0088751960388594 w+  bank=f alpha=0.001 R=3755.78558348297 G_phys=0.000266255881165782 G_eff=2.66255881165782e-07
Ro2p17f1 h17f o2p 3646.92142366397
* o2 input 18 w=-0.194172060066752 w-  bank=n alpha=1 R=171669.051262443 G_phys=5.82516180200256e-06 G_eff=5.82516180200256e-06
Ro2n18n1 h18buf o2n 165854.730041014
* o2 input 19 w=+0.341327626188232 w+  bank=n alpha=1 R=97657.8828546125 G_phys=1.0239828785647e-05 G_eff=1.0239828785647e-05
Ro2p19n1 h19buf o2p 94511.5883439441
* o2 input 20 w=-0.0323870183321868 w-  bank=f alpha=0.001 R=1029.21896024637 G_phys=0.000971610549965604 G_eff=9.71610549965604e-07
Ro2n20f1 h20f o2n 996.781746298578
* o2 input 21 w=-0.0999542141187652 w-  bank=n alpha=1 R=333486.022847689 G_phys=2.99862642356296e-06 G_eff=2.99862642356296e-06
Ro2n21n1 h21buf o2n 324722.512500052
* o2 input 22 w=+0.693789300406694 w+  bank=n alpha=1 R=48045.3263170729 G_phys=2.08136790122008e-05 G_eff=2.08136790122008e-05
Ro2p22n1 h22buf o2p 46549.1346020847
* o2 input 23 w=+0.0972685864670828 w+  bank=n alpha=1 R=342693.715864925 G_phys=2.91805759401248e-06 G_eff=2.91805759401248e-06
Ro2p23n1 h23buf o2p 332995.700874289
* o2 input 24 w=-0.0293783170287994 w-  bank=f alpha=0.001 R=1134.6236512002 G_phys=0.000881349510863982 G_eff=8.81349510863982e-07
Ro2n24f1 h24f o2n 1102.19680095496
* o2 input 25 w=+0.0497492024826392 w+  bank=n alpha=1 R=670027.491294269 G_phys=1.49247607447918e-06 G_eff=1.49247607447918e-06
Ro2p25n1 h25buf o2p 646168.93819689
* o2 input 26 w=-0.466063512962686 w-  bank=n alpha=1 R=71521.0103477937 G_phys=1.39819053888806e-05 G_eff=1.39819053888806e-05
Ro2n26n1 h26buf o2n 69185.3496692173
* o2 input 27 w=+0.194887582685885 w+  bank=n alpha=1 R=171038.774630702 G_phys=5.84662748057655e-06 G_eff=5.84662748057655e-06
Ro2p27n1 h27buf o2p 165995.58547123
* o2 input 28 w=+0.209047565197081 w+  bank=n alpha=1 R=159453.344036359 G_phys=6.27142695591242e-06 G_eff=6.27142695591242e-06
Ro2p28n1 h28buf o2p 154726.419603654
* o2 input 29 w=+0.00919963467526149 w+  bank=f alpha=0.001 R=3623.33228546229 G_phys=0.000275989040257845 G_eff=2.75989040257845e-07
Ro2p29f1 h29f o2p 3513.66066099225
* o2 input 30 w=-0.379437042796868 w-  bank=n alpha=1 R=87849.4442388387 G_phys=1.13831112839061e-05 G_eff=1.13831112839061e-05
Ro2n30n1 h30buf o2n 84907.3171834996
* o2 input 31 w=-0.216631724491884 w-  bank=n alpha=1 R=153870.96885979 G_phys=6.49895173475653e-06 G_eff=6.49895173475653e-06
Ro2n31n1 h31buf o2n 148766.223217985
* o2 input 32 w=+0.139103822260271 w+  bank=n alpha=1 R=239629.169002738 G_phys=4.17311466780814e-06 G_eff=4.17311466780814e-06
Ro2p32n1 h32buf o2p 231569.842290753
* o2 bias=+0.0322130531942455 b+  bank=f alpha=0.001 R=1034.77721072674 G_phys=0.000966391595827364 G_eff=9.66391595827364e-07
Ro2bpf1 vreff o2p 1003.81093576251
Vo2p o2p 0 DC 0
Vo2n o2n 0 DC 0
Fo2p 0 o2d Vo2p 1
Fo2n o2d 0 Vo2n 1
Vo2d o2d 0 DC 0
Ho2 o2raw 0 Vo2d 33333.3333333333
Eo2sc o2lin 0 o2raw 0 1

* o3 input 1 w=-0.100595944434035 w-  bank=n alpha=1 R=331358.620080271 G_phys=3.01787833302104e-06 G_eff=3.01787833302104e-06
Ro3n1n1 h1buf o3n 321898.900531998
* o3 input 2 w=-0.265315115107159 w-  bank=n alpha=1 R=125636.767132058 G_phys=7.95945345321476e-06 G_eff=7.95945345321476e-06
Ro3n2n1 h2buf o3n 121557.55908155
* o3 input 3 w=-0.0591677372187977 w-  bank=n alpha=1 R=563370.088162562 G_phys=1.77503211656393e-06 G_eff=1.77503211656393e-06
Ro3n3n1 h3buf o3n 545370.672718387
* o3 input 4 w=-0.0695954531730398 w-  bank=n alpha=1 R=478958.492452868 G_phys=2.08786359519119e-06 G_eff=2.08786359519119e-06
Ro3n4n1 h4buf o3n 464924.85684915
* o3 input 5 w=-0.284313347850547 w-  bank=n alpha=1 R=117241.53503639 G_phys=8.52940043551641e-06 G_eff=8.52940043551641e-06
Ro3n5n1 h5buf o3n 113745.930538306
* o3 input 6 w=+0.314440272159438 w+  bank=n alpha=1 R=106008.473737841 G_phys=9.43320816478313e-06 G_eff=9.43320816478313e-06
Ro3p6n1 h6buf o3p 103187.185679869
* o3 input 7 w=-0.349535009995164 w-  bank=n alpha=1 R=95364.7914519193 G_phys=1.04860502998549e-05 G_eff=1.04860502998549e-05
Ro3n7n1 h7buf o3n 91917.7321302066
* o3 input 8 w=-0.295696300813859 w-  bank=n alpha=1 R=112728.273034152 G_phys=8.87088902441576e-06 G_eff=8.87088902441576e-06
Ro3n8n1 h8buf o3n 109003.692768613
* o3 input 9 w=-0.735854867565559 w-  bank=n alpha=1 R=45298.7875769723 G_phys=2.20756460269668e-05 G_eff=2.20756460269668e-05
Ro3n9n1 h9buf o3n 43933.1042962417
* o3 input 10 w=-0.0859238760568894 w-  bank=n alpha=1 R=387940.289277262 G_phys=2.57771628170668e-06 G_eff=2.57771628170668e-06
Ro3n10n1 h10buf o3n 376662.994409506
* o3 input 11 w=-0.105996934570411 w-  bank=n alpha=1 R=314474.503139436 G_phys=3.17990803711233e-06 G_eff=3.17990803711233e-06
Ro3n11n1 h11buf o3n 304817.222027854
* o3 input 12 w=-0.193541479603888 w-  bank=n alpha=1 R=172228.36883109 G_phys=5.80624438811663e-06 G_eff=5.80624438811663e-06
Ro3n12n1 h12buf o3n 166428.226351375
* o3 input 13 w=-0.351950930756974 w-  bank=n alpha=1 R=94710.172414206 G_phys=1.05585279227092e-05 G_eff=1.05585279227092e-05
Ro3n13n1 h13buf o3n 91699.6496732573
* o3 input 14 w=+0.0402342325324318 w+  bank=n alpha=1 R=828481.898007229 G_phys=1.20702697597296e-06 G_eff=1.20702697597296e-06
Ro3p14n1 h14buf o3p 801863.516744989
* o3 input 15 w=+0.188158881095559 w+  bank=n alpha=1 R=177155.248475381 G_phys=5.64476643286676e-06 G_eff=5.64476643286676e-06
Ro3p15n1 h15buf o3p 172447.016666075
* o3 input 16 w=+0.204693314484602 w+  bank=n alpha=1 R=162845.246886853 G_phys=6.14079943453807e-06 G_eff=6.14079943453807e-06
Ro3p16n1 h16buf o3p 158119.800818504
* o3 input 17 w=+0.153640089266272 w+  bank=n alpha=1 R=216957.263514496 G_phys=4.60920267798816e-06 G_eff=4.60920267798816e-06
Ro3p17n1 h17buf o3p 209259.554919675
* o3 input 18 w=+0.463153650429953 w+  bank=n alpha=1 R=71970.3564948468 G_phys=1.38946095128986e-05 G_eff=1.38946095128986e-05
Ro3p18n1 h18buf o3p 69724.1721219057
* o3 input 19 w=-0.0426705918571366 w-  bank=n alpha=1 R=781178.134227318 G_phys=1.2801177557141e-06 G_eff=1.2801177557141e-06
Ro3n19n1 h19buf o3n 755436.508262363
* o3 input 20 w=+0.210331327799834 w+  bank=n alpha=1 R=158480.116500076 G_phys=6.30993983399502e-06 G_eff=6.30993983399502e-06
Ro3p20n1 h20buf o3p 153180.706827806
* o3 input 21 w=-0.0625815721904128 w-  bank=n alpha=1 R=532638.157953466 G_phys=1.87744716571238e-06 G_eff=1.87744716571238e-06
Ro3n21n1 h21buf o3n 514005.843272968
* o3 input 22 w=+0.238697201684848 w+  bank=n alpha=1 R=139646.938037185 G_phys=7.16091605054544e-06 G_eff=7.16091605054544e-06
Ro3p22n1 h22buf o3p 135061.229803671
* o3 input 23 w=-0.0558624260671465 w-  bank=n alpha=1 R=596704.004463873 G_phys=1.67587278201439e-06 G_eff=1.67587278201439e-06
Ro3n23n1 h23buf o3n 577042.727559996
* o3 input 24 w=+0.439236044835332 w+  bank=n alpha=1 R=75889.3395140872 G_phys=1.317708134506e-05 G_eff=1.317708134506e-05
Ro3p24n1 h24buf o3p 73482.8913363545
* o3 input 25 w=+0.113742741787302 w+  bank=n alpha=1 R=293058.992684265 G_phys=3.41228225361907e-06 G_eff=3.41228225361907e-06
Ro3p25n1 h25buf o3p 283076.086924933
* o3 input 26 w=-0.433617266896606 w-  bank=n alpha=1 R=76872.7075190056 G_phys=1.30085180068982e-05 G_eff=1.30085180068982e-05
Ro3n26n1 h26buf o3n 74654.161159394
* o3 input 27 w=+0.230315174630548 w+  bank=n alpha=1 R=144729.210252012 G_phys=6.90945523891643e-06 G_eff=6.90945523891643e-06
Ro3p27n1 h27buf o3p 140479.810760978
* o3 input 28 w=-0.12398109066818 w-  bank=n alpha=1 R=268858.203728388 G_phys=3.71943272004541e-06 G_eff=3.71943272004541e-06
Ro3n28n1 h28buf o3n 261113.22833476
* o3 input 29 w=-0.26178305647614 w-  bank=n alpha=1 R=127331.897572108 G_phys=7.85349169428421e-06 G_eff=7.85349169428421e-06
Ro3n29n1 h29buf o3n 123634.100274323
* o3 input 30 w=-0.44647126763401 w-  bank=n alpha=1 R=74659.5262668906 G_phys=1.33941380290203e-05 G_eff=1.33941380290203e-05
Ro3n30n1 h30buf o3n 72658.2312495575
* o3 input 31 w=-0.53039390006668 w-  bank=n alpha=1 R=62846.3738537392 G_phys=1.59118170020004e-05 G_eff=1.59118170020004e-05
Ro3n31n1 h31buf o3n 60685.5222264361
* o3 input 32 w=+0.288818654520262 w+  bank=n alpha=1 R=115412.674394946 G_phys=8.66455963560785e-06 G_eff=8.66455963560785e-06
Ro3p32n1 h32buf o3p 111295.779878499
* o3 bias=+0.0635007025703613 b+  bank=n alpha=1 R=524928.575339756 G_phys=1.90502107711084e-06 G_eff=1.90502107711084e-06
Ro3bpn1 vref o3p 509001.912093144
Vo3p o3p 0 DC 0
Vo3n o3n 0 DC 0
Fo3p 0 o3d Vo3p 1
Fo3n o3d 0 Vo3n 1
Vo3d o3d 0 DC 0
Ho3 o3raw 0 Vo3d 33333.3333333333
Eo3sc o3lin 0 o3raw 0 1

* o4 input 1 w=+0.274757256178841 w+  bank=n alpha=1 R=121319.210261863 G_phys=8.24271768536522e-06 G_eff=8.24271768536522e-06
Ro4p1n1 h1buf o4p 117986.533398439
* o4 input 2 w=-0.133159767354893 w-  bank=n alpha=1 R=250325.860396666 G_phys=3.99479302064678e-06 G_eff=3.99479302064678e-06
Ro4n2n1 h2buf o4n 242780.390337566
* o4 input 3 w=-0.106623598682841 w-  bank=n alpha=1 R=312626.226699453 G_phys=3.19870796048523e-06 G_eff=3.19870796048523e-06
Ro4n3n1 h3buf o4n 303951.092822627
* o4 input 4 w=+0.10049322803724 w+  bank=n alpha=1 R=331697.309205562 G_phys=3.01479684111719e-06 G_eff=3.01479684111719e-06
Ro4p4n1 h4buf o4p 320194.852215501
* o4 input 5 w=-0.195742340683107 w-  bank=n alpha=1 R=170291.890947078 G_phys=5.87227022049321e-06 G_eff=5.87227022049321e-06
Ro4n5n1 h5buf o4n 164132.917240835
* o4 input 6 w=-0.202179592890339 w-  bank=n alpha=1 R=164869.920137851 G_phys=6.06538778671016e-06 G_eff=6.06538778671016e-06
Ro4n6n1 h6buf o4n 159158.885118537
* o4 input 7 w=-0.112561544712497 w-  bank=n alpha=1 R=296134.291853162 G_phys=3.37684634137491e-06 G_eff=3.37684634137491e-06
Ro4n7n1 h7buf o4n 285511.39053442
* o4 input 8 w=+0.0264861793940817 w+  bank=f alpha=0.001 R=1258.5179930021 G_phys=0.000794585381822452 G_eff=7.94585381822452e-07
Ro4p8f1 h8f o4p 1216.83991662327
* o4 input 9 w=-0.0974936293293829 w-  bank=n alpha=1 R=341902.681873874 G_phys=2.92480887988149e-06 G_eff=2.92480887988149e-06
Ro4n9n1 h9buf o4n 332712.438479528
* o4 input 10 w=-0.296895349286464 w-  bank=n alpha=1 R=112273.006005127 G_phys=8.90686047859392e-06 G_eff=8.90686047859392e-06
Ro4n10n1 h10buf o4n 108419.071844247
* o4 input 11 w=-0.580818210763829 w-  bank=n alpha=1 R=57390.303395441 G_phys=1.74245463229149e-05 G_eff=1.74245463229149e-05
Ro4n11n1 h11buf o4n 55859.772768611
* o4 input 12 w=-0.276549005245937 w-  bank=n alpha=1 R=120533.188335607 G_phys=8.29647015737811e-06 G_eff=8.29647015737811e-06
Ro4n12n1 h12buf o4n 116406.760246536
* o4 input 13 w=-0.164579538023522 w-  bank=n alpha=1 R=202536.316079398 G_phys=4.93738614070565e-06 G_eff=4.93738614070565e-06
Ro4n13n1 h13buf o4n 196923.442086051
* o4 input 14 w=-0.00939321676538441 w-  bank=f alpha=0.001 R=3548.66007736267 G_phys=0.000281796502961532 G_eff=2.81796502961532e-07
Ro4n14f1 h14f o4n 3441.67966653405
* o4 input 15 w=-0.0690593814994067 w-  bank=n alpha=1 R=482676.395438319 G_phys=2.0717814449822e-06 G_eff=2.0717814449822e-06
Ro4n15n1 h15buf o4n 468746.621053859
* o4 input 16 w=-0.272869230842632 w-  bank=n alpha=1 R=122158.637052623 G_phys=8.18607692527895e-06 G_eff=8.18607692527895e-06
Ro4n16n1 h16buf o4n 118561.156464232
* o4 input 17 w=+0.168866320874711 w+  bank=n alpha=1 R=197394.798208843 G_phys=5.06598962624132e-06 G_eff=5.06598962624132e-06
Ro4p17n1 h17buf o4p 190802.905922787
* o4 input 18 w=-0.0339148293163791 w-  bank=n alpha=1 R=982854.226461786 G_phys=1.01744487949137e-06 G_eff=1.01744487949137e-06
Ro4n18n1 h18buf o4n 948098.730570752
* o4 input 19 w=-0.0805852645818897 w-  bank=n alpha=1 R=413640.552106898 G_phys=2.41755793745669e-06 G_eff=2.41755793745669e-06
Ro4n19n1 h19buf o4n 399502.30337046
* o4 input 20 w=+0.0499049155841609 w+  bank=n alpha=1 R=667936.874417093 G_phys=1.49714746752483e-06 G_eff=1.49714746752483e-06
Ro4p20n1 h20buf o4p 644048.492477329
* o4 input 21 w=+0.0630428027700635 w+  bank=n alpha=1 R=528741.29747864 G_phys=1.8912840831019e-06 G_eff=1.8912840831019e-06
Ro4p21n1 h21buf o4p 510336.961505162
* o4 input 22 w=+0.077534797791833 w+  bank=n alpha=1 R=429914.493655189 G_phys=2.32604393375499e-06 G_eff=2.32604393375499e-06
Ro4p22n1 h22buf o4p 415870.420000206
* o4 input 23 w=+0.0744829629231984 w+  bank=n alpha=1 R=447529.636645958 G_phys=2.23448888769595e-06 G_eff=2.23448888769595e-06
Ro4p23n1 h23buf o4p 434532.660839806
* o4 input 24 w=-0.00836970221956497 w-  bank=f alpha=0.001 R=3982.61879083506 G_phys=0.000251091066586949 G_eff=2.51091066586949e-07
Ro4n24f1 h24f o4n 3847.10685026023
* o4 input 25 w=-0.0959555339157937 w-  bank=n alpha=1 R=347383.126048626 G_phys=2.87866601747381e-06 G_eff=2.87866601747381e-06
Ro4n25n1 h25buf o4n 336392.838685618
* o4 input 26 w=-0.27047998771669 w-  bank=n alpha=1 R=123237.706474047 G_phys=8.1143996315007e-06 G_eff=8.1143996315007e-06
Ro4n26n1 h26buf o4n 119207.999898362
* o4 input 27 w=-0.0478904255869687 w-  bank=n alpha=1 R=696033.349563792 G_phys=1.43671276760906e-06 G_eff=1.43671276760906e-06
Ro4n27n1 h27buf o4n 674868.731057378
* o4 input 28 w=-0.311644423649809 w-  bank=n alpha=1 R=106959.505140351 G_phys=9.34933270949427e-06 G_eff=9.34933270949427e-06
Ro4n28n1 h28buf o4n 103413.69181276
* o4 input 29 w=-0.0286856006407659 w-  bank=f alpha=0.001 R=1162.02319591532 G_phys=0.000860568019222978 G_eff=8.60568019222978e-07
Ro4n29f1 h29f o4n 1128.06956798522
* o4 input 30 w=-0.016265879828258 w-  bank=f alpha=0.001 R=2049.27945400314 G_phys=0.000487976394847741 G_eff=4.87976394847741e-07
Ro4n30f1 h30f o4n 1986.43205175994
* o4 input 31 w=-0.119685509607977 w-  bank=n alpha=1 R=278507.677683913 G_phys=3.59056528823931e-06 G_eff=3.59056528823931e-06
Ro4n31n1 h31buf o4n 270188.113623294
* o4 input 32 w=-0.0356690164245122 w-  bank=n alpha=1 R=934517.872223306 G_phys=1.07007049273537e-06 G_eff=1.07007049273537e-06
Ro4n32n1 h32buf o4n 902425.325419815
* o4 bias=+0.0671312079863495 b+  bank=n alpha=1 R=496540.049452281 G_phys=2.01393623959048e-06 G_eff=2.01393623959048e-06
Ro4bpn1 vref o4p 479275.67227735
Vo4p o4p 0 DC 0
Vo4n o4n 0 DC 0
Fo4p 0 o4d Vo4p 1
Fo4n o4d 0 Vo4n 1
Vo4d o4d 0 DC 0
Ho4 o4raw 0 Vo4d 33333.3333333333
Eo4sc o4lin 0 o4raw 0 1

* o5 input 1 w=+0.0860510418468527 w+  bank=n alpha=1 R=387366.99309995 G_phys=2.58153125540558e-06 G_eff=2.58153125540558e-06
Ro5p1n1 h1buf o5p 375341.46817623
* o5 input 2 w=-0.140209371980717 w-  bank=n alpha=1 R=237739.695017803 G_phys=4.20628115942151e-06 G_eff=4.20628115942151e-06
Ro5n2n1 h2buf o5n 230998.224473158
* o5 input 3 w=-0.298670153474102 w-  bank=n alpha=1 R=111605.839906008 G_phys=8.96010460422305e-06 G_eff=8.96010460422305e-06
Ro5n3n1 h3buf o5n 108068.179147703
* o5 input 4 w=+0.194023589749981 w+  bank=n alpha=1 R=171800.415487038 G_phys=5.82070769249943e-06 G_eff=5.82070769249943e-06
Ro5p4n1 h4buf o5p 167279.041200571
* o5 input 5 w=+0.104223096266613 w+  bank=n alpha=1 R=319826.74212694 G_phys=3.1266928879984e-06 G_eff=3.1266928879984e-06
Ro5p5n1 h5buf o5p 311420.999490084
* o5 input 6 w=+0.179601423642336 w+  bank=n alpha=1 R=185596.153178131 G_phys=5.38804270927008e-06 G_eff=5.38804270927008e-06
Ro5p6n1 h6buf o5p 179013.672579429
* o5 input 7 w=-0.15816414054373 w-  bank=n alpha=1 R=210751.521923626 G_phys=4.74492421631189e-06 G_eff=4.74492421631189e-06
Ro5n7n1 h7buf o5n 203610.40924116
* o5 input 8 w=-0.249576912278698 w-  bank=n alpha=1 R=133559.362638923 G_phys=7.48730736836095e-06 G_eff=7.48730736836095e-06
Ro5n8n1 h8buf o5n 129248.335846801
* o5 input 9 w=-0.031381439286146 w-  bank=f alpha=0.001 R=1062.19899697364 G_phys=0.00094144317858438 G_eff=9.41443178584379e-07
Ro5n9f1 h9f o5n 1025.80818796884
* o5 input 10 w=+0.375618440651073 w+  bank=n alpha=1 R=88742.5369094113 G_phys=1.12685532195322e-05 G_eff=1.12685532195322e-05
Ro5p10n1 h10buf o5p 85789.9928675232
* o5 input 11 w=+0.0953608962368974 w+  bank=n alpha=1 R=349549.287482848 G_phys=2.86082688710692e-06 G_eff=2.86082688710692e-06
Ro5p11n1 h11buf o5p 339045.377887236
* o5 input 12 w=+0.235920649298708 w+  bank=n alpha=1 R=141290.44419138 G_phys=7.07761947896125e-06 G_eff=7.07761947896125e-06
Ro5p12n1 h12buf o5p 136774.017504701
* o5 input 13 w=-0.0940916695355706 w-  bank=n alpha=1 R=354264.447616502 G_phys=2.82275008606712e-06 G_eff=2.82275008606712e-06
Ro5n13n1 h13buf o5n 344467.652323985
* o5 input 14 w=+0.00295126144933853 w+  bank=f alpha=0.001 R=11294.6053426762 G_phys=8.85378434801559e-05 G_eff=8.85378434801559e-08
Ro5p14f1 h14f o5p 10925.5593003041
* o5 input 15 w=+0.529616924207031 w+  bank=n alpha=1 R=62938.572786815 G_phys=1.58885077262109e-05 G_eff=1.58885077262109e-05
Ro5p15n1 h15buf o5p 61020.824592282
* o5 input 16 w=+0.319042125899952 w+  bank=n alpha=1 R=104479.410796637 G_phys=9.57126377699856e-06 G_eff=9.57126377699856e-06
Ro5p16n1 h16buf o5p 100827.781130284
* o5 input 17 w=-0.466616152697173 w-  bank=n alpha=1 R=71436.3039956017 G_phys=1.39984845809152e-05 G_eff=1.39984845809152e-05
Ro5n17n1 h17buf o5n 69481.3281790338
* o5 input 18 w=-0.243973793531226 w-  bank=n alpha=1 R=136626.696051546 G_phys=7.31921380593677e-06 G_eff=7.31921380593677e-06
Ro5n18n1 h18buf o5n 132841.156396208
* o5 input 19 w=-0.167620412829882 w-  bank=n alpha=1 R=198862.01668745 G_phys=5.02861238489647e-06 G_eff=5.02861238489647e-06
Ro5n19n1 h19buf o5n 191756.578847488
* o5 input 20 w=+0.191248887162316 w+  bank=n alpha=1 R=174292.953166534 G_phys=5.73746661486949e-06 G_eff=5.73746661486949e-06
Ro5p20n1 h20buf o5p 169007.14340889
* o5 input 21 w=+0.174220054558956 w+  bank=n alpha=1 R=191328.91111599 G_phys=5.22660163676868e-06 G_eff=5.22660163676868e-06
Ro5p21n1 h21buf o5p 184472.022086629
* o5 input 22 w=-0.14737880105185 w-  bank=n alpha=1 R=226174.545426015 G_phys=4.4213640315555e-06 G_eff=4.4213640315555e-06
Ro5n22n1 h22buf o5n 218619.064883342
* o5 input 23 w=-0.261133636281725 w-  bank=n alpha=1 R=127648.562659203 G_phys=7.83400908845174e-06 G_eff=7.83400908845174e-06
Ro5n23n1 h23buf o5n 123070.342358712
* o5 input 24 w=+0.130521837388059 w+  bank=n alpha=1 R=255385.106434174 G_phys=3.91565512164177e-06 G_eff=3.91565512164177e-06
Ro5p24n1 h24buf o5p 247943.099550451
* o5 input 25 w=-0.326372621774105 w-  bank=n alpha=1 R=102132.749837101 G_phys=9.79117865322314e-06 G_eff=9.79117865322314e-06
Ro5n25n1 h25buf o5n 99358.0207320556
* o5 input 26 w=+0.16696553546102 w+  bank=n alpha=1 R=199641.99941799 G_phys=5.00896606383059e-06 G_eff=5.00896606383059e-06
Ro5p26n1 h26buf o5p 193780.260509129
* o5 input 27 w=-0.105618085709112 w-  bank=n alpha=1 R=315602.513618153 G_phys=3.16854257127337e-06 G_eff=3.16854257127337e-06
Ro5n27n1 h27buf o5n 306364.70281684
* o5 input 28 w=+0.0630335864648206 w+  bank=n alpha=1 R=528818.606124163 G_phys=1.89100759394462e-06 G_eff=1.89100759394462e-06
Ro5p28n1 h28buf o5p 511408.08118647
* o5 input 29 w=+0.231531157265063 w+  bank=n alpha=1 R=143969.104318744 G_phys=6.94593471795189e-06 G_eff=6.94593471795189e-06
Ro5p29n1 h29buf o5p 139794.479386071
* o5 input 30 w=-0.0894419530377066 w-  bank=n alpha=1 R=372681.188203491 G_phys=2.6832585911312e-06 G_eff=2.6832585911312e-06
Ro5n30n1 h30buf o5n 360295.968144799
* o5 input 31 w=+0.216486138811528 w+  bank=n alpha=1 R=153974.446199316 G_phys=6.49458416434585e-06 G_eff=6.49458416434585e-06
Ro5p31n1 h31buf o5p 149625.659683925
* o5 input 32 w=-0.32037829849107 w-  bank=n alpha=1 R=104043.668033472 G_phys=9.6113489547321e-06 G_eff=9.6113489547321e-06
Ro5n32n1 h32buf o5n 101275.648618114
* o5 bias=+0.0022999314168152 b+  bank=f alpha=0.001 R=14493.185792249 G_phys=6.89979425044561e-05 G_eff=6.89979425044561e-08
Ro5bpf1 vreff o5p 14089.7762301344
Vo5p o5p 0 DC 0
Vo5n o5n 0 DC 0
Fo5p 0 o5d Vo5p 1
Fo5n o5d 0 Vo5n 1
Vo5d o5d 0 DC 0
Ho5 o5raw 0 Vo5d 33333.3333333333
Eo5sc o5lin 0 o5raw 0 1

* o6 input 1 w=+0.177051530119574 w+  bank=n alpha=1 R=188269.106236028 G_phys=5.31154590358722e-06 G_eff=5.31154590358722e-06
Ro6p1n1 h1buf o6p 182280.309465281
* o6 input 2 w=+0.301592495922723 w+  bank=n alpha=1 R=110524.412191855 G_phys=9.04777487768168e-06 G_eff=9.04777487768168e-06
Ro6p2n1 h2buf o6p 106520.363566767
* o6 input 3 w=+0.171870982949934 w+  bank=n alpha=1 R=193943.92678282 G_phys=5.15612948849803e-06 G_eff=5.15612948849803e-06
Ro6p3n1 h3buf o6p 187207.53477839
* o6 input 4 w=-0.3405205591368 w-  bank=n alpha=1 R=97889.3415946205 G_phys=1.0215616774104e-05 G_eff=1.0215616774104e-05
Ro6n4n1 h4buf o6n 95251.0960068957
* o6 input 5 w=-0.19025500833844 w-  bank=n alpha=1 R=175203.447333368 G_phys=5.70765025015321e-06 G_eff=5.70765025015321e-06
Ro6n5n1 h5buf o6n 169025.097650054
* o6 input 6 w=+0.141724280050197 w+  bank=n alpha=1 R=235198.466497956 G_phys=4.25172840150592e-06 G_eff=4.25172840150592e-06
Ro6p6n1 h6buf o6p 227269.334246062
* o6 input 7 w=-0.0326153624876146 w-  bank=f alpha=0.001 R=1022.01327199694 G_phys=0.000978460874628438 G_eff=9.78460874628438e-07
Ro6n7f1 h7f o6n 986.208249662202
* o6 input 8 w=+0.106637930601 w+  bank=n alpha=1 R=312584.210378712 G_phys=3.19913791802999e-06 G_eff=3.19913791802999e-06
Ro6p8n1 h8buf o6p 302154.668384964
* o6 input 9 w=+0.167194950685368 w+  bank=n alpha=1 R=199368.062233296 G_phys=5.01584852056104e-06 G_eff=5.01584852056104e-06
Ro6p9n1 h9buf o6p 192407.740664756
* o6 input 10 w=-0.113695758135469 w-  bank=n alpha=1 R=293180.096425556 G_phys=3.41087274406406e-06 G_eff=3.41087274406406e-06
Ro6n10n1 h10buf o6n 283074.224452221
* o6 input 11 w=+0.174899957381211 w+  bank=n alpha=1 R=190585.142686343 G_phys=5.24699872143633e-06 G_eff=5.24699872143633e-06
Ro6p11n1 h11buf o6p 184263.98864184
* o6 input 12 w=-0.244360694504916 w-  bank=n alpha=1 R=136410.372383611 G_phys=7.33082083514748e-06 G_eff=7.33082083514748e-06
Ro6n12n1 h12buf o6n 132401.655183349
* o6 input 13 w=+0.255772583539878 w+  bank=n alpha=1 R=130324.106172764 G_phys=7.67317750619635e-06 G_eff=7.67317750619635e-06
Ro6p13n1 h13buf o6p 125618.570923928
* o6 input 14 w=+0.139949769298614 w+  bank=n alpha=1 R=238180.695119327 G_phys=4.19849307895843e-06 G_eff=4.19849307895843e-06
Ro6p14n1 h14buf o6p 231855.305270236
* o6 input 15 w=-0.401168375335584 w-  bank=n alpha=1 R=83090.6307244419 G_phys=1.20350512600675e-05 G_eff=1.20350512600675e-05
Ro6n15n1 h15buf o6n 80512.488501019
* o6 input 16 w=+0.405832076822582 w+  bank=n alpha=1 R=82135.777916603 G_phys=1.21749623046775e-05 G_eff=1.21749623046775e-05
Ro6p16n1 h16buf o6p 79751.0390969762
* o6 input 17 w=-0.113061682974004 w-  bank=n alpha=1 R=294824.315864798 G_phys=3.39185048922012e-06 G_eff=3.39185048922012e-06
Ro6n17n1 h17buf o6n 284365.906536938
* o6 input 18 w=-0.197513353657142 w-  bank=n alpha=1 R=168764.960526141 G_phys=5.92540060971425e-06 G_eff=5.92540060971425e-06
Ro6n18n1 h18buf o6n 164151.045107957
* o6 input 19 w=-0.228990652840289 w-  bank=n alpha=1 R=145566.349193222 G_phys=6.86971958520868e-06 G_eff=6.86971958520868e-06
Ro6n19n1 h19buf o6n 140848.588014625
* o6 input 20 w=-0.216778558754084 w-  bank=n alpha=1 R=153766.744852045 G_phys=6.50335676262251e-06 G_eff=6.50335676262251e-06
Ro6n20n1 h20buf o6n 149712.059813519
* o6 input 21 w=-0.139531541535413 w-  bank=n alpha=1 R=238894.610971336 G_phys=4.18594624606239e-06 G_eff=4.18594624606239e-06
Ro6n21n1 h21buf o6n 230487.782125093
* o6 input 22 w=-0.394983843934915 w-  bank=n alpha=1 R=84391.6373927081 G_phys=1.18495153180474e-05 G_eff=1.18495153180474e-05
Ro6n22n1 h22buf o6n 82131.7665422861
* o6 input 23 w=-0.193849822273603 w-  bank=n alpha=1 R=171954.41781879 G_phys=5.81549466820809e-06 G_eff=5.81549466820809e-06
Ro6n23n1 h23buf o6n 167272.787107854
* o6 input 24 w=-0.0741873589980665 w-  bank=n alpha=1 R=449312.844984846 G_phys=2.22562076994199e-06 G_eff=2.22562076994199e-06
Ro6n24n1 h24buf o6n 437042.484542056
* o6 input 25 w=-0.172655508406202 w-  bank=n alpha=1 R=193062.669364194 G_phys=5.17966525218605e-06 G_eff=5.17966525218605e-06
Ro6n25n1 h25buf o6n 187201.337831999
* o6 input 26 w=+0.0670699610875517 w+  bank=n alpha=1 R=496993.479537295 G_phys=2.01209883262655e-06 G_eff=2.01209883262655e-06
Ro6p26n1 h26buf o6p 482323.406905679
* o6 input 27 w=+0.25363855276468 w+  bank=n alpha=1 R=131420.610037384 G_phys=7.60915658294039e-06 G_eff=7.60915658294039e-06
Ro6p27n1 h27buf o6p 127178.05695056
* o6 input 28 w=-0.179185579156039 w-  bank=n alpha=1 R=186026.874988115 G_phys=5.37556737468116e-06 G_eff=5.37556737468116e-06
Ro6n28n1 h28buf o6n 179963.692175255
* o6 input 29 w=-0.129923130427228 w-  bank=n alpha=1 R=256561.962629155 G_phys=3.89769391281685e-06 G_eff=3.89769391281685e-06
Ro6n29n1 h29buf o6n 249018.712318679
* o6 input 30 w=-0.169171092451912 w-  bank=n alpha=1 R=197039.179981701 G_phys=5.07513277355737e-06 G_eff=5.07513277355737e-06
Ro6n30n1 h30buf o6n 190437.954433773
* o6 input 31 w=+0.218686712022964 w+  bank=n alpha=1 R=152425.051458238 G_phys=6.56060136068893e-06 G_eff=6.56060136068893e-06
Ro6p31n1 h31buf o6p 147081.402972378
* o6 input 32 w=+0.133370937368681 w+  bank=n alpha=1 R=249929.512313385 G_phys=4.00112812106042e-06 G_eff=4.00112812106042e-06
Ro6p32n1 h32buf o6p 243289.471325553
* o6 bias=+0.0648246120847975 b+  bank=n alpha=1 R=514207.987696552 G_phys=1.94473836254393e-06 G_eff=1.94473836254393e-06
Ro6bpn1 vref o6p 498184.521442401
Vo6p o6p 0 DC 0
Vo6n o6n 0 DC 0
Fo6p 0 o6d Vo6p 1
Fo6n o6d 0 Vo6n 1
Vo6d o6d 0 DC 0
Ho6 o6raw 0 Vo6d 33333.3333333333
Eo6sc o6lin 0 o6raw 0 1

* o7 input 1 w=+0.130193574665561 w+  bank=n alpha=1 R=256029.020010853 G_phys=3.90580723996683e-06 G_eff=3.90580723996683e-06
Ro7p1n1 h1buf o7p 249151.616926465
* o7 input 2 w=+0.394190134763453 w+  bank=n alpha=1 R=84561.5615249634 G_phys=1.18257040429036e-05 G_eff=1.18257040429036e-05
Ro7p2n1 h2buf o7p 82017.8226108949
* o7 input 3 w=+0.206617853142924 w+  bank=n alpha=1 R=161328.427463021 G_phys=6.19853559428773e-06 G_eff=6.19853559428773e-06
Ro7p3n1 h3buf o7p 156678.679512145
* o7 input 4 w=-0.378033462280536 w-  bank=n alpha=1 R=88175.6158098959 G_phys=1.13410038684161e-05 G_eff=1.13410038684161e-05
Ro7n4n1 h4buf o7n 85296.3772769019
* o7 input 5 w=-0.580108461232067 w-  bank=n alpha=1 R=57460.5191286783 G_phys=1.7403253836962e-05 G_eff=1.7403253836962e-05
Ro7n5n1 h5buf o7n 55514.1729691769
* o7 input 6 w=+0.107934080055711 w+  bank=n alpha=1 R=308830.476121427 G_phys=3.23802240167132e-06 G_eff=3.23802240167132e-06
Ro7p6n1 h6buf o7p 300723.539754169
* o7 input 7 w=+0.101501144533757 w+  bank=n alpha=1 R=328403.521816913 G_phys=3.04503433601271e-06 G_eff=3.04503433601271e-06
Ro7p7n1 h7buf o7p 318577.015388466
* o7 input 8 w=+0.0692471666647439 w+  bank=n alpha=1 R=481367.468718463 G_phys=2.07741499994232e-06 G_eff=2.07741499994232e-06
Ro7p8n1 h8buf o7p 468154.93724395
* o7 input 9 w=-0.335430638558454 w-  bank=n alpha=1 R=99374.7424999297 G_phys=1.00629191567536e-05 G_eff=1.00629191567536e-05
Ro7n9n1 h9buf o7n 96266.7139751847
* o7 input 10 w=+0.101094797691112 w+  bank=n alpha=1 R=329723.527764315 G_phys=3.03284393073337e-06 G_eff=3.03284393073337e-06
Ro7p10n1 h10buf o7p 319974.349412165
* o7 input 11 w=-0.148243371766924 w-  bank=n alpha=1 R=224855.472025703 G_phys=4.44730115300771e-06 G_eff=4.44730115300771e-06
Ro7n11n1 h11buf o7n 218614.406200329
* o7 input 12 w=-0.334713947003149 w-  bank=n alpha=1 R=99587.5243077928 G_phys=1.00414184100945e-05 G_eff=1.00414184100945e-05
Ro7n12n1 h12buf o7n 96844.6036429259
* o7 input 13 w=-0.322800486422993 w-  bank=n alpha=1 R=103262.958809962 G_phys=9.68401459268979e-06 G_eff=9.68401459268979e-06
Ro7n13n1 h13buf o7n 100144.69782583
* o7 input 14 w=-0.104357857187523 w-  bank=n alpha=1 R=319413.73876081 G_phys=3.13073571562568e-06 G_eff=3.13073571562568e-06
Ro7n14n1 h14buf o7n 309467.464434293
* o7 input 15 w=+0.182195051802482 w+  bank=n alpha=1 R=182954.108816688 G_phys=5.46585155407446e-06 G_eff=5.46585155407446e-06
Ro7p15n1 h15buf o7p 178014.053402464
* o7 input 16 w=+0.0146234127477982 w+  bank=f alpha=0.001 R=2279.44966802309 G_phys=0.000438702382433947 G_eff=4.38702382433947e-07
Ro7p16f1 h16f o7p 2203.62459188705
* o7 input 17 w=-0.0268461940667064 w-  bank=f alpha=0.001 R=1241.64092871071 G_phys=0.000805385822001192 G_eff=8.05385822001192e-07
Ro7n17f1 h17f o7n 1206.16390794932
* o7 input 18 w=+0.263886686193095 w+  bank=n alpha=1 R=126316.843847674 G_phys=7.91660058579284e-06 G_eff=7.91660058579284e-06
Ro7p18n1 h18buf o7p 122708.969073662
* o7 input 19 w=+0.184182739421503 w+  bank=n alpha=1 R=180979.680495738 G_phys=5.52548218264508e-06 G_eff=5.52548218264508e-06
Ro7p19n1 h19buf o7p 175278.181563754
* o7 input 20 w=-0.16994338127458 w-  bank=n alpha=1 R=196143.757311009 G_phys=5.09830143823739e-06 G_eff=5.09830143823739e-06
Ro7n20n1 h20buf o7n 190517.957222955
* o7 input 21 w=-0.17515931490212 w-  bank=n alpha=1 R=190302.94421944 G_phys=5.25477944706359e-06 G_eff=5.25477944706359e-06
Ro7n21n1 h21buf o7n 185286.125808336
* o7 input 22 w=+0.170460541565249 w+  bank=n alpha=1 R=195548.67670401 G_phys=5.11381624695746e-06 G_eff=5.11381624695746e-06
Ro7p22n1 h22buf o7p 189553.356537356
* o7 input 23 w=-0.342102206419994 w-  bank=n alpha=1 R=97436.7680412165 G_phys=1.02630661925998e-05 G_eff=1.02630661925998e-05
Ro7n23n1 h23buf o7n 94309.641355647
* o7 input 24 w=-0.0940891241579366 w-  bank=n alpha=1 R=354274.031474461 G_phys=2.8226737247381e-06 G_eff=2.8226737247381e-06
Ro7n24n1 h24buf o7n 342123.161556927
* o7 input 25 w=-0.147263798833488 w-  bank=n alpha=1 R=226351.171145758 G_phys=4.41791396500465e-06 G_eff=4.41791396500465e-06
Ro7n25n1 h25buf o7n 218455.196831829
* o7 input 26 w=-0.0975787524659246 w-  bank=n alpha=1 R=341604.421976738 G_phys=2.92736257397774e-06 G_eff=2.92736257397774e-06
Ro7n26n1 h26buf o7n 332143.815960242
* o7 input 27 w=-0.201262065009158 w-  bank=n alpha=1 R=165621.540908947 G_phys=6.03786195027474e-06 G_eff=6.03786195027474e-06
Ro7n27n1 h27buf o7n 160577.587542127
* o7 input 28 w=-0.060609790215781 w-  bank=n alpha=1 R=549966.155874506 G_phys=1.81829370647343e-06 G_eff=1.81829370647343e-06
Ro7n28n1 h28buf o7n 532042.106277437
* o7 input 29 w=-0.355920486311588 w-  bank=n alpha=1 R=93653.8766811862 G_phys=1.06776145893477e-05 G_eff=1.06776145893477e-05
Ro7n29n1 h29buf o7n 90661.6383761875
* o7 input 30 w=+0.0702967455487947 w+  bank=n alpha=1 R=474180.320484337 G_phys=2.10890236646384e-06 G_eff=2.10890236646384e-06
Ro7p30n1 h30buf o7p 458788.620935527
* o7 input 31 w=+0.188674793501044 w+  bank=n alpha=1 R=176670.835116874 G_phys=5.66024380503133e-06 G_eff=5.66024380503133e-06
Ro7p31n1 h31buf o7p 171457.511325608
* o7 input 32 w=-0.221533996080022 w-  bank=n alpha=1 R=150465.995843332 G_phys=6.64601988240065e-06 G_eff=6.64601988240065e-06
Ro7n32n1 h32buf o7n 145988.059470662
* o7 bias=+0.0479731403374592 b+  bank=n alpha=1 R=694833.256669366 G_phys=1.43919421012378e-06 G_eff=1.43919421012378e-06
Ro7bpn1 vref o7p 672360.209687395
Vo7p o7p 0 DC 0
Vo7n o7n 0 DC 0
Fo7p 0 o7d Vo7p 1
Fo7n o7d 0 Vo7n 1
Vo7d o7d 0 DC 0
Ho7 o7raw 0 Vo7d 33333.3333333333
Eo7sc o7lin 0 o7raw 0 1

* o8 input 1 w=-0.264579445854062 w-  bank=n alpha=1 R=125986.103061534 G_phys=7.93738337562187e-06 G_eff=7.93738337562187e-06
Ro8n1n1 h1buf o8n 121860.313302109
* o8 input 2 w=-0.461651647659873 w-  bank=n alpha=1 R=72204.5150327114 G_phys=1.38495494297962e-05 G_eff=1.38495494297962e-05
Ro8n2n1 h2buf o8n 69714.4230237377
* o8 input 3 w=-0.248506615035073 w-  bank=n alpha=1 R=134134.591663199 G_phys=7.45519845105219e-06 G_eff=7.45519845105219e-06
Ro8n3n1 h3buf o8n 130444.273177352
* o8 input 4 w=-0.0596907059046396 w-  bank=n alpha=1 R=558434.22905043 G_phys=1.79072117713919e-06 G_eff=1.79072117713919e-06
Ro8n4n1 h4buf o8n 540912.304087377
* o8 input 5 w=-0.142952779428107 w-  bank=n alpha=1 R=233177.231437442 G_phys=4.28858338284322e-06 G_eff=4.28858338284322e-06
Ro8n5n1 h5buf o8n 226217.301916628
* o8 input 6 w=+0.230947580946818 w+  bank=n alpha=1 R=144332.896654195 G_phys=6.92842742840454e-06 G_eff=6.92842742840454e-06
Ro8p6n1 h6buf o8p 140256.664520066
* o8 input 7 w=+0.224542704495923 w+  bank=n alpha=1 R=148449.861277673 G_phys=6.7362811348777e-06 G_eff=6.7362811348777e-06
Ro8p7n1 h7buf o8p 144529.965185623
* o8 input 8 w=-0.0814289785611842 w-  bank=n alpha=1 R=409354.678424307 G_phys=2.44286935683553e-06 G_eff=2.44286935683553e-06
Ro8n8n1 h8buf o8n 394609.391916921
* o8 input 9 w=+0.151871407153412 w+  bank=n alpha=1 R=219483.93024147 G_phys=4.55614221460235e-06 G_eff=4.55614221460235e-06
Ro8p9n1 h9buf o8p 213647.342928344
* o8 input 10 w=-0.0439376442611886 w-  bank=n alpha=1 R=758650.899333209 G_phys=1.31812932783566e-06 G_eff=1.31812932783566e-06
Ro8n10n1 h10buf o8n 736952.167298721
* o8 input 11 w=-0.0114777570667242 w-  bank=f alpha=0.001 R=2904.16787352748 G_phys=0.000344332712001725 G_eff=3.44332712001725e-07
Ro8n11f1 h11f o8n 2801.85687050807
* o8 input 12 w=-0.184091969163629 w-  bank=n alpha=1 R=181068.91617692 G_phys=5.52275907490888e-06 G_eff=5.52275907490888e-06
Ro8n12n1 h12buf o8n 175880.236585348
* o8 input 13 w=+0.167375709493599 w+  bank=n alpha=1 R=199152.753014069 G_phys=5.02127128480798e-06 G_eff=5.02127128480798e-06
Ro8p13n1 h13buf o8p 193702.592543598
* o8 input 14 w=+0.639794426458427 w+  bank=n alpha=1 R=52100.068326399 G_phys=1.91938327937528e-05 G_eff=1.91938327937528e-05
Ro8p14n1 h14buf o8p 50709.0379075233
* o8 input 15 w=+0.00251732875304732 w+  bank=f alpha=0.001 R=13241.5495167177 G_phys=7.55198625914195e-05 G_eff=7.55198625914195e-08
Ro8p15f1 h15f o8p 12799.8942960094
* o8 input 16 w=+0.510552134317183 w+  bank=n alpha=1 R=65288.7944106113 G_phys=1.53165640295155e-05 G_eff=1.53165640295155e-05
Ro8p16n1 h16buf o8p 63171.7712572678
* o8 input 17 w=-0.402994248540282 w-  bank=n alpha=1 R=82714.166403299 G_phys=1.20898274562085e-05 G_eff=1.20898274562085e-05
Ro8n17n1 h17buf o8n 79897.8006691369
* o8 input 18 w=+0.141582671709231 w+  bank=n alpha=1 R=235433.707606466 G_phys=4.24748015127692e-06 G_eff=4.24748015127692e-06
Ro8p18n1 h18buf o8p 228861.931328208
* o8 input 19 w=+0.181760587882604 w+  bank=n alpha=1 R=183391.425620073 G_phys=5.45281763647812e-06 G_eff=5.45281763647812e-06
Ro8p19n1 h19buf o8p 178338.023822762
* o8 input 20 w=+0.465247625040388 w+  bank=n alpha=1 R=71646.4341552301 G_phys=1.39574287512116e-05 G_eff=1.39574287512116e-05
Ro8p20n1 h20buf o8p 69255.504255924
* o8 input 21 w=-0.129997678502292 w-  bank=n alpha=1 R=256414.835382969 G_phys=3.89993035506876e-06 G_eff=3.89993035506876e-06
Ro8n21n1 h21buf o8n 247650.571277551
* o8 input 22 w=+0.727771195072513 w+  bank=n alpha=1 R=45801.9409932982 G_phys=2.18331358521754e-05 G_eff=2.18331358521754e-05
Ro8p22n1 h22buf o8p 44363.5611682041
* o8 input 23 w=+0.0590279674258587 w+  bank=n alpha=1 R=564704.068036922 G_phys=1.77083902277576e-06 G_eff=1.77083902277576e-06
Ro8p23n1 h23buf o8p 547865.213711078
* o8 input 24 w=-0.0219880792573176 w-  bank=f alpha=0.001 R=1515.97294803456 G_phys=0.000659642377719527 G_eff=6.59642377719527e-07
Ro8n24f1 h24f o8n 1464.24065894065
* o8 input 25 w=-0.000673889145733125 w-  bank=f alpha=0.001 R=49464.1196469635 G_phys=2.02166743719938e-05 G_eff=2.02166743719938e-08
Ro8n25f1 h25f o8n 47684.4774215935
* o8 input 26 w=-0.0895992045192751 w-  bank=n alpha=1 R=372027.112430027 G_phys=2.68797613557825e-06 G_eff=2.68797613557825e-06
Ro8n26n1 h26buf o8n 361533.60319442
* o8 input 27 w=-0.161030155307918 w-  bank=n alpha=1 R=207000.56625788 G_phys=4.83090465923753e-06 G_eff=4.83090465923753e-06
Ro8n27n1 h27buf o8n 200750.025107913
* o8 input 28 w=-0.0515875057732319 w-  bank=n alpha=1 R=646151.288644577 G_phys=1.54762517319696e-06 G_eff=1.54762517319696e-06
Ro8n28n1 h28buf o8n 628576.963658953
* o8 input 29 w=-0.167333727666792 w-  bank=n alpha=1 R=199202.71781496 G_phys=5.02001183000377e-06 G_eff=5.02001183000377e-06
Ro8n29n1 h29buf o8n 192821.711405032
* o8 input 30 w=+0.117154510339097 w+  bank=n alpha=1 R=284524.541452582 G_phys=3.5146353101729e-06 G_eff=3.5146353101729e-06
Ro8p30n1 h30buf o8p 274496.386326391
* o8 input 31 w=-0.114263857072683 w-  bank=n alpha=1 R=291722.458766031 G_phys=3.42791571218049e-06 G_eff=3.42791571218049e-06
Ro8n31n1 h31buf o8n 282192.694896801
* o8 input 32 w=+0.185068242761295 w+  bank=n alpha=1 R=180113.739861503 G_phys=5.55204728283885e-06 G_eff=5.55204728283885e-06
Ro8p32n1 h32buf o8p 173953.152686162
* o8 bias=+0.070334250370477 b+  bank=n alpha=1 R=473927.47001289 G_phys=2.11002751111431e-06 G_eff=2.11002751111431e-06
Ro8bpn1 vref o8p 461447.064881603
Vo8p o8p 0 DC 0
Vo8n o8n 0 DC 0
Fo8p 0 o8d Vo8p 1
Fo8n o8d 0 Vo8n 1
Vo8d o8d 0 DC 0
Ho8 o8raw 0 Vo8d 33333.3333333333
Eo8sc o8lin 0 o8raw 0 1

* o9 input 1 w=-0.342788496026982 w-  bank=n alpha=1 R=97241.6919461309 G_phys=1.02836548808095e-05 G_eff=1.02836548808095e-05
Ro9n1n1 h1buf o9n 94217.3707234325
* o9 input 2 w=+0.117901804588507 w+  bank=n alpha=1 R=282721.146208671 G_phys=3.5370541376552e-06 G_eff=3.5370541376552e-06
Ro9p2n1 h2buf o9p 272523.138946247
* o9 input 3 w=-0.555835720214104 w-  bank=n alpha=1 R=59969.7574680763 G_phys=1.66750716064231e-05 G_eff=1.66750716064231e-05
Ro9n3n1 h3buf o9n 57923.5889977805
* o9 input 4 w=+0.355136587925528 w+  bank=n alpha=1 R=93860.6003060526 G_phys=1.06540976377658e-05 G_eff=1.06540976377658e-05
Ro9p4n1 h4buf o9p 91164.4591260891
* o9 input 5 w=+0.236432436172994 w+  bank=n alpha=1 R=140984.603774686 G_phys=7.09297308518982e-06 G_eff=7.09297308518982e-06
Ro9p5n1 h5buf o9p 137134.191212363
* o9 input 6 w=-0.00589463242951189 w-  bank=f alpha=0.001 R=5654.86206848924 G_phys=0.000176838972885357 G_eff=1.76838972885357e-07
Ro9n6f1 h6f o9n 5465.58905145771
* o9 input 7 w=-0.175810166557473 w-  bank=n alpha=1 R=189598.440101794 G_phys=5.27430499672418e-06 G_eff=5.27430499672418e-06
Ro9n7n1 h7buf o9n 184171.214998937
* o9 input 8 w=+0.162552656301944 w+  bank=n alpha=1 R=205061.757166343 G_phys=4.87657968905832e-06 G_eff=4.87657968905832e-06
Ro9p8n1 h8buf o9p 198132.761855888
* o9 input 9 w=-0.443497798175432 w-  bank=n alpha=1 R=75160.0875370025 G_phys=1.3304933945263e-05 G_eff=1.3304933945263e-05
Ro9n9n1 h9buf o9n 72512.0013246657
* o9 input 10 w=+0.114863161009978 w+  bank=n alpha=1 R=290200.383136224 G_phys=3.44589483029933e-06 G_eff=3.44589483029933e-06
Ro9p10n1 h10buf o9p 280537.742986411
* o9 input 11 w=-0.051706338551111 w-  bank=n alpha=1 R=644666.287874624 G_phys=1.55119015653333e-06 G_eff=1.55119015653333e-06
Ro9n11n1 h11buf o9n 624491.192577558
* o9 input 12 w=-0.247913853258797 w-  bank=n alpha=1 R=134455.307338298 G_phys=7.43741559776392e-06 G_eff=7.43741559776392e-06
Ro9n12n1 h12buf o9n 129768.478796892
* o9 input 13 w=+0.0720916431840902 w+  bank=n alpha=1 R=462374.442599605 G_phys=2.16274929552271e-06 G_eff=2.16274929552271e-06
Ro9p13n1 h13buf o9p 449675.750001723
* o9 input 14 w=+0.00473033723811417 w+  bank=f alpha=0.001 R=7046.71393505597 G_phys=0.000141910117143425 G_eff=1.41910117143425e-07
Ro9p14f1 h14f o9p 6842.47743488287
* o9 input 15 w=-0.290577914446662 w-  bank=n alpha=1 R=114713.925856371 G_phys=8.71733743339986e-06 G_eff=8.71733743339986e-06
Ro9n15n1 h15buf o9n 111558.989811839
* o9 input 16 w=-0.0531648681945055 w-  bank=n alpha=1 R=626980.456556052 G_phys=1.59494604583516e-06 G_eff=1.59494604583516e-06
Ro9n16n1 h16buf o9n 606021.314006064
* o9 input 17 w=+0.0157425177085947 w+  bank=f alpha=0.001 R=2117.40802521917 G_phys=0.000472275531257841 G_eff=4.72275531257841e-07
Ro9p17f1 h17f o9p 2054.65872691018
* o9 input 18 w=-0.104777957691913 w-  bank=n alpha=1 R=318133.06985183 G_phys=3.14333873075738e-06 G_eff=3.14333873075738e-06
Ro9n18n1 h18buf o9n 307754.145765057
* o9 input 19 w=-0.368259428743895 w-  bank=n alpha=1 R=90515.8992046201 G_phys=1.10477828623168e-05 G_eff=1.10477828623168e-05
Ro9n19n1 h19buf o9n 87677.6598136351
* o9 input 20 w=+0.100989358745228 w+  bank=n alpha=1 R=330067.778897631 G_phys=3.02968076235683e-06 G_eff=3.02968076235683e-06
Ro9p20n1 h20buf o9p 319059.840609379
* o9 input 21 w=+0.084258883556939 w+  bank=n alpha=1 R=395606.15956664 G_phys=2.52776650670817e-06 G_eff=2.52776650670817e-06
Ro9p21n1 h21buf o9p 383018.381748394
* o9 input 22 w=+0.093068688723566 w+  bank=n alpha=1 R=358158.40741391 G_phys=2.79206066170698e-06 G_eff=2.79206066170698e-06
Ro9p22n1 h22buf o9p 346505.74672018
* o9 input 23 w=+0.153137872499505 w+  bank=n alpha=1 R=217668.776438311 G_phys=4.59413617498515e-06 G_eff=4.59413617498515e-06
Ro9p23n1 h23buf o9p 211324.633360661
* o9 input 24 w=+0.0107021071757068 w+  bank=f alpha=0.001 R=3114.65142201137 G_phys=0.000321063215271205 G_eff=3.21063215271205e-07
Ro9p24f1 h24f o9p 3024.53364514367
* o9 input 25 w=+0.151859492007221 w+  bank=n alpha=1 R=219501.151312611 G_phys=4.55578476021664e-06 G_eff=4.55578476021664e-06
Ro9p25n1 h25buf o9p 212806.125552057
* o9 input 26 w=-0.0745603298060184 w-  bank=n alpha=1 R=447065.261380358 G_phys=2.23680989418055e-06 G_eff=2.23680989418055e-06
Ro9n26n1 h26buf o9n 434688.592047552
* o9 input 27 w=+0.475223780202243 w+  bank=n alpha=1 R=70142.3933775947 G_phys=1.42567134060673e-05 G_eff=1.42567134060673e-05
Ro9p27n1 h27buf o9p 67940.1767797544
* o9 input 28 w=+0.715956917954612 w+  bank=n alpha=1 R=46557.736223238 G_phys=2.14787075386384e-05 G_eff=2.14787075386384e-05
Ro9p28n1 h28buf o9p 45284.6678956479
* o9 input 29 w=-0.520384445309866 w-  bank=n alpha=1 R=64055.2069412544 G_phys=1.5611533359296e-05 G_eff=1.5611533359296e-05
Ro9n29n1 h29buf o9n 61991.9226329723
* o9 input 30 w=+0.217731604854565 w+  bank=n alpha=1 R=153093.683186685 G_phys=6.53194814563695e-06 G_eff=6.53194814563695e-06
Ro9p30n1 h30buf o9p 147839.967422864
* o9 input 31 w=-0.123913004875871 w-  bank=n alpha=1 R=269005.931756111 G_phys=3.71739014627614e-06 G_eff=3.71739014627614e-06
Ro9n31n1 h31buf o9n 261249.392124724
* o9 input 32 w=+0.0869405958454977 w+  bank=n alpha=1 R=383403.552841644 G_phys=2.60821787536493e-06 G_eff=2.60821787536493e-06
Ro9p32n1 h32buf o9p 371904.100537888
* o9 bias=-0.00785769582167887 b-  bank=f alpha=0.001 R=4242.12569305226 G_phys=0.000235730874650366 G_eff=2.35730874650366e-07
Ro9bnf1 vreff o9n 4111.32382606978
Vo9p o9p 0 DC 0
Vo9n o9n 0 DC 0
Fo9p 0 o9d Vo9p 1
Fo9n o9d 0 Vo9n 1
Vo9d o9d 0 DC 0
Ho9 o9raw 0 Vo9d 33333.3333333333
Eo9sc o9lin 0 o9raw 0 1

* o10 input 1 w=-0.0381763956958746 w-  bank=n alpha=1 R=873139.874148344 G_phys=1.14529187087624e-06 G_eff=1.14529187087624e-06
Ro10n1n1 h1buf o10n 844015.765698894
* o10 input 2 w=+0.410781186996451 w+  bank=n alpha=1 R=81146.2023785947 G_phys=1.23234356098935e-05 G_eff=1.23234356098935e-05
Ro10p2n1 h2buf o10p 79007.0532360866
* o10 input 3 w=+0.475033421735393 w+  bank=n alpha=1 R=70170.5012913827 G_phys=1.42510026520618e-05 G_eff=1.42510026520618e-05
Ro10p3n1 h3buf o10p 67904.7111974717
* o10 input 4 w=+0.0271427582394968 w+  bank=f alpha=0.001 R=1228.07465030685 G_phys=0.000814282747184905 G_eff=8.14282747184905e-07
Ro10p4f1 h4f o10p 1183.77463634106
* o10 input 5 w=+0.0212799641995083 w+  bank=f alpha=0.001 R=1566.41867537087 G_phys=0.00063839892598525 G_eff=6.3839892598525e-07
Ro10p5f1 h5f o10p 1510.94983260783
* o10 input 6 w=+0.0201273268189427 w+  bank=f alpha=0.001 R=1656.12322158758 G_phys=0.00060381980456828 G_eff=6.0381980456828e-07
Ro10p6f1 h6f o10p 1598.15791782693
* o10 input 7 w=-0.036291550108304 w-  bank=n alpha=1 R=918487.450490747 G_phys=1.08874650324912e-06 G_eff=1.08874650324912e-06
Ro10n7n1 h7buf o10n 890182.893218029
* o10 input 8 w=+0.0509688710938526 w+  bank=n alpha=1 R=653993.949992621 G_phys=1.52906613281558e-06 G_eff=1.52906613281558e-06
Ro10p8n1 h8buf o10p 635692.129396169
* o10 input 9 w=-0.135969386219015 w-  bank=n alpha=1 R=245153.223532546 G_phys=4.07908158657046e-06 G_eff=4.07908158657046e-06
Ro10n9n1 h9buf o10n 236940.170852153
* o10 input 10 w=+0.542965243347564 w+  bank=n alpha=1 R=61391.2837731971 G_phys=1.62889573004269e-05 G_eff=1.62889573004269e-05
Ro10p10n1 h10buf o10p 59167.1324009818
* o10 input 11 w=+0.200790198383509 w+  bank=n alpha=1 R=166010.759497666 G_phys=6.02370595150528e-06 G_eff=6.02370595150528e-06
Ro10p11n1 h11buf o10p 161386.006769749
* o10 input 12 w=-0.0602452386161185 w-  bank=n alpha=1 R=553294.071017507 G_phys=1.80735715848356e-06 G_eff=1.80735715848356e-06
Ro10n12n1 h12buf o10n 533419.354937528
* o10 input 13 w=-0.18784742953156 w-  bank=n alpha=1 R=177448.972373258 G_phys=5.6354228859468e-06 G_eff=5.6354228859468e-06
Ro10n13n1 h13buf o10n 171935.143076621
* o10 input 14 w=-0.0121063802780956 w-  bank=f alpha=0.001 R=2753.36909692523 G_phys=0.000363191408342867 G_eff=3.63191408342867e-07
Ro10n14f1 h14f o10n 2680.51219147376
* o10 input 15 w=+0.162912924713055 w+  bank=n alpha=1 R=204608.280110646 G_phys=4.88738774139165e-06 G_eff=4.88738774139165e-06
Ro10p15n1 h15buf o10p 197707.51087711
* o10 input 16 w=+0.000496602144198326 w+  bank=f alpha=0.001 R=67122.8139522916 G_phys=1.48980643259498e-05 G_eff=1.48980643259498e-08
Ro10p16f1 h16f o10p 65165.9404621635
* o10 input 17 w=+0.150471984074884 w+  bank=n alpha=1 R=221525.179841748 G_phys=4.51415952224652e-06 G_eff=4.51415952224652e-06
Ro10p17n1 h17buf o10p 214699.702780928
* o10 input 18 w=-0.0993574349593851 w-  bank=n alpha=1 R=335489.068804556 G_phys=2.98072304878155e-06 G_eff=2.98072304878155e-06
Ro10n18n1 h18buf o10n 325112.989890648
* o10 input 19 w=-0.0430450321763909 w-  bank=n alpha=1 R=774382.818364248 G_phys=1.29135096529173e-06 G_eff=1.29135096529173e-06
Ro10n19n1 h19buf o10n 753957.816434075
* o10 input 20 w=-0.498578232263262 w-  bank=n alpha=1 R=66856.7762816658 G_phys=1.49573469678979e-05 G_eff=1.49573469678979e-05
Ro10n20n1 h20buf o10n 64749.7946987285
* o10 input 21 w=-0.135185117923925 w-  bank=n alpha=1 R=246575.465149141 G_phys=4.05555353771776e-06 G_eff=4.05555353771776e-06
Ro10n21n1 h21buf o10n 239944.81210363
* o10 input 22 w=+0.00794231626553338 w+  bank=f alpha=0.001 R=4196.92848016985 G_phys=0.000238269487966002 G_eff=2.38269487966002e-07
Ro10p22f1 h22f o10p 4053.44535441264
* o10 input 23 w=-0.411689837989046 w-  bank=n alpha=1 R=80967.1025550556 G_phys=1.23506951396714e-05 G_eff=1.23506951396714e-05
Ro10n23n1 h23buf o10n 78290.0966755968
* o10 input 24 w=+0.321047972853849 w+  bank=n alpha=1 R=103826.643217921 G_phys=9.63143918561547e-06 G_eff=9.63143918561547e-06
Ro10p24n1 h24buf o10p 100640.176579772
* o10 input 25 w=-0.130972309748016 w-  bank=n alpha=1 R=254506.722813891 G_phys=3.92916929244047e-06 G_eff=3.92916929244047e-06
Ro10n25n1 h25buf o10n 245992.3300133
* o10 input 26 w=+0.0365278526067883 w+  bank=n alpha=1 R=912545.659120916 G_phys=1.09583557820365e-06 G_eff=1.09583557820365e-06
Ro10p26n1 h26buf o10p 882970.798171077
* o10 input 27 w=-0.205674584301975 w-  bank=n alpha=1 R=162068.315083563 G_phys=6.17023752905924e-06 G_eff=6.17023752905924e-06
Ro10n27n1 h27buf o10n 156943.800376304
* o10 input 28 w=-0.0123163999797875 w-  bank=f alpha=0.001 R=2706.41854665624 G_phys=0.000369491999393624 G_eff=3.69491999393624e-07
Ro10n28f1 h28f o10n 2627.49954740756
* o10 input 29 w=-0.120487475126756 w-  bank=n alpha=1 R=276653.928537102 G_phys=3.61462425380267e-06 G_eff=3.61462425380267e-06
Ro10n29n1 h29buf o10n 268787.358110264
* o10 input 30 w=-0.421650115672696 w-  bank=n alpha=1 R=79054.486396034 G_phys=1.26495034701809e-05 G_eff=1.26495034701809e-05
Ro10n30n1 h30buf o10n 76875.1250491421
* o10 input 31 w=+0.15176529701113 w+  bank=n alpha=1 R=219637.387398838 G_phys=4.55295891033391e-06 G_eff=4.55295891033391e-06
Ro10p31n1 h31buf o10p 213448.720921306
* o10 input 32 w=+0.00307524765960727 w+  bank=f alpha=0.001 R=10839.2354122107 G_phys=9.22574297882182e-05 G_eff=9.22574297882182e-08
Ro10p32f1 h32f o10p 10499.8756434868
* o10 bias=-0.031263579434271 b-  bank=f alpha=0.001 R=1066.20335663783 G_phys=0.000937907383028131 G_eff=9.37907383028131e-07
Ro10bnf1 vreff o10n 1031.37291322126
Vo10p o10p 0 DC 0
Vo10n o10n 0 DC 0
Fo10p 0 o10d Vo10p 1
Fo10n o10d 0 Vo10n 1
Vo10d o10d 0 DC 0
Ho10 o10raw 0 Vo10d 33333.3333333333
Eo10sc o10lin 0 o10raw 0 1

* o11 input 1 w=-0.160102279955593 w-  bank=n alpha=1 R=208200.241386812 G_phys=4.80306839866778e-06 G_eff=4.80306839866778e-06
Ro11n1n1 h1buf o11n 200668.385063809
* o11 input 2 w=+0.011469223690656 w+  bank=f alpha=0.001 R=2906.32864371544 G_phys=0.00034407671071968 G_eff=3.4407671071968e-07
Ro11p2f1 h2f o11p 2817.11706573318
* o11 input 3 w=+0.0176041755498141 w+  bank=f alpha=0.001 R=1893.49016879608 G_phys=0.000528125266494424 G_eff=5.28125266494424e-07
Ro11p3f1 h3f o11p 1826.16671493064
* o11 input 4 w=-0.0193710750418404 w-  bank=f alpha=0.001 R=1720.77870027013 G_phys=0.000581132251255212 G_eff=5.81132251255212e-07
Ro11n4f1 h4f o11n 1666.70008759874
* o11 input 5 w=+0.112602634979867 w+  bank=n alpha=1 R=296026.228331984 G_phys=3.37807904939602e-06 G_eff=3.37807904939602e-06
Ro11p5n1 h5buf o11p 286606.583799215
* o11 input 6 w=+0.00163262396170036 w+  bank=f alpha=0.001 R=20417.0305687643 G_phys=4.89787188510109e-05 G_eff=4.89787188510109e-08
Ro11p6f1 h6f o11p 19837.4813597056
* o11 input 7 w=-0.0344149127536822 w-  bank=n alpha=1 R=968572.361984759 G_phys=1.03244738261047e-06 G_eff=1.03244738261047e-06
Ro11n7n1 h7buf o11n 934262.583122408
* o11 input 8 w=+0.0140339587694358 w+  bank=f alpha=0.001 R=2375.19105485255 G_phys=0.000421018763083073 G_eff=4.21018763083073e-07
Ro11p8f1 h8f o11p 2308.80430550511
* o11 input 9 w=+0.200472625000294 w+  bank=n alpha=1 R=166273.741032146 G_phys=6.01417875000882e-06 G_eff=6.01417875000882e-06
Ro11p9n1 h9buf o11p 161496.707795687
* o11 input 10 w=+0.127220756971711 w+  bank=n alpha=1 R=262011.751280064 G_phys=3.81662270915132e-06 G_eff=3.81662270915132e-06
Ro11p10n1 h10buf o11p 252892.236932747
* o11 input 11 w=-0.215899699488286 w-  bank=n alpha=1 R=154392.680547209 G_phys=6.47699098464857e-06 G_eff=6.47699098464857e-06
Ro11n11n1 h11buf o11n 149064.584922066
* o11 input 12 w=-0.0276713436872213 w-  bank=f alpha=0.001 R=1204.61563811687 G_phys=0.000830140310616638 G_eff=8.30140310616639e-07
Ro11n12f1 h12f o11n 1170.07269825532
* o11 input 13 w=+0.188664634231365 w+  bank=n alpha=1 R=176680.34854087 G_phys=5.65993902694096e-06 G_eff=5.65993902694096e-06
Ro11p13n1 h13buf o11p 171558.719612827
* o11 input 14 w=-0.119078372545684 w-  bank=n alpha=1 R=279927.686453265 G_phys=3.57235117637052e-06 G_eff=3.57235117637052e-06
Ro11n14n1 h14buf o11n 271613.978098947
* o11 input 15 w=+0.15422975355602 w+  bank=n alpha=1 R=216127.774082359 G_phys=4.6268926066806e-06 G_eff=4.6268926066806e-06
Ro11p15n1 h15buf o11p 209150.163537337
* o11 input 16 w=-0.104607206722078 w-  bank=n alpha=1 R=318652.360366468 G_phys=3.13821620166235e-06 G_eff=3.13821620166235e-06
Ro11n16n1 h16buf o11n 310110.591780323
* o11 input 17 w=+0.106639727219858 w+  bank=n alpha=1 R=312578.944098482 G_phys=3.19919181659573e-06 G_eff=3.19919181659573e-06
Ro11p17n1 h17buf o11p 302878.89892754
* o11 input 18 w=+0.310905721051453 w+  bank=n alpha=1 R=107213.637692492 G_phys=9.32717163154358e-06 G_eff=9.32717163154358e-06
Ro11p18n1 h18buf o11p 104321.416604696
* o11 input 19 w=+0.210141672521531 w+  bank=n alpha=1 R=158623.146629415 G_phys=6.30425017564592e-06 G_eff=6.30425017564592e-06
Ro11p19n1 h19buf o11p 153790.855516391
* o11 input 20 w=+0.009349861892821 w+  bank=f alpha=0.001 R=3565.11504826903 G_phys=0.00028049585678463 G_eff=2.8049585678463e-07
Ro11p20f1 h20f o11p 3453.7798101806
* o11 input 21 w=-0.148461029214851 w-  bank=n alpha=1 R=224525.81333714 G_phys=4.45383087644554e-06 G_eff=4.45383087644554e-06
Ro11n21n1 h21buf o11n 217102.976246348
* o11 input 22 w=-0.118671866129314 w-  bank=n alpha=1 R=280886.56916384 G_phys=3.56015598387941e-06 G_eff=3.56015598387941e-06
Ro11n22n1 h22buf o11n 271497.299701403
* o11 input 23 w=-0.109207143921327 w-  bank=n alpha=1 R=305230.336921427 G_phys=3.2762143176398e-06 G_eff=3.2762143176398e-06
Ro11n23n1 h23buf o11n 296657.109134577
* o11 input 24 w=-0.0902417819363344 w-  bank=n alpha=1 R=369378.048816124 G_phys=2.70725345809003e-06 G_eff=2.70725345809003e-06
Ro11n24n1 h24buf o11n 358257.647203946
* o11 input 25 w=+0.314745464583241 w+  bank=n alpha=1 R=105905.68279505 G_phys=9.44236393749723e-06 G_eff=9.44236393749723e-06
Ro11p25n1 h25buf o11p 102969.287762369
* o11 input 26 w=+0.0956381358816812 w+  bank=n alpha=1 R=348536.000059346 G_phys=2.86914407645044e-06 G_eff=2.86914407645044e-06
Ro11p26n1 h26buf o11p 338954.792888779
* o11 input 27 w=-0.150311342322866 w-  bank=n alpha=1 R=221761.929726726 G_phys=4.50934026968598e-06 G_eff=4.50934026968598e-06
Ro11n27n1 h27buf o11n 214618.304265782
* o11 input 28 w=-0.0832874521070705 w-  bank=n alpha=1 R=400220.351205864 G_phys=2.49862356321211e-06 G_eff=2.49862356321211e-06
Ro11n28n1 h28buf o11n 388028.1611907
* o11 input 29 w=+0.0404370827831914 w+  bank=n alpha=1 R=824325.86722574 G_phys=1.21311248349574e-06 G_eff=1.21311248349574e-06
Ro11p29n1 h29buf o11p 799671.479305581
* o11 input 30 w=-0.0722629324126473 w-  bank=n alpha=1 R=461278.448305807 G_phys=2.16788797237942e-06 G_eff=2.16788797237942e-06
Ro11n30n1 h30buf o11n 444757.455986935
* o11 input 31 w=-0.0830409064130833 w-  bank=n alpha=1 R=401408.592140338 G_phys=2.4912271923925e-06 G_eff=2.4912271923925e-06
Ro11n31n1 h31buf o11n 389124.500163713
* o11 input 32 w=-0.390143512242536 w-  bank=n alpha=1 R=85438.6457479045 G_phys=1.17043053672761e-05 G_eff=1.17043053672761e-05
Ro11n32n1 h32buf o11n 82813.555904104
* o11 bias=-0.00144268984703634 b-  bank=f alpha=0.001 R=23104.9891990359 G_phys=4.32806954110901e-05 G_eff=4.32806954110902e-08
Ro11bnf1 vreff o11n 22486.1621286287
Vo11p o11p 0 DC 0
Vo11n o11n 0 DC 0
Fo11p 0 o11d Vo11p 1
Fo11n o11d 0 Vo11n 1
Vo11d o11d 0 DC 0
Ho11 o11raw 0 Vo11d 33333.3333333333
Eo11sc o11lin 0 o11raw 0 1

* o12 input 1 w=-0.0568819810826339 w-  bank=n alpha=1 R=586008.656852319 G_phys=1.70645943247902e-06 G_eff=1.70645943247902e-06
Ro12n1n1 h1buf o12n 569722.284982957
* o12 input 2 w=-0.116449760348513 w-  bank=n alpha=1 R=286246.47430422 G_phys=3.4934928104554e-06 G_eff=3.4934928104554e-06
Ro12n2n1 h2buf o12n 278414.383903979
* o12 input 3 w=-0.394245634375715 w-  bank=n alpha=1 R=84549.6574391152 G_phys=1.18273690312714e-05 G_eff=1.18273690312714e-05
Ro12n3n1 h3buf o12n 81681.3691995343
* o12 input 4 w=-0.0304757769901363 w-  bank=f alpha=0.001 R=1093.76483966666 G_phys=0.000914273309704088 G_eff=9.14273309704088e-07
Ro12n4f1 h4f o12n 1058.87635633447
* o12 input 5 w=-0.225077356892672 w-  bank=n alpha=1 R=148097.231074329 G_phys=6.75232070678017e-06 G_eff=6.75232070678017e-06
Ro12n5n1 h5buf o12n 143121.127468524
* o12 input 6 w=-0.48876360312342 w-  bank=n alpha=1 R=68199.2953655269 G_phys=1.46629080937026e-05 G_eff=1.46629080937026e-05
Ro12n6n1 h6buf o12n 66376.0404547865
* o12 input 7 w=+0.269859073889073 w+  bank=n alpha=1 R=123521.261868093 G_phys=8.09577221667219e-06 G_eff=8.09577221667219e-06
Ro12p7n1 h7buf o12p 119724.219032049
* o12 input 8 w=-0.0167144075003679 w-  bank=f alpha=0.001 R=1994.28746323192 G_phys=0.000501432225011038 G_eff=5.01432225011038e-07
Ro12n8f1 h8f o12n 1925.11067516669
* o12 input 9 w=-0.271168635938693 w-  bank=n alpha=1 R=122924.737287352 G_phys=8.13505907816079e-06 G_eff=8.13505907816079e-06
Ro12n9n1 h9buf o12n 119680.267107195
* o12 input 10 w=-0.229866523415109 w-  bank=n alpha=1 R=145011.691298509 G_phys=6.89599570245327e-06 G_eff=6.89599570245327e-06
Ro12n10n1 h10buf o12n 140536.384430862
* o12 input 11 w=+0.111794037161303 w+  bank=n alpha=1 R=298167.363660355 G_phys=3.35382111483908e-06 G_eff=3.35382111483908e-06
Ro12p11n1 h11buf o12p 289670.530264978
* o12 input 12 w=-0.187970289472281 w-  bank=n alpha=1 R=177332.989308658 G_phys=5.63910868416843e-06 G_eff=5.63910868416843e-06
Ro12n12n1 h12buf o12n 172054.419800508
* o12 input 13 w=+0.219867348390274 w+  bank=n alpha=1 R=151606.564491628 G_phys=6.59602045170821e-06 G_eff=6.59602045170821e-06
Ro12p13n1 h13buf o12p 146204.189598377
* o12 input 14 w=-0.127058880326711 w-  bank=n alpha=1 R=262345.561739739 G_phys=3.81176640980134e-06 G_eff=3.81176640980134e-06
Ro12n14n1 h14buf o12n 253572.622692465
* o12 input 15 w=+0.40629100094033 w+  bank=n alpha=1 R=82043.0018291959 G_phys=1.21887300282099e-05 G_eff=1.21887300282099e-05
Ro12p15n1 h15buf o12p 79316.1254433093
* o12 input 16 w=-0.479164967789437 w-  bank=n alpha=1 R=69565.4640344684 G_phys=1.43749490336831e-05 G_eff=1.43749490336831e-05
Ro12n16n1 h16buf o12n 67135.6115003568
* o12 input 17 w=-0.142691971348636 w-  bank=n alpha=1 R=233603.425744892 G_phys=4.28075914045907e-06 G_eff=4.28075914045907e-06
Ro12n17n1 h17buf o12n 226433.955299368
* o12 input 18 w=+0.0750962927559542 w+  bank=n alpha=1 R=443874.552391808 G_phys=2.25288878267863e-06 G_eff=2.25288878267863e-06
Ro12p18n1 h18buf o12p 428736.561403907
* o12 input 19 w=-0.0357891000093011 w-  bank=n alpha=1 R=931382.273504235 G_phys=1.07367300027903e-06 G_eff=1.07367300027903e-06
Ro12n19n1 h19buf o12n 897797.698134488
* o12 input 20 w=-0.274882313904053 w-  bank=n alpha=1 R=121264.016079871 G_phys=8.24646941712159e-06 G_eff=8.24646941712159e-06
Ro12n20n1 h20buf o12n 116932.719015533
* o12 input 21 w=+0.0723735016816067 w+  bank=n alpha=1 R=460573.726002328 G_phys=2.1712050504482e-06 G_eff=2.1712050504482e-06
Ro12p21n1 h21buf o12p 447342.984223732
* o12 input 22 w=-0.42830678611073 w-  bank=n alpha=1 R=77825.8351589968 G_phys=1.28492035833219e-05 G_eff=1.28492035833219e-05
Ro12n22n1 h22buf o12n 75563.018123882
* o12 input 23 w=-0.495732058756383 w-  bank=n alpha=1 R=67240.6247377966 G_phys=1.48719617626915e-05 G_eff=1.48719617626915e-05
Ro12n23n1 h23buf o12n 64953.360300156
* o12 input 24 w=-0.0511653226482421 w-  bank=n alpha=1 R=651482.910847599 G_phys=1.53495967944726e-06 G_eff=1.53495967944726e-06
Ro12n24n1 h24buf o12n 632782.194956579
* o12 input 25 w=+0.0558940521557335 w+  bank=n alpha=1 R=596366.376165735 G_phys=1.676821564672e-06 G_eff=1.676821564672e-06
Ro12p25n1 h25buf o12p 579042.969434702
* o12 input 26 w=+0.307817092263132 w+  bank=n alpha=1 R=108289.416576123 G_phys=9.23451276789396e-06 G_eff=9.23451276789396e-06
Ro12p26n1 h26buf o12p 104899.939341893
* o12 input 27 w=-0.124284155438311 w-  bank=n alpha=1 R=268202.597634244 G_phys=3.72852466314934e-06 G_eff=3.72852466314934e-06
Ro12n27n1 h27buf o12n 258943.077525108
* o12 input 28 w=+0.511620988407946 w+  bank=n alpha=1 R=65152.3961850343 G_phys=1.53486296522384e-05 G_eff=1.53486296522384e-05
Ro12p28n1 h28buf o12p 62837.8971224009
* o12 input 29 w=-0.110998740438628 w-  bank=n alpha=1 R=300303.70796652 G_phys=3.32996221315884e-06 G_eff=3.32996221315884e-06
Ro12n29n1 h29buf o12n 291656.062731491
* o12 input 30 w=+0.0696620617055659 w+  bank=n alpha=1 R=478500.528368227 G_phys=2.08986185116698e-06 G_eff=2.08986185116698e-06
Ro12p30n1 h30buf o12p 462673.054373338
* o12 input 31 w=+0.219973071991933 w+  bank=n alpha=1 R=151533.699245496 G_phys=6.59919215975798e-06 G_eff=6.59919215975798e-06
Ro12p31n1 h31buf o12p 146653.613378704
* o12 input 32 w=+0.138023444689957 w+  bank=n alpha=1 R=241504.864685924 G_phys=4.14070334069872e-06 G_eff=4.14070334069872e-06
Ro12p32n1 h32buf o12p 234899.282318194
* o12 bias=+0.00625312847600372 b+  bank=f alpha=0.001 R=5330.66503610944 G_phys=0.000187593854280111 G_eff=1.87593854280111e-07
Ro12bpf1 vreff o12p 5151.82945098401
Vo12p o12p 0 DC 0
Vo12n o12n 0 DC 0
Fo12p 0 o12d Vo12p 1
Fo12n o12d 0 Vo12n 1
Vo12d o12d 0 DC 0
Ho12 o12raw 0 Vo12d 33333.3333333333
Eo12sc o12lin 0 o12raw 0 1

* o13 input 1 w=+0.00200007413415942 w+  bank=f alpha=0.001 R=16666.0489049035 G_phys=6.00022240247825e-05 G_eff=6.00022240247825e-08
Ro13p1f1 h1f o13p 16222.1539182742
* o13 input 2 w=-0.0237460165980216 w-  bank=f alpha=0.001 R=1403.74421098108 G_phys=0.000712380497940648 G_eff=7.12380497940648e-07
Ro13n2f1 h2f o13n 1365.25578950309
* o13 input 3 w=-0.481641955158027 w-  bank=n alpha=1 R=69207.7028929023 G_phys=1.44492586547408e-05 G_eff=1.44492586547408e-05
Ro13n3n1 h3buf o13n 66754.5871341277
* o13 input 4 w=-0.401500412219866 w-  bank=n alpha=1 R=83021.9155916573 G_phys=1.2045012366596e-05 G_eff=1.2045012366596e-05
Ro13n4n1 h4buf o13n 80675.3093281717
* o13 input 5 w=-0.324731283585407 w-  bank=n alpha=1 R=102648.974762441 G_phys=9.7419385075622e-06 G_eff=9.7419385075622e-06
Ro13n5n1 h5buf o13n 99859.2509537678
* o13 input 6 w=+0.0791891194793975 w+  bank=n alpha=1 R=420933.248815901 G_phys=2.37567358438193e-06 G_eff=2.37567358438193e-06
Ro13p6n1 h6buf o13p 409794.007547604
* o13 input 7 w=+0.286949833874567 w+  bank=n alpha=1 R=116164.323509956 G_phys=8.60849501623701e-06 G_eff=8.60849501623701e-06
Ro13p7n1 h7buf o13p 112653.238440722
* o13 input 8 w=-0.153846131933853 w-  bank=n alpha=1 R=216666.697526495 G_phys=4.61538395801558e-06 G_eff=4.61538395801558e-06
Ro13n8n1 h8buf o13n 209103.120334448
* o13 input 9 w=-0.0455077430770376 w-  bank=n alpha=1 R=732476.081639671 G_phys=1.36523229231113e-06 G_eff=1.36523229231113e-06
Ro13n9n1 h9buf o13n 706804.352716739
* o13 input 10 w=+0.122909253832841 w+  bank=n alpha=1 R=271202.796322133 G_phys=3.68727761498523e-06 G_eff=3.68727761498523e-06
Ro13p10n1 h10buf o13p 262550.369401601
* o13 input 11 w=+0.0797228425783465 w+  bank=n alpha=1 R=418115.213347736 G_phys=2.3916852773504e-06 G_eff=2.3916852773504e-06
Ro13p11n1 h11buf o13p 406058.402186253
* o13 input 12 w=-0.0916703213430956 w-  bank=n alpha=1 R=363621.866324394 G_phys=2.75010964029287e-06 G_eff=2.75010964029287e-06
Ro13n12n1 h12buf o13n 352933.432106994
* o13 input 13 w=-0.00253109868008519 w-  bank=f alpha=0.001 R=13169.5115625486 G_phys=7.59329604025557e-05 G_eff=7.59329604025556e-08
Ro13n13f1 h13f o13n 12807.6082340992
* o13 input 14 w=+0.523873822520012 w+  bank=n alpha=1 R=63628.5530988905 G_phys=1.57162146756004e-05 G_eff=1.57162146756004e-05
Ro13p14n1 h14buf o13p 61858.5435306212
* o13 input 15 w=+0.0718975606852002 w+  bank=n alpha=1 R=463622.590469816 G_phys=2.15692682055601e-06 G_eff=2.15692682055601e-06
Ro13p15n1 h15buf o13p 449275.32436578
* o13 input 16 w=+0.212010526629755 w+  bank=n alpha=1 R=157224.897570982 G_phys=6.36031579889266e-06 G_eff=6.36031579889266e-06
Ro13p16n1 h16buf o13p 151677.291515781
* o13 input 17 w=+0.50252589011925 w+  bank=n alpha=1 R=66331.5741312817 G_phys=1.50757767035775e-05 G_eff=1.50757767035775e-05
Ro13p17n1 h17buf o13p 64164.869461517
* o13 input 18 w=-0.0631368164337741 w-  bank=n alpha=1 R=527953.97703173 G_phys=1.89410449301322e-06 G_eff=1.89410449301322e-06
Ro13n18n1 h18buf o13n 510342.693669274
* o13 input 19 w=+0.124615759492256 w+  bank=n alpha=1 R=267488.907254983 G_phys=3.73847278476769e-06 G_eff=3.73847278476769e-06
Ro13p19n1 h19buf o13p 258633.000255508
* o13 input 20 w=-0.0825374863137293 w-  bank=n alpha=1 R=403856.899719863 G_phys=2.47612458941188e-06 G_eff=2.47612458941188e-06
Ro13n20n1 h20buf o13n 390091.33910104
* o13 input 21 w=-0.0332297714786912 w-  bank=f alpha=0.001 R=1003.11653827377 G_phys=0.000996893144360737 G_eff=9.96893144360737e-07
Ro13n21f1 h21f o13n 976.770242598895
* o13 input 22 w=+0.217350752944783 w+  bank=n alpha=1 R=153361.940925972 G_phys=6.5205225883435e-06 G_eff=6.5205225883435e-06
Ro13p22n1 h22buf o13p 148649.406888799
* o13 input 23 w=+0.00620341639632115 w+  bank=f alpha=0.001 R=5373.38318174179 G_phys=0.000186102491889634 G_eff=1.86102491889634e-07
Ro13p23f1 h23f o13p 5193.75061914325
* o13 input 24 w=-0.56329887647671 w-  bank=n alpha=1 R=59175.2171455139 G_phys=1.68989662943013e-05 G_eff=1.68989662943013e-05
Ro13n24n1 h24buf o13n 57234.0209624897
* o13 input 25 w=+0.121217122487375 w+  bank=n alpha=1 R=274988.653824918 G_phys=3.63651367462124e-06 G_eff=3.63651367462124e-06
Ro13p25n1 h25buf o13p 266251.48478162
* o13 input 26 w=-0.0619389520134905 w-  bank=n alpha=1 R=538164.309368251 G_phys=1.85816856040471e-06 G_eff=1.85816856040471e-06
Ro13n26n1 h26buf o13n 522046.270346345
* o13 input 27 w=-0.148385692307615 w-  bank=n alpha=1 R=224639.807349019 G_phys=4.45157076922844e-06 G_eff=4.45157076922844e-06
Ro13n27n1 h27buf o13n 217299.169559225
* o13 input 28 w=+0.0960859107643036 w+  bank=n alpha=1 R=346911.769563169 G_phys=2.88257732292911e-06 G_eff=2.88257732292911e-06
Ro13p28n1 h28buf o13p 336298.493472256
* o13 input 29 w=-0.0967464729103534 w-  bank=n alpha=1 R=344543.137652372 G_phys=2.9023941873106e-06 G_eff=2.9023941873106e-06
Ro13n29n1 h29buf o13n 333761.612903984
* o13 input 30 w=+0.0502110731232858 w+  bank=n alpha=1 R=663864.188910847 G_phys=1.50633219369857e-06 G_eff=1.50633219369857e-06
Ro13p30n1 h30buf o13p 642024.508185664
* o13 input 31 w=+0.0717291842082243 w+  bank=n alpha=1 R=464710.894195719 G_phys=2.15187552624673e-06 G_eff=2.15187552624673e-06
Ro13p31n1 h31buf o13p 452325.2786374
* o13 input 32 w=+0.117218732023777 w+  bank=n alpha=1 R=284368.656424059 G_phys=3.51656196071332e-06 G_eff=3.51656196071332e-06
Ro13p32n1 h32buf o13p 275894.831365207
* o13 bias=+0.00474280842399728 b+  bank=f alpha=0.001 R=7028.1846436546 G_phys=0.000142284252719918 G_eff=1.42284252719918e-07
Ro13bpf1 vreff o13p 6779.53767172937
Vo13p o13p 0 DC 0
Vo13n o13n 0 DC 0
Fo13p 0 o13d Vo13p 1
Fo13n o13d 0 Vo13n 1
Vo13d o13d 0 DC 0
Ho13 o13raw 0 Vo13d 33333.3333333333
Eo13sc o13lin 0 o13raw 0 1

* o14 input 1 w=-0.25477230027339 w-  bank=n alpha=1 R=130835.782765882 G_phys=7.64316900820172e-06 G_eff=7.64316900820172e-06
Ro14n1n1 h1buf o14n 126176.911958322
* o14 input 2 w=+0.102637632071701 w+  bank=n alpha=1 R=324767.170291372 G_phys=3.07912896215104e-06 G_eff=3.07912896215104e-06
Ro14p2n1 h2buf o14p 315284.706852303
* o14 input 3 w=+0.107208211835011 w+  bank=n alpha=1 R=310921.456134648 G_phys=3.21624635505032e-06 G_eff=3.21624635505032e-06
Ro14p3n1 h3buf o14p 300530.832578584
* o14 input 4 w=-0.361346054145307 w-  bank=n alpha=1 R=92247.6749114552 G_phys=1.08403816243592e-05 G_eff=1.08403816243592e-05
Ro14n4n1 h4buf o14n 89304.4829246475
* o14 input 5 w=+0.0565127294479513 w+  bank=n alpha=1 R=589837.611082537 G_phys=1.69538188343854e-06 G_eff=1.69538188343854e-06
Ro14p5n1 h5buf o14p 568530.310020784
* o14 input 6 w=-0.166023137794918 w-  bank=n alpha=1 R=200775.22793545 G_phys=4.98069413384754e-06 G_eff=4.98069413384754e-06
Ro14n6n1 h6buf o14n 195370.933816282
* o14 input 7 w=+0.0533068959488943 w+  bank=n alpha=1 R=625309.96674971 G_phys=1.59920687846683e-06 G_eff=1.59920687846683e-06
Ro14p7n1 h7buf o14p 607314.651607558
* o14 input 8 w=-0.334728977765226 w-  bank=n alpha=1 R=99583.0524022118 G_phys=1.00418693329568e-05 G_eff=1.00418693329568e-05
Ro14n8n1 h8buf o14n 96047.4950053464
* o14 input 9 w=-0.184424571200296 w-  bank=n alpha=1 R=180742.365924394 G_phys=5.53273713600887e-06 G_eff=5.53273713600887e-06
Ro14n9n1 h9buf o14n 175073.340054457
* o14 input 10 w=+0.263838736865495 w+  bank=n alpha=1 R=126339.800324039 G_phys=7.91516210596486e-06 G_eff=7.91516210596486e-06
Ro14p10n1 h10buf o14p 121993.422452397
* o14 input 11 w=+0.0215454170832462 w+  bank=f alpha=0.001 R=1547.11942704759 G_phys=0.000646362512497387 G_eff=6.46362512497387e-07
Ro14p11f1 h11f o14p 1495.126645703
* o14 input 12 w=-0.0509620245346412 w-  bank=n alpha=1 R=654081.811657133 G_phys=1.52886073603923e-06 G_eff=1.52886073603923e-06
Ro14n12n1 h12buf o14n 635897.494260073
* o14 input 13 w=-0.289718223355261 w-  bank=n alpha=1 R=115054.320530121 G_phys=8.69154670065782e-06 G_eff=8.69154670065782e-06
Ro14n13n1 h13buf o14n 111221.264957515
* o14 input 14 w=+0.114352462647064 w+  bank=n alpha=1 R=291496.41871914 G_phys=3.43057387941191e-06 G_eff=3.43057387941191e-06
Ro14p14n1 h14buf o14p 281968.140994101
* o14 input 15 w=-0.172686817087866 w-  bank=n alpha=1 R=193027.666474232 G_phys=5.18060451263599e-06 G_eff=5.18060451263599e-06
Ro14n15n1 h15buf o14n 187739.64457743
* o14 input 16 w=-0.0880371911025684 w-  bank=n alpha=1 R=378627.860746921 G_phys=2.64111573307705e-06 G_eff=2.64111573307705e-06
Ro14n16n1 h16buf o14n 366994.339025636
* o14 input 17 w=-0.0970577820037651 w-  bank=n alpha=1 R=343438.028823286 G_phys=2.91173346011295e-06 G_eff=2.91173346011295e-06
Ro14n17n1 h17buf o14n 333047.490845118
* o14 input 18 w=+0.279065168461303 w+  bank=n alpha=1 R=119446.412883145 G_phys=8.3719550538391e-06 G_eff=8.3719550538391e-06
Ro14p18n1 h18buf o14p 115896.638225435
* o14 input 19 w=+0.12574844379754 w+  bank=n alpha=1 R=265079.489866303 G_phys=3.7724533139262e-06 G_eff=3.7724533139262e-06
Ro14p19n1 h19buf o14p 255576.314684181
* o14 input 20 w=+0.196093228285189 w+  bank=n alpha=1 R=169987.172044793 G_phys=5.88279684855566e-06 G_eff=5.88279684855566e-06
Ro14p20n1 h20buf o14p 165281.35406351
* o14 input 21 w=+0.0606582432664274 w+  bank=n alpha=1 R=549526.849746115 G_phys=1.81974729799282e-06 G_eff=1.81974729799282e-06
Ro14p21n1 h21buf o14p 532495.339142908
* o14 input 22 w=+0.471542863591523 w+  bank=n alpha=1 R=70689.9327867011 G_phys=1.41462859077457e-05 G_eff=1.41462859077457e-05
Ro14p22n1 h22buf o14p 68763.1301182119
* o14 input 23 w=+0.132895212526076 w+  bank=n alpha=1 R=250824.184707127 G_phys=3.98685637578228e-06 G_eff=3.98685637578228e-06
Ro14p23n1 h23buf o14p 242377.476831753
* o14 input 24 w=-0.150700282102261 w-  bank=n alpha=1 R=221189.588156937 G_phys=4.52100846306782e-06 G_eff=4.52100846306782e-06
Ro14n24n1 h24buf o14n 214232.856308628
* o14 input 25 w=-0.172018927572569 w-  bank=n alpha=1 R=193777.125597247 G_phys=5.16056782717707e-06 G_eff=5.16056782717707e-06
Ro14n25n1 h25buf o14n 187094.099617033
* o14 input 26 w=-0.144277203051731 w-  bank=n alpha=1 R=231036.730878278 G_phys=4.32831609155192e-06 G_eff=4.32831609155192e-06
Ro14n26n1 h26buf o14n 223338.043230798
* o14 input 27 w=-0.0456897569368309 w-  bank=n alpha=1 R=729558.12348529 G_phys=1.37069270810493e-06 G_eff=1.37069270810493e-06
Ro14n27n1 h27buf o14n 703556.630529061
* o14 input 28 w=-0.269930966859316 w-  bank=n alpha=1 R=123488.363418141 G_phys=8.09792900577949e-06 G_eff=8.09792900577949e-06
Ro14n28n1 h28buf o14n 119811.083497366
* o14 input 29 w=-0.380176315173873 w-  bank=n alpha=1 R=87678.6164811146 G_phys=1.14052894552162e-05 G_eff=1.14052894552162e-05
Ro14n29n1 h29buf o14n 85228.5032975544
* o14 input 30 w=+0.211443520189348 w+  bank=n alpha=1 R=157646.511482042 G_phys=6.34330560568043e-06 G_eff=6.34330560568043e-06
Ro14p30n1 h30buf o14p 153392.92945377
* o14 input 31 w=+0.0784944631218348 w+  bank=n alpha=1 R=424658.402741034 G_phys=2.35483389365504e-06 G_eff=2.35483389365504e-06
Ro14p31n1 h31buf o14p 411803.855237858
* o14 input 32 w=+0.0843025902123393 w+  bank=n alpha=1 R=395401.057658776 G_phys=2.52907770637018e-06 G_eff=2.52907770637018e-06
Ro14p32n1 h32buf o14p 382727.608775518
* o14 bias=-0.0124822366617376 b-  bank=f alpha=0.001 R=2670.46157164376 G_phys=0.00037446709985213 G_eff=3.74467099852129e-07
Ro14bnf1 vreff o14n 2581.04823709775
Vo14p o14p 0 DC 0
Vo14n o14n 0 DC 0
Fo14p 0 o14d Vo14p 1
Fo14n o14d 0 Vo14n 1
Vo14d o14d 0 DC 0
Ho14 o14raw 0 Vo14d 33333.3333333333
Eo14sc o14lin 0 o14raw 0 1

* o15 input 1 w=-0.113449668897813 w-  bank=n alpha=1 R=293816.047743229 G_phys=3.40349006693439e-06 G_eff=3.40349006693439e-06
Ro15n1n1 h1buf o15n 283761.499143924
* o15 input 2 w=-0.169978823552936 w-  bank=n alpha=1 R=196102.85938326 G_phys=5.09936470658807e-06 G_eff=5.09936470658807e-06
Ro15n2n1 h2buf o15n 190638.361683425
* o15 input 3 w=+0.0133598434574407 w+  bank=f alpha=0.001 R=2495.03921505672 G_phys=0.00040079530372322 G_eff=4.0079530372322e-07
Ro15p3f1 h3f o15p 2408.96327621039
* o15 input 4 w=-0.169966115485037 w-  bank=n alpha=1 R=196117.52164959 G_phys=5.0989834645511e-06 G_eff=5.0989834645511e-06
Ro15n4n1 h4buf o15n 190540.417075756
* o15 input 5 w=-0.0418903282162887 w-  bank=n alpha=1 R=795728.626455878 G_phys=1.25670984648866e-06 G_eff=1.25670984648866e-06
Ro15n5n1 h5buf o15n 771199.897990553
* o15 input 6 w=-0.324291927905124 w-  bank=n alpha=1 R=102788.045168628 G_phys=9.72875783715372e-06 G_eff=9.72875783715372e-06
Ro15n6n1 h6buf o15n 99113.1870183465
* o15 input 7 w=+0.558916704640692 w+  bank=n alpha=1 R=59639.1788911769 G_phys=1.67675011392208e-05 G_eff=1.67675011392208e-05
Ro15p7n1 h7buf o15p 57676.6046672481
* o15 input 8 w=-0.047599242693459 w-  bank=n alpha=1 R=700291.253539501 G_phys=1.42797728080377e-06 G_eff=1.42797728080377e-06
Ro15n8n1 h8buf o15n 674916.020613919
* o15 input 9 w=-0.103084990895521 w-  bank=n alpha=1 R=323357.775402217 G_phys=3.09254972686562e-06 G_eff=3.09254972686562e-06
Ro15n9n1 h9buf o15n 312276.263892402
* o15 input 10 w=-0.115049291784761 w-  bank=n alpha=1 R=289730.886789766 G_phys=3.45147875354283e-06 G_eff=3.45147875354283e-06
Ro15n10n1 h10buf o15n 280621.229839324
* o15 input 11 w=+0.0920546297717411 w+  bank=n alpha=1 R=362103.822653861 G_phys=2.76163889315223e-06 G_eff=2.76163889315223e-06
Ro15p11n1 h11buf o15p 349085.966023832
* o15 input 12 w=+0.0505985364133342 w+  bank=n alpha=1 R=658780.583316418 G_phys=1.51795609240003e-06 G_eff=1.51795609240003e-06
Ro15p12n1 h12buf o15p 637513.533837239
* o15 input 13 w=-0.145296396139138 w-  bank=n alpha=1 R=229416.105416771 G_phys=4.35889188417414e-06 G_eff=4.35889188417414e-06
Ro15n13n1 h13buf o15n 222856.507996311
* o15 input 14 w=-0.379881852318272 w-  bank=n alpha=1 R=87746.579969306 G_phys=1.13964555695482e-05 G_eff=1.13964555695482e-05
Ro15n14n1 h14buf o15n 85348.1305208199
* o15 input 15 w=+0.223112491519187 w+  bank=n alpha=1 R=149401.466078231 G_phys=6.69337474557561e-06 G_eff=6.69337474557561e-06
Ro15p15n1 h15buf o15p 145154.234771351
* o15 input 16 w=-0.14757878301826 w-  bank=n alpha=1 R=225868.059429714 G_phys=4.42736349054781e-06 G_eff=4.42736349054781e-06
Ro15n16n1 h16buf o15n 219796.514609396
* o15 input 17 w=+0.173921977011029 w+  bank=n alpha=1 R=191656.821674811 G_phys=5.21765931033087e-06 G_eff=5.21765931033087e-06
Ro15p17n1 h17buf o15p 185586.169639694
* o15 input 18 w=+0.133725887369399 w+  bank=n alpha=1 R=249266.121833648 G_phys=4.01177662108198e-06 G_eff=4.01177662108198e-06
Ro15p18n1 h18buf o15p 242717.615551049
* o15 input 19 w=+0.209560948195519 w+  bank=n alpha=1 R=159062.714787077 G_phys=6.28682844586558e-06 G_eff=6.28682844586558e-06
Ro15p19n1 h19buf o15p 154359.889566135
* o15 input 20 w=-0.0239329977507233 w-  bank=f alpha=0.001 R=1392.7771890726 G_phys=0.000717989932521699 G_eff=7.179899325217e-07
Ro15n20f1 h20f o15n 1354.80760403983
* o15 input 21 w=+0.196041920231295 w+  bank=n alpha=1 R=170031.661054972 G_phys=5.88125760693885e-06 G_eff=5.88125760693885e-06
Ro15p21n1 h21buf o15p 164382.906968255
* o15 input 22 w=-0.0995510863910355 w-  bank=n alpha=1 R=334836.459769011 G_phys=2.98653259173107e-06 G_eff=2.98653259173107e-06
Ro15n22n1 h22buf o15n 325556.7001571
* o15 input 23 w=+0.102107365264583 w+  bank=n alpha=1 R=326453.760186243 G_phys=3.06322095793749e-06 G_eff=3.06322095793749e-06
Ro15p23n1 h23buf o15p 317843.750229333
* o15 input 24 w=-0.21795159550845 w-  bank=n alpha=1 R=152939.157226958 G_phys=6.53854786525351e-06 G_eff=6.53854786525351e-06
Ro15n24n1 h24buf o15n 148432.721966609
* o15 input 25 w=+0.202525001628457 w+  bank=n alpha=1 R=164588.732577744 G_phys=6.07575004885372e-06 G_eff=6.07575004885372e-06
Ro15p25n1 h25buf o15p 159897.434312773
* o15 input 26 w=-0.281017181998367 w-  bank=n alpha=1 R=118616.709114701 G_phys=8.43051545995101e-06 G_eff=8.43051545995101e-06
Ro15n26n1 h26buf o15n 115366.488511558
* o15 input 27 w=+0.141610254018665 w+  bank=n alpha=1 R=235387.850719764 G_phys=4.24830762055994e-06 G_eff=4.24830762055994e-06
Ro15p27n1 h27buf o15p 228215.864055255
* o15 input 28 w=+0.444984802739648 w+  bank=n alpha=1 R=74908.9252669063 G_phys=1.33495440821894e-05 G_eff=1.33495440821894e-05
Ro15p28n1 h28buf o15p 72632.2282847551
* o15 input 29 w=-0.120073433142323 w-  bank=n alpha=1 R=277607.897608986 G_phys=3.60220299426968e-06 G_eff=3.60220299426968e-06
Ro15n29n1 h29buf o15n 268040.196277981
* o15 input 30 w=-0.0538706707421541 w-  bank=n alpha=1 R=618765.886411172 G_phys=1.61612012226462e-06 G_eff=1.61612012226462e-06
Ro15n30n1 h30buf o15n 598266.663696663
* o15 input 31 w=+0.148090323839994 w+  bank=n alpha=1 R=225087.854959036 G_phys=4.44270971519983e-06 G_eff=4.44270971519983e-06
Ro15p31n1 h31buf o15p 219033.205768045
* o15 input 32 w=-0.347735979661958 w-  bank=n alpha=1 R=95858.1662033862 G_phys=1.04320793898588e-05 G_eff=1.04320793898588e-05
Ro15n32n1 h32buf o15n 92637.2148752712
* o15 bias=+0.0711229172621247 b+  bank=n alpha=1 R=468672.189169108 G_phys=2.13368751786374e-06 G_eff=2.13368751786374e-06
Ro15bpn1 vref o15p 452582.65141958
Vo15p o15p 0 DC 0
Vo15n o15n 0 DC 0
Fo15p 0 o15d Vo15p 1
Fo15n o15d 0 Vo15n 1
Vo15d o15d 0 DC 0
Ho15 o15raw 0 Vo15d 33333.3333333333
Eo15sc o15lin 0 o15raw 0 1

* o16 input 1 w=-0.0239168211298723 w-  bank=f alpha=0.001 R=1393.71922181162 G_phys=0.000717504633896169 G_eff=7.17504633896169e-07
Ro16n1f1 h1f o16n 1356.72983624778
* o16 input 2 w=-0.455843018824687 w-  bank=n alpha=1 R=73124.5888535874 G_phys=1.36752905647406e-05 G_eff=1.36752905647406e-05
Ro16n2n1 h2buf o16n 71167.5445126331
* o16 input 3 w=-0.360558107273835 w-  bank=n alpha=1 R=92449.2686778431 G_phys=1.0816743218215e-05 G_eff=1.0816743218215e-05
Ro16n3n1 h3buf o16n 89725.3980423446
* o16 input 4 w=+0.281324980833712 w+  bank=n alpha=1 R=118486.930078336 G_phys=8.43974942501135e-06 G_eff=8.43974942501135e-06
Ro16p4n1 h4buf o16p 115008.494555092
* o16 input 5 w=-0.0789059543438914 w-  bank=n alpha=1 R=422443.827091407 G_phys=2.36717863031674e-06 G_eff=2.36717863031674e-06
Ro16n5n1 h5buf o16n 408985.584538339
* o16 input 6 w=+0.0459206910877794 w+  bank=n alpha=1 R=725889.191641633 G_phys=1.37762073263338e-06 G_eff=1.37762073263338e-06
Ro16p6n1 h6buf o16p 701733.559049228
* o16 input 7 w=-0.348093944852844 w-  bank=n alpha=1 R=95759.5896918717 G_phys=1.04428183455853e-05 G_eff=1.04428183455853e-05
Ro16n7n1 h7buf o16n 92763.0839777886
* o16 input 8 w=-0.0796710739452782 w-  bank=n alpha=1 R=418386.896055 G_phys=2.39013221835835e-06 G_eff=2.39013221835835e-06
Ro16n8n1 h8buf o16n 406997.314115704
* o16 input 9 w=-0.173339228342165 w-  bank=n alpha=1 R=192301.15220967 G_phys=5.20017685026494e-06 G_eff=5.20017685026494e-06
Ro16n9n1 h9buf o16n 186163.053255937
* o16 input 10 w=+0.194262181446587 w+  bank=n alpha=1 R=171589.411202501 G_phys=5.82786544339762e-06 G_eff=5.82786544339762e-06
Ro16p10n1 h10buf o16p 166680.99720078
* o16 input 11 w=+0.155708231075043 w+  bank=n alpha=1 R=214075.602190025 G_phys=4.67124693225129e-06 G_eff=4.67124693225129e-06
Ro16p11n1 h11buf o16p 206709.961677489
* o16 input 12 w=+0.124882648574468 w+  bank=n alpha=1 R=266917.251626487 G_phys=3.74647945723404e-06 G_eff=3.74647945723404e-06
Ro16p12n1 h12buf o16p 257455.499452629
* o16 input 13 w=+0.270423516346849 w+  bank=n alpha=1 R=123263.441669694 G_phys=8.11270549040547e-06 G_eff=8.11270549040547e-06
Ro16p13n1 h13buf o16p 118812.720630406
* o16 input 14 w=-0.22936067173287 w-  bank=n alpha=1 R=145331.512510374 G_phys=6.88082015198609e-06 G_eff=6.88082015198609e-06
Ro16n14n1 h14buf o16n 140368.881931921
* o16 input 15 w=+0.0349795005301705 w+  bank=n alpha=1 R=952939.087983336 G_phys=1.04938501590512e-06 G_eff=1.04938501590512e-06
Ro16p15n1 h15buf o16p 926807.533502677
* o16 input 16 w=+0.104322324768401 w+  bank=n alpha=1 R=319522.531800691 G_phys=3.12966974305203e-06 G_eff=3.12966974305203e-06
Ro16p16n1 h16buf o16p 309034.760131715
* o16 input 17 w=-0.351176137449102 w-  bank=n alpha=1 R=94919.129686494 G_phys=1.05352841234731e-05 G_eff=1.05352841234731e-05
Ro16n17n1 h17buf o16n 91968.3282247062
* o16 input 18 w=+0.119462358831177 w+  bank=n alpha=1 R=279027.918580107 G_phys=3.58387076493532e-06 G_eff=3.58387076493532e-06
Ro16p18n1 h18buf o16p 270119.888087595
* o16 input 19 w=+0.230688311648174 w+  bank=n alpha=1 R=144495.111586626 G_phys=6.92064934944523e-06 G_eff=6.92064934944523e-06
Ro16p19n1 h19buf o16p 139457.555039067
* o16 input 20 w=-0.0614748986253126 w-  bank=n alpha=1 R=542226.731214294 G_phys=1.84424695875938e-06 G_eff=1.84424695875938e-06
Ro16n20n1 h20buf o16n 526648.037429386
* o16 input 21 w=+0.36727529530057 w+  bank=n alpha=1 R=90758.4413104999 G_phys=1.10182588590171e-05 G_eff=1.10182588590171e-05
Ro16p21n1 h21buf o16p 88173.6919668383
* o16 input 22 w=+0.579638140801163 w+  bank=n alpha=1 R=57507.1427964708 G_phys=1.73891442240349e-05 G_eff=1.73891442240349e-05
Ro16p22n1 h22buf o16p 55725.7902657366
* o16 input 23 w=-0.0387096142803063 w-  bank=n alpha=1 R=861112.515664923 G_phys=1.16128842840919e-06 G_eff=1.16128842840919e-06
Ro16n23n1 h23buf o16n 830718.009599388
* o16 input 24 w=+0.0384174368738491 w+  bank=n alpha=1 R=867661.563232072 G_phys=1.15252310621547e-06 G_eff=1.15252310621547e-06
Ro16p24n1 h24buf o16p 839988.601527091
* o16 input 25 w=+0.201641208818347 w+  bank=n alpha=1 R=165310.12449624 G_phys=6.04923626455041e-06 G_eff=6.04923626455041e-06
Ro16p25n1 h25buf o16p 159879.805478616
* o16 input 26 w=-0.606109769372092 w-  bank=n alpha=1 R=54995.5387913735 G_phys=1.81832930811628e-05 G_eff=1.81832930811628e-05
Ro16n26n1 h26buf o16n 53501.0251441491
* o16 input 27 w=-0.101484914332963 w-  bank=n alpha=1 R=328456.04248105 G_phys=3.04454742998888e-06 G_eff=3.04454742998888e-06
Ro16n27n1 h27buf o16n 316963.51365274
* o16 input 28 w=+0.04265872854179 w+  bank=n alpha=1 R=781395.378455286 G_phys=1.2797618562537e-06 G_eff=1.2797618562537e-06
Ro16p28n1 h28buf o16p 753755.748247142
* o16 input 29 w=+0.0889131834636398 w+  bank=n alpha=1 R=374897.535267812 G_phys=2.66739550390919e-06 G_eff=2.66739550390919e-06
Ro16p29n1 h29buf o16p 363128.214106069
* o16 input 30 w=+0.0420485970959956 w+  bank=n alpha=1 R=792733.54250641 G_phys=1.26145791287987e-06 G_eff=1.26145791287987e-06
Ro16p30n1 h30buf o16p 764713.357417693
* o16 input 31 w=-0.332324220948992 w-  bank=n alpha=1 R=100303.652975236 G_phys=9.96972662846976e-06 G_eff=9.96972662846976e-06
Ro16n31n1 h31buf o16n 97388.960830958
* o16 input 32 w=+0.137132637809711 w+  bank=n alpha=1 R=243073.668425948 G_phys=4.11397913429134e-06 G_eff=4.11397913429134e-06
Ro16p32n1 h32buf o16p 234323.715702056
* o16 bias=+0.0410780079484629 b+  bank=n alpha=1 R=811464.21158382 G_phys=1.23234023845389e-06 G_eff=1.23234023845389e-06
Ro16bpn1 vref o16p 788389.212428416
Vo16p o16p 0 DC 0
Vo16n o16n 0 DC 0
Fo16p 0 o16d Vo16p 1
Fo16n o16d 0 Vo16n 1
Vo16d o16d 0 DC 0
Ho16 o16raw 0 Vo16d 33333.3333333333
Eo16sc o16lin 0 o16raw 0 1

* calibration cell layer 1: expected v(cal1lin)=1
Vcal1 cal1in 0 DC 0
Rcal1w cal1in cal1p 32705.4649503888
Vcal1p cal1p 0 DC 0
Fcal1 0 cal1d Vcal1p 1
Vcal1d cal1d 0 DC 0
Hcal1 cal1lin 0 Vcal1d 33333.3333333333
* calibration cell layer 2: expected v(cal2lin)=1
Vcal2 cal2in 0 DC 0
Rcal2w cal2in cal2p 32310.6168698507
Vcal2p cal2p 0 DC 0
Fcal2 0 cal2d Vcal2p 1
Vcal2d cal2d 0 DC 0
Hcal2 cal2lin 0 Vcal2d 33333.3333333333
.control
set numdgt=15
alter Vin1 DC 0.632568504068692
alter Vin2 DC 0.130751912471634
alter Vin3 DC 0.498395519129232
alter Vin4 DC 0.508991138596361
alter Vin5 DC 0.741696432510955
alter Vin6 DC -0.174816274310903
alter Vin7 DC -0.711636899513491
alter Vin8 DC -0.992297390491566
alter Vin9 DC 0.124859661764151
alter Vin10 DC 0.927115220977617
alter Vin11 DC 0.757625693253616
alter Vin12 DC -0.349962125380286
alter Vin13 DC 0.772046924490164
alter Vin14 DC 0.809792344935797
alter Vin15 DC 0.311400434804866
alter Vin16 DC 0.38369938347353
op
print v(o1lin)
print v(o2lin)
print v(o3lin)
print v(o4lin)
print v(o5lin)
print v(o6lin)
print v(o7lin)
print v(o8lin)
print v(o9lin)
print v(o10lin)
print v(o11lin)
print v(o12lin)
print v(o13lin)
print v(o14lin)
print v(o15lin)
print v(o16lin)
alter Vin1 DC -0.974788209071848
alter Vin2 DC -0.200637826852555
alter Vin3 DC 0.823173051424639
alter Vin4 DC 0.925543502570132
alter Vin5 DC -0.235735032734585
alter Vin6 DC -0.141680228154392
alter Vin7 DC -0.886626844533918
alter Vin8 DC 0.40575230866322
alter Vin9 DC -0.9068934262577
alter Vin10 DC -0.71518146061856
alter Vin11 DC 0.507768822660382
alter Vin12 DC -0.423033389400712
alter Vin13 DC -0.189634986503447
alter Vin14 DC -0.729894999162038
alter Vin15 DC -0.822420852539174
alter Vin16 DC 0.729238013944139
op
print v(o1lin)
print v(o2lin)
print v(o3lin)
print v(o4lin)
print v(o5lin)
print v(o6lin)
print v(o7lin)
print v(o8lin)
print v(o9lin)
print v(o10lin)
print v(o11lin)
print v(o12lin)
print v(o13lin)
print v(o14lin)
print v(o15lin)
print v(o16lin)
alter Vin1 DC 0.847734806115268
alter Vin2 DC -0.795676825133873
alter Vin3 DC -0.576906573311323
alter Vin4 DC 0.808070915111557
alter Vin5 DC -0.272832325997157
alter Vin6 DC 0.984764551383679
alter Vin7 DC 0.873557149180198
alter Vin8 DC -0.395997821263188
alter Vin9 DC -0.91476403063532
alter Vin10 DC -0.814982443313317
alter Vin11 DC 0.386244963375333
alter Vin12 DC 0.97673536509706
alter Vin13 DC 0.859516677956838
alter Vin14 DC -0.48344879964576
alter Vin15 DC -0.389119391902879
alter Vin16 DC -0.0777429346880354
op
print v(o1lin)
print v(o2lin)
print v(o3lin)
print v(o4lin)
print v(o5lin)
print v(o6lin)
print v(o7lin)
print v(o8lin)
print v(o9lin)
print v(o10lin)
print v(o11lin)
print v(o12lin)
print v(o13lin)
print v(o14lin)
print v(o15lin)
print v(o16lin)
alter Vin1 DC -0.634763869503377
alter Vin2 DC 0.66136408923338
alter Vin3 DC -0.0583013778475243
alter Vin4 DC 0.720990552465887
alter Vin5 DC 0.260016013717853
alter Vin6 DC 0.577414589397466
alter Vin7 DC 0.854892175873237
alter Vin8 DC -0.100267864923785
alter Vin9 DC -0.2976521369567
alter Vin10 DC 0.530570623968421
alter Vin11 DC 0.0982353459122769
alter Vin12 DC -0.228498741708201
alter Vin13 DC -0.423704441504684
alter Vin14 DC -0.324453707550555
alter Vin15 DC 0.963733756086886
alter Vin16 DC 0.888564654599973
op
print v(o1lin)
print v(o2lin)
print v(o3lin)
print v(o4lin)
print v(o5lin)
print v(o6lin)
print v(o7lin)
print v(o8lin)
print v(o9lin)
print v(o10lin)
print v(o11lin)
print v(o12lin)
print v(o13lin)
print v(o14lin)
print v(o15lin)
print v(o16lin)
alter Vin1 DC 0.399419993562847
alter Vin2 DC 0.822754861286246
alter Vin3 DC -0.217979993499255
alter Vin4 DC -0.524840716208239
alter Vin5 DC -0.343585224682448
alter Vin6 DC 0.597298680392867
alter Vin7 DC 0.745769924406716
alter Vin8 DC -0.31122778594332
alter Vin9 DC -0.551408564506993
alter Vin10 DC 0.508813890470598
alter Vin11 DC 0.967095039058534
alter Vin12 DC 0.436711939252078
alter Vin13 DC -0.637944426107168
alter Vin14 DC -0.610126039852947
alter Vin15 DC -0.0266004623343832
alter Vin16 DC 0.865503835859949
op
print v(o1lin)
print v(o2lin)
print v(o3lin)
print v(o4lin)
print v(o5lin)
print v(o6lin)
print v(o7lin)
print v(o8lin)
print v(o9lin)
print v(o10lin)
print v(o11lin)
print v(o12lin)
print v(o13lin)
print v(o14lin)
print v(o15lin)
print v(o16lin)
alter Vin1 DC -0.39950651162754
alter Vin2 DC 0.845146280157393
alter Vin3 DC -0.293453062060104
alter Vin4 DC -0.935486140839395
alter Vin5 DC -0.0810356399901349
alter Vin6 DC -0.902253265490345
alter Vin7 DC -0.555846545167458
alter Vin8 DC 0.760951343886015
alter Vin9 DC 0.759556104325771
alter Vin10 DC -0.949711300869059
alter Vin11 DC 0.0303569257790743
alter Vin12 DC -0.0286488050711204
alter Vin13 DC -0.578375740619194
alter Vin14 DC 0.906957053187536
alter Vin15 DC -0.073548295446664
alter Vin16 DC 0.0683418880828401
op
print v(o1lin)
print v(o2lin)
print v(o3lin)
print v(o4lin)
print v(o5lin)
print v(o6lin)
print v(o7lin)
print v(o8lin)
print v(o9lin)
print v(o10lin)
print v(o11lin)
print v(o12lin)
print v(o13lin)
print v(o14lin)
print v(o15lin)
print v(o16lin)
alter Vin1 DC -0.269700131318679
alter Vin2 DC -0.0587851098186172
alter Vin3 DC -0.93859148153159
alter Vin4 DC 0.37397748574996
alter Vin5 DC -0.640198473614279
alter Vin6 DC 0.28300439655269
alter Vin7 DC 0.495573806278234
alter Vin8 DC 0.4844036398211
alter Vin9 DC 0.865719664227782
alter Vin10 DC -0.637807257193159
alter Vin11 DC 0.140608503083495
alter Vin12 DC -0.793259398029265
alter Vin13 DC 0.803362583110163
alter Vin14 DC 0.644880503300019
alter Vin15 DC 0.80511980776248
alter Vin16 DC 0.00183769605351314
op
print v(o1lin)
print v(o2lin)
print v(o3lin)
print v(o4lin)
print v(o5lin)
print v(o6lin)
print v(o7lin)
print v(o8lin)
print v(o9lin)
print v(o10lin)
print v(o11lin)
print v(o12lin)
print v(o13lin)
print v(o14lin)
print v(o15lin)
print v(o16lin)
alter Vin1 DC -0.681053369759573
alter Vin2 DC 0.971345998932643
alter Vin3 DC 0.0228486000093842
alter Vin4 DC -0.68100585488642
alter Vin5 DC 0.935892877213541
alter Vin6 DC 0.408157507560112
alter Vin7 DC 0.0488412507809939
alter Vin8 DC 0.828266383636528
alter Vin9 DC 0.784246855742534
alter Vin10 DC 0.207324880526272
alter Vin11 DC 0.218839873002423
alter Vin12 DC -0.64711694724826
alter Vin13 DC -0.45152559776989
alter Vin14 DC -0.16638824613438
alter Vin15 DC 0.56955443939986
alter Vin16 DC -0.894236938055073
op
print v(o1lin)
print v(o2lin)
print v(o3lin)
print v(o4lin)
print v(o5lin)
print v(o6lin)
print v(o7lin)
print v(o8lin)
print v(o9lin)
print v(o10lin)
print v(o11lin)
print v(o12lin)
print v(o13lin)
print v(o14lin)
print v(o15lin)
print v(o16lin)
alter Vin1 DC -0.924906884178613
alter Vin2 DC 0.267791334016869
alter Vin3 DC 0.386698050737095
alter Vin4 DC -0.375678093248884
alter Vin5 DC -0.481472424709471
alter Vin6 DC -0.590426934613701
alter Vin7 DC 0.274930056654101
alter Vin8 DC -0.495416670165966
alter Vin9 DC 0.662447960935986
alter Vin10 DC -0.39828366695253
alter Vin11 DC -0.435305893543825
alter Vin12 DC -0.673137852956615
alter Vin13 DC 0.399291241842683
alter Vin14 DC -0.135245929167714
alter Vin15 DC 0.191750308509824
alter Vin16 DC -0.317239774769057
op
print v(o1lin)
print v(o2lin)
print v(o3lin)
print v(o4lin)
print v(o5lin)
print v(o6lin)
print v(o7lin)
print v(o8lin)
print v(o9lin)
print v(o10lin)
print v(o11lin)
print v(o12lin)
print v(o13lin)
print v(o14lin)
print v(o15lin)
print v(o16lin)
alter Vin1 DC 0.691315307576891
alter Vin2 DC -0.966597973272848
alter Vin3 DC 0.337819856228323
alter Vin4 DC 0.445958641593821
alter Vin5 DC 0.28794565803369
alter Vin6 DC -0.437558044466196
alter Vin7 DC 0.335767271835964
alter Vin8 DC 0.741106323711654
alter Vin9 DC -0.498474688285342
alter Vin10 DC -0.937258343994007
alter Vin11 DC 0.628549591207388
alter Vin12 DC 0.0809865794436
alter Vin13 DC -0.792347081447127
alter Vin14 DC 0.290895831462678
alter Vin15 DC 0.917514644221665
alter Vin16 DC -0.636405891470935
op
print v(o1lin)
print v(o2lin)
print v(o3lin)
print v(o4lin)
print v(o5lin)
print v(o6lin)
print v(o7lin)
print v(o8lin)
print v(o9lin)
print v(o10lin)
print v(o11lin)
print v(o12lin)
print v(o13lin)
print v(o14lin)
print v(o15lin)
print v(o16lin)
alter Vin1 DC -0.436056235334991
alter Vin2 DC 0.359995773967924
alter Vin3 DC -0.862040082296962
alter Vin4 DC -0.613020281079166
alter Vin5 DC -0.682661118108276
alter Vin6 DC 0.0327240219234706
alter Vin7 DC -0.254762451719826
alter Vin8 DC -0.628386977446209
alter Vin9 DC -0.435404154442101
alter Vin10 DC -0.560268250029906
alter Vin11 DC -0.34004922102946
alter Vin12 DC 0.828462300998657
alter Vin13 DC -0.258762364783062
alter Vin14 DC 0.0615557520793739
alter Vin15 DC -0.749003484831865
alter Vin16 DC -0.461728905661948
op
print v(o1lin)
print v(o2lin)
print v(o3lin)
print v(o4lin)
print v(o5lin)
print v(o6lin)
print v(o7lin)
print v(o8lin)
print v(o9lin)
print v(o10lin)
print v(o11lin)
print v(o12lin)
print v(o13lin)
print v(o14lin)
print v(o15lin)
print v(o16lin)
alter Vin1 DC 0.402941317710264
alter Vin2 DC 0.676235321348749
alter Vin3 DC 0.422742637816617
alter Vin4 DC 0.294030371745866
alter Vin5 DC -0.638561187867718
alter Vin6 DC -0.0501402124484349
alter Vin7 DC -0.126876472940439
alter Vin8 DC 0.249620810954959
alter Vin9 DC 0.800022887685632
alter Vin10 DC -0.267525733933315
alter Vin11 DC -0.0493799961815793
alter Vin12 DC 0.412930540027973
alter Vin13 DC 0.168971578589697
alter Vin14 DC 0.402529908662486
alter Vin15 DC 0.590508734712441
alter Vin16 DC -0.809797572982249
op
print v(o1lin)
print v(o2lin)
print v(o3lin)
print v(o4lin)
print v(o5lin)
print v(o6lin)
print v(o7lin)
print v(o8lin)
print v(o9lin)
print v(o10lin)
print v(o11lin)
print v(o12lin)
print v(o13lin)
print v(o14lin)
print v(o15lin)
print v(o16lin)
alter Vin1 DC -0.720940644465072
alter Vin2 DC 0.811090286911281
alter Vin3 DC 0.0887704649024641
alter Vin4 DC -0.703881870777446
alter Vin5 DC 0.792271352370679
alter Vin6 DC -0.611577475657032
alter Vin7 DC 0.630598962593579
alter Vin8 DC -0.909175170042211
alter Vin9 DC 0.45028681887581
alter Vin10 DC -0.610646509410917
alter Vin11 DC 0.942769230832138
alter Vin12 DC 0.253399891858326
alter Vin13 DC 0.239806152599995
alter Vin14 DC -0.424323687911083
alter Vin15 DC -0.132402036224528
alter Vin16 DC 0.499567887714755
op
print v(o1lin)
print v(o2lin)
print v(o3lin)
print v(o4lin)
print v(o5lin)
print v(o6lin)
print v(o7lin)
print v(o8lin)
print v(o9lin)
print v(o10lin)
print v(o11lin)
print v(o12lin)
print v(o13lin)
print v(o14lin)
print v(o15lin)
print v(o16lin)
alter Vin1 DC -0.553601012740836
alter Vin2 DC -0.0853827874775894
alter Vin3 DC 0.472526855220367
alter Vin4 DC 0.983320104826496
alter Vin5 DC -0.32589641106305
alter Vin6 DC 0.620602426134993
alter Vin7 DC -0.529649272081957
alter Vin8 DC -0.400401658684954
alter Vin9 DC 0.506127142109278
alter Vin10 DC -0.0613843649963521
alter Vin11 DC 0.194508563247131
alter Vin12 DC -0.0888973979013215
alter Vin13 DC 0.304485213029303
alter Vin14 DC 0.571192626328441
alter Vin15 DC 0.39987631868635
alter Vin16 DC 0.458594801121468
op
print v(o1lin)
print v(o2lin)
print v(o3lin)
print v(o4lin)
print v(o5lin)
print v(o6lin)
print v(o7lin)
print v(o8lin)
print v(o9lin)
print v(o10lin)
print v(o11lin)
print v(o12lin)
print v(o13lin)
print v(o14lin)
print v(o15lin)
print v(o16lin)
alter Vin1 DC 0.941921702845139
alter Vin2 DC -0.797590224953611
alter Vin3 DC -0.353544884625478
alter Vin4 DC -0.223679714692619
alter Vin5 DC 0.934853237163932
alter Vin6 DC 0.813220120283511
alter Vin7 DC 0.620477689684263
alter Vin8 DC -0.971969304466214
alter Vin9 DC -0.591538023713506
alter Vin10 DC 0.157162778762541
alter Vin11 DC -0.00954942079742005
alter Vin12 DC -0.766378178791702
alter Vin13 DC 0.781165514171662
alter Vin14 DC -0.870653903905813
alter Vin15 DC -0.855576259711061
alter Vin16 DC 0.576744547964966
op
print v(o1lin)
print v(o2lin)
print v(o3lin)
print v(o4lin)
print v(o5lin)
print v(o6lin)
print v(o7lin)
print v(o8lin)
print v(o9lin)
print v(o10lin)
print v(o11lin)
print v(o12lin)
print v(o13lin)
print v(o14lin)
print v(o15lin)
print v(o16lin)
alter Vin1 DC 0.0847980140064368
alter Vin2 DC -0.546436186199117
alter Vin3 DC 0.157551439199196
alter Vin4 DC -0.675094911660673
alter Vin5 DC 0.251984062858915
alter Vin6 DC 0.533034777990185
alter Vin7 DC -0.636309229712619
alter Vin8 DC 0.205266715162125
alter Vin9 DC 0.355151588504783
alter Vin10 DC -0.763079400779309
alter Vin11 DC 0.279208117784239
alter Vin12 DC -0.046053502725351
alter Vin13 DC -0.0674199792200116
alter Vin14 DC -0.0988424326224195
alter Vin15 DC 0.341224431366531
alter Vin16 DC -0.128234288046615
op
print v(o1lin)
print v(o2lin)
print v(o3lin)
print v(o4lin)
print v(o5lin)
print v(o6lin)
print v(o7lin)
print v(o8lin)
print v(o9lin)
print v(o10lin)
print v(o11lin)
print v(o12lin)
print v(o13lin)
print v(o14lin)
print v(o15lin)
print v(o16lin)
alter Vin1 DC -0.595380417251091
alter Vin2 DC -0.170465926726426
alter Vin3 DC -0.165712373937593
alter Vin4 DC 0.484522499674577
alter Vin5 DC 0.78085882899596
alter Vin6 DC -0.00693757328167033
alter Vin7 DC -0.498016397952294
alter Vin8 DC -0.76057897931883
alter Vin9 DC -0.343082475402419
alter Vin10 DC 0.0125577265451373
alter Vin11 DC 0.60192661275731
alter Vin12 DC -0.0810399461010238
alter Vin13 DC 0.308396489131115
alter Vin14 DC -0.555444513107257
alter Vin15 DC -0.388314730894595
alter Vin16 DC 0.923801824090698
op
print v(o1lin)
print v(o2lin)
print v(o3lin)
print v(o4lin)
print v(o5lin)
print v(o6lin)
print v(o7lin)
print v(o8lin)
print v(o9lin)
print v(o10lin)
print v(o11lin)
print v(o12lin)
print v(o13lin)
print v(o14lin)
print v(o15lin)
print v(o16lin)
alter Vin1 DC -0.344075298305219
alter Vin2 DC -0.299983052907286
alter Vin3 DC -0.203058505077156
alter Vin4 DC 0.435239788418766
alter Vin5 DC 0.363815756954568
alter Vin6 DC 0.837980352083505
alter Vin7 DC -0.538527300440037
alter Vin8 DC -0.938627722316779
alter Vin9 DC 0.4922043173456
alter Vin10 DC 0.207737109101553
alter Vin11 DC 0.020741026962491
alter Vin12 DC 0.25637018547913
alter Vin13 DC -0.83211091299048
alter Vin14 DC 0.766421841791898
alter Vin15 DC -0.927411256783522
alter Vin16 DC 0.369430588094565
op
print v(o1lin)
print v(o2lin)
print v(o3lin)
print v(o4lin)
print v(o5lin)
print v(o6lin)
print v(o7lin)
print v(o8lin)
print v(o9lin)
print v(o10lin)
print v(o11lin)
print v(o12lin)
print v(o13lin)
print v(o14lin)
print v(o15lin)
print v(o16lin)
alter Vin1 DC 0.627063489212866
alter Vin2 DC -0.582648694346974
alter Vin3 DC -0.765786006835309
alter Vin4 DC 0.102836606226475
alter Vin5 DC -0.66611661718385
alter Vin6 DC 0.412069103904774
alter Vin7 DC -0.320626602803983
alter Vin8 DC 0.664935939224919
alter Vin9 DC -0.907582410736682
alter Vin10 DC 0.138301736499832
alter Vin11 DC -0.124043342050667
alter Vin12 DC -0.444462469724564
alter Vin13 DC 0.993018090945098
alter Vin14 DC 0.384970115288437
alter Vin15 DC 0.988144749211259
alter Vin16 DC 0.83719280846034
op
print v(o1lin)
print v(o2lin)
print v(o3lin)
print v(o4lin)
print v(o5lin)
print v(o6lin)
print v(o7lin)
print v(o8lin)
print v(o9lin)
print v(o10lin)
print v(o11lin)
print v(o12lin)
print v(o13lin)
print v(o14lin)
print v(o15lin)
print v(o16lin)
alter Vin1 DC -0.45182957480955
alter Vin2 DC -0.662024952982424
alter Vin3 DC -0.229489946519203
alter Vin4 DC 0.68091685978688
alter Vin5 DC -0.524794188274996
alter Vin6 DC -0.775298122631856
alter Vin7 DC 0.477695002661498
alter Vin8 DC 0.318249373784927
alter Vin9 DC 0.0674353216224022
alter Vin10 DC -0.757574746285693
alter Vin11 DC 0.194480016220294
alter Vin12 DC -0.986058532734065
alter Vin13 DC -0.858099129281211
alter Vin14 DC 0.875413943263164
alter Vin15 DC -0.355937045022594
alter Vin16 DC -0.909269999495478
op
print v(o1lin)
print v(o2lin)
print v(o3lin)
print v(o4lin)
print v(o5lin)
print v(o6lin)
print v(o7lin)
print v(o8lin)
print v(o9lin)
print v(o10lin)
print v(o11lin)
print v(o12lin)
print v(o13lin)
print v(o14lin)
print v(o15lin)
print v(o16lin)
alter Vin1 DC -0.166134124041978
alter Vin2 DC 0.326271636139386
alter Vin3 DC 0.0377865575229868
alter Vin4 DC 0.642967168503026
alter Vin5 DC -0.0313452796975957
alter Vin6 DC -0.898196834887308
alter Vin7 DC -0.0223210703281855
alter Vin8 DC 0.0240743286141054
alter Vin9 DC -0.32939698929494
alter Vin10 DC 0.156138339259947
alter Vin11 DC 0.998037514156259
alter Vin12 DC 0.996329734012833
alter Vin13 DC -0.792547573290175
alter Vin14 DC 0.272037484511549
alter Vin15 DC 0.144597423090336
alter Vin16 DC 0.648759180262861
op
print v(o1lin)
print v(o2lin)
print v(o3lin)
print v(o4lin)
print v(o5lin)
print v(o6lin)
print v(o7lin)
print v(o8lin)
print v(o9lin)
print v(o10lin)
print v(o11lin)
print v(o12lin)
print v(o13lin)
print v(o14lin)
print v(o15lin)
print v(o16lin)
alter Vin1 DC 0.513767503102245
alter Vin2 DC -0.993130673228192
alter Vin3 DC -0.741368455463561
alter Vin4 DC -0.673172294979255
alter Vin5 DC 0.53329038934038
alter Vin6 DC 0.273011112722964
alter Vin7 DC -0.22429483417346
alter Vin8 DC -0.904486174889755
alter Vin9 DC -0.0476389722976311
alter Vin10 DC 0.0830713748633647
alter Vin11 DC -0.0631237690576123
alter Vin12 DC -0.387190151349574
alter Vin13 DC 0.490599598157352
alter Vin14 DC -0.431150162403273
alter Vin15 DC -0.494227353798093
alter Vin16 DC 0.199587837072336
op
print v(o1lin)
print v(o2lin)
print v(o3lin)
print v(o4lin)
print v(o5lin)
print v(o6lin)
print v(o7lin)
print v(o8lin)
print v(o9lin)
print v(o10lin)
print v(o11lin)
print v(o12lin)
print v(o13lin)
print v(o14lin)
print v(o15lin)
print v(o16lin)
alter Vin1 DC -0.527641643915313
alter Vin2 DC -0.760469900825891
alter Vin3 DC -0.971812928614647
alter Vin4 DC -0.462029484155251
alter Vin5 DC -0.0990347067926469
alter Vin6 DC -0.431709782876269
alter Vin7 DC 0.582115295594787
alter Vin8 DC 0.490760521778589
alter Vin9 DC -0.597773697850127
alter Vin10 DC -0.146377118439857
alter Vin11 DC 0.77673031103089
alter Vin12 DC -0.958686104499727
alter Vin13 DC -0.651792165711311
alter Vin14 DC -0.771428363238295
alter Vin15 DC -0.274616062196005
alter Vin16 DC 0.797804290304925
op
print v(o1lin)
print v(o2lin)
print v(o3lin)
print v(o4lin)
print v(o5lin)
print v(o6lin)
print v(o7lin)
print v(o8lin)
print v(o9lin)
print v(o10lin)
print v(o11lin)
print v(o12lin)
print v(o13lin)
print v(o14lin)
print v(o15lin)
print v(o16lin)
alter Vin1 DC -0.0660406839746723
alter Vin2 DC -0.199767810717373
alter Vin3 DC 0.433496899757818
alter Vin4 DC 0.179118988466795
alter Vin5 DC -0.213841522026575
alter Vin6 DC 0.556646137550105
alter Vin7 DC -0.700676048926627
alter Vin8 DC -0.447891404812417
alter Vin9 DC -0.03646969314408
alter Vin10 DC 0.356038664374622
alter Vin11 DC -0.898261479878571
alter Vin12 DC -0.522238075094493
alter Vin13 DC 0.470385125738646
alter Vin14 DC -0.934570154871633
alter Vin15 DC -0.215637621907727
alter Vin16 DC -0.839313330640211
op
print v(o1lin)
print v(o2lin)
print v(o3lin)
print v(o4lin)
print v(o5lin)
print v(o6lin)
print v(o7lin)
print v(o8lin)
print v(o9lin)
print v(o10lin)
print v(o11lin)
print v(o12lin)
print v(o13lin)
print v(o14lin)
print v(o15lin)
print v(o16lin)
alter Vin1 DC 0.944694975466901
alter Vin2 DC 0.557429746816729
alter Vin3 DC 0.0879434025868335
alter Vin4 DC -0.971277715280804
alter Vin5 DC 0.469272183979264
alter Vin6 DC 0.0553351732696565
alter Vin7 DC 0.319789179040026
alter Vin8 DC 0.105605881218313
alter Vin9 DC -0.808751474487991
alter Vin10 DC 0.345207050357025
alter Vin11 DC 0.887488099386043
alter Vin12 DC -0.946434379958131
alter Vin13 DC -0.756800857731664
alter Vin14 DC 0.584597058025779
alter Vin15 DC -0.172504938226507
alter Vin16 DC 0.057467887193803
op
print v(o1lin)
print v(o2lin)
print v(o3lin)
print v(o4lin)
print v(o5lin)
print v(o6lin)
print v(o7lin)
print v(o8lin)
print v(o9lin)
print v(o10lin)
print v(o11lin)
print v(o12lin)
print v(o13lin)
print v(o14lin)
print v(o15lin)
print v(o16lin)
alter Vin1 DC 0.268139611364692
alter Vin2 DC -0.0761352932592003
alter Vin3 DC 0.257679787771012
alter Vin4 DC 0.647151913043588
alter Vin5 DC 0.688559040420576
alter Vin6 DC 0.195725091292368
alter Vin7 DC -0.650874124907297
alter Vin8 DC 0.757864910663943
alter Vin9 DC -0.801870229804984
alter Vin10 DC 0.0650107507341318
alter Vin11 DC 0.76839506437409
alter Vin12 DC 0.626485114847845
alter Vin13 DC -0.916744432608743
alter Vin14 DC -0.0381884442222795
alter Vin15 DC -0.39538459366548
alter Vin16 DC -0.53577973836249
op
print v(o1lin)
print v(o2lin)
print v(o3lin)
print v(o4lin)
print v(o5lin)
print v(o6lin)
print v(o7lin)
print v(o8lin)
print v(o9lin)
print v(o10lin)
print v(o11lin)
print v(o12lin)
print v(o13lin)
print v(o14lin)
print v(o15lin)
print v(o16lin)
alter Vin1 DC -0.399980891864974
alter Vin2 DC -0.311058824105357
alter Vin3 DC -0.121767102063513
alter Vin4 DC -0.1825017503415
alter Vin5 DC -0.384605419902336
alter Vin6 DC 0.330631581125283
alter Vin7 DC -0.386290416681561
alter Vin8 DC -0.384489741601594
alter Vin9 DC 0.461619066894131
alter Vin10 DC 0.340745152205258
alter Vin11 DC 0.0704341709189509
alter Vin12 DC -0.729253158394329
alter Vin13 DC -0.938300926484224
alter Vin14 DC -0.138387864413021
alter Vin15 DC -0.774754191520238
alter Vin16 DC -0.06472577537549
op
print v(o1lin)
print v(o2lin)
print v(o3lin)
print v(o4lin)
print v(o5lin)
print v(o6lin)
print v(o7lin)
print v(o8lin)
print v(o9lin)
print v(o10lin)
print v(o11lin)
print v(o12lin)
print v(o13lin)
print v(o14lin)
print v(o15lin)
print v(o16lin)
alter Vin1 DC 0.829033111352976
alter Vin2 DC 0.280583414286498
alter Vin3 DC -0.120742403743087
alter Vin4 DC 0.0243484731867412
alter Vin5 DC 0.814584378326768
alter Vin6 DC 0.126953925080522
alter Vin7 DC -0.480745642214154
alter Vin8 DC 0.58301448926957
alter Vin9 DC -0.81340983633115
alter Vin10 DC -0.0371270227098195
alter Vin11 DC 0.20534777858118
alter Vin12 DC 0.195891870031178
alter Vin13 DC 0.970242611575792
alter Vin14 DC -0.260742875944806
alter Vin15 DC -0.707389032009879
alter Vin16 DC -0.834880031964718
op
print v(o1lin)
print v(o2lin)
print v(o3lin)
print v(o4lin)
print v(o5lin)
print v(o6lin)
print v(o7lin)
print v(o8lin)
print v(o9lin)
print v(o10lin)
print v(o11lin)
print v(o12lin)
print v(o13lin)
print v(o14lin)
print v(o15lin)
print v(o16lin)
alter Vin1 DC 0.857714478615315
alter Vin2 DC -0.977990911511488
alter Vin3 DC 0.522120406530206
alter Vin4 DC -0.818687889680604
alter Vin5 DC -0.375725178244296
alter Vin6 DC 0.0646773078474716
alter Vin7 DC -0.0696743243817957
alter Vin8 DC -0.260504274511249
alter Vin9 DC 0.991412947690472
alter Vin10 DC -0.736994622705201
alter Vin11 DC -0.989748939020532
alter Vin12 DC 0.745774856471066
alter Vin13 DC 0.801402815326226
alter Vin14 DC -0.709499539722716
alter Vin15 DC 0.652792790844334
alter Vin16 DC 0.832995677945966
op
print v(o1lin)
print v(o2lin)
print v(o3lin)
print v(o4lin)
print v(o5lin)
print v(o6lin)
print v(o7lin)
print v(o8lin)
print v(o9lin)
print v(o10lin)
print v(o11lin)
print v(o12lin)
print v(o13lin)
print v(o14lin)
print v(o15lin)
print v(o16lin)
alter Vin1 DC 0.578295068169871
alter Vin2 DC -0.645738590777075
alter Vin3 DC -0.438695216585002
alter Vin4 DC 0.354791332621486
alter Vin5 DC 0.572376875240838
alter Vin6 DC 0.283557785900749
alter Vin7 DC 0.801480336715229
alter Vin8 DC 0.837498240545797
alter Vin9 DC -0.162628392977149
alter Vin10 DC 0.0188708173241798
alter Vin11 DC 0.732770034383577
alter Vin12 DC 0.829886941830955
alter Vin13 DC -0.215883555562326
alter Vin14 DC 0.778511642633058
alter Vin15 DC 0.726117246545339
alter Vin16 DC -0.836770051577228
op
print v(o1lin)
print v(o2lin)
print v(o3lin)
print v(o4lin)
print v(o5lin)
print v(o6lin)
print v(o7lin)
print v(o8lin)
print v(o9lin)
print v(o10lin)
print v(o11lin)
print v(o12lin)
print v(o13lin)
print v(o14lin)
print v(o15lin)
print v(o16lin)
alter Vin1 DC 0.512666764012534
alter Vin2 DC -0.91042789183315
alter Vin3 DC -0.674618340260172
alter Vin4 DC 0.77595275679209
alter Vin5 DC 0.541729157541262
alter Vin6 DC 0.434965717552227
alter Vin7 DC 0.812555641142557
alter Vin8 DC -0.696450119180847
alter Vin9 DC 0.349416262802516
alter Vin10 DC 0.238837808121401
alter Vin11 DC -0.606665588660031
alter Vin12 DC 0.394312915601357
alter Vin13 DC -0.299226531600345
alter Vin14 DC -0.590822138784816
alter Vin15 DC -0.900583331081588
alter Vin16 DC 0.969002954577666
op
print v(o1lin)
print v(o2lin)
print v(o3lin)
print v(o4lin)
print v(o5lin)
print v(o6lin)
print v(o7lin)
print v(o8lin)
print v(o9lin)
print v(o10lin)
print v(o11lin)
print v(o12lin)
print v(o13lin)
print v(o14lin)
print v(o15lin)
print v(o16lin)
alter Vin1 DC 0.996964849631111
alter Vin2 DC -0.382670628895657
alter Vin3 DC -0.589629194051136
alter Vin4 DC -0.257488018342011
alter Vin5 DC -0.0225875667849409
alter Vin6 DC 0.316086952435916
alter Vin7 DC 0.923082372784055
alter Vin8 DC 0.0720344794803358
alter Vin9 DC -0.570888117083981
alter Vin10 DC 0.636196022229113
alter Vin11 DC -0.59824376349448
alter Vin12 DC 0.724608074730714
alter Vin13 DC -0.224915642937104
alter Vin14 DC 0.262010847512565
alter Vin15 DC -0.401587833404117
alter Vin16 DC 0.438103800930035
op
print v(o1lin)
print v(o2lin)
print v(o3lin)
print v(o4lin)
print v(o5lin)
print v(o6lin)
print v(o7lin)
print v(o8lin)
print v(o9lin)
print v(o10lin)
print v(o11lin)
print v(o12lin)
print v(o13lin)
print v(o14lin)
print v(o15lin)
print v(o16lin)
alter Vin1 DC 0.146388210996796
alter Vin2 DC 0.851378176855976
alter Vin3 DC -0.545296719530172
alter Vin4 DC 0.936320371011729
alter Vin5 DC -0.659971945152452
alter Vin6 DC 0.637939687045485
alter Vin7 DC 0.775987953987478
alter Vin8 DC -0.7151329644111
alter Vin9 DC -0.403349246529835
alter Vin10 DC -0.818560699155668
alter Vin11 DC 0.66658468821056
alter Vin12 DC 0.229852048443837
alter Vin13 DC 0.152309271507268
alter Vin14 DC -0.0441514852931166
alter Vin15 DC 0.0779565043300003
alter Vin16 DC -0.122549087436726
op
print v(o1lin)
print v(o2lin)
print v(o3lin)
print v(o4lin)
print v(o5lin)
print v(o6lin)
print v(o7lin)
print v(o8lin)
print v(o9lin)
print v(o10lin)
print v(o11lin)
print v(o12lin)
print v(o13lin)
print v(o14lin)
print v(o15lin)
print v(o16lin)
alter Vin1 DC -0.926439381972823
alter Vin2 DC -0.615234894251263
alter Vin3 DC -0.0340238055806736
alter Vin4 DC 0.109946635985621
alter Vin5 DC -0.227895739326049
alter Vin6 DC 0.455407156960182
alter Vin7 DC 0.400984605846592
alter Vin8 DC -0.461739950266764
alter Vin9 DC 0.962599087089418
alter Vin10 DC 0.712808562717367
alter Vin11 DC 0.514105913709235
alter Vin12 DC 0.33339311864586
alter Vin13 DC 0.983543769948446
alter Vin14 DC 0.536587909150327
alter Vin15 DC 0.0318213121438755
alter Vin16 DC 0.666927443816752
op
print v(o1lin)
print v(o2lin)
print v(o3lin)
print v(o4lin)
print v(o5lin)
print v(o6lin)
print v(o7lin)
print v(o8lin)
print v(o9lin)
print v(o10lin)
print v(o11lin)
print v(o12lin)
print v(o13lin)
print v(o14lin)
print v(o15lin)
print v(o16lin)
alter Vin1 DC -0.322834862686127
alter Vin2 DC -0.584062888919473
alter Vin3 DC -0.720596149709497
alter Vin4 DC -0.678155702025423
alter Vin5 DC -0.50355911783956
alter Vin6 DC 0.493391744831513
alter Vin7 DC 0.77110097674651
alter Vin8 DC 0.35657120941032
alter Vin9 DC -0.299379898988419
alter Vin10 DC 0.913130383361827
alter Vin11 DC 0.047342951298037
alter Vin12 DC -0.309370616770426
alter Vin13 DC 0.192831131458793
alter Vin14 DC 0.116497038265849
alter Vin15 DC 0.128520413216278
alter Vin16 DC 0.177999850779134
op
print v(o1lin)
print v(o2lin)
print v(o3lin)
print v(o4lin)
print v(o5lin)
print v(o6lin)
print v(o7lin)
print v(o8lin)
print v(o9lin)
print v(o10lin)
print v(o11lin)
print v(o12lin)
print v(o13lin)
print v(o14lin)
print v(o15lin)
print v(o16lin)
alter Vin1 DC -0.727341455542907
alter Vin2 DC 0.529599033013268
alter Vin3 DC 0.521024787135614
alter Vin4 DC -0.866776027386548
alter Vin5 DC 0.776840732388895
alter Vin6 DC -0.717793598737009
alter Vin7 DC -0.591867360923596
alter Vin8 DC -0.0815920521485731
alter Vin9 DC -0.0328119134751146
alter Vin10 DC 0.509073071940425
alter Vin11 DC -0.546284331957509
alter Vin12 DC 0.481384262792588
alter Vin13 DC -0.859595413394354
alter Vin14 DC -0.291234569240053
alter Vin15 DC -0.870152250182007
alter Vin16 DC -0.435785443442337
op
print v(o1lin)
print v(o2lin)
print v(o3lin)
print v(o4lin)
print v(o5lin)
print v(o6lin)
print v(o7lin)
print v(o8lin)
print v(o9lin)
print v(o10lin)
print v(o11lin)
print v(o12lin)
print v(o13lin)
print v(o14lin)
print v(o15lin)
print v(o16lin)
alter Vin1 DC 0.308674565966459
alter Vin2 DC 0.476522030460678
alter Vin3 DC 0.176116940403099
alter Vin4 DC -0.269696616647023
alter Vin5 DC -0.835425825203222
alter Vin6 DC -0.257374488996112
alter Vin7 DC 0.861825960245245
alter Vin8 DC -0.757200981805819
alter Vin9 DC 0.219570221593069
alter Vin10 DC -0.737313772662746
alter Vin11 DC 0.916532670163939
alter Vin12 DC -0.326724749976099
alter Vin13 DC -0.258958621423432
alter Vin14 DC 0.110523904762884
alter Vin15 DC -0.262524879020353
alter Vin16 DC 0.595305764490593
op
print v(o1lin)
print v(o2lin)
print v(o3lin)
print v(o4lin)
print v(o5lin)
print v(o6lin)
print v(o7lin)
print v(o8lin)
print v(o9lin)
print v(o10lin)
print v(o11lin)
print v(o12lin)
print v(o13lin)
print v(o14lin)
print v(o15lin)
print v(o16lin)
alter Vin1 DC -0.121565718815817
alter Vin2 DC 0.85026137362778
alter Vin3 DC -0.725882120507907
alter Vin4 DC 0.0407127903627837
alter Vin5 DC 0.486714139870312
alter Vin6 DC -0.174725929659921
alter Vin7 DC 0.197358954375944
alter Vin8 DC 0.807395499014515
alter Vin9 DC 0.843354973338086
alter Vin10 DC 0.282953221647761
alter Vin11 DC -0.999304235886526
alter Vin12 DC -0.950389802844308
alter Vin13 DC 0.771638055757985
alter Vin14 DC -0.140350408284357
alter Vin15 DC 0.438700172314504
alter Vin16 DC 0.766208145137089
op
print v(o1lin)
print v(o2lin)
print v(o3lin)
print v(o4lin)
print v(o5lin)
print v(o6lin)
print v(o7lin)
print v(o8lin)
print v(o9lin)
print v(o10lin)
print v(o11lin)
print v(o12lin)
print v(o13lin)
print v(o14lin)
print v(o15lin)
print v(o16lin)
alter Vin1 DC 0.524565147427742
alter Vin2 DC -0.228728707561463
alter Vin3 DC 0.622966092889961
alter Vin4 DC 0.442099278822348
alter Vin5 DC -0.68185971324033
alter Vin6 DC -0.657022993439861
alter Vin7 DC 0.606146642396182
alter Vin8 DC -0.234310724429887
alter Vin9 DC 0.330684414271566
alter Vin10 DC 0.118943468091141
alter Vin11 DC -0.905603957323895
alter Vin12 DC -0.647082133976604
alter Vin13 DC -0.988277487148225
alter Vin14 DC -0.0351159487862691
alter Vin15 DC 0.0357885445778272
alter Vin16 DC -0.573737602016074
op
print v(o1lin)
print v(o2lin)
print v(o3lin)
print v(o4lin)
print v(o5lin)
print v(o6lin)
print v(o7lin)
print v(o8lin)
print v(o9lin)
print v(o10lin)
print v(o11lin)
print v(o12lin)
print v(o13lin)
print v(o14lin)
print v(o15lin)
print v(o16lin)
alter Vin1 DC 0.420805696758339
alter Vin2 DC -0.616530557983683
alter Vin3 DC 0.364821943112122
alter Vin4 DC -0.395523393484615
alter Vin5 DC -0.679355100506025
alter Vin6 DC -0.65784113684798
alter Vin7 DC 0.438381846487236
alter Vin8 DC -0.85021400464495
alter Vin9 DC -0.420415477822893
alter Vin10 DC 0.0361561564656332
alter Vin11 DC -0.815551896898906
alter Vin12 DC -0.241219421510256
alter Vin13 DC -0.0373494349822094
alter Vin14 DC -0.135841212962577
alter Vin15 DC 0.57727959838417
alter Vin16 DC -0.210802787968692
op
print v(o1lin)
print v(o2lin)
print v(o3lin)
print v(o4lin)
print v(o5lin)
print v(o6lin)
print v(o7lin)
print v(o8lin)
print v(o9lin)
print v(o10lin)
print v(o11lin)
print v(o12lin)
print v(o13lin)
print v(o14lin)
print v(o15lin)
print v(o16lin)
.endc

.end
