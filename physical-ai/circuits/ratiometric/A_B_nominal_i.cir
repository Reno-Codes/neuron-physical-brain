* Physical AI - Experiment 13 architecture B: multi-reference voltage encoding
* VCVS range copies; nominal path is passive
* Frozen Experiment 9 network A. Weights were not edited.
* Behavioral circuit analysis. Not transistor-level or PCB power.
* scale_error=0 Vos=0 rail=15 linear=False
* shape: 2 -> 4 -> 1

Vin1 in1 0 DC 0
Efin1 inf1 0 in1 0 0.0001
Emed1 inm1 0 in1 0 0.01
Vin2 in2 0 DC 0
Efin2 inf2 0 in2 0 0.0001
Emed2 inm2 0 in2 0 0.01
Vref vref 0 DC 1
Ereff vreff 0 vref 0 0.0001
Erefm vrefm 0 vref 0 0.01

* h1 input 1 w=+0.683760795348816 w+  bank=n alpha=1 R=487499.920441162 G_phys=2.05128238604645e-06 G_eff=2.05128238604645e-06
Rh1p1n1 in1 h1p 487499.920441162
* h1 input 2 w=+0.309366783045794 w+  bank=m alpha=0.01 R=10774.6969487669 G_phys=9.28100349137381e-05 G_eff=9.28100349137381e-07
Rh1p2m1 inm2 h1p 10774.6969487669
* h1 bias=-0.0265987962576462 b-  bank=m alpha=0.01 R=125318.954325804 G_phys=7.97963887729386e-06 G_eff=7.97963887729386e-08
Rh1bnm1 vrefm h1n 125318.954325804
Vh1p h1p 0 DC 0
Vh1n h1n 0 DC 0
Fh1p 0 h1d Vh1p 1
Fh1n h1d 0 Vh1n 1
Vh1d h1d 0 DC 0
Hh1 h1lin 0 Vh1d 333333.333333333
* direct bounded ReLU: y=max(0, min(15, v(h1lin))) no high-gain op-amp loop
Bh1relu h1y 0 V = max(0, min(15, v(h1lin)))
Eh1 h1buf 0 h1y 0 1

* h2 input 1 w=-0.884821731731664 w-  bank=n alpha=1 R=376723.718890781 G_phys=2.65446519519499e-06 G_eff=2.65446519519499e-06
Rh2n1n1 in1 h2n 376723.718890781
* h2 input 2 w=+0.782653240240456 w+  bank=n alpha=1 R=425901.684417639 G_phys=2.34795972072137e-06 G_eff=2.34795972072137e-06
Rh2p2n1 in2 h2p 425901.684417639
* h2 bias=+5.94215208512688e-05 b+  bank=f alpha=0.0001 R=560963.988396833 G_phys=1.78264562553806e-06 G_eff=1.78264562553806e-10
Rh2bpf1 vreff h2p 560963.988396833
Vh2p h2p 0 DC 0
Vh2n h2n 0 DC 0
Fh2p 0 h2d Vh2p 1
Fh2n h2d 0 Vh2n 1
Vh2d h2d 0 DC 0
Hh2 h2lin 0 Vh2d 333333.333333333
* direct bounded ReLU: y=max(0, min(15, v(h2lin))) no high-gain op-amp loop
Bh2relu h2y 0 V = max(0, min(15, v(h2lin)))
Eh2 h2buf 0 h2y 0 1

* h3 input 1 w=+0.80723931339229 w+  bank=n alpha=1 R=412930.004526854 G_phys=2.42171794017687e-06 G_eff=2.42171794017687e-06
Rh3p1n1 in1 h3p 412930.004526854
* h3 input 2 w=+1.71882311343666 w+  bank=n alpha=1 R=193931.144355429 G_phys=5.15646934030999e-06 G_eff=5.15646934030999e-06
Rh3p2n1 in2 h3p 193931.144355429
* h3 bias=+0.0173783581286745 b+  bank=m alpha=0.01 R=191809.451080035 G_phys=5.21350743860236e-06 G_eff=5.21350743860236e-08
Rh3bpm1 vrefm h3p 191809.451080035
Vh3p h3p 0 DC 0
Vh3n h3n 0 DC 0
Fh3p 0 h3d Vh3p 1
Fh3n h3d 0 Vh3n 1
Vh3d h3d 0 DC 0
Hh3 h3lin 0 Vh3d 333333.333333333
* direct bounded ReLU: y=max(0, min(15, v(h3lin))) no high-gain op-amp loop
Bh3relu h3y 0 V = max(0, min(15, v(h3lin)))
Eh3 h3buf 0 h3y 0 1

* h4 input 1 w=-2.16286246457598 w-  bank=n alpha=1 R=154116.749813161 G_phys=6.48858739372794e-06 G_eff=6.48858739372794e-06
Rh4n1n1 in1 h4n 154116.749813161
* h4 input 2 w=+0.726967919426763 w+  bank=n alpha=1 R=458525.506319697 G_phys=2.18090375828029e-06 G_eff=2.18090375828029e-06
Rh4p2n1 in2 h4p 458525.506319697
* h4 bias=-0.0184151286231249 b-  bank=m alpha=0.01 R=181010.591973139 G_phys=5.52453858693748e-06 G_eff=5.52453858693748e-08
Rh4bnm1 vrefm h4n 181010.591973139
Vh4p h4p 0 DC 0
Vh4n h4n 0 DC 0
Fh4p 0 h4d Vh4p 1
Fh4n h4d 0 Vh4n 1
Vh4d h4d 0 DC 0
Hh4 h4lin 0 Vh4d 333333.333333333
* direct bounded ReLU: y=max(0, min(15, v(h4lin))) no high-gain op-amp loop
Bh4relu h4y 0 V = max(0, min(15, v(h4lin)))
Eh4 h4buf 0 h4y 0 1

Ehfin1 h1f 0 h1buf 0 0.0001
Ehmed1 h1m 0 h1buf 0 0.01
Ehfin2 h2f 0 h2buf 0 0.0001
Ehmed2 h2m 0 h2buf 0 0.01
Ehfin3 h3f 0 h3buf 0 0.0001
Ehmed3 h3m 0 h3buf 0 0.01
Ehfin4 h4f 0 h4buf 0 0.0001
Ehmed4 h4m 0 h4buf 0 0.01
* o1 input 1 w=+0.601889648539537 w+  bank=n alpha=1 R=553811.374131711 G_phys=1.80566894561861e-06 G_eff=1.80566894561861e-06
Ro1p1n1 h1buf o1p 553811.374131711
* o1 input 2 w=+0.347315954504283 w+  bank=n alpha=1 R=959740.918925228 G_phys=1.04194786351285e-06 G_eff=1.04194786351285e-06
Ro1p2n1 h2buf o1p 959740.918925228
* o1 input 3 w=+0.876922607606196 w+  bank=n alpha=1 R=380117.16249768 G_phys=2.63076782281859e-06 G_eff=2.63076782281859e-06
Ro1p3n1 h3buf o1p 380117.16249768
* o1 input 4 w=+0.929527796434486 w+  bank=n alpha=1 R=358605.019249499 G_phys=2.78858338930346e-06 G_eff=2.78858338930346e-06
Ro1p4n1 h4buf o1p 358605.019249499
* o1 bias=+0.0103504514823374 b+  bank=m alpha=0.01 R=322047.143452777 G_phys=3.10513544470123e-06 G_eff=3.10513544470123e-08
Ro1bpm1 vrefm o1p 322047.143452777
Vo1p o1p 0 DC 0
Vo1n o1n 0 DC 0
Fo1p 0 o1d Vo1p 1
Fo1n o1d 0 Vo1n 1
Vo1d o1d 0 DC 0
Ho1 o1lin 0 Vo1d 333333.333333333
.control
set numdgt=15
alter Vin1 DC 0.494125531810799
alter Vin2 DC -0.229451673774848
op
print i(Vin1)
print i(Vin2)
print i(Vref)
.endc

.end
