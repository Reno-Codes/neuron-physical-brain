* Experiment 22 isolated TIA neuron n1
* frozen n=16 L1=4.5665167 b=0.0212362032828689
* A=100000 vos=0 Ileak=0 Rout=0 fp=0 invertA=1e+07
* Behavioral TIA. Not transistor-level. Weights were not edited.
* shape: 16 -> 1 (linear Vlin vs z unless ReLU requested)

* Experiment 26 MOS primitive. Models included, not copied.
.include "C:/ngspice/examples/xspice/see/CMOSOpAmp/modelcard.nmos"
.include "C:/ngspice/examples/xspice/see/CMOSOpAmp/modelcard.pmos"

.subckt NCH D G S B W=1u L=1.4u m=1
MN1 D G S B N1 W={W} L={L} M={m} AS={3*L*W} AD={3*L*W} PS={6*L+W} PD={6*L+W}
.ends NCH

.subckt PCH D G S B W=1u L=1.4u m=1
MP1 D G S B P1 W={W} L={L} M={m} AS={3*L*W} AD={3*L*W} PS={6*L+W} PD={6*L+W}
.ends PCH

* Two-stage Miller CMOS OTA. Topology from ngspice CMOS-OP1, dual supply.
* Bodies to rails. Analog ground is node 0.
.subckt miller_tia inp inn out vdd vss
.param L=1.4u WD=2.8u WT=5.0u WL=2.8u
+ WOP=14.5u WON=17.4u WDI=5.0u
+ MD=2 MT=2 MO=4 CC=2p IBIAS=40u DW=0 L1=1.4u
Ibias vdd vb {IBIAS}
Xdiode vb vb vss vss NCH W={WDI} L={L} m={MT}
Xtail vs vb vss vss NCH W={WT} L={L} m={MT}
* Diode load on IN- drain (CMOS-OP1 polarity). DW unbalances the pair.
Xdp dplus inp vs vss NCH W={WD*(1+DW)} L={L1} m={MD}
Xdn dmin inn vs vss NCH W={WD*(1-DW)} L={L1} m={MD}
Xln dmin dmin vdd vdd PCH W={WL} L={L1} m={MD}
Xlp dplus dmin vdd vdd PCH W={WL} L={L1} m={MD}
Xop out dplus vdd vdd PCH W={WOP} L={L} m={MO}
Xon out vb vss vss NCH W={WON} L={L} m={MO}
Cc dplus out {CC}
.ends miller_tia

* Telescopic-cascode first stage + Miller CS. Higher DC gain for o2 load.
.subckt miller_cascode inp inn out vdd vss
.param L=1.4u WD=2.8u WT=5.0u WL=2.8u
+ WOP=14.5u WON=17.4u WDI=5.0u WC=2.8u
+ MD=2 MT=2 MO=4 CC=2p IBIAS=40u DW=0
Ibias vdd vb {IBIAS}
Xdiode vb vb vss vss NCH W={WDI} L={L} m={MT}
Xstack vcn vcn vb vss NCH W={WDI} L={L} m={MT}
Xtail vs vb vss vss NCH W={WT} L={L} m={MT}
Xdp splus inp vs vss NCH W={WD*(1+DW)} L={L} m={MD}
Xdn smin inn vs vss NCH W={WD*(1-DW)} L={L} m={MD}
Xcn dplus vcn splus vss NCH W={WC} L={L} m={MD}
Xcm dmin vcn smin vss NCH W={WC} L={L} m={MD}
Xln dmin dmin vdd vdd PCH W={WL} L={L} m={MD}
Xlp dplus dmin vdd vdd PCH W={WL} L={L} m={MD}
Xop out dplus vdd vdd PCH W={WOP} L={L} m={MO}
Xon out vb vss vss NCH W={WON} L={L} m={MO}
Cc dplus out {CC}
.ends miller_cascode

* 5-transistor OTA used as a slow integrator (capacitive load).
.subckt servo_ota inp inn out vdd vss
.param L=1.4u WD=2.8u WT=5.0u WL=2.8u
+ MD=1 MT=1 IBIAS=2u DW=0
Ibias vdd vb {IBIAS}
Xdiode vb vb vss vss NCH W={WT} L={L} m={MT}
Xtail vs vb vss vss NCH W={WT} L={L} m={MT}
Xdp dplus inp vs vss NCH W={WD*(1+DW)} L={L} m={MD}
Xdn dmin inn vs vss NCH W={WD*(1-DW)} L={L} m={MD}
Xlp dplus dplus vdd vdd PCH W={WL} L={L} m={MD}
Xln out dplus vdd vdd PCH W={WL} L={L} m={MD}
.ends servo_ota

* Experiment 26 device TIA  VDD=2.5 VSS=-2.5
* Ibias=4e-05 m_diff=2 m_out=4 Cc=2e-12
* servo=True vos_inject=0 dw_frac=0.00185
* Weights were not edited. SPICE is not Python-corrected.
Vdd vdd 0 DC 2.5
Vss vss 0 DC -2.5
.temp 27
.options reltol=1e-6 abstol=1e-12 vntol=1e-8

Vin1 in1 0 DC 0.742902638868
* passive invert in1 -> in1n: R2/R1=1.0000002 closed-loop -1 at A=1e+07
Rinv1ia in1 inv1m 10000
Rinv1ib in1n inv1m 10000.0020000002
Einv1amp in1n 0 0 inv1m 10000000
Vin2 in2 0 DC -0.654505185575727
Vin3 in3 0 DC 0.720607561993658
* passive invert in3 -> in3n: R2/R1=1.0000002 closed-loop -1 at A=1e+07
Rinv3ia in3 inv3m 10000
Rinv3ib in3n inv3m 10000.0020000002
Einv3amp in3n 0 0 inv3m 10000000
Vin4 in4 0 DC 0.392537169111366
Vin5 in5 0 DC -0.276359736057417
Vin6 in6 0 DC 0.496053448090667
* passive invert in6 -> in6n: R2/R1=1.0000002 closed-loop -1 at A=1e+07
Rinv6ia in6 inv6m 10000
Rinv6ib in6n inv6m 10000.0020000002
Einv6amp in6n 0 0 inv6m 10000000
Vin7 in7 0 DC -0.689791575759108
Vin8 in8 0 DC -0.363567902542475
Vin9 in9 0 DC -0.69453919319847
* passive invert in9 -> in9n: R2/R1=1.0000002 closed-loop -1 at A=1e+07
Rinv9ia in9 inv9m 10000
Rinv9ib in9n inv9m 10000.0020000002
Einv9amp in9n 0 0 inv9m 10000000
Vin10 in10 0 DC 0.770131317907264
Vin11 in11 0 DC 0.255147615191356
Vin12 in12 0 DC 0.172554728875387
* passive invert in12 -> in12n: R2/R1=1.0000002 closed-loop -1 at A=1e+07
Rinv12ia in12 inv12m 10000
Rinv12ib in12n inv12m 10000.0020000002
Einv12amp in12n 0 0 inv12m 10000000
Vin13 in13 0 DC 0.830068494982322
* passive invert in13 -> in13n: R2/R1=1.0000002 closed-loop -1 at A=1e+07
Rinv13ia in13 inv13m 10000
Rinv13ib in13n inv13m 10000.0020000002
Einv13amp in13n 0 0 inv13m 10000000
Vin14 in14 0 DC -0.000668150335241036
* passive invert in14 -> in14n: R2/R1=1.0000002 closed-loop -1 at A=1e+07
Rinv14ia in14 inv14m 10000
Rinv14ib in14n inv14m 10000.0020000002
Einv14amp in14n 0 0 inv14m 10000000
Vin15 in15 0 DC -0.634510524419976
Vin16 in16 0 DC -0.720696935834754
Vref vref 0 DC 1
* passive invert vref -> vrefn: R2/R1=1.0000002 closed-loop -1 at A=1e+07
Rinvrefia vref invrefm 10000
Rinvrefib vrefn invrefm 10000.0020000002
Einvrefamp vrefn 0 0 invrefm 10000000
* load-compensated divider vrefn->taprefn: G_load=0.000637086098486067 Ra=610230.580373169 Rb=1000 target beta=0.001 (no tap buffer)
Rdivrefna vrefn taprefn 610230.580373169
Rdivrefnb taprefn 0 1000

* n1 input 1 w=+0.034343742118514 w+  bank=n alpha=1 R=970579.537264929 G_phys=1.03031226355542e-06 G_eff=1.03031226355542e-06
Rn1p1n1 in1n n1p 970579.537264929
* n1 input 2 w=-0.102232912320493 w-  bank=n alpha=1 R=326052.858876169 G_phys=3.06698736961478e-06 G_eff=3.06698736961478e-06
Rn1n2n1 in2 n1p 326052.858876169
* n1 input 3 w=+1.31993068300228 w+  bank=n alpha=1 R=25253.8514049194 G_phys=3.95979204900683e-05 G_eff=3.95979204900683e-05
Rn1p3n1 in3n n1p 25253.8514049194
* n1 input 4 w=-0.233319639483811 w-  bank=n alpha=1 R=142865.527338714 G_phys=6.99958918451433e-06 G_eff=6.99958918451433e-06
Rn1n4n1 in4 n1p 142865.527338714
* n1 input 5 w=-0.375430599339701 w-  bank=n alpha=1 R=88786.9379639253 G_phys=1.1262917980191e-05 G_eff=1.1262917980191e-05
Rn1n5n1 in5 n1p 88786.9379639253
* n1 input 6 w=+0.442115486842334 w+  bank=n alpha=1 R=75395.0818855177 G_phys=1.326346460527e-05 G_eff=1.326346460527e-05
Rn1p6n1 in6n n1p 75395.0818855177
* n1 input 7 w=-0.102130412545238 w-  bank=n alpha=1 R=326380.090930979 G_phys=3.06391237635715e-06 G_eff=3.06391237635715e-06
Rn1n7n1 in7 n1p 326380.090930979
* n1 input 8 w=-0.136235661297007 w-  bank=n alpha=1 R=244674.067098066 G_phys=4.08706983891021e-06 G_eff=4.08706983891021e-06
Rn1n8n1 in8 n1p 244674.067098066
* n1 input 9 w=+0.0915800560074952 w+  bank=n alpha=1 R=363980.268046628 G_phys=2.74740168022485e-06 G_eff=2.74740168022485e-06
Rn1p9n1 in9n n1p 363980.268046628
* n1 input 10 w=-0.194905587913072 w-  bank=n alpha=1 R=171022.974201232 G_phys=5.84716763739217e-06 G_eff=5.84716763739217e-06
Rn1n10n1 in10 n1p 171022.974201232
* n1 input 11 w=-0.611958537828416 w-  bank=n alpha=1 R=54469.9212002489 G_phys=1.83587561348525e-05 G_eff=1.83587561348525e-05
Rn1n11n1 in11 n1p 54469.9212002489
* n1 input 12 w=+0.19411196838682 w+  bank=n alpha=1 R=171722.195237894 G_phys=5.8233590516046e-06 G_eff=5.8233590516046e-06
Rn1p12n1 in12n n1p 171722.195237894
* n1 input 13 w=+0.146421986160596 w+  bank=n alpha=1 R=227652.514539539 G_phys=4.39265958481789e-06 G_eff=4.39265958481789e-06
Rn1p13n1 in13n n1p 227652.514539539
* n1 input 14 w=+0.246088955287688 w+  bank=n alpha=1 R=135452.374505655 G_phys=7.38266865863065e-06 G_eff=7.38266865863065e-06
Rn1p14n1 in14n n1p 135452.374505655
* n1 input 15 w=-0.101801651380703 w-  bank=n alpha=1 R=327434.112131228 G_phys=3.05404954142109e-06 G_eff=3.05404954142109e-06
Rn1n15n1 in15 n1p 327434.112131228
* n1 input 16 w=-0.212672591801914 w-  bank=n alpha=1 R=156735.445084435 G_phys=6.38017775405741e-06 G_eff=6.38017775405741e-06
Rn1n16n1 in16 n1p 156735.445084435
* n1 bias w+  bank=f alpha=0.001 R=1569.64655542844 G_phys=0.000637086098486067 G_eff=6.37086098486067e-07
Rn1bpf1 taprefn n1p 1569.64655542844
* feedback TIA n1: Rf=33333.3333333333 A=100000 V(n1lin) = -I(n1p)*Rf*A/(A+1)  (uncompensated)
Rn1f n1lin n1p 33333.3333333333

* MOS TIA + optional MOS servo. IN- sense at n1p (sum). OUT = n1lin.
* TIA subckt=miller_tia topology=miller
* Vn1ib is a 0 V ammeter: i(Vn1ib) = current from sum into MOS IN-.
Vn1ib n1p n1inn DC 0
Vosinj n1osp n1srv DC 0
Xn1tia n1osp n1inn n1lin vdd vss miller_tia MD=2 MT=2 MO=4 CC=2e-12 IBIAS=4e-05 DW=0.00185 L1=1.4u
* MOS miller leaky integrator servo: tau~Rin*C=5e-05 s
Rn1si n1p n1sint 50000
Cn1int n1sint n1srv 1e-09
Rn1leak n1sint n1srv 100000000
Xn1srv 0 n1sint n1srv vdd vss miller_tia MD=2 MT=2 MO=4 CC=2e-12 IBIAS=2e-05 DW=0.001487
.ic v(n1srv)=0
.control
set numdgt=15
op
print v(n1lin)
print v(n1p)
print v(n1srv)
print i(Vn1ib)
print i(Vdd)
print i(Vss)
.endc
.end
