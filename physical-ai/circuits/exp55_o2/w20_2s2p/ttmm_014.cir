* Experiment 55 w20_2s2p tt_mm draw 14 A=1e6 · model AGAUSS
* PDK sky130A open_pdks 1689ac3f2dc763876eaf967227c7dfe831b031ae
* Frozen weights were not edited. SPICE is not Python-corrected.
.lib "C:/dev/pdk/sky130A/libs.tech/ngspice/sky130.lib.spice" tt_mm
.temp 27

* Experiment 22 isolated TIA neuron n1
* frozen n=32 L1=6.7601697 b=0.0322130531942455
* A=1000000 vos=0 Ileak=0 Rout=0 fp=0 invertA=1e+07
* Behavioral TIA. Not transistor-level. Weights were not edited.
* shape: 32 -> 1 (linear Vlin vs z unless ReLU requested)

Vin1 in1 0 DC 0.288635987619693
Vin2 in2 0 DC 0.653552961415873
* passive invert in2 -> in2n: R2/R1=1.0000002 closed-loop -1 at A=1e+07
* PDK sky130_fd_pr__res_xhigh_po Rinv2ia W=20 L=99.603427
* tile Rinv2ia 2s x 2p same W=20 L=99.603427
XRinv2iap0s0 in2 Rinv2iat0s0 0 sky130_fd_pr__res_xhigh_po w=20 l=99.603427
XRinv2iap0s1 Rinv2iat0s0 inv2m 0 sky130_fd_pr__res_xhigh_po w=20 l=99.603427
XRinv2iap1s0 in2 Rinv2iat1s0 0 sky130_fd_pr__res_xhigh_po w=20 l=99.603427
XRinv2iap1s1 Rinv2iat1s0 inv2m 0 sky130_fd_pr__res_xhigh_po w=20 l=99.603427
* PDK sky130_fd_pr__res_xhigh_po Rinv2ib W=20 L=99.603447
* tile Rinv2ib 2s x 2p same W=20 L=99.603447
XRinv2ibp0s0 in2n Rinv2ibt0s0 0 sky130_fd_pr__res_xhigh_po w=20 l=99.603447
XRinv2ibp0s1 Rinv2ibt0s0 inv2m 0 sky130_fd_pr__res_xhigh_po w=20 l=99.603447
XRinv2ibp1s0 in2n Rinv2ibt1s0 0 sky130_fd_pr__res_xhigh_po w=20 l=99.603447
XRinv2ibp1s1 Rinv2ibt1s0 inv2m 0 sky130_fd_pr__res_xhigh_po w=20 l=99.603447
Einv2amp in2n 0 0 inv2m 10000000
Vin3 in3 0 DC 1.14933536319878
* passive invert in3 -> in3n: R2/R1=1.0000002 closed-loop -1 at A=1e+07
* PDK sky130_fd_pr__res_xhigh_po Rinv3ia W=20 L=99.603427
* tile Rinv3ia 2s x 2p same W=20 L=99.603427
XRinv3iap0s0 in3 Rinv3iat0s0 0 sky130_fd_pr__res_xhigh_po w=20 l=99.603427
XRinv3iap0s1 Rinv3iat0s0 inv3m 0 sky130_fd_pr__res_xhigh_po w=20 l=99.603427
XRinv3iap1s0 in3 Rinv3iat1s0 0 sky130_fd_pr__res_xhigh_po w=20 l=99.603427
XRinv3iap1s1 Rinv3iat1s0 inv3m 0 sky130_fd_pr__res_xhigh_po w=20 l=99.603427
* PDK sky130_fd_pr__res_xhigh_po Rinv3ib W=20 L=99.603447
* tile Rinv3ib 2s x 2p same W=20 L=99.603447
XRinv3ibp0s0 in3n Rinv3ibt0s0 0 sky130_fd_pr__res_xhigh_po w=20 l=99.603447
XRinv3ibp0s1 Rinv3ibt0s0 inv3m 0 sky130_fd_pr__res_xhigh_po w=20 l=99.603447
XRinv3ibp1s0 in3n Rinv3ibt1s0 0 sky130_fd_pr__res_xhigh_po w=20 l=99.603447
XRinv3ibp1s1 Rinv3ibt1s0 inv3m 0 sky130_fd_pr__res_xhigh_po w=20 l=99.603447
Einv3amp in3n 0 0 inv3m 10000000
Vin4 in4 0 DC 0
Vin5 in5 0 DC 1.37476380462716
* passive invert in5 -> in5n: R2/R1=1.0000002 closed-loop -1 at A=1e+07
* PDK sky130_fd_pr__res_xhigh_po Rinv5ia W=20 L=99.603427
* tile Rinv5ia 2s x 2p same W=20 L=99.603427
XRinv5iap0s0 in5 Rinv5iat0s0 0 sky130_fd_pr__res_xhigh_po w=20 l=99.603427
XRinv5iap0s1 Rinv5iat0s0 inv5m 0 sky130_fd_pr__res_xhigh_po w=20 l=99.603427
XRinv5iap1s0 in5 Rinv5iat1s0 0 sky130_fd_pr__res_xhigh_po w=20 l=99.603427
XRinv5iap1s1 Rinv5iat1s0 inv5m 0 sky130_fd_pr__res_xhigh_po w=20 l=99.603427
* PDK sky130_fd_pr__res_xhigh_po Rinv5ib W=20 L=99.603447
* tile Rinv5ib 2s x 2p same W=20 L=99.603447
XRinv5ibp0s0 in5n Rinv5ibt0s0 0 sky130_fd_pr__res_xhigh_po w=20 l=99.603447
XRinv5ibp0s1 Rinv5ibt0s0 inv5m 0 sky130_fd_pr__res_xhigh_po w=20 l=99.603447
XRinv5ibp1s0 in5n Rinv5ibt1s0 0 sky130_fd_pr__res_xhigh_po w=20 l=99.603447
XRinv5ibp1s1 Rinv5ibt1s0 inv5m 0 sky130_fd_pr__res_xhigh_po w=20 l=99.603447
Einv5amp in5n 0 0 inv5m 10000000
Vin6 in6 0 DC 1.19986134609244
* passive invert in6 -> in6n: R2/R1=1.0000002 closed-loop -1 at A=1e+07
* PDK sky130_fd_pr__res_xhigh_po Rinv6ia W=20 L=99.603427
* tile Rinv6ia 2s x 2p same W=20 L=99.603427
XRinv6iap0s0 in6 Rinv6iat0s0 0 sky130_fd_pr__res_xhigh_po w=20 l=99.603427
XRinv6iap0s1 Rinv6iat0s0 inv6m 0 sky130_fd_pr__res_xhigh_po w=20 l=99.603427
XRinv6iap1s0 in6 Rinv6iat1s0 0 sky130_fd_pr__res_xhigh_po w=20 l=99.603427
XRinv6iap1s1 Rinv6iat1s0 inv6m 0 sky130_fd_pr__res_xhigh_po w=20 l=99.603427
* PDK sky130_fd_pr__res_xhigh_po Rinv6ib W=20 L=99.603447
* tile Rinv6ib 2s x 2p same W=20 L=99.603447
XRinv6ibp0s0 in6n Rinv6ibt0s0 0 sky130_fd_pr__res_xhigh_po w=20 l=99.603447
XRinv6ibp0s1 Rinv6ibt0s0 inv6m 0 sky130_fd_pr__res_xhigh_po w=20 l=99.603447
XRinv6ibp1s0 in6n Rinv6ibt1s0 0 sky130_fd_pr__res_xhigh_po w=20 l=99.603447
XRinv6ibp1s1 Rinv6ibt1s0 inv6m 0 sky130_fd_pr__res_xhigh_po w=20 l=99.603447
Einv6amp in6n 0 0 inv6m 10000000
Vin7 in7 0 DC 0
Vin8 in8 0 DC 0.317097301363568
Vin9 in9 0 DC 0
* passive invert in9 -> in9n: R2/R1=1.0000002 closed-loop -1 at A=1e+07
* PDK sky130_fd_pr__res_xhigh_po Rinv9ia W=20 L=99.603427
* tile Rinv9ia 2s x 2p same W=20 L=99.603427
XRinv9iap0s0 in9 Rinv9iat0s0 0 sky130_fd_pr__res_xhigh_po w=20 l=99.603427
XRinv9iap0s1 Rinv9iat0s0 inv9m 0 sky130_fd_pr__res_xhigh_po w=20 l=99.603427
XRinv9iap1s0 in9 Rinv9iat1s0 0 sky130_fd_pr__res_xhigh_po w=20 l=99.603427
XRinv9iap1s1 Rinv9iat1s0 inv9m 0 sky130_fd_pr__res_xhigh_po w=20 l=99.603427
* PDK sky130_fd_pr__res_xhigh_po Rinv9ib W=20 L=99.603447
* tile Rinv9ib 2s x 2p same W=20 L=99.603447
XRinv9ibp0s0 in9n Rinv9ibt0s0 0 sky130_fd_pr__res_xhigh_po w=20 l=99.603447
XRinv9ibp0s1 Rinv9ibt0s0 inv9m 0 sky130_fd_pr__res_xhigh_po w=20 l=99.603447
XRinv9ibp1s0 in9n Rinv9ibt1s0 0 sky130_fd_pr__res_xhigh_po w=20 l=99.603447
XRinv9ibp1s1 Rinv9ibt1s0 inv9m 0 sky130_fd_pr__res_xhigh_po w=20 l=99.603447
Einv9amp in9n 0 0 inv9m 10000000
Vin10 in10 0 DC 0.827257420094178
* passive invert in10 -> in10n: R2/R1=1.0000002 closed-loop -1 at A=1e+07
* PDK sky130_fd_pr__res_xhigh_po Rinv10ia W=20 L=99.603427
* tile Rinv10ia 2s x 2p same W=20 L=99.603427
XRinv10iap0s0 in10 Rinv10iat0s0 0 sky130_fd_pr__res_xhigh_po w=20 l=99.603427
XRinv10iap0s1 Rinv10iat0s0 inv10m 0 sky130_fd_pr__res_xhigh_po w=20 l=99.603427
XRinv10iap1s0 in10 Rinv10iat1s0 0 sky130_fd_pr__res_xhigh_po w=20 l=99.603427
XRinv10iap1s1 Rinv10iat1s0 inv10m 0 sky130_fd_pr__res_xhigh_po w=20 l=99.603427
* PDK sky130_fd_pr__res_xhigh_po Rinv10ib W=20 L=99.603447
* tile Rinv10ib 2s x 2p same W=20 L=99.603447
XRinv10ibp0s0 in10n Rinv10ibt0s0 0 sky130_fd_pr__res_xhigh_po w=20 l=99.603447
XRinv10ibp0s1 Rinv10ibt0s0 inv10m 0 sky130_fd_pr__res_xhigh_po w=20 l=99.603447
XRinv10ibp1s0 in10n Rinv10ibt1s0 0 sky130_fd_pr__res_xhigh_po w=20 l=99.603447
XRinv10ibp1s1 Rinv10ibt1s0 inv10m 0 sky130_fd_pr__res_xhigh_po w=20 l=99.603447
Einv10amp in10n 0 0 inv10m 10000000
Vin11 in11 0 DC 0
Vin12 in12 0 DC 0
Vin13 in13 0 DC 0
Vin14 in14 0 DC 1.25893915448753
* passive invert in14 -> in14n: R2/R1=1.0000002 closed-loop -1 at A=1e+07
* PDK sky130_fd_pr__res_xhigh_po Rinv14ia W=20 L=99.603427
* tile Rinv14ia 2s x 2p same W=20 L=99.603427
XRinv14iap0s0 in14 Rinv14iat0s0 0 sky130_fd_pr__res_xhigh_po w=20 l=99.603427
XRinv14iap0s1 Rinv14iat0s0 inv14m 0 sky130_fd_pr__res_xhigh_po w=20 l=99.603427
XRinv14iap1s0 in14 Rinv14iat1s0 0 sky130_fd_pr__res_xhigh_po w=20 l=99.603427
XRinv14iap1s1 Rinv14iat1s0 inv14m 0 sky130_fd_pr__res_xhigh_po w=20 l=99.603427
* PDK sky130_fd_pr__res_xhigh_po Rinv14ib W=20 L=99.603447
* tile Rinv14ib 2s x 2p same W=20 L=99.603447
XRinv14ibp0s0 in14n Rinv14ibt0s0 0 sky130_fd_pr__res_xhigh_po w=20 l=99.603447
XRinv14ibp0s1 Rinv14ibt0s0 inv14m 0 sky130_fd_pr__res_xhigh_po w=20 l=99.603447
XRinv14ibp1s0 in14n Rinv14ibt1s0 0 sky130_fd_pr__res_xhigh_po w=20 l=99.603447
XRinv14ibp1s1 Rinv14ibt1s0 inv14m 0 sky130_fd_pr__res_xhigh_po w=20 l=99.603447
Einv14amp in14n 0 0 inv14m 10000000
Vin15 in15 0 DC 0.398142284790337
Vin16 in16 0 DC 0
* load-compensated divider in16->tap16: G_load=0.000666445780473128 Ra=599479.450040294 Rb=1000 target beta=0.001 (no tap buffer)
* PDK sky130_fd_pr__res_xhigh_po Rdiv16a W=20 L=5977.8925
* tile Rdiv16a 2s x 2p same W=20 L=5977.8925
XRdiv16ap0s0 in16 Rdiv16at0s0 0 sky130_fd_pr__res_xhigh_po w=20 l=5977.8925
XRdiv16ap0s1 Rdiv16at0s0 tap16 0 sky130_fd_pr__res_xhigh_po w=20 l=5977.8925
XRdiv16ap1s0 in16 Rdiv16at1s0 0 sky130_fd_pr__res_xhigh_po w=20 l=5977.8925
XRdiv16ap1s1 Rdiv16at1s0 tap16 0 sky130_fd_pr__res_xhigh_po w=20 l=5977.8925
* PDK sky130_fd_pr__res_xhigh_po Rdiv16b W=20 L=9.8554268
* tile Rdiv16b 2s x 2p same W=20 L=9.8554268
XRdiv16bp0s0 tap16 Rdiv16bt0s0 0 sky130_fd_pr__res_xhigh_po w=20 l=9.8554268
XRdiv16bp0s1 Rdiv16bt0s0 0 0 sky130_fd_pr__res_xhigh_po w=20 l=9.8554268
XRdiv16bp1s0 tap16 Rdiv16bt1s0 0 sky130_fd_pr__res_xhigh_po w=20 l=9.8554268
XRdiv16bp1s1 Rdiv16bt1s0 0 0 sky130_fd_pr__res_xhigh_po w=20 l=9.8554268
Vin17 in17 0 DC 0
* passive invert in17 -> in17n: R2/R1=1.0000002 closed-loop -1 at A=1e+07
* PDK sky130_fd_pr__res_xhigh_po Rinv17ia W=20 L=99.603427
* tile Rinv17ia 2s x 2p same W=20 L=99.603427
XRinv17iap0s0 in17 Rinv17iat0s0 0 sky130_fd_pr__res_xhigh_po w=20 l=99.603427
XRinv17iap0s1 Rinv17iat0s0 inv17m 0 sky130_fd_pr__res_xhigh_po w=20 l=99.603427
XRinv17iap1s0 in17 Rinv17iat1s0 0 sky130_fd_pr__res_xhigh_po w=20 l=99.603427
XRinv17iap1s1 Rinv17iat1s0 inv17m 0 sky130_fd_pr__res_xhigh_po w=20 l=99.603427
* PDK sky130_fd_pr__res_xhigh_po Rinv17ib W=20 L=99.603447
* tile Rinv17ib 2s x 2p same W=20 L=99.603447
XRinv17ibp0s0 in17n Rinv17ibt0s0 0 sky130_fd_pr__res_xhigh_po w=20 l=99.603447
XRinv17ibp0s1 Rinv17ibt0s0 inv17m 0 sky130_fd_pr__res_xhigh_po w=20 l=99.603447
XRinv17ibp1s0 in17n Rinv17ibt1s0 0 sky130_fd_pr__res_xhigh_po w=20 l=99.603447
XRinv17ibp1s1 Rinv17ibt1s0 inv17m 0 sky130_fd_pr__res_xhigh_po w=20 l=99.603447
Einv17amp in17n 0 0 inv17m 10000000
* load-compensated divider in17n->tap17n: G_load=0.000266255881165782 Ra=788940.067216326 Rb=1000 target beta=0.001 (no tap buffer)
* PDK sky130_fd_pr__res_xhigh_po Rdiv17na W=20 L=7867.1938
* tile Rdiv17na 2s x 2p same W=20 L=7867.1938
XRdiv17nap0s0 in17n Rdiv17nat0s0 0 sky130_fd_pr__res_xhigh_po w=20 l=7867.1938
XRdiv17nap0s1 Rdiv17nat0s0 tap17n 0 sky130_fd_pr__res_xhigh_po w=20 l=7867.1938
XRdiv17nap1s0 in17n Rdiv17nat1s0 0 sky130_fd_pr__res_xhigh_po w=20 l=7867.1938
XRdiv17nap1s1 Rdiv17nat1s0 tap17n 0 sky130_fd_pr__res_xhigh_po w=20 l=7867.1938
* PDK sky130_fd_pr__res_xhigh_po Rdiv17nb W=20 L=9.8554268
* tile Rdiv17nb 2s x 2p same W=20 L=9.8554268
XRdiv17nbp0s0 tap17n Rdiv17nbt0s0 0 sky130_fd_pr__res_xhigh_po w=20 l=9.8554268
XRdiv17nbp0s1 Rdiv17nbt0s0 0 0 sky130_fd_pr__res_xhigh_po w=20 l=9.8554268
XRdiv17nbp1s0 tap17n Rdiv17nbt1s0 0 sky130_fd_pr__res_xhigh_po w=20 l=9.8554268
XRdiv17nbp1s1 Rdiv17nbt1s0 0 0 sky130_fd_pr__res_xhigh_po w=20 l=9.8554268
Vin18 in18 0 DC 1.19134595226048
Vin19 in19 0 DC 0
* passive invert in19 -> in19n: R2/R1=1.0000002 closed-loop -1 at A=1e+07
* PDK sky130_fd_pr__res_xhigh_po Rinv19ia W=20 L=99.603427
* tile Rinv19ia 2s x 2p same W=20 L=99.603427
XRinv19iap0s0 in19 Rinv19iat0s0 0 sky130_fd_pr__res_xhigh_po w=20 l=99.603427
XRinv19iap0s1 Rinv19iat0s0 inv19m 0 sky130_fd_pr__res_xhigh_po w=20 l=99.603427
XRinv19iap1s0 in19 Rinv19iat1s0 0 sky130_fd_pr__res_xhigh_po w=20 l=99.603427
XRinv19iap1s1 Rinv19iat1s0 inv19m 0 sky130_fd_pr__res_xhigh_po w=20 l=99.603427
* PDK sky130_fd_pr__res_xhigh_po Rinv19ib W=20 L=99.603447
* tile Rinv19ib 2s x 2p same W=20 L=99.603447
XRinv19ibp0s0 in19n Rinv19ibt0s0 0 sky130_fd_pr__res_xhigh_po w=20 l=99.603447
XRinv19ibp0s1 Rinv19ibt0s0 inv19m 0 sky130_fd_pr__res_xhigh_po w=20 l=99.603447
XRinv19ibp1s0 in19n Rinv19ibt1s0 0 sky130_fd_pr__res_xhigh_po w=20 l=99.603447
XRinv19ibp1s1 Rinv19ibt1s0 inv19m 0 sky130_fd_pr__res_xhigh_po w=20 l=99.603447
Einv19amp in19n 0 0 inv19m 10000000
Vin20 in20 0 DC 0
* load-compensated divider in20->tap20: G_load=0.000971610549965604 Ra=506692.358700063 Rb=1000 target beta=0.001 (no tap buffer)
* PDK sky130_fd_pr__res_xhigh_po Rdiv20a W=20 L=5052.6196
* tile Rdiv20a 2s x 2p same W=20 L=5052.6196
XRdiv20ap0s0 in20 Rdiv20at0s0 0 sky130_fd_pr__res_xhigh_po w=20 l=5052.6196
XRdiv20ap0s1 Rdiv20at0s0 tap20 0 sky130_fd_pr__res_xhigh_po w=20 l=5052.6196
XRdiv20ap1s0 in20 Rdiv20at1s0 0 sky130_fd_pr__res_xhigh_po w=20 l=5052.6196
XRdiv20ap1s1 Rdiv20at1s0 tap20 0 sky130_fd_pr__res_xhigh_po w=20 l=5052.6196
* PDK sky130_fd_pr__res_xhigh_po Rdiv20b W=20 L=9.8554268
* tile Rdiv20b 2s x 2p same W=20 L=9.8554268
XRdiv20bp0s0 tap20 Rdiv20bt0s0 0 sky130_fd_pr__res_xhigh_po w=20 l=9.8554268
XRdiv20bp0s1 Rdiv20bt0s0 0 0 sky130_fd_pr__res_xhigh_po w=20 l=9.8554268
XRdiv20bp1s0 tap20 Rdiv20bt1s0 0 sky130_fd_pr__res_xhigh_po w=20 l=9.8554268
XRdiv20bp1s1 Rdiv20bt1s0 0 0 sky130_fd_pr__res_xhigh_po w=20 l=9.8554268
Vin21 in21 0 DC 0
Vin22 in22 0 DC 0
* passive invert in22 -> in22n: R2/R1=1.0000002 closed-loop -1 at A=1e+07
* PDK sky130_fd_pr__res_xhigh_po Rinv22ia W=20 L=99.603427
* tile Rinv22ia 2s x 2p same W=20 L=99.603427
XRinv22iap0s0 in22 Rinv22iat0s0 0 sky130_fd_pr__res_xhigh_po w=20 l=99.603427
XRinv22iap0s1 Rinv22iat0s0 inv22m 0 sky130_fd_pr__res_xhigh_po w=20 l=99.603427
XRinv22iap1s0 in22 Rinv22iat1s0 0 sky130_fd_pr__res_xhigh_po w=20 l=99.603427
XRinv22iap1s1 Rinv22iat1s0 inv22m 0 sky130_fd_pr__res_xhigh_po w=20 l=99.603427
* PDK sky130_fd_pr__res_xhigh_po Rinv22ib W=20 L=99.603447
* tile Rinv22ib 2s x 2p same W=20 L=99.603447
XRinv22ibp0s0 in22n Rinv22ibt0s0 0 sky130_fd_pr__res_xhigh_po w=20 l=99.603447
XRinv22ibp0s1 Rinv22ibt0s0 inv22m 0 sky130_fd_pr__res_xhigh_po w=20 l=99.603447
XRinv22ibp1s0 in22n Rinv22ibt1s0 0 sky130_fd_pr__res_xhigh_po w=20 l=99.603447
XRinv22ibp1s1 Rinv22ibt1s0 inv22m 0 sky130_fd_pr__res_xhigh_po w=20 l=99.603447
Einv22amp in22n 0 0 inv22m 10000000
Vin23 in23 0 DC 0.370520947636909
* passive invert in23 -> in23n: R2/R1=1.0000002 closed-loop -1 at A=1e+07
* PDK sky130_fd_pr__res_xhigh_po Rinv23ia W=20 L=99.603427
* tile Rinv23ia 2s x 2p same W=20 L=99.603427
XRinv23iap0s0 in23 Rinv23iat0s0 0 sky130_fd_pr__res_xhigh_po w=20 l=99.603427
XRinv23iap0s1 Rinv23iat0s0 inv23m 0 sky130_fd_pr__res_xhigh_po w=20 l=99.603427
XRinv23iap1s0 in23 Rinv23iat1s0 0 sky130_fd_pr__res_xhigh_po w=20 l=99.603427
XRinv23iap1s1 Rinv23iat1s0 inv23m 0 sky130_fd_pr__res_xhigh_po w=20 l=99.603427
* PDK sky130_fd_pr__res_xhigh_po Rinv23ib W=20 L=99.603447
* tile Rinv23ib 2s x 2p same W=20 L=99.603447
XRinv23ibp0s0 in23n Rinv23ibt0s0 0 sky130_fd_pr__res_xhigh_po w=20 l=99.603447
XRinv23ibp0s1 Rinv23ibt0s0 inv23m 0 sky130_fd_pr__res_xhigh_po w=20 l=99.603447
XRinv23ibp1s0 in23n Rinv23ibt1s0 0 sky130_fd_pr__res_xhigh_po w=20 l=99.603447
XRinv23ibp1s1 Rinv23ibt1s0 inv23m 0 sky130_fd_pr__res_xhigh_po w=20 l=99.603447
Einv23amp in23n 0 0 inv23m 10000000
Vin24 in24 0 DC 0
* load-compensated divider in24->tap24: G_load=0.000881349510863982 Ra=531001.812385847 Rb=1000 target beta=0.001 (no tap buffer)
* PDK sky130_fd_pr__res_xhigh_po Rdiv24a W=20 L=5295.0335
* tile Rdiv24a 2s x 2p same W=20 L=5295.0335
XRdiv24ap0s0 in24 Rdiv24at0s0 0 sky130_fd_pr__res_xhigh_po w=20 l=5295.0335
XRdiv24ap0s1 Rdiv24at0s0 tap24 0 sky130_fd_pr__res_xhigh_po w=20 l=5295.0335
XRdiv24ap1s0 in24 Rdiv24at1s0 0 sky130_fd_pr__res_xhigh_po w=20 l=5295.0335
XRdiv24ap1s1 Rdiv24at1s0 tap24 0 sky130_fd_pr__res_xhigh_po w=20 l=5295.0335
* PDK sky130_fd_pr__res_xhigh_po Rdiv24b W=20 L=9.8554268
* tile Rdiv24b 2s x 2p same W=20 L=9.8554268
XRdiv24bp0s0 tap24 Rdiv24bt0s0 0 sky130_fd_pr__res_xhigh_po w=20 l=9.8554268
XRdiv24bp0s1 Rdiv24bt0s0 0 0 sky130_fd_pr__res_xhigh_po w=20 l=9.8554268
XRdiv24bp1s0 tap24 Rdiv24bt1s0 0 sky130_fd_pr__res_xhigh_po w=20 l=9.8554268
XRdiv24bp1s1 Rdiv24bt1s0 0 0 sky130_fd_pr__res_xhigh_po w=20 l=9.8554268
Vin25 in25 0 DC 0
* passive invert in25 -> in25n: R2/R1=1.0000002 closed-loop -1 at A=1e+07
* PDK sky130_fd_pr__res_xhigh_po Rinv25ia W=20 L=99.603427
* tile Rinv25ia 2s x 2p same W=20 L=99.603427
XRinv25iap0s0 in25 Rinv25iat0s0 0 sky130_fd_pr__res_xhigh_po w=20 l=99.603427
XRinv25iap0s1 Rinv25iat0s0 inv25m 0 sky130_fd_pr__res_xhigh_po w=20 l=99.603427
XRinv25iap1s0 in25 Rinv25iat1s0 0 sky130_fd_pr__res_xhigh_po w=20 l=99.603427
XRinv25iap1s1 Rinv25iat1s0 inv25m 0 sky130_fd_pr__res_xhigh_po w=20 l=99.603427
* PDK sky130_fd_pr__res_xhigh_po Rinv25ib W=20 L=99.603447
* tile Rinv25ib 2s x 2p same W=20 L=99.603447
XRinv25ibp0s0 in25n Rinv25ibt0s0 0 sky130_fd_pr__res_xhigh_po w=20 l=99.603447
XRinv25ibp0s1 Rinv25ibt0s0 inv25m 0 sky130_fd_pr__res_xhigh_po w=20 l=99.603447
XRinv25ibp1s0 in25n Rinv25ibt1s0 0 sky130_fd_pr__res_xhigh_po w=20 l=99.603447
XRinv25ibp1s1 Rinv25ibt1s0 inv25m 0 sky130_fd_pr__res_xhigh_po w=20 l=99.603447
Einv25amp in25n 0 0 inv25m 10000000
Vin26 in26 0 DC 0
Vin27 in27 0 DC 1.88293545008737
* passive invert in27 -> in27n: R2/R1=1.0000002 closed-loop -1 at A=1e+07
* PDK sky130_fd_pr__res_xhigh_po Rinv27ia W=20 L=99.603427
* tile Rinv27ia 2s x 2p same W=20 L=99.603427
XRinv27iap0s0 in27 Rinv27iat0s0 0 sky130_fd_pr__res_xhigh_po w=20 l=99.603427
XRinv27iap0s1 Rinv27iat0s0 inv27m 0 sky130_fd_pr__res_xhigh_po w=20 l=99.603427
XRinv27iap1s0 in27 Rinv27iat1s0 0 sky130_fd_pr__res_xhigh_po w=20 l=99.603427
XRinv27iap1s1 Rinv27iat1s0 inv27m 0 sky130_fd_pr__res_xhigh_po w=20 l=99.603427
* PDK sky130_fd_pr__res_xhigh_po Rinv27ib W=20 L=99.603447
* tile Rinv27ib 2s x 2p same W=20 L=99.603447
XRinv27ibp0s0 in27n Rinv27ibt0s0 0 sky130_fd_pr__res_xhigh_po w=20 l=99.603447
XRinv27ibp0s1 Rinv27ibt0s0 inv27m 0 sky130_fd_pr__res_xhigh_po w=20 l=99.603447
XRinv27ibp1s0 in27n Rinv27ibt1s0 0 sky130_fd_pr__res_xhigh_po w=20 l=99.603447
XRinv27ibp1s1 Rinv27ibt1s0 inv27m 0 sky130_fd_pr__res_xhigh_po w=20 l=99.603447
Einv27amp in27n 0 0 inv27m 10000000
Vin28 in28 0 DC 1.38172289531745
* passive invert in28 -> in28n: R2/R1=1.0000002 closed-loop -1 at A=1e+07
* PDK sky130_fd_pr__res_xhigh_po Rinv28ia W=20 L=99.603427
* tile Rinv28ia 2s x 2p same W=20 L=99.603427
XRinv28iap0s0 in28 Rinv28iat0s0 0 sky130_fd_pr__res_xhigh_po w=20 l=99.603427
XRinv28iap0s1 Rinv28iat0s0 inv28m 0 sky130_fd_pr__res_xhigh_po w=20 l=99.603427
XRinv28iap1s0 in28 Rinv28iat1s0 0 sky130_fd_pr__res_xhigh_po w=20 l=99.603427
XRinv28iap1s1 Rinv28iat1s0 inv28m 0 sky130_fd_pr__res_xhigh_po w=20 l=99.603427
* PDK sky130_fd_pr__res_xhigh_po Rinv28ib W=20 L=99.603447
* tile Rinv28ib 2s x 2p same W=20 L=99.603447
XRinv28ibp0s0 in28n Rinv28ibt0s0 0 sky130_fd_pr__res_xhigh_po w=20 l=99.603447
XRinv28ibp0s1 Rinv28ibt0s0 inv28m 0 sky130_fd_pr__res_xhigh_po w=20 l=99.603447
XRinv28ibp1s0 in28n Rinv28ibt1s0 0 sky130_fd_pr__res_xhigh_po w=20 l=99.603447
XRinv28ibp1s1 Rinv28ibt1s0 inv28m 0 sky130_fd_pr__res_xhigh_po w=20 l=99.603447
Einv28amp in28n 0 0 inv28m 10000000
Vin29 in29 0 DC 0
* passive invert in29 -> in29n: R2/R1=1.0000002 closed-loop -1 at A=1e+07
* PDK sky130_fd_pr__res_xhigh_po Rinv29ia W=20 L=99.603427
* tile Rinv29ia 2s x 2p same W=20 L=99.603427
XRinv29iap0s0 in29 Rinv29iat0s0 0 sky130_fd_pr__res_xhigh_po w=20 l=99.603427
XRinv29iap0s1 Rinv29iat0s0 inv29m 0 sky130_fd_pr__res_xhigh_po w=20 l=99.603427
XRinv29iap1s0 in29 Rinv29iat1s0 0 sky130_fd_pr__res_xhigh_po w=20 l=99.603427
XRinv29iap1s1 Rinv29iat1s0 inv29m 0 sky130_fd_pr__res_xhigh_po w=20 l=99.603427
* PDK sky130_fd_pr__res_xhigh_po Rinv29ib W=20 L=99.603447
* tile Rinv29ib 2s x 2p same W=20 L=99.603447
XRinv29ibp0s0 in29n Rinv29ibt0s0 0 sky130_fd_pr__res_xhigh_po w=20 l=99.603447
XRinv29ibp0s1 Rinv29ibt0s0 inv29m 0 sky130_fd_pr__res_xhigh_po w=20 l=99.603447
XRinv29ibp1s0 in29n Rinv29ibt1s0 0 sky130_fd_pr__res_xhigh_po w=20 l=99.603447
XRinv29ibp1s1 Rinv29ibt1s0 inv29m 0 sky130_fd_pr__res_xhigh_po w=20 l=99.603447
Einv29amp in29n 0 0 inv29m 10000000
* load-compensated divider in29n->tap29n: G_load=0.000275989040257845 Ra=782922.085128668 Rb=1000 target beta=0.001 (no tap buffer)
* PDK sky130_fd_pr__res_xhigh_po Rdiv29na W=20 L=7807.1825
* tile Rdiv29na 2s x 2p same W=20 L=7807.1825
XRdiv29nap0s0 in29n Rdiv29nat0s0 0 sky130_fd_pr__res_xhigh_po w=20 l=7807.1825
XRdiv29nap0s1 Rdiv29nat0s0 tap29n 0 sky130_fd_pr__res_xhigh_po w=20 l=7807.1825
XRdiv29nap1s0 in29n Rdiv29nat1s0 0 sky130_fd_pr__res_xhigh_po w=20 l=7807.1825
XRdiv29nap1s1 Rdiv29nat1s0 tap29n 0 sky130_fd_pr__res_xhigh_po w=20 l=7807.1825
* PDK sky130_fd_pr__res_xhigh_po Rdiv29nb W=20 L=9.8554268
* tile Rdiv29nb 2s x 2p same W=20 L=9.8554268
XRdiv29nbp0s0 tap29n Rdiv29nbt0s0 0 sky130_fd_pr__res_xhigh_po w=20 l=9.8554268
XRdiv29nbp0s1 Rdiv29nbt0s0 0 0 sky130_fd_pr__res_xhigh_po w=20 l=9.8554268
XRdiv29nbp1s0 tap29n Rdiv29nbt1s0 0 sky130_fd_pr__res_xhigh_po w=20 l=9.8554268
XRdiv29nbp1s1 Rdiv29nbt1s0 0 0 sky130_fd_pr__res_xhigh_po w=20 l=9.8554268
Vin30 in30 0 DC 0.0467434987671904
Vin31 in31 0 DC 0.376944739491497
Vin32 in32 0 DC 0.0618086911540602
* passive invert in32 -> in32n: R2/R1=1.0000002 closed-loop -1 at A=1e+07
* PDK sky130_fd_pr__res_xhigh_po Rinv32ia W=20 L=99.603427
* tile Rinv32ia 2s x 2p same W=20 L=99.603427
XRinv32iap0s0 in32 Rinv32iat0s0 0 sky130_fd_pr__res_xhigh_po w=20 l=99.603427
XRinv32iap0s1 Rinv32iat0s0 inv32m 0 sky130_fd_pr__res_xhigh_po w=20 l=99.603427
XRinv32iap1s0 in32 Rinv32iat1s0 0 sky130_fd_pr__res_xhigh_po w=20 l=99.603427
XRinv32iap1s1 Rinv32iat1s0 inv32m 0 sky130_fd_pr__res_xhigh_po w=20 l=99.603427
* PDK sky130_fd_pr__res_xhigh_po Rinv32ib W=20 L=99.603447
* tile Rinv32ib 2s x 2p same W=20 L=99.603447
XRinv32ibp0s0 in32n Rinv32ibt0s0 0 sky130_fd_pr__res_xhigh_po w=20 l=99.603447
XRinv32ibp0s1 Rinv32ibt0s0 inv32m 0 sky130_fd_pr__res_xhigh_po w=20 l=99.603447
XRinv32ibp1s0 in32n Rinv32ibt1s0 0 sky130_fd_pr__res_xhigh_po w=20 l=99.603447
XRinv32ibp1s1 Rinv32ibt1s0 inv32m 0 sky130_fd_pr__res_xhigh_po w=20 l=99.603447
Einv32amp in32n 0 0 inv32m 10000000
Vref vref 0 DC 1
* passive invert vref -> vrefn: R2/R1=1.0000002 closed-loop -1 at A=1e+07
* PDK sky130_fd_pr__res_xhigh_po Rinvrefia W=20 L=99.603427
* tile Rinvrefia 2s x 2p same W=20 L=99.603427
XRinvrefiap0s0 vref Rinvrefiat0s0 0 sky130_fd_pr__res_xhigh_po w=20 l=99.603427
XRinvrefiap0s1 Rinvrefiat0s0 invrefm 0 sky130_fd_pr__res_xhigh_po w=20 l=99.603427
XRinvrefiap1s0 vref Rinvrefiat1s0 0 sky130_fd_pr__res_xhigh_po w=20 l=99.603427
XRinvrefiap1s1 Rinvrefiat1s0 invrefm 0 sky130_fd_pr__res_xhigh_po w=20 l=99.603427
* PDK sky130_fd_pr__res_xhigh_po Rinvrefib W=20 L=99.603447
* tile Rinvrefib 2s x 2p same W=20 L=99.603447
XRinvrefibp0s0 vrefn Rinvrefibt0s0 0 sky130_fd_pr__res_xhigh_po w=20 l=99.603447
XRinvrefibp0s1 Rinvrefibt0s0 invrefm 0 sky130_fd_pr__res_xhigh_po w=20 l=99.603447
XRinvrefibp1s0 vrefn Rinvrefibt1s0 0 sky130_fd_pr__res_xhigh_po w=20 l=99.603447
XRinvrefibp1s1 Rinvrefibt1s0 invrefm 0 sky130_fd_pr__res_xhigh_po w=20 l=99.603447
Einvrefamp vrefn 0 0 invrefm 10000000
* load-compensated divider vrefn->taprefn: G_load=0.000966391595827364 Ra=508037.159088685 Rb=1000 target beta=0.001 (no tap buffer)
* PDK sky130_fd_pr__res_xhigh_po Rdivrefna W=20 L=5066.03
* tile Rdivrefna 2s x 2p same W=20 L=5066.03
XRdivrefnap0s0 vrefn Rdivrefnat0s0 0 sky130_fd_pr__res_xhigh_po w=20 l=5066.03
XRdivrefnap0s1 Rdivrefnat0s0 taprefn 0 sky130_fd_pr__res_xhigh_po w=20 l=5066.03
XRdivrefnap1s0 vrefn Rdivrefnat1s0 0 sky130_fd_pr__res_xhigh_po w=20 l=5066.03
XRdivrefnap1s1 Rdivrefnat1s0 taprefn 0 sky130_fd_pr__res_xhigh_po w=20 l=5066.03
* PDK sky130_fd_pr__res_xhigh_po Rdivrefnb W=20 L=9.8554268
* tile Rdivrefnb 2s x 2p same W=20 L=9.8554268
XRdivrefnbp0s0 taprefn Rdivrefnbt0s0 0 sky130_fd_pr__res_xhigh_po w=20 l=9.8554268
XRdivrefnbp0s1 Rdivrefnbt0s0 0 0 sky130_fd_pr__res_xhigh_po w=20 l=9.8554268
XRdivrefnbp1s0 taprefn Rdivrefnbt1s0 0 sky130_fd_pr__res_xhigh_po w=20 l=9.8554268
XRdivrefnbp1s1 Rdivrefnbt1s0 0 0 sky130_fd_pr__res_xhigh_po w=20 l=9.8554268

* n1 input 1 w=-0.195521390350609 w-  bank=n alpha=1 R=170484.330505015 G_phys=5.86564171051827e-06 G_eff=5.86564171051827e-06
* PDK sky130_fd_pr__res_xhigh_po Rn1n1n1 W=20 L=1699.9532
* tile Rn1n1n1 2s x 2p same W=20 L=1699.9532
XRn1n1n1p0s0 in1 Rn1n1n1t0s0 0 sky130_fd_pr__res_xhigh_po w=20 l=1699.9532
XRn1n1n1p0s1 Rn1n1n1t0s0 n1p 0 sky130_fd_pr__res_xhigh_po w=20 l=1699.9532
XRn1n1n1p1s0 in1 Rn1n1n1t1s0 0 sky130_fd_pr__res_xhigh_po w=20 l=1699.9532
XRn1n1n1p1s1 Rn1n1n1t1s0 n1p 0 sky130_fd_pr__res_xhigh_po w=20 l=1699.9532
* n1 input 2 w=+0.386445174905558 w+  bank=n alpha=1 R=86256.3061926689 G_phys=1.15933552471668e-05 G_eff=1.15933552471668e-05
* PDK sky130_fd_pr__res_xhigh_po Rn1p2n1 W=20 L=860.03131
* tile Rn1p2n1 2s x 2p same W=20 L=860.03131
XRn1p2n1p0s0 in2n Rn1p2n1t0s0 0 sky130_fd_pr__res_xhigh_po w=20 l=860.03131
XRn1p2n1p0s1 Rn1p2n1t0s0 n1p 0 sky130_fd_pr__res_xhigh_po w=20 l=860.03131
XRn1p2n1p1s0 in2n Rn1p2n1t1s0 0 sky130_fd_pr__res_xhigh_po w=20 l=860.03131
XRn1p2n1p1s1 Rn1p2n1t1s0 n1p 0 sky130_fd_pr__res_xhigh_po w=20 l=860.03131
* n1 input 3 w=+0.296294588630229 w+  bank=n alpha=1 R=112500.648383197 G_phys=8.88883765890688e-06 G_eff=8.88883765890688e-06
* PDK sky130_fd_pr__res_xhigh_po Rn1p3n1 W=20 L=1121.7399
* tile Rn1p3n1 2s x 2p same W=20 L=1121.7399
XRn1p3n1p0s0 in3n Rn1p3n1t0s0 0 sky130_fd_pr__res_xhigh_po w=20 l=1121.7399
XRn1p3n1p0s1 Rn1p3n1t0s0 n1p 0 sky130_fd_pr__res_xhigh_po w=20 l=1121.7399
XRn1p3n1p1s0 in3n Rn1p3n1t1s0 0 sky130_fd_pr__res_xhigh_po w=20 l=1121.7399
XRn1p3n1p1s1 Rn1p3n1t1s0 n1p 0 sky130_fd_pr__res_xhigh_po w=20 l=1121.7399
* n1 input 4 w=-0.299308681857295 w-  bank=n alpha=1 R=111367.746256108 G_phys=8.97926045571886e-06 G_eff=8.97926045571886e-06
* PDK sky130_fd_pr__res_xhigh_po Rn1n4n1 W=20 L=1110.4426
* tile Rn1n4n1 2s x 2p same W=20 L=1110.4426
XRn1n4n1p0s0 in4 Rn1n4n1t0s0 0 sky130_fd_pr__res_xhigh_po w=20 l=1110.4426
XRn1n4n1p0s1 Rn1n4n1t0s0 n1p 0 sky130_fd_pr__res_xhigh_po w=20 l=1110.4426
XRn1n4n1p1s0 in4 Rn1n4n1t1s0 0 sky130_fd_pr__res_xhigh_po w=20 l=1110.4426
XRn1n4n1p1s1 Rn1n4n1t1s0 n1p 0 sky130_fd_pr__res_xhigh_po w=20 l=1110.4426
* n1 input 5 w=+0.732671792857329 w+  bank=n alpha=1 R=45495.5870531571 G_phys=2.19801537857199e-05 G_eff=2.19801537857199e-05
* PDK sky130_fd_pr__res_xhigh_po Rn1p5n1 W=20 L=453.56542
* tile Rn1p5n1 2s x 2p same W=20 L=453.56542
XRn1p5n1p0s0 in5n Rn1p5n1t0s0 0 sky130_fd_pr__res_xhigh_po w=20 l=453.56542
XRn1p5n1p0s1 Rn1p5n1t0s0 n1p 0 sky130_fd_pr__res_xhigh_po w=20 l=453.56542
XRn1p5n1p1s0 in5n Rn1p5n1t1s0 0 sky130_fd_pr__res_xhigh_po w=20 l=453.56542
XRn1p5n1p1s1 Rn1p5n1t1s0 n1p 0 sky130_fd_pr__res_xhigh_po w=20 l=453.56542
* n1 input 6 w=+0.124925987288217 w+  bank=n alpha=1 R=266824.65399637 G_phys=3.7477796186465e-06 G_eff=3.7477796186465e-06
* PDK sky130_fd_pr__res_xhigh_po Rn1p6n1 W=20 L=2660.6589
* tile Rn1p6n1 2s x 2p same W=20 L=2660.6589
XRn1p6n1p0s0 in6n Rn1p6n1t0s0 0 sky130_fd_pr__res_xhigh_po w=20 l=2660.6589
XRn1p6n1p0s1 Rn1p6n1t0s0 n1p 0 sky130_fd_pr__res_xhigh_po w=20 l=2660.6589
XRn1p6n1p1s0 in6n Rn1p6n1t1s0 0 sky130_fd_pr__res_xhigh_po w=20 l=2660.6589
XRn1p6n1p1s1 Rn1p6n1t1s0 n1p 0 sky130_fd_pr__res_xhigh_po w=20 l=2660.6589
* n1 input 7 w=-0.0857938493267301 w-  bank=n alpha=1 R=388528.240601368 G_phys=2.5738154798019e-06 G_eff=2.5738154798019e-06
* PDK sky130_fd_pr__res_xhigh_po Rn1n7n1 W=20 L=3874.287
* tile Rn1n7n1 2s x 2p same W=20 L=3874.287
XRn1n7n1p0s0 in7 Rn1n7n1t0s0 0 sky130_fd_pr__res_xhigh_po w=20 l=3874.287
XRn1n7n1p0s1 Rn1n7n1t0s0 n1p 0 sky130_fd_pr__res_xhigh_po w=20 l=3874.287
XRn1n7n1p1s0 in7 Rn1n7n1t1s0 0 sky130_fd_pr__res_xhigh_po w=20 l=3874.287
XRn1n7n1p1s1 Rn1n7n1t1s0 n1p 0 sky130_fd_pr__res_xhigh_po w=20 l=3874.287
* n1 input 8 w=-0.0609936542707342 w-  bank=n alpha=1 R=546504.939438057 G_phys=1.82980962812202e-06 G_eff=1.82980962812202e-06
* PDK sky130_fd_pr__res_xhigh_po Rn1n8n1 W=20 L=5449.6307
* tile Rn1n8n1 2s x 2p same W=20 L=5449.6307
XRn1n8n1p0s0 in8 Rn1n8n1t0s0 0 sky130_fd_pr__res_xhigh_po w=20 l=5449.6307
XRn1n8n1p0s1 Rn1n8n1t0s0 n1p 0 sky130_fd_pr__res_xhigh_po w=20 l=5449.6307
XRn1n8n1p1s0 in8 Rn1n8n1t1s0 0 sky130_fd_pr__res_xhigh_po w=20 l=5449.6307
XRn1n8n1p1s1 Rn1n8n1t1s0 n1p 0 sky130_fd_pr__res_xhigh_po w=20 l=5449.6307
* n1 input 9 w=+0.256981204903229 w+  bank=n alpha=1 R=129711.172246568 G_phys=7.70943614709688e-06 G_eff=7.70943614709688e-06
* PDK sky130_fd_pr__res_xhigh_po Rn1p9n1 W=20 L=1293.3632
* tile Rn1p9n1 2s x 2p same W=20 L=1293.3632
XRn1p9n1p0s0 in9n Rn1p9n1t0s0 0 sky130_fd_pr__res_xhigh_po w=20 l=1293.3632
XRn1p9n1p0s1 Rn1p9n1t0s0 n1p 0 sky130_fd_pr__res_xhigh_po w=20 l=1293.3632
XRn1p9n1p1s0 in9n Rn1p9n1t1s0 0 sky130_fd_pr__res_xhigh_po w=20 l=1293.3632
XRn1p9n1p1s1 Rn1p9n1t1s0 n1p 0 sky130_fd_pr__res_xhigh_po w=20 l=1293.3632
* n1 input 10 w=+0.073638013162671 w+  bank=n alpha=1 R=452664.756987643 G_phys=2.20914039488013e-06 G_eff=2.20914039488013e-06
* PDK sky130_fd_pr__res_xhigh_po Rn1p10n1 W=20 L=4513.8564
* tile Rn1p10n1 2s x 2p same W=20 L=4513.8564
XRn1p10n1p0s0 in10n Rn1p10n1t0s0 0 sky130_fd_pr__res_xhigh_po w=20 l=4513.8564
XRn1p10n1p0s1 Rn1p10n1t0s0 n1p 0 sky130_fd_pr__res_xhigh_po w=20 l=4513.8564
XRn1p10n1p1s0 in10n Rn1p10n1t1s0 0 sky130_fd_pr__res_xhigh_po w=20 l=4513.8564
XRn1p10n1p1s1 Rn1p10n1t1s0 n1p 0 sky130_fd_pr__res_xhigh_po w=20 l=4513.8564
* n1 input 11 w=-0.149208279345328 w-  bank=n alpha=1 R=223401.365390634 G_phys=4.47624838035983e-06 G_eff=4.47624838035983e-06
* PDK sky130_fd_pr__res_xhigh_po Rn1n11n1 W=20 L=2227.6418
* tile Rn1n11n1 2s x 2p same W=20 L=2227.6418
XRn1n11n1p0s0 in11 Rn1n11n1t0s0 0 sky130_fd_pr__res_xhigh_po w=20 l=2227.6418
XRn1n11n1p0s1 Rn1n11n1t0s0 n1p 0 sky130_fd_pr__res_xhigh_po w=20 l=2227.6418
XRn1n11n1p1s0 in11 Rn1n11n1t1s0 0 sky130_fd_pr__res_xhigh_po w=20 l=2227.6418
XRn1n11n1p1s1 Rn1n11n1t1s0 n1p 0 sky130_fd_pr__res_xhigh_po w=20 l=2227.6418
* n1 input 12 w=-0.475362564845884 w-  bank=n alpha=1 R=70121.9149306388 G_phys=1.42608769453765e-05 G_eff=1.42608769453765e-05
* PDK sky130_fd_pr__res_xhigh_po Rn1n12n1 W=20 L=699.13916
* tile Rn1n12n1 2s x 2p same W=20 L=699.13916
XRn1n12n1p0s0 in12 Rn1n12n1t0s0 0 sky130_fd_pr__res_xhigh_po w=20 l=699.13916
XRn1n12n1p0s1 Rn1n12n1t0s0 n1p 0 sky130_fd_pr__res_xhigh_po w=20 l=699.13916
XRn1n12n1p1s0 in12 Rn1n12n1t1s0 0 sky130_fd_pr__res_xhigh_po w=20 l=699.13916
XRn1n12n1p1s1 Rn1n12n1t1s0 n1p 0 sky130_fd_pr__res_xhigh_po w=20 l=699.13916
* n1 input 13 w=-0.0533811781970356 w-  bank=n alpha=1 R=624439.820535554 G_phys=1.60143534591107e-06 G_eff=1.60143534591107e-06
* PDK sky130_fd_pr__res_xhigh_po Rn1n13n1 W=20 L=6226.7973
* tile Rn1n13n1 2s x 2p same W=20 L=6226.7973
XRn1n13n1p0s0 in13 Rn1n13n1t0s0 0 sky130_fd_pr__res_xhigh_po w=20 l=6226.7973
XRn1n13n1p0s1 Rn1n13n1t0s0 n1p 0 sky130_fd_pr__res_xhigh_po w=20 l=6226.7973
XRn1n13n1p1s0 in13 Rn1n13n1t1s0 0 sky130_fd_pr__res_xhigh_po w=20 l=6226.7973
XRn1n13n1p1s1 Rn1n13n1t1s0 n1p 0 sky130_fd_pr__res_xhigh_po w=20 l=6226.7973
* n1 input 14 w=+0.279456004632752 w+  bank=n alpha=1 R=119279.359830319 G_phys=8.38368013898257e-06 G_eff=8.38368013898257e-06
* PDK sky130_fd_pr__res_xhigh_po Rn1p14n1 W=20 L=1189.3372
* tile Rn1p14n1 2s x 2p same W=20 L=1189.3372
XRn1p14n1p0s0 in14n Rn1p14n1t0s0 0 sky130_fd_pr__res_xhigh_po w=20 l=1189.3372
XRn1p14n1p0s1 Rn1p14n1t0s0 n1p 0 sky130_fd_pr__res_xhigh_po w=20 l=1189.3372
XRn1p14n1p1s0 in14n Rn1p14n1t1s0 0 sky130_fd_pr__res_xhigh_po w=20 l=1189.3372
XRn1p14n1p1s1 Rn1p14n1t1s0 n1p 0 sky130_fd_pr__res_xhigh_po w=20 l=1189.3372
* n1 input 15 w=-0.0744870090943736 w-  bank=n alpha=1 R=447505.326614748 G_phys=2.23461027283121e-06 G_eff=2.23461027283121e-06
* PDK sky130_fd_pr__res_xhigh_po Rn1n15n1 W=20 L=4462.4065
* tile Rn1n15n1 2s x 2p same W=20 L=4462.4065
XRn1n15n1p0s0 in15 Rn1n15n1t0s0 0 sky130_fd_pr__res_xhigh_po w=20 l=4462.4065
XRn1n15n1p0s1 Rn1n15n1t0s0 n1p 0 sky130_fd_pr__res_xhigh_po w=20 l=4462.4065
XRn1n15n1p1s0 in15 Rn1n15n1t1s0 0 sky130_fd_pr__res_xhigh_po w=20 l=4462.4065
XRn1n15n1p1s1 Rn1n15n1t1s0 n1p 0 sky130_fd_pr__res_xhigh_po w=20 l=4462.4065
* n1 input 16 w=-0.0222148593491043 w-  bank=f alpha=0.001 R=1500.49715865869 G_phys=0.000666445780473128 G_eff=6.66445780473128e-07
* PDK sky130_fd_pr__res_xhigh_po Rn1n16f1 W=20 L=14.846384
* tile Rn1n16f1 2s x 2p same W=20 L=14.846384
XRn1n16f1p0s0 tap16 Rn1n16f1t0s0 0 sky130_fd_pr__res_xhigh_po w=20 l=14.846384
XRn1n16f1p0s1 Rn1n16f1t0s0 n1p 0 sky130_fd_pr__res_xhigh_po w=20 l=14.846384
XRn1n16f1p1s0 tap16 Rn1n16f1t1s0 0 sky130_fd_pr__res_xhigh_po w=20 l=14.846384
XRn1n16f1p1s1 Rn1n16f1t1s0 n1p 0 sky130_fd_pr__res_xhigh_po w=20 l=14.846384
* n1 input 17 w=+0.0088751960388594 w+  bank=f alpha=0.001 R=3755.78558348297 G_phys=0.000266255881165782 G_eff=2.66255881165782e-07
* PDK sky130_fd_pr__res_xhigh_po Rn1p17f1 W=20 L=37.336121
* tile Rn1p17f1 2s x 2p same W=20 L=37.336121
XRn1p17f1p0s0 tap17n Rn1p17f1t0s0 0 sky130_fd_pr__res_xhigh_po w=20 l=37.336121
XRn1p17f1p0s1 Rn1p17f1t0s0 n1p 0 sky130_fd_pr__res_xhigh_po w=20 l=37.336121
XRn1p17f1p1s0 tap17n Rn1p17f1t1s0 0 sky130_fd_pr__res_xhigh_po w=20 l=37.336121
XRn1p17f1p1s1 Rn1p17f1t1s0 n1p 0 sky130_fd_pr__res_xhigh_po w=20 l=37.336121
* n1 input 18 w=-0.194172060066752 w-  bank=n alpha=1 R=171669.051262443 G_phys=5.82516180200256e-06 G_eff=5.82516180200256e-06
* PDK sky130_fd_pr__res_xhigh_po Rn1n18n1 W=20 L=1711.7672
* tile Rn1n18n1 2s x 2p same W=20 L=1711.7672
XRn1n18n1p0s0 in18 Rn1n18n1t0s0 0 sky130_fd_pr__res_xhigh_po w=20 l=1711.7672
XRn1n18n1p0s1 Rn1n18n1t0s0 n1p 0 sky130_fd_pr__res_xhigh_po w=20 l=1711.7672
XRn1n18n1p1s0 in18 Rn1n18n1t1s0 0 sky130_fd_pr__res_xhigh_po w=20 l=1711.7672
XRn1n18n1p1s1 Rn1n18n1t1s0 n1p 0 sky130_fd_pr__res_xhigh_po w=20 l=1711.7672
* n1 input 19 w=+0.341327626188232 w+  bank=n alpha=1 R=97657.8828546125 G_phys=1.0239828785647e-05 G_eff=1.0239828785647e-05
* PDK sky130_fd_pr__res_xhigh_po Rn1p19n1 W=20 L=973.72783
* tile Rn1p19n1 2s x 2p same W=20 L=973.72783
XRn1p19n1p0s0 in19n Rn1p19n1t0s0 0 sky130_fd_pr__res_xhigh_po w=20 l=973.72783
XRn1p19n1p0s1 Rn1p19n1t0s0 n1p 0 sky130_fd_pr__res_xhigh_po w=20 l=973.72783
XRn1p19n1p1s0 in19n Rn1p19n1t1s0 0 sky130_fd_pr__res_xhigh_po w=20 l=973.72783
XRn1p19n1p1s1 Rn1p19n1t1s0 n1p 0 sky130_fd_pr__res_xhigh_po w=20 l=973.72783
* n1 input 20 w=-0.0323870183321868 w-  bank=f alpha=0.001 R=1029.21896024637 G_phys=0.000971610549965604 G_eff=9.71610549965604e-07
* PDK sky130_fd_pr__res_xhigh_po Rn1n20f1 W=20 L=10.146798
* tile Rn1n20f1 2s x 2p same W=20 L=10.146798
XRn1n20f1p0s0 tap20 Rn1n20f1t0s0 0 sky130_fd_pr__res_xhigh_po w=20 l=10.146798
XRn1n20f1p0s1 Rn1n20f1t0s0 n1p 0 sky130_fd_pr__res_xhigh_po w=20 l=10.146798
XRn1n20f1p1s0 tap20 Rn1n20f1t1s0 0 sky130_fd_pr__res_xhigh_po w=20 l=10.146798
XRn1n20f1p1s1 Rn1n20f1t1s0 n1p 0 sky130_fd_pr__res_xhigh_po w=20 l=10.146798
* n1 input 21 w=-0.0999542141187652 w-  bank=n alpha=1 R=333486.022847689 G_phys=2.99862642356296e-06 G_eff=2.99862642356296e-06
* PDK sky130_fd_pr__res_xhigh_po Rn1n21n1 W=20 L=3325.406
* tile Rn1n21n1 2s x 2p same W=20 L=3325.406
XRn1n21n1p0s0 in21 Rn1n21n1t0s0 0 sky130_fd_pr__res_xhigh_po w=20 l=3325.406
XRn1n21n1p0s1 Rn1n21n1t0s0 n1p 0 sky130_fd_pr__res_xhigh_po w=20 l=3325.406
XRn1n21n1p1s0 in21 Rn1n21n1t1s0 0 sky130_fd_pr__res_xhigh_po w=20 l=3325.406
XRn1n21n1p1s1 Rn1n21n1t1s0 n1p 0 sky130_fd_pr__res_xhigh_po w=20 l=3325.406
* n1 input 22 w=+0.693789300406694 w+  bank=n alpha=1 R=48045.3263170729 G_phys=2.08136790122008e-05 G_eff=2.08136790122008e-05
* PDK sky130_fd_pr__res_xhigh_po Rn1p22n1 W=20 L=478.99142
* tile Rn1p22n1 2s x 2p same W=20 L=478.99142
XRn1p22n1p0s0 in22n Rn1p22n1t0s0 0 sky130_fd_pr__res_xhigh_po w=20 l=478.99142
XRn1p22n1p0s1 Rn1p22n1t0s0 n1p 0 sky130_fd_pr__res_xhigh_po w=20 l=478.99142
XRn1p22n1p1s0 in22n Rn1p22n1t1s0 0 sky130_fd_pr__res_xhigh_po w=20 l=478.99142
XRn1p22n1p1s1 Rn1p22n1t1s0 n1p 0 sky130_fd_pr__res_xhigh_po w=20 l=478.99142
* n1 input 23 w=+0.0972685864670828 w+  bank=n alpha=1 R=342693.715864925 G_phys=2.91805759401248e-06 G_eff=2.91805759401248e-06
* PDK sky130_fd_pr__res_xhigh_po Rn1p23n1 W=20 L=3417.2252
* tile Rn1p23n1 2s x 2p same W=20 L=3417.2252
XRn1p23n1p0s0 in23n Rn1p23n1t0s0 0 sky130_fd_pr__res_xhigh_po w=20 l=3417.2252
XRn1p23n1p0s1 Rn1p23n1t0s0 n1p 0 sky130_fd_pr__res_xhigh_po w=20 l=3417.2252
XRn1p23n1p1s0 in23n Rn1p23n1t1s0 0 sky130_fd_pr__res_xhigh_po w=20 l=3417.2252
XRn1p23n1p1s1 Rn1p23n1t1s0 n1p 0 sky130_fd_pr__res_xhigh_po w=20 l=3417.2252
* n1 input 24 w=-0.0293783170287994 w-  bank=f alpha=0.001 R=1134.6236512002 G_phys=0.000881349510863982 G_eff=8.81349510863982e-07
* PDK sky130_fd_pr__res_xhigh_po Rn1n24f1 W=20 L=11.197894
* tile Rn1n24f1 2s x 2p same W=20 L=11.197894
XRn1n24f1p0s0 tap24 Rn1n24f1t0s0 0 sky130_fd_pr__res_xhigh_po w=20 l=11.197894
XRn1n24f1p0s1 Rn1n24f1t0s0 n1p 0 sky130_fd_pr__res_xhigh_po w=20 l=11.197894
XRn1n24f1p1s0 tap24 Rn1n24f1t1s0 0 sky130_fd_pr__res_xhigh_po w=20 l=11.197894
XRn1n24f1p1s1 Rn1n24f1t1s0 n1p 0 sky130_fd_pr__res_xhigh_po w=20 l=11.197894
* n1 input 25 w=+0.0497492024826392 w+  bank=n alpha=1 R=670027.491294269 G_phys=1.49247607447918e-06 G_eff=1.49247607447918e-06
* PDK sky130_fd_pr__res_xhigh_po Rn1p25n1 W=20 L=6681.3976
* tile Rn1p25n1 2s x 2p same W=20 L=6681.3976
XRn1p25n1p0s0 in25n Rn1p25n1t0s0 0 sky130_fd_pr__res_xhigh_po w=20 l=6681.3976
XRn1p25n1p0s1 Rn1p25n1t0s0 n1p 0 sky130_fd_pr__res_xhigh_po w=20 l=6681.3976
XRn1p25n1p1s0 in25n Rn1p25n1t1s0 0 sky130_fd_pr__res_xhigh_po w=20 l=6681.3976
XRn1p25n1p1s1 Rn1p25n1t1s0 n1p 0 sky130_fd_pr__res_xhigh_po w=20 l=6681.3976
* n1 input 26 w=-0.466063512962686 w-  bank=n alpha=1 R=71521.0103477937 G_phys=1.39819053888806e-05 G_eff=1.39819053888806e-05
* PDK sky130_fd_pr__res_xhigh_po Rn1n26n1 W=20 L=713.09094
* tile Rn1n26n1 2s x 2p same W=20 L=713.09094
XRn1n26n1p0s0 in26 Rn1n26n1t0s0 0 sky130_fd_pr__res_xhigh_po w=20 l=713.09094
XRn1n26n1p0s1 Rn1n26n1t0s0 n1p 0 sky130_fd_pr__res_xhigh_po w=20 l=713.09094
XRn1n26n1p1s0 in26 Rn1n26n1t1s0 0 sky130_fd_pr__res_xhigh_po w=20 l=713.09094
XRn1n26n1p1s1 Rn1n26n1t1s0 n1p 0 sky130_fd_pr__res_xhigh_po w=20 l=713.09094
* n1 input 27 w=+0.194887582685885 w+  bank=n alpha=1 R=171038.774630702 G_phys=5.84662748057655e-06 G_eff=5.84662748057655e-06
* PDK sky130_fd_pr__res_xhigh_po Rn1p27n1 W=20 L=1705.4821
* tile Rn1p27n1 2s x 2p same W=20 L=1705.4821
XRn1p27n1p0s0 in27n Rn1p27n1t0s0 0 sky130_fd_pr__res_xhigh_po w=20 l=1705.4821
XRn1p27n1p0s1 Rn1p27n1t0s0 n1p 0 sky130_fd_pr__res_xhigh_po w=20 l=1705.4821
XRn1p27n1p1s0 in27n Rn1p27n1t1s0 0 sky130_fd_pr__res_xhigh_po w=20 l=1705.4821
XRn1p27n1p1s1 Rn1p27n1t1s0 n1p 0 sky130_fd_pr__res_xhigh_po w=20 l=1705.4821
* n1 input 28 w=+0.209047565197081 w+  bank=n alpha=1 R=159453.344036359 G_phys=6.27142695591242e-06 G_eff=6.27142695591242e-06
* PDK sky130_fd_pr__res_xhigh_po Rn1p28n1 W=20 L=1589.9522
* tile Rn1p28n1 2s x 2p same W=20 L=1589.9522
XRn1p28n1p0s0 in28n Rn1p28n1t0s0 0 sky130_fd_pr__res_xhigh_po w=20 l=1589.9522
XRn1p28n1p0s1 Rn1p28n1t0s0 n1p 0 sky130_fd_pr__res_xhigh_po w=20 l=1589.9522
XRn1p28n1p1s0 in28n Rn1p28n1t1s0 0 sky130_fd_pr__res_xhigh_po w=20 l=1589.9522
XRn1p28n1p1s1 Rn1p28n1t1s0 n1p 0 sky130_fd_pr__res_xhigh_po w=20 l=1589.9522
* n1 input 29 w=+0.00919963467526149 w+  bank=f alpha=0.001 R=3623.33228546229 G_phys=0.000275989040257845 G_eff=2.75989040257845e-07
* PDK sky130_fd_pr__res_xhigh_po Rn1p29f1 W=20 L=36.015296
* tile Rn1p29f1 2s x 2p same W=20 L=36.015296
XRn1p29f1p0s0 tap29n Rn1p29f1t0s0 0 sky130_fd_pr__res_xhigh_po w=20 l=36.015296
XRn1p29f1p0s1 Rn1p29f1t0s0 n1p 0 sky130_fd_pr__res_xhigh_po w=20 l=36.015296
XRn1p29f1p1s0 tap29n Rn1p29f1t1s0 0 sky130_fd_pr__res_xhigh_po w=20 l=36.015296
XRn1p29f1p1s1 Rn1p29f1t1s0 n1p 0 sky130_fd_pr__res_xhigh_po w=20 l=36.015296
* n1 input 30 w=-0.379437042796868 w-  bank=n alpha=1 R=87849.4442388387 G_phys=1.13831112839061e-05 G_eff=1.13831112839061e-05
* PDK sky130_fd_pr__res_xhigh_po Rn1n30n1 W=20 L=875.91808
* tile Rn1n30n1 2s x 2p same W=20 L=875.91808
XRn1n30n1p0s0 in30 Rn1n30n1t0s0 0 sky130_fd_pr__res_xhigh_po w=20 l=875.91808
XRn1n30n1p0s1 Rn1n30n1t0s0 n1p 0 sky130_fd_pr__res_xhigh_po w=20 l=875.91808
XRn1n30n1p1s0 in30 Rn1n30n1t1s0 0 sky130_fd_pr__res_xhigh_po w=20 l=875.91808
XRn1n30n1p1s1 Rn1n30n1t1s0 n1p 0 sky130_fd_pr__res_xhigh_po w=20 l=875.91808
* n1 input 31 w=-0.216631724491884 w-  bank=n alpha=1 R=153870.96885979 G_phys=6.49895173475653e-06 G_eff=6.49895173475653e-06
* PDK sky130_fd_pr__res_xhigh_po Rn1n31n1 W=20 L=1534.2847
* tile Rn1n31n1 2s x 2p same W=20 L=1534.2847
XRn1n31n1p0s0 in31 Rn1n31n1t0s0 0 sky130_fd_pr__res_xhigh_po w=20 l=1534.2847
XRn1n31n1p0s1 Rn1n31n1t0s0 n1p 0 sky130_fd_pr__res_xhigh_po w=20 l=1534.2847
XRn1n31n1p1s0 in31 Rn1n31n1t1s0 0 sky130_fd_pr__res_xhigh_po w=20 l=1534.2847
XRn1n31n1p1s1 Rn1n31n1t1s0 n1p 0 sky130_fd_pr__res_xhigh_po w=20 l=1534.2847
* n1 input 32 w=+0.139103822260271 w+  bank=n alpha=1 R=239629.169002738 G_phys=4.17311466780814e-06 G_eff=4.17311466780814e-06
* PDK sky130_fd_pr__res_xhigh_po Rn1p32n1 W=20 L=2389.4655
* tile Rn1p32n1 2s x 2p same W=20 L=2389.4655
XRn1p32n1p0s0 in32n Rn1p32n1t0s0 0 sky130_fd_pr__res_xhigh_po w=20 l=2389.4655
XRn1p32n1p0s1 Rn1p32n1t0s0 n1p 0 sky130_fd_pr__res_xhigh_po w=20 l=2389.4655
XRn1p32n1p1s0 in32n Rn1p32n1t1s0 0 sky130_fd_pr__res_xhigh_po w=20 l=2389.4655
XRn1p32n1p1s1 Rn1p32n1t1s0 n1p 0 sky130_fd_pr__res_xhigh_po w=20 l=2389.4655
* n1 bias w+  bank=f alpha=0.001 R=1034.77721072674 G_phys=0.000966391595827364 G_eff=9.66391595827364e-07
* PDK sky130_fd_pr__res_xhigh_po Rn1bpf1 W=20 L=10.202225
* tile Rn1bpf1 2s x 2p same W=20 L=10.202225
XRn1bpf1p0s0 taprefn Rn1bpf1t0s0 0 sky130_fd_pr__res_xhigh_po w=20 l=10.202225
XRn1bpf1p0s1 Rn1bpf1t0s0 n1p 0 sky130_fd_pr__res_xhigh_po w=20 l=10.202225
XRn1bpf1p1s0 taprefn Rn1bpf1t1s0 0 sky130_fd_pr__res_xhigh_po w=20 l=10.202225
XRn1bpf1p1s1 Rn1bpf1t1s0 n1p 0 sky130_fd_pr__res_xhigh_po w=20 l=10.202225
* feedback TIA n1: Rf=33333.3333333333 A=1000000 V(n1lin) = -I(n1p)*Rf*A/(A+1)  (uncompensated)
En1tia n1lin 0 0 n1p 1000000
* PDK sky130_fd_pr__res_xhigh_po Rn1f W=20 L=332.28343
* tile Rn1f 2s x 2p same W=20 L=332.28343
XRn1fp0s0 n1lin Rn1ft0s0 0 sky130_fd_pr__res_xhigh_po w=20 l=332.28343
XRn1fp0s1 Rn1ft0s0 n1p 0 sky130_fd_pr__res_xhigh_po w=20 l=332.28343
XRn1fp1s0 n1lin Rn1ft1s0 0 sky130_fd_pr__res_xhigh_po w=20 l=332.28343
XRn1fp1s1 Rn1ft1s0 n1p 0 sky130_fd_pr__res_xhigh_po w=20 l=332.28343

.control
set numdgt=12
set seed=55014
op
print v(n1lin)
print v(n1p)
.endc
.end
