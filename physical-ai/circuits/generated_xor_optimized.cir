* Matter Compiler v1 mapping: G=1e-05 quant=exact range=unconstrained
* Frozen model weights were not changed.
* Physical AI - Experiment 6: compiled trained XOR network
* Source: models/xor_model.npz  (frozen; this file does not retrain)
* Hidden: precision ReLU. Output: linear.
* Signed weights: G+/G- paths, I_diff = I+ - I- by KCL in SPICE.
* Bias: 1 V reference through G_SCALE*|b| onto the + or - path.
* G_SCALE = 1e-05

Vin1 in1 0 DC 0
Vin2 in2 0 DC 0
Vref vref 0 DC 1

* --- neuron h1 ---
* h1 input 1 w=+1.19815674317629 w+  G = 1.19815674317629e-05 S  R = 83461.5342020291 Ohm
Rh1p1 in1 h1p 83461.5342020291
* h1 input 2 w=-1.50292758377884 w-  G = 1.50292758377884e-05 S  R = 66536.8052854338 Ohm
Rh1n2 in2 h1n 66536.8052854338
* h1 bias=-0.263318577180974 b-  G = 2.63318577180974e-06 S  R = 379768.116137404 Ohm
Rh1bn vref h1n 379768.116137404
Vh1p h1p 0 DC 0
Vh1n h1n 0 DC 0
Fh1p 0 h1d Vh1p 1
Fh1n h1d 0 Vh1n 1
Vh1d h1d 0 DC 0
Hh1 h1lin 0 Vh1d 100000
Bh1 h1amp 0 V = max(-15, min(15, 100000 * v(h1lin, h1y)))
Dh1 h1amp h1y Dsi
RLh1 h1y 0 10000
Eh1 h1buf 0 h1y 0 1

* --- neuron h2 ---
* h2 input 1 w=-1.32632227505072 w-  G = 1.32632227505072e-05 S  R = 75396.4567142449 Ohm
Rh2n1 in1 h2n 75396.4567142449
* h2 input 2 w=+1.07610691190505 w+  G = 1.07610691190505e-05 S  R = 92927.5696435857 Ohm
Rh2p2 in2 h2p 92927.5696435857
* h2 bias=-0.150794171118301 b-  G = 1.50794171118301e-06 S  R = 663155.606469353 Ohm
Rh2bn vref h2n 663155.606469353
Vh2p h2p 0 DC 0
Vh2n h2n 0 DC 0
Fh2p 0 h2d Vh2p 1
Fh2n h2d 0 Vh2n 1
Vh2d h2d 0 DC 0
Hh2 h2lin 0 Vh2d 100000
Bh2 h2amp 0 V = max(-15, min(15, 100000 * v(h2lin, h2y)))
Dh2 h2amp h2y Dsi
RLh2 h2y 0 10000
Eh2 h2buf 0 h2y 0 1

* --- neuron h3 ---
* h3 input 1 w=-1.95103518865384 w-  G = 1.95103518865384e-05 S  R = 51254.8418304015 Ohm
Rh3n1 in1 h3n 51254.8418304015
* h3 input 2 w=-1.30217950686232 w-  G = 1.30217950686232e-05 S  R = 76794.3278733945 Ohm
Rh3n2 in2 h3n 76794.3278733945
* h3 bias=-0.38586653272309 b-  G = 3.8586653272309e-06 S  R = 259156.966255384 Ohm
Rh3bn vref h3n 259156.966255384
Vh3p h3p 0 DC 0
Vh3n h3n 0 DC 0
Fh3p 0 h3d Vh3p 1
Fh3n h3d 0 Vh3n 1
Vh3d h3d 0 DC 0
Hh3 h3lin 0 Vh3d 100000
Bh3 h3amp 0 V = max(-15, min(15, 100000 * v(h3lin, h3y)))
Dh3 h3amp h3y Dsi
RLh3 h3y 0 10000
Eh3 h3buf 0 h3y 0 1

* --- neuron h4 ---
* h4 input 1 w=-0.389860187546613 w-  G = 3.89860187546613e-06 S  R = 256502.210777918 Ohm
Rh4n1 in1 h4n 256502.210777918
* h4 input 2 w=-0.316242592343582 w-  G = 3.16242592343582e-06 S  R = 316212.940385193 Ohm
Rh4n2 in2 h4n 316212.940385193
* h4 bias=-0.440210309856559 b-  G = 4.40210309856559e-06 S  R = 227164.148046838 Ohm
Rh4bn vref h4n 227164.148046838
Vh4p h4p 0 DC 0
Vh4n h4n 0 DC 0
Fh4p 0 h4d Vh4p 1
Fh4n h4d 0 Vh4n 1
Vh4d h4d 0 DC 0
Hh4 h4lin 0 Vh4d 100000
Bh4 h4amp 0 V = max(-15, min(15, 100000 * v(h4lin, h4y)))
Dh4 h4amp h4y Dsi
RLh4 h4y 0 10000
Eh4 h4buf 0 h4y 0 1

* --- neuron o1 ---
* o1 input 1 w=+1.08721396161991 w+  G = 1.08721396161991e-05 S  R = 91978.2154480464 Ohm
Ro1p1 h1buf o1p 91978.2154480464
* o1 input 2 w=+1.08166020799012 w+  G = 1.08166020799012e-05 S  R = 92450.4749840197 Ohm
Ro1p2 h2buf o1p 92450.4749840197
* o1 input 3 w=-0.181304037590092 w-  G = 1.81304037590092e-06 S  R = 551559.696790035 Ohm
Ro1n3 h3buf o1n 551559.696790035
* o1 input 4 w=-0.194127908586592 w-  G = 1.94127908586592e-06 S  R = 515124.284437413 Ohm
Ro1n4 h4buf o1n 515124.284437413
* o1 bias=+0.00165034061256185 b+  G = 1.65034061256185e-08 S  R = 60593552.1666454 Ohm
Ro1bp vref o1p 60593552.1666454
Vo1p o1p 0 DC 0
Vo1n o1n 0 DC 0
Fo1p 0 o1d Vo1p 1
Fo1n o1d 0 Vo1n 1
Vo1d o1d 0 DC 0
Ho1 o1lin 0 Vo1d 100000

.model Dsi D(Is=1e-14 N=1 Rs=1)

.control
set numdgt=15
op
print i(Vh1p)
print i(Vh1n)
print i(Vh1d)
print v(h1lin)
print v(h1y)
print i(Vh2p)
print i(Vh2n)
print i(Vh2d)
print v(h2lin)
print v(h2y)
print i(Vh3p)
print i(Vh3n)
print i(Vh3d)
print v(h3lin)
print v(h3y)
print i(Vh4p)
print i(Vh4n)
print i(Vh4d)
print v(h4lin)
print v(h4y)
print i(Vo1p)
print i(Vo1n)
print i(Vo1d)
print v(o1lin)
.endc

.end
