* Experiment 32 isolated invert kind=servo Vin=2.60818 Rload=4914.01
Vin in 0 DC 2.60817586522917
R1 in mid 10000
R2 out mid 10000
Rload out 0 4914.01304862554
.include "C:/ngspice/examples/optran/models/opa1656.lib"
Vdd vdd 0 DC 15
Vss vss 0 DC -15
* LEVEL 2 invert servo: IN+ integrates (v(out)+v(in))
Berr err 0 V = v(out)+v(in)
Gsrv inp 0 err 0 2e-4
Csrv inp 0 20n
Rleak inp 0 1e9
Xinv inp mid vdd vss out OPA1656
Ccl out 0 1p
.control
set numdgt=15
tran 5e-07 0.0001
meas tran vout_end find v(out) at=0.0001
meas tran vmid_end find v(mid) at=0.0001
print vout_end
print vmid_end
.endc
.end
