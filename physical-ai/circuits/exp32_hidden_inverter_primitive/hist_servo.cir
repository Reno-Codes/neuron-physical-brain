* Experiment 32 isolated invert kind=servo Vin=0 Rload=4914.01
Vin in 0 PWL(0 0 0.0002 0 0.000201 2.60817586522917 0.0004 2.60817586522917 0.000401 1 0.0006 1 0.000601 0 0.0008 0)
R1 in mid 10000
R2 out mid 10000
Rload out 0 4914.01304862554
.include "C:/ngspice/examples/optran/models/opa1656.lib"
Vdd vdd 0 DC 15
Vss vss 0 DC -15
* LEVEL 2 invert servo: IN+ integrates (v(out)+v(in))
Berr err 0 V = v(out)+v(in)
Gsrv inp 0 err 0 2e-4
Csrv inp 0 20n
Rleak inp 0 1e9
Xinv inp mid vdd vss out OPA1656
Ccl out 0 1p
.control
set numdgt=15
tran 2e-06 0.0008
meas tran vs0 find v(out) at=0.0002
print vs0
meas tran vs1 find v(out) at=0.0004
print vs1
meas tran vs2 find v(out) at=0.0006
print vs2
meas tran vs3 find v(out) at=0.0008
print vs3
.endc
.end
