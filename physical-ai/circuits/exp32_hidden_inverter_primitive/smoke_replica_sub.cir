* Experiment 32 isolated invert kind=replica_sub Vin=0 Rload=4914.01
Vin in 0 DC 0
R1 in mid 10000
R2 raw mid 10000
Rload out 0 4914.01304862554
.include "C:/ngspice/examples/optran/models/opa1656.lib"
Vdd vdd 0 DC 15
Vss vss 0 DC -15
* dest = raw - replica_out. B-source also drives the load.
Rra 0 rmid 10000
Rrb rout rmid 10000
Xrep 0 rmid vdd vss rout OPA1656
Crc rout 0 1p
Rrl rout 0 4914.01304862554
Xinv 0 mid vdd vss raw OPA1656
Ccl raw 0 1p
Bcorr out 0 V = v(raw)-v(rout)
.control
set numdgt=15
op
print v(out)
print v(mid)
print v(in)
print i(Rload)
print v(rmid)
print v(rout)
print i(Vdd)
.endc
.end
